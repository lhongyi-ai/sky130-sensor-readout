* Canonical Day 4 OTA subcircuit.
* DAY4_MANIFEST_SHA256=6b90c7326a881914a362e3b2e6e96e4716b20c8b8196590f22c2ce5e1ab460ab
* Pin order: VDD VSS VINP VINN VOUT VBP(IREF input node)
.subckt SKY130_TWO_STAGE_OTA VDD VSS VINP VINN VOUT VBP

* Single-IREF bias tree.  Every bulk and return has an explicit rail.
XM8  VBP  VBP VDD VDD sky130_fd_pr__pfet_01v8 L=0.8 W=7.22005 nf=1 mult=1
XM9  VBN  VBP VDD VDD sky130_fd_pr__pfet_01v8 L=0.8 W=7.22005 nf=1 mult=1
XM10 VBN  VBN VSS VSS sky130_fd_pr__nfet_01v8 L=0.8 W=8.08605 nf=1 mult=1

* Differential first stage; M3/M4 are each two explicit parallel units.
XM1  NMIR VINN TAIL VSS sky130_fd_pr__nfet_01v8 L=0.5 W=16.83798 nf=1 mult=1
XM2  VX   VINP TAIL VSS sky130_fd_pr__nfet_01v8 L=0.5 W=16.83798 nf=1 mult=1
XM3A NMIR NMIR VDD VDD sky130_fd_pr__pfet_01v8 L=0.5 W=25 nf=1 mult=1
XM3B NMIR NMIR VDD VDD sky130_fd_pr__pfet_01v8 L=0.5 W=25 nf=1 mult=1
XM4A VX   NMIR VDD VDD sky130_fd_pr__pfet_01v8 L=0.5 W=25 nf=1 mult=1
XM4B VX   NMIR VDD VDD sky130_fd_pr__pfet_01v8 L=0.5 W=25 nf=1 mult=1
XM5  TAIL VBN  VSS VSS sky130_fd_pr__nfet_01v8 L=0.8 W=25.8754 nf=1 mult=1

* Common-source second stage and Miller compensation.
XM6 VOUT VX  VSS VSS sky130_fd_pr__nfet_01v8 L=0.5 W=8.83907427041 nf=1 mult=1
XM7 VOUT VBP VDD VDD sky130_fd_pr__pfet_01v8 L=0.8 W=72.2005 nf=1 mult=1
RZ1 VX NCC 2000
CC1 NCC VOUT 3e-12

.ends SKY130_TWO_STAGE_OTA
