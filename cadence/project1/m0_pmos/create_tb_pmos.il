; project1 M0 v0.1.0: native topology. Device sizing uses the PDK property form.
; Never overwrite any existing cell, including a partial previous attempt.
procedure(p1pmPin(inst name)
  let((term pin)
    term=dbFindTermByName(inst~>master name)
    unless(term error("Missing terminal %s on %s\n" name inst~>name))
    pin=car(term~>pins)
    unless(pin error("No symbol pin for %s\n" name))
    dbTransformPoint(centerBox(pin~>fig~>bBox) inst~>transform)
  )
)
procedure(p1pmWire(cv points)
  unless(schCreateWire(cv "draw" "full" points 0.0625 0.0625 0.0)
    error("Wire creation failed; preserve partial cell for diagnosis.\n"))
)
procedure(p1pmCreate()
  let((cv nm vm gm m vd vg vs g1 g2 g3 d s b gate vp vn gp gn sp sn)
    unless(ddGetObj("project1") error("project1 not found.\n"))
    when(ddGetObj("project1" "tb_pmos_dc")
      error("tb_pmos_dc already exists. No overwrite. Open existing cell; report errors if incomplete.\n"))
    nm=dbOpenCellViewByType("sky130_fd_pr_main" "pfet_01v8" "symbol" "" "r")
    vm=dbOpenCellViewByType("analogLib" "vdc" "symbol" "" "r")
    gm=dbOpenCellViewByType("analogLib" "gnd" "symbol" "" "r")
    unless(and(nm vm gm) error("Required PDK or analogLib symbols unavailable.\n"))
    cv=dbOpenCellViewByType("project1" "tb_pmos_dc" "schematic" "schematic" "w")
    unless(cv error("Cannot create schematic.\n"))
    dbReplaceProp(cv "project1HandoffVersion" "string" "m0_pmos_0.1.0")
    dbReplaceProp(cv "project1Qualification" "string" "TOPOLOGY_ONLY_SIZE_IN_PROPERTY_FORM_THEN_VERIFY_NETLIST")
    m=dbCreateInst(cv nm "M0" 0:0 "R0")
    vd=dbCreateInst(cv vm "VD" 2.5:-1.0 "R0")
    vs=dbCreateInst(cv vm "VS" 1.5:0.75 "R0")
    dbReplaceProp(vs "vdc" "string" "1.8")
    vg=dbCreateInst(cv vm "VG" -1.5:0 "R0")
    dbReplaceProp(vd "vdc" "string" "0.9")
    dbReplaceProp(vg "vdc" "string" "1.8-VSG")
    ; Keep PDK default MOS sizes until user edits the CDF form: callbacks matter.
    d=p1pmPin(m "D") s=p1pmPin(m "S") b=p1pmPin(m "B") gate=p1pmPin(m "G")
    vp=p1pmPin(vd "PLUS") vn=p1pmPin(vd "MINUS")
    gp=p1pmPin(vg "PLUS") gn=p1pmPin(vg "MINUS")
    sp=p1pmPin(vs "PLUS") sn=p1pmPin(vs "MINUS")
    p1pmWire(cv list(s list(xCoord(s) yCoord(sp)) sp))
    p1pmWire(cv list(b 0.75:0 0.75:0.75))
    p1pmWire(cv list(gp gate))
    p1pmWire(cv list(d 0.25:-1.0 vp))
    p1pmWire(cv list(sn 1.5:-0.25))
    g1=dbCreateInst(cv gm "GND_S" 1.5:-0.25 "R0")
    p1pmWire(cv list(vn 2.5:-1.75))
    g2=dbCreateInst(cv gm "GND_D" 2.5:-1.75 "R0")
    p1pmWire(cv list(gn -1.5:-0.75))
    g3=dbCreateInst(cv gm "GND_G" -1.5:-0.75 "R0")
    schCheck(cv)
    dbSave(cv)
    dbClose(cv)
    dbClose(nm) dbClose(vm) dbClose(gm)
    printf("P1_PMOS_TOPOLOGY_CREATED: project1/tb_pmos_dc/schematic\n")
    printf("NEXT: open schematic; edit M0 via q to L=0.5u, total/finger W=5u, fingers=1, m=1. Read manual.\n")
    printf("NOT A SIMULATION PASS. Check CIW schematic diagnostics.\n")
    t
  )
)
p1pmCreate()
