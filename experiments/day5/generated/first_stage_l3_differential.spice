* DAY5_MANIFEST_SHA256=89f886ce2a150b84945a5378f29c2d4ee3faa5ef832876aeb122deb05e01391e
.lib "/foss/pdks/ciel/sky130/versions/026824c7969ce6f4fc9678e6ca04b0a06a596c4b/sky130A/libs.tech/ngspice/sky130.lib.spice" tt
.temp 27
.include "experiments/day5/generated/dut_first_stage_l3.spice"

VSSSUP VSS 0 0
VDD VDD VSS 1.8
IREF VBP VSS 1e-05
VINP VINP VSS DC 0.9 AC 0.5
VNEG VNEG VSS DC 0 AC -0.5
LBREAK VOUT VINN 1G
CBREAK VNEG VINN 1G
RLOAD VOUT VSS 100000
CLOAD VOUT VSS 5e-12
XOTA VDD VSS VINP VINN VOUT VBP OTA
.control
set noaskquit
set wr_singlescale
set wr_vecnames
ac lin 1 1k 1k
let vdiff=v(VINP)-v(VINN)
let ad=v(VOUT)/vdiff
wrdata experiments/day5/raw/first_stage_l3_differential_1k.tsv ad
quit
.endc
.end
