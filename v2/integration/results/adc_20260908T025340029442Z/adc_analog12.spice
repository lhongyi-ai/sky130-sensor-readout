* Generated by generate_analog_wrapper.py; deterministic schematic prototype.
* Requires adc_blocks.spice. NOT full ADC qualification.
* SAMPLE/TOP TG opens 10ns before ACQ falls; CONV rises >=20ns after ACQ falls.
* EVAL clock drives dynamic comparator; Q/QB are static retained outputs.
.subckt adc_analog12 INP INN Q QB SAMPLE SAMPLEB ACQ CONV EVAL B11 B10 B9 B8 B7 B6 B5 B4 B3 B2 B1 B0 RP RN VCM VDD VSS
XSP INP TP SAMPLE SAMPLEB VDD VSS adc_tgate
XSN INN TN SAMPLE SAMPLEB VDD VSS adc_tgate
XCMP TP TN Q QB EVAL VDD VSS adc_latched_comparator
XP0 BP0 B0 ACQ CONV RN RP VCM VDD VSS adc_ref_switch WN=0.84 WP=1.68
XN0 BN0 B0 ACQ CONV RP RN VCM VDD VSS adc_ref_switch WN=0.84 WP=1.68
XP1 BP1 B1 ACQ CONV RN RP VCM VDD VSS adc_ref_switch WN=1.1879394 WP=2.3758788
XN1 BN1 B1 ACQ CONV RP RN VCM VDD VSS adc_ref_switch WN=1.1879394 WP=2.3758788
XP2 BP2 B2 ACQ CONV RN RP VCM VDD VSS adc_ref_switch WN=1.68 WP=3.36
XN2 BN2 B2 ACQ CONV RP RN VCM VDD VSS adc_ref_switch WN=1.68 WP=3.36
XP3 BP3 B3 ACQ CONV RN RP VCM VDD VSS adc_ref_switch WN=2.3758788 WP=4.7517576
XN3 BN3 B3 ACQ CONV RP RN VCM VDD VSS adc_ref_switch WN=2.3758788 WP=4.7517576
XP4 BP4 B4 ACQ CONV RN RP VCM VDD VSS adc_ref_switch WN=3.36 WP=6.72
XN4 BN4 B4 ACQ CONV RP RN VCM VDD VSS adc_ref_switch WN=3.36 WP=6.72
XP5 BP5 B5 ACQ CONV RN RP VCM VDD VSS adc_ref_switch WN=4.7517576 WP=9.5035151
XN5 BN5 B5 ACQ CONV RP RN VCM VDD VSS adc_ref_switch WN=4.7517576 WP=9.5035151
XP6 BP6 B6 ACQ CONV RN RP VCM VDD VSS adc_ref_switch WN=6.72 WP=13.44
XN6 BN6 B6 ACQ CONV RP RN VCM VDD VSS adc_ref_switch WN=6.72 WP=13.44
XP7 BP7 B7 ACQ CONV RN RP VCM VDD VSS adc_ref_switch WN=8 WP=16
XN7 BN7 B7 ACQ CONV RP RN VCM VDD VSS adc_ref_switch WN=8 WP=16
XP8 BP8 B8 ACQ CONV RN RP VCM VDD VSS adc_ref_switch WN=8 WP=16
XN8 BN8 B8 ACQ CONV RP RN VCM VDD VSS adc_ref_switch WN=8 WP=16
XP9 BP9 B9 ACQ CONV RN RP VCM VDD VSS adc_ref_switch WN=8 WP=16
XN9 BN9 B9 ACQ CONV RP RN VCM VDD VSS adc_ref_switch WN=8 WP=16
XP10 BP10 B10 ACQ CONV RN RP VCM VDD VSS adc_ref_switch WN=8 WP=16
XN10 BN10 B10 ACQ CONV RP RN VCM VDD VSS adc_ref_switch WN=8 WP=16
XP11 BP11 B11 ACQ CONV RN RP VCM VDD VSS adc_ref_switch WN=8 WP=16
XN11 BN11 B11 ACQ CONV RP RN VCM VDD VSS adc_ref_switch WN=8 WP=16
XDP DP VDD ACQ CONV RP RN VCM VDD VSS adc_ref_switch
XDN DN VSS ACQ CONV RP RN VCM VDD VSS adc_ref_switch
XCP TP BP11 BP10 BP9 BP8 BP7 BP6 BP5 BP4 BP3 BP2 BP1 BP0 DP adc_cdac12
XCN TN BN11 BN10 BN9 BN8 BN7 BN6 BN5 BN4 BN3 BN2 BN1 BN0 DN adc_cdac12
.ends adc_analog12
