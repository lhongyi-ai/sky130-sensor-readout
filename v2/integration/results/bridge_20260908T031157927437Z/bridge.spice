Live unchanged SAR RTL bridge qualification with ideal ADC analog fixture
Vclk clk 0 PULSE(0 1.98 1u 1n 1n 311.5n 625n)
Vrst rst 0 PWL(0 0 200n 0 201n 1.98)
Vstart start 0 PWL(0 0 800n 0 801n 1.98)
Vg1 gain_sel1 0 0
Vg0 gain_sel0 0 1.98
Vsignal vin_diff 0 0.123
Ainputs [clk rst start gain_sel1 gain_sel0 decision] [d_clk d_rst d_start d_gain_sel1 d_gain_sel0 d_decision] logic_in
.model logic_in adc_bridge(in_low=0.495 in_high=1.4849999999999999)
Asar [d_clk d_rst d_start d_gain_sel1 d_gain_sel0 d_decision] [d_ready d_busy d_valid d_data11 d_data10 d_data9 d_data8 d_data7 d_data6 d_data5 d_data4 d_data3 d_data2 d_data1 d_data0 d_dgain1 d_dgain0 d_gain1 d_gain0 d_sample d_trial11 d_trial10 d_trial9 d_trial8 d_trial7 d_trial6 d_trial5 d_trial4 d_trial3 d_trial2 d_trial1 d_trial0 d_evaluate] null sar_model
.model sar_model d_cosim simulation="/repo/v2/integration/results/bridge_20260908T031157927437Z/cosim_controller.so"
Aoutputs [d_ready d_busy d_valid d_data11 d_data10 d_data9 d_data8 d_data7 d_data6 d_data5 d_data4 d_data3 d_data2 d_data1 d_data0 d_dgain1 d_dgain0 d_gain1 d_gain0 d_sample d_trial11 d_trial10 d_trial9 d_trial8 d_trial7 d_trial6 d_trial5 d_trial4 d_trial3 d_trial2 d_trial1 d_trial0 d_evaluate] [ready busy valid data11 data10 data9 data8 data7 data6 data5 data4 data3 data2 data1 data0 dgain1 dgain0 gain1 gain0 sample trial11 trial10 trial9 trial8 trial7 trial6 trial5 trial4 trial3 trial2 trial1 trial0 evaluate] logic_out
.model logic_out dac_bridge(out_low=0 out_high=1.98 out_undef=0.99 t_rise=1n t_fall=1n)
Rbridge_ready ready 0 1g
Rbridge_busy busy 0 1g
Rbridge_valid valid 0 1g
Rbridge_data11 data11 0 1g
Rbridge_data10 data10 0 1g
Rbridge_data9 data9 0 1g
Rbridge_data8 data8 0 1g
Rbridge_data7 data7 0 1g
Rbridge_data6 data6 0 1g
Rbridge_data5 data5 0 1g
Rbridge_data4 data4 0 1g
Rbridge_data3 data3 0 1g
Rbridge_data2 data2 0 1g
Rbridge_data1 data1 0 1g
Rbridge_data0 data0 0 1g
Rbridge_dgain1 dgain1 0 1g
Rbridge_dgain0 dgain0 0 1g
Rbridge_gain1 gain1 0 1g
Rbridge_gain0 gain0 0 1g
Rbridge_sample sample 0 1g
Rbridge_trial11 trial11 0 1g
Rbridge_trial10 trial10 0 1g
Rbridge_trial9 trial9 0 1g
Rbridge_trial8 trial8 0 1g
Rbridge_trial7 trial7 0 1g
Rbridge_trial6 trial6 0 1g
Rbridge_trial5 trial5 0 1g
Rbridge_trial4 trial4 0 1g
Rbridge_trial3 trial3 0 1g
Rbridge_trial2 trial2 0 1g
Rbridge_trial1 trial1 0 1g
Rbridge_trial0 trial0 0 1g
Rbridge_evaluate evaluate 0 1g
Bdac ideal_dac 0 V=-0.4+(0.8/4096)*(1*v(trial0)/1.98+2*v(trial1)/1.98+4*v(trial2)/1.98+8*v(trial3)/1.98+16*v(trial4)/1.98+32*v(trial5)/1.98+64*v(trial6)/1.98+128*v(trial7)/1.98+256*v(trial8)/1.98+512*v(trial9)/1.98+1024*v(trial10)/1.98+2048*v(trial11)/1.98)
Bdecision decision 0 V=1.98*(v(vin_diff)>=v(ideal_dac))
.control
set num_threads=1
set wr_singlescale
set wr_vecnames
set numdgt=12
tran 1n 40u
wrdata bridge_waveform.dat v(clk) v(sample) v(evaluate) v(valid) v(ideal_dac) v(decision)
quit
.endc
.end
