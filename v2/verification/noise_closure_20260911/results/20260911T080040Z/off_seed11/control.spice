Intrinsic noise capability: native RC, OSDI RC, unchanged SKY130 NFET
.lib /foss/pdks/sky130A/libs.tech/combined/sky130.lib.spice tt
.param mc_mm_switch=0 mc_pr_switch=0
VDD vdd 0 1.8
VG gate 0 DC .7 AC 1
RLOAD vdd out 20k
CLOAD out 0 1p
XM out gate 0 0 sky130_fd_pr__nfet_01v8 W=2 L=1
VRC in 0 DC 0 AC 1
RRC in rc_native 10k noisy=0
CRC rc_native 0 1n
NRC in rc_osdi thermal
CVA rc_osdi 0 1n
.model thermal closure_thermal_resistor r=10000 noisy=0
.temp 27
.end
