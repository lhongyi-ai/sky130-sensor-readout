* Frozen candidate_06: G4, acquire
.lib /foss/pdks/sky130A/libs.tech/combined/sky130.lib.spice tt
.include candidate_06.spice
.include adc_blocks.spice
.include sampling_switch.spice
.temp 27
.options reltol=1e-6 abstol=1e-14 vntol=1e-9 chgtol=1e-18 itl1=300 itl2=300 method=gear maxord=2
VDD VDD 0 1.8
VCM VCM 0 0.9
VACQ ACQ 0 1.8
VACQB ACQB 0 0
VSEL0 SEL0 0 1.8
VSEL1 SEL1 0 0
VSW SW 0 dc 0 ac 1
BSP VINP 0 V={.9+v(SW)/8}
BSN VINN 0 V={.9-v(SW)/8}
RSP VINP IP 350
RSN VINN IN 350
XPGA IP IN OP ON VDD 0 VCM SEL0 SEL1 sky130_v2_switchable_pga
XRIP OP FP 0 rd_hr R=1500
XRIN ON FN 0 rd_hr R=1500
XCFP FP 0 rd_c4p
XCFN FN 0 rd_c4p
XTGP FP HP ACQ ACQB VDD 0 rd_sampling_tgate
XTGN FN HN ACQ ACQB VDD 0 rd_sampling_tgate
XCP HP VCM adc_mim_bank COUNT=4096
XCN HN VCM adc_mim_bank COUNT=4096
RLEAKP HP VCM 1g
RLEAKN HN VCM 1g
.control
set noaskquit
set num_threads=1
set wr_singlescale
set wr_vecnames
set numdgt=15
set filetype=ascii
op
wrdata op.dat v(op) v(on) v(fp) v(fn) v(xpga.xota.ncm) v(xpga.xota.cms) i(vdd) i(vcm)
ac lin 1 1k 1k
let differential_gain=mag(v(fp)-v(fn))
wrdata ac.dat differential_gain
dc VSW -.32 .32 .32
wrdata dc.dat v(sw) v(fp) v(fn) i(vdd) i(vcm)
quit
.endc
.end
