* SKY130 transistor frontend pre-layout experiment; inspect included snapshot for passive types.
.lib /foss/pdks/sky130A/libs.tech/combined/sky130.lib.spice tt
.include /repo/v2/analog/frontend/repair_20260910/qualification_cas65_deg1000_cap1/sampling_tt_1.8_27_g16_r1_sw_iso2200.0/frontend_pdk_snapshot.spice
.temp 27
.options reltol=1e-6 abstol=1e-14 vntol=1e-9 chgtol=1e-18 itl1=200 itl2=200
VDD VDD 0 1.8
VCM VCM 0 0.9
.options method=gear maxord=2
.include /repo/v2/analog/frontend/repair_20260910/qualification_cas65_deg1000_cap1/sampling_tt_1.8_27_g16_r1_sw_iso2200.0/adc_blocks_snapshot.spice
.include /repo/v2/analog/frontend/repair_20260910/qualification_cas65_deg1000_cap1/sampling_tt_1.8_27_g16_r1_sw_iso2200.0/sampling_switch_snapshot.spice

VIP SP 0 PULSE(0.88875 0.91125 10u 10n 10n 10u 20u)
VIN SN 0 PULSE(0.91125 0.88875 10u 10n 10n 10u 20u)

RSP SP IP 350
RSN SN IN 350
VSEL0 SEL0 0 0
VSEL1 SEL1 0 1.8
XPGA IP IN OP ON VDD 0 VCM SEL0 SEL1 sky130_v2_switchable_pga

VACQ ACQ 0 PULSE(0 1.8 10u 1n 1n 2.476847754u 10u)
VACQB ACQB 0 PULSE(1.8 0 10u 1n 1n 2.476847754u 10u)
VRST RST 0 PULSE(0 1.8 8u 1n 1n 1u 10u)
VRSTB RSTB 0 PULSE(1.8 0 8u 1n 1n 1u 10u)
XRIP OP FILTP 0 frontend_r R=2200.0
XRIN ON FILTN 0 frontend_r R=2200.0
XCFP FILTP 0 frontend_c4p
XCFN FILTN 0 frontend_c4p
XTGP FILTP HP ACQ ACQB VDD 0 adc_tgate_dual_lvt_dummy
XTGN FILTN HN ACQ ACQB VDD 0 adc_tgate_dual_lvt_dummy
XCP HP VCM adc_mim_bank COUNT=4096
XCN HN VCM adc_mim_bank COUNT=4096
XRSTP VCM HP RST RSTB VDD 0 adc_tgate_dual_lvt_dummy
XRSTN VCM HN RST RSTB VDD 0 adc_tgate_dual_lvt_dummy
* Explicit testbench leakage only, avoids mathematically floating held nodes.
RLEAKP HP VCM 1g
RLEAKN HN VCM 1g
.control
set noaskquit
set wr_singlescale
set wr_vecnames

tran 2.0n 40u 0 2.0n
let od=v(op)-v(on)
let hd=v(hp)-v(hn)
let cm=(v(op)+v(on))/2
wrdata sampling.dat od hd cm v(acq) v(sp) v(sn) i(vdd) i(vcm)
quit
.endc
.end
