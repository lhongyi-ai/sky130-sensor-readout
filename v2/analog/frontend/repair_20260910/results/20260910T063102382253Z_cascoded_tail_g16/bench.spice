SKY130 frozen common-mode repair diagnostic
.lib /foss/pdks/sky130A/libs.tech/combined/sky130.lib.spice tt
.include candidate.spice
.temp 85.0
.options reltol=1e-6 abstol=1e-14 vntol=1e-9 chgtol=1e-18 itl1=200 itl2=200 method=gear maxord=2
VDD VDD 0 1.62
VCM VCM 0 0.81
VCMS CMS 0 PWL(0 0 2u 0 2.01u .05 6u .05 6.01u 0)
VDIFF DIFF 0 PWL(0 0 7u 0 7.01u 0.0225 12u 0.0225 12.01u -0.0225 18u -0.0225 18.01u 0)
BIP SP 0 v=0.81+v(cms)+v(diff)/2
BIN SN 0 v=0.81+v(cms)-v(diff)/2
RSP SP IP 350
RSN SN IN 350
VSEL0 SEL0 0 0
VSEL1 SEL1 0 1.62
XPGA IP IN OP ON VDD 0 VCM SEL0 SEL1 sky130_v2_switchable_pga
XRIP OP FP 0 frontend_r R=2800
XRIN ON FN 0 frontend_r R=2800
XCFP FP 0 frontend_c4p
XCFN FN 0 frontend_c4p
CLP FP 0 81.28512p
CLN FN 0 81.28512p
.save v(op) v(on) v(fp) v(fn) v(sp) v(sn) i(vdd) i(vcm) v(xpga.xamp.cmctl) v(xpga.xamp.xerrp.tail) v(xpga.xamp.xp) v(xpga.xamp.xn)
.control
set num_threads=1
set wr_singlescale
set wr_vecnames
set numdgt=12
op
wrdata op.dat v(op) v(on) v(xpga.xamp.cmctl) v(xpga.xamp.xerrp.tail) v(xpga.xamp.xp) v(xpga.xamp.xn) i(vdd)
tran 2n 25u 0 2n
wrdata transient.dat v(op) v(on) v(fp) v(fn) v(sp) v(sn) i(vdd) i(vcm) v(xpga.xamp.cmctl) v(xpga.xamp.xerrp.tail) v(xpga.xamp.xp) v(xpga.xamp.xn)
quit
.endc
.end
