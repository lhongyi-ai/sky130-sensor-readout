* SKY130 transistor frontend pre-layout experiment; inspect included snapshot for passive types.
.lib /foss/pdks/sky130A/libs.tech/combined/sky130.lib.spice tt
.include /repo/v2/analog/frontend/repair_20260910/qualification_g16_pvt/20260910T065233498654Z/linearity_tt_1.62_-20_g16_r1_sw_iso2600.0/frontend_pdk_snapshot.spice
.temp -20.0
.options reltol=1e-6 abstol=1e-14 vntol=1e-9 chgtol=1e-18 itl1=200 itl2=200
VDD VDD 0 1.62
VCM VCM 0 0.81
VIP SP 0 0.81
BIN SN 0 v=1.62-v(sp)

RSP SP IP 350
RSN SN IN 350
VSEL0 SEL0 0 0
VSEL1 SEL1 0 1.62
XPGA IP IN OP ON VDD 0 VCM SEL0 SEL1 sky130_v2_switchable_pga
CLP OP 0 81.285p
CLN ON 0 81.285p
.control
set noaskquit
set wr_singlescale
set wr_vecnames

op
wrdata op_nodes.dat all
dc VIP 0.7975000000000001 0.8225 0.0003125
let od=v(op)-v(on)
let id=v(sp)-v(sn)
let cm=(v(op)+v(on))/2
wrdata linearity.dat id od cm
quit
.endc
.end
