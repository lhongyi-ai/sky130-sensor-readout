* Frozen redesign TT diagnostic: all gains, real sampler
.lib /foss/pdks/sky130A/libs.tech/combined/sky130.lib.spice tt
.include candidate_snapshot.spice
.include adc_blocks_snapshot.spice
.include sampling_switch_snapshot.spice
.temp 27
.options reltol=1e-6 abstol=1e-14 vntol=1e-9 chgtol=1e-18 itl1=300 itl2=300 method=gear maxord=2
VSW SW 0 PULSE(-.36 .36 10u 10n 10n 10u 20u)
VACQ ACQ 0 PULSE(0 1.8 10u 10n 10n 2.476847754e-06 10u)
VACQB ACQB 0 PULSE(1.8 0 10u 10n 10n 2.476847754e-06 10u)
VRST RST 0 PULSE(0 1.8 8u 10n 10n 1u 10u)
VRSTB RSTB 0 PULSE(1.8 0 8u 10n 10n 1u 10u)
.global SW ACQ ACQB RST RSTB

.subckt rd_case params: SUP=1.8 G=4 S0=1.8 S1=0
VDDC VDD 0 {SUP}
VCMC VCM 0 {SUP/2}
BSP SP 0 V={SUP/2+V(SW)/(2*G)}
BSN SN 0 V={SUP/2-V(SW)/(2*G)}
RSP SP IP 350
RSN SN IN 350
VSEL0 SEL0 0 {S0}
VSEL1 SEL1 0 {S1}
XDUT IP IN COREP COREN VDD 0 VCM SEL0 SEL1 sky130_v2_switchable_pga

* Same real isolation/filter and 4096-unit ADC sampling load for every gain.
XRIP COREP FILTP 0 rd_hr R=1800
XRIN COREN FILTN 0 rd_hr R=1800
XCFP FILTP 0 rd_c4p
XCFN FILTN 0 rd_c4p
XTGP FILTP HP ACQ ACQB VDD 0 rd_sampling_tgate
XTGN FILTN HN ACQ ACQB VDD 0 rd_sampling_tgate
XCP HP VCM adc_mim_bank COUNT=4096
XCN HN VCM adc_mim_bank COUNT=4096
XRSTP VCM HP RST RSTB VDD 0 rd_sampling_tgate
XRSTN VCM HN RST RSTB VDD 0 rd_sampling_tgate
RLEAKP HP VCM 1g
RLEAKN HN VCM 1g
.ends rd_case

XG1 rd_case SUP=1.8 G=1 S0=0 S1=0
XG4 rd_case SUP=1.8 G=4 S0=1.8 S1=0
XG16 rd_case SUP=1.8 G=16 S0=0 S1=1.8
.control
set noaskquit
set num_threads=1
set wr_singlescale
set wr_vecnames
set numdgt=12
op
wrdata op.dat v(xg1.sp) v(xg1.sn) v(xg1.ip) v(xg1.in) v(xg1.corep) v(xg1.coren) v(xg1.filtp) v(xg1.filtn) v(xg1.hp) v(xg1.hn) v(xg1.xdut.xota.n1) v(xg1.xdut.xota.n2) v(xg1.xdut.xota.tail) v(xg1.xdut.xota.cms) v(xg1.xdut.xota.cmctl) v(xg1.xdut.xota.ds) v(xg1.xdut.xota.bn) v(xg1.xdut.xota.bp) v(xg1.xdut.xota.ncm) v(xg1.xdut.xota.fds) v(xg1.xdut.xota.ftail) i(v.xg1.vddc) i(v.xg1.vcmc) @m.xg1.xdut.xota.xmip.msky130_fd_pr__nfet_01v8[id] @m.xg1.xdut.xota.xmip.msky130_fd_pr__nfet_01v8[gm] @m.xg1.xdut.xota.xmip.msky130_fd_pr__nfet_01v8[gds] @m.xg1.xdut.xota.xmip.msky130_fd_pr__nfet_01v8[vds] @m.xg1.xdut.xota.xmip.msky130_fd_pr__nfet_01v8[vdsat] @m.xg1.xdut.xota.xmip.msky130_fd_pr__nfet_01v8[vgs] @m.xg1.xdut.xota.xmip.msky130_fd_pr__nfet_01v8[vth] @m.xg1.xdut.xota.xmin.msky130_fd_pr__nfet_01v8[id] @m.xg1.xdut.xota.xmin.msky130_fd_pr__nfet_01v8[gm] @m.xg1.xdut.xota.xmin.msky130_fd_pr__nfet_01v8[gds] @m.xg1.xdut.xota.xmin.msky130_fd_pr__nfet_01v8[vds] @m.xg1.xdut.xota.xmin.msky130_fd_pr__nfet_01v8[vdsat] @m.xg1.xdut.xota.xmin.msky130_fd_pr__nfet_01v8[vgs] @m.xg1.xdut.xota.xmin.msky130_fd_pr__nfet_01v8[vth] @m.xg1.xdut.xota.xmtail.msky130_fd_pr__nfet_01v8[id] @m.xg1.xdut.xota.xmtail.msky130_fd_pr__nfet_01v8[gm] @m.xg1.xdut.xota.xmtail.msky130_fd_pr__nfet_01v8[gds] @m.xg1.xdut.xota.xmtail.msky130_fd_pr__nfet_01v8[vds] @m.xg1.xdut.xota.xmtail.msky130_fd_pr__nfet_01v8[vdsat] @m.xg1.xdut.xota.xmtail.msky130_fd_pr__nfet_01v8[vgs] @m.xg1.xdut.xota.xmtail.msky130_fd_pr__nfet_01v8[vth] @m.xg1.xdut.xota.xmlp.msky130_fd_pr__pfet_01v8[id] @m.xg1.xdut.xota.xmlp.msky130_fd_pr__pfet_01v8[gm] @m.xg1.xdut.xota.xmlp.msky130_fd_pr__pfet_01v8[gds] @m.xg1.xdut.xota.xmlp.msky130_fd_pr__pfet_01v8[vds] @m.xg1.xdut.xota.xmlp.msky130_fd_pr__pfet_01v8[vdsat] @m.xg1.xdut.xota.xmlp.msky130_fd_pr__pfet_01v8[vgs] @m.xg1.xdut.xota.xmlp.msky130_fd_pr__pfet_01v8[vth] @m.xg1.xdut.xota.xmln.msky130_fd_pr__pfet_01v8[id] @m.xg1.xdut.xota.xmln.msky130_fd_pr__pfet_01v8[gm] @m.xg1.xdut.xota.xmln.msky130_fd_pr__pfet_01v8[gds] @m.xg1.xdut.xota.xmln.msky130_fd_pr__pfet_01v8[vds] @m.xg1.xdut.xota.xmln.msky130_fd_pr__pfet_01v8[vdsat] @m.xg1.xdut.xota.xmln.msky130_fd_pr__pfet_01v8[vgs] @m.xg1.xdut.xota.xmln.msky130_fd_pr__pfet_01v8[vth] @m.xg1.xdut.xota.xmsp.msky130_fd_pr__pfet_01v8[id] @m.xg1.xdut.xota.xmsp.msky130_fd_pr__pfet_01v8[gm] @m.xg1.xdut.xota.xmsp.msky130_fd_pr__pfet_01v8[gds] @m.xg1.xdut.xota.xmsp.msky130_fd_pr__pfet_01v8[vds] @m.xg1.xdut.xota.xmsp.msky130_fd_pr__pfet_01v8[vdsat] @m.xg1.xdut.xota.xmsp.msky130_fd_pr__pfet_01v8[vgs] @m.xg1.xdut.xota.xmsp.msky130_fd_pr__pfet_01v8[vth] @m.xg1.xdut.xota.xmsn.msky130_fd_pr__pfet_01v8[id] @m.xg1.xdut.xota.xmsn.msky130_fd_pr__pfet_01v8[gm] @m.xg1.xdut.xota.xmsn.msky130_fd_pr__pfet_01v8[gds] @m.xg1.xdut.xota.xmsn.msky130_fd_pr__pfet_01v8[vds] @m.xg1.xdut.xota.xmsn.msky130_fd_pr__pfet_01v8[vdsat] @m.xg1.xdut.xota.xmsn.msky130_fd_pr__pfet_01v8[vgs] @m.xg1.xdut.xota.xmsn.msky130_fd_pr__pfet_01v8[vth] @m.xg1.xdut.xota.xmop.msky130_fd_pr__nfet_01v8[id] @m.xg1.xdut.xota.xmop.msky130_fd_pr__nfet_01v8[gm] @m.xg1.xdut.xota.xmop.msky130_fd_pr__nfet_01v8[gds] @m.xg1.xdut.xota.xmop.msky130_fd_pr__nfet_01v8[vds] @m.xg1.xdut.xota.xmop.msky130_fd_pr__nfet_01v8[vdsat] @m.xg1.xdut.xota.xmop.msky130_fd_pr__nfet_01v8[vgs] @m.xg1.xdut.xota.xmop.msky130_fd_pr__nfet_01v8[vth] @m.xg1.xdut.xota.xmon.msky130_fd_pr__nfet_01v8[id] @m.xg1.xdut.xota.xmon.msky130_fd_pr__nfet_01v8[gm] @m.xg1.xdut.xota.xmon.msky130_fd_pr__nfet_01v8[gds] @m.xg1.xdut.xota.xmon.msky130_fd_pr__nfet_01v8[vds] @m.xg1.xdut.xota.xmon.msky130_fd_pr__nfet_01v8[vdsat] @m.xg1.xdut.xota.xmon.msky130_fd_pr__nfet_01v8[vgs] @m.xg1.xdut.xota.xmon.msky130_fd_pr__nfet_01v8[vth] @m.xg1.xdut.xota.xcms.msky130_fd_pr__nfet_01v8[id] @m.xg1.xdut.xota.xcms.msky130_fd_pr__nfet_01v8[gm] @m.xg1.xdut.xota.xcms.msky130_fd_pr__nfet_01v8[gds] @m.xg1.xdut.xota.xcms.msky130_fd_pr__nfet_01v8[vds] @m.xg1.xdut.xota.xcms.msky130_fd_pr__nfet_01v8[vdsat] @m.xg1.xdut.xota.xcms.msky130_fd_pr__nfet_01v8[vgs] @m.xg1.xdut.xota.xcms.msky130_fd_pr__nfet_01v8[vth] @m.xg1.xdut.xota.xcmr.msky130_fd_pr__nfet_01v8[id] @m.xg1.xdut.xota.xcmr.msky130_fd_pr__nfet_01v8[gm] @m.xg1.xdut.xota.xcmr.msky130_fd_pr__nfet_01v8[gds] @m.xg1.xdut.xota.xcmr.msky130_fd_pr__nfet_01v8[vds] @m.xg1.xdut.xota.xcmr.msky130_fd_pr__nfet_01v8[vdsat] @m.xg1.xdut.xota.xcmr.msky130_fd_pr__nfet_01v8[vgs] @m.xg1.xdut.xota.xcmr.msky130_fd_pr__nfet_01v8[vth] @m.xg1.xdut.xota.xcmt.msky130_fd_pr__nfet_01v8[id] @m.xg1.xdut.xota.xcmt.msky130_fd_pr__nfet_01v8[gm] @m.xg1.xdut.xota.xcmt.msky130_fd_pr__nfet_01v8[gds] @m.xg1.xdut.xota.xcmt.msky130_fd_pr__nfet_01v8[vds] @m.xg1.xdut.xota.xcmt.msky130_fd_pr__nfet_01v8[vdsat] @m.xg1.xdut.xota.xcmt.msky130_fd_pr__nfet_01v8[vgs] @m.xg1.xdut.xota.xcmt.msky130_fd_pr__nfet_01v8[vth] @m.xg1.xdut.xota.xbias.xdbn.msky130_fd_pr__nfet_01v8[id] @m.xg1.xdut.xota.xbias.xdbn.msky130_fd_pr__nfet_01v8[gm] @m.xg1.xdut.xota.xbias.xdbn.msky130_fd_pr__nfet_01v8[gds] @m.xg1.xdut.xota.xbias.xdbn.msky130_fd_pr__nfet_01v8[vds] @m.xg1.xdut.xota.xbias.xdbn.msky130_fd_pr__nfet_01v8[vdsat] @m.xg1.xdut.xota.xbias.xdbn.msky130_fd_pr__nfet_01v8[vgs] @m.xg1.xdut.xota.xbias.xdbn.msky130_fd_pr__nfet_01v8[vth] @m.xg1.xdut.xota.xfcs.msky130_fd_pr__nfet_01v8[id] @m.xg1.xdut.xota.xfcs.msky130_fd_pr__nfet_01v8[gm] @m.xg1.xdut.xota.xfcs.msky130_fd_pr__nfet_01v8[gds] @m.xg1.xdut.xota.xfcs.msky130_fd_pr__nfet_01v8[vds] @m.xg1.xdut.xota.xfcs.msky130_fd_pr__nfet_01v8[vdsat] @m.xg1.xdut.xota.xfcs.msky130_fd_pr__nfet_01v8[vgs] @m.xg1.xdut.xota.xfcs.msky130_fd_pr__nfet_01v8[vth] @m.xg1.xdut.xota.xfcr.msky130_fd_pr__nfet_01v8[id] @m.xg1.xdut.xota.xfcr.msky130_fd_pr__nfet_01v8[gm] @m.xg1.xdut.xota.xfcr.msky130_fd_pr__nfet_01v8[gds] @m.xg1.xdut.xota.xfcr.msky130_fd_pr__nfet_01v8[vds] @m.xg1.xdut.xota.xfcr.msky130_fd_pr__nfet_01v8[vdsat] @m.xg1.xdut.xota.xfcr.msky130_fd_pr__nfet_01v8[vgs] @m.xg1.xdut.xota.xfcr.msky130_fd_pr__nfet_01v8[vth] @m.xg1.xdut.xota.xft.msky130_fd_pr__nfet_01v8[id] @m.xg1.xdut.xota.xft.msky130_fd_pr__nfet_01v8[gm] @m.xg1.xdut.xota.xft.msky130_fd_pr__nfet_01v8[gds] @m.xg1.xdut.xota.xft.msky130_fd_pr__nfet_01v8[vds] @m.xg1.xdut.xota.xft.msky130_fd_pr__nfet_01v8[vdsat] @m.xg1.xdut.xota.xft.msky130_fd_pr__nfet_01v8[vgs] @m.xg1.xdut.xota.xft.msky130_fd_pr__nfet_01v8[vth] v(xg4.sp) v(xg4.sn) v(xg4.ip) v(xg4.in) v(xg4.corep) v(xg4.coren) v(xg4.filtp) v(xg4.filtn) v(xg4.hp) v(xg4.hn) v(xg4.xdut.xota.n1) v(xg4.xdut.xota.n2) v(xg4.xdut.xota.tail) v(xg4.xdut.xota.cms) v(xg4.xdut.xota.cmctl) v(xg4.xdut.xota.ds) v(xg4.xdut.xota.bn) v(xg4.xdut.xota.bp) v(xg4.xdut.xota.ncm) v(xg4.xdut.xota.fds) v(xg4.xdut.xota.ftail) i(v.xg4.vddc) i(v.xg4.vcmc) @m.xg4.xdut.xota.xmip.msky130_fd_pr__nfet_01v8[id] @m.xg4.xdut.xota.xmip.msky130_fd_pr__nfet_01v8[gm] @m.xg4.xdut.xota.xmip.msky130_fd_pr__nfet_01v8[gds] @m.xg4.xdut.xota.xmip.msky130_fd_pr__nfet_01v8[vds] @m.xg4.xdut.xota.xmip.msky130_fd_pr__nfet_01v8[vdsat] @m.xg4.xdut.xota.xmip.msky130_fd_pr__nfet_01v8[vgs] @m.xg4.xdut.xota.xmip.msky130_fd_pr__nfet_01v8[vth] @m.xg4.xdut.xota.xmin.msky130_fd_pr__nfet_01v8[id] @m.xg4.xdut.xota.xmin.msky130_fd_pr__nfet_01v8[gm] @m.xg4.xdut.xota.xmin.msky130_fd_pr__nfet_01v8[gds] @m.xg4.xdut.xota.xmin.msky130_fd_pr__nfet_01v8[vds] @m.xg4.xdut.xota.xmin.msky130_fd_pr__nfet_01v8[vdsat] @m.xg4.xdut.xota.xmin.msky130_fd_pr__nfet_01v8[vgs] @m.xg4.xdut.xota.xmin.msky130_fd_pr__nfet_01v8[vth] @m.xg4.xdut.xota.xmtail.msky130_fd_pr__nfet_01v8[id] @m.xg4.xdut.xota.xmtail.msky130_fd_pr__nfet_01v8[gm] @m.xg4.xdut.xota.xmtail.msky130_fd_pr__nfet_01v8[gds] @m.xg4.xdut.xota.xmtail.msky130_fd_pr__nfet_01v8[vds] @m.xg4.xdut.xota.xmtail.msky130_fd_pr__nfet_01v8[vdsat] @m.xg4.xdut.xota.xmtail.msky130_fd_pr__nfet_01v8[vgs] @m.xg4.xdut.xota.xmtail.msky130_fd_pr__nfet_01v8[vth] @m.xg4.xdut.xota.xmlp.msky130_fd_pr__pfet_01v8[id] @m.xg4.xdut.xota.xmlp.msky130_fd_pr__pfet_01v8[gm] @m.xg4.xdut.xota.xmlp.msky130_fd_pr__pfet_01v8[gds] @m.xg4.xdut.xota.xmlp.msky130_fd_pr__pfet_01v8[vds] @m.xg4.xdut.xota.xmlp.msky130_fd_pr__pfet_01v8[vdsat] @m.xg4.xdut.xota.xmlp.msky130_fd_pr__pfet_01v8[vgs] @m.xg4.xdut.xota.xmlp.msky130_fd_pr__pfet_01v8[vth] @m.xg4.xdut.xota.xmln.msky130_fd_pr__pfet_01v8[id] @m.xg4.xdut.xota.xmln.msky130_fd_pr__pfet_01v8[gm] @m.xg4.xdut.xota.xmln.msky130_fd_pr__pfet_01v8[gds] @m.xg4.xdut.xota.xmln.msky130_fd_pr__pfet_01v8[vds] @m.xg4.xdut.xota.xmln.msky130_fd_pr__pfet_01v8[vdsat] @m.xg4.xdut.xota.xmln.msky130_fd_pr__pfet_01v8[vgs] @m.xg4.xdut.xota.xmln.msky130_fd_pr__pfet_01v8[vth] @m.xg4.xdut.xota.xmsp.msky130_fd_pr__pfet_01v8[id] @m.xg4.xdut.xota.xmsp.msky130_fd_pr__pfet_01v8[gm] @m.xg4.xdut.xota.xmsp.msky130_fd_pr__pfet_01v8[gds] @m.xg4.xdut.xota.xmsp.msky130_fd_pr__pfet_01v8[vds] @m.xg4.xdut.xota.xmsp.msky130_fd_pr__pfet_01v8[vdsat] @m.xg4.xdut.xota.xmsp.msky130_fd_pr__pfet_01v8[vgs] @m.xg4.xdut.xota.xmsp.msky130_fd_pr__pfet_01v8[vth] @m.xg4.xdut.xota.xmsn.msky130_fd_pr__pfet_01v8[id] @m.xg4.xdut.xota.xmsn.msky130_fd_pr__pfet_01v8[gm] @m.xg4.xdut.xota.xmsn.msky130_fd_pr__pfet_01v8[gds] @m.xg4.xdut.xota.xmsn.msky130_fd_pr__pfet_01v8[vds] @m.xg4.xdut.xota.xmsn.msky130_fd_pr__pfet_01v8[vdsat] @m.xg4.xdut.xota.xmsn.msky130_fd_pr__pfet_01v8[vgs] @m.xg4.xdut.xota.xmsn.msky130_fd_pr__pfet_01v8[vth] @m.xg4.xdut.xota.xmop.msky130_fd_pr__nfet_01v8[id] @m.xg4.xdut.xota.xmop.msky130_fd_pr__nfet_01v8[gm] @m.xg4.xdut.xota.xmop.msky130_fd_pr__nfet_01v8[gds] @m.xg4.xdut.xota.xmop.msky130_fd_pr__nfet_01v8[vds] @m.xg4.xdut.xota.xmop.msky130_fd_pr__nfet_01v8[vdsat] @m.xg4.xdut.xota.xmop.msky130_fd_pr__nfet_01v8[vgs] @m.xg4.xdut.xota.xmop.msky130_fd_pr__nfet_01v8[vth] @m.xg4.xdut.xota.xmon.msky130_fd_pr__nfet_01v8[id] @m.xg4.xdut.xota.xmon.msky130_fd_pr__nfet_01v8[gm] @m.xg4.xdut.xota.xmon.msky130_fd_pr__nfet_01v8[gds] @m.xg4.xdut.xota.xmon.msky130_fd_pr__nfet_01v8[vds] @m.xg4.xdut.xota.xmon.msky130_fd_pr__nfet_01v8[vdsat] @m.xg4.xdut.xota.xmon.msky130_fd_pr__nfet_01v8[vgs] @m.xg4.xdut.xota.xmon.msky130_fd_pr__nfet_01v8[vth] @m.xg4.xdut.xota.xcms.msky130_fd_pr__nfet_01v8[id] @m.xg4.xdut.xota.xcms.msky130_fd_pr__nfet_01v8[gm] @m.xg4.xdut.xota.xcms.msky130_fd_pr__nfet_01v8[gds] @m.xg4.xdut.xota.xcms.msky130_fd_pr__nfet_01v8[vds] @m.xg4.xdut.xota.xcms.msky130_fd_pr__nfet_01v8[vdsat] @m.xg4.xdut.xota.xcms.msky130_fd_pr__nfet_01v8[vgs] @m.xg4.xdut.xota.xcms.msky130_fd_pr__nfet_01v8[vth] @m.xg4.xdut.xota.xcmr.msky130_fd_pr__nfet_01v8[id] @m.xg4.xdut.xota.xcmr.msky130_fd_pr__nfet_01v8[gm] @m.xg4.xdut.xota.xcmr.msky130_fd_pr__nfet_01v8[gds] @m.xg4.xdut.xota.xcmr.msky130_fd_pr__nfet_01v8[vds] @m.xg4.xdut.xota.xcmr.msky130_fd_pr__nfet_01v8[vdsat] @m.xg4.xdut.xota.xcmr.msky130_fd_pr__nfet_01v8[vgs] @m.xg4.xdut.xota.xcmr.msky130_fd_pr__nfet_01v8[vth] @m.xg4.xdut.xota.xcmt.msky130_fd_pr__nfet_01v8[id] @m.xg4.xdut.xota.xcmt.msky130_fd_pr__nfet_01v8[gm] @m.xg4.xdut.xota.xcmt.msky130_fd_pr__nfet_01v8[gds] @m.xg4.xdut.xota.xcmt.msky130_fd_pr__nfet_01v8[vds] @m.xg4.xdut.xota.xcmt.msky130_fd_pr__nfet_01v8[vdsat] @m.xg4.xdut.xota.xcmt.msky130_fd_pr__nfet_01v8[vgs] @m.xg4.xdut.xota.xcmt.msky130_fd_pr__nfet_01v8[vth] @m.xg4.xdut.xota.xbias.xdbn.msky130_fd_pr__nfet_01v8[id] @m.xg4.xdut.xota.xbias.xdbn.msky130_fd_pr__nfet_01v8[gm] @m.xg4.xdut.xota.xbias.xdbn.msky130_fd_pr__nfet_01v8[gds] @m.xg4.xdut.xota.xbias.xdbn.msky130_fd_pr__nfet_01v8[vds] @m.xg4.xdut.xota.xbias.xdbn.msky130_fd_pr__nfet_01v8[vdsat] @m.xg4.xdut.xota.xbias.xdbn.msky130_fd_pr__nfet_01v8[vgs] @m.xg4.xdut.xota.xbias.xdbn.msky130_fd_pr__nfet_01v8[vth] @m.xg4.xdut.xota.xfcs.msky130_fd_pr__nfet_01v8[id] @m.xg4.xdut.xota.xfcs.msky130_fd_pr__nfet_01v8[gm] @m.xg4.xdut.xota.xfcs.msky130_fd_pr__nfet_01v8[gds] @m.xg4.xdut.xota.xfcs.msky130_fd_pr__nfet_01v8[vds] @m.xg4.xdut.xota.xfcs.msky130_fd_pr__nfet_01v8[vdsat] @m.xg4.xdut.xota.xfcs.msky130_fd_pr__nfet_01v8[vgs] @m.xg4.xdut.xota.xfcs.msky130_fd_pr__nfet_01v8[vth] @m.xg4.xdut.xota.xfcr.msky130_fd_pr__nfet_01v8[id] @m.xg4.xdut.xota.xfcr.msky130_fd_pr__nfet_01v8[gm] @m.xg4.xdut.xota.xfcr.msky130_fd_pr__nfet_01v8[gds] @m.xg4.xdut.xota.xfcr.msky130_fd_pr__nfet_01v8[vds] @m.xg4.xdut.xota.xfcr.msky130_fd_pr__nfet_01v8[vdsat] @m.xg4.xdut.xota.xfcr.msky130_fd_pr__nfet_01v8[vgs] @m.xg4.xdut.xota.xfcr.msky130_fd_pr__nfet_01v8[vth] @m.xg4.xdut.xota.xft.msky130_fd_pr__nfet_01v8[id] @m.xg4.xdut.xota.xft.msky130_fd_pr__nfet_01v8[gm] @m.xg4.xdut.xota.xft.msky130_fd_pr__nfet_01v8[gds] @m.xg4.xdut.xota.xft.msky130_fd_pr__nfet_01v8[vds] @m.xg4.xdut.xota.xft.msky130_fd_pr__nfet_01v8[vdsat] @m.xg4.xdut.xota.xft.msky130_fd_pr__nfet_01v8[vgs] @m.xg4.xdut.xota.xft.msky130_fd_pr__nfet_01v8[vth] v(xg16.sp) v(xg16.sn) v(xg16.ip) v(xg16.in) v(xg16.corep) v(xg16.coren) v(xg16.filtp) v(xg16.filtn) v(xg16.hp) v(xg16.hn) v(xg16.xdut.xota.n1) v(xg16.xdut.xota.n2) v(xg16.xdut.xota.tail) v(xg16.xdut.xota.cms) v(xg16.xdut.xota.cmctl) v(xg16.xdut.xota.ds) v(xg16.xdut.xota.bn) v(xg16.xdut.xota.bp) v(xg16.xdut.xota.ncm) v(xg16.xdut.xota.fds) v(xg16.xdut.xota.ftail) i(v.xg16.vddc) i(v.xg16.vcmc) @m.xg16.xdut.xota.xmip.msky130_fd_pr__nfet_01v8[id] @m.xg16.xdut.xota.xmip.msky130_fd_pr__nfet_01v8[gm] @m.xg16.xdut.xota.xmip.msky130_fd_pr__nfet_01v8[gds] @m.xg16.xdut.xota.xmip.msky130_fd_pr__nfet_01v8[vds] @m.xg16.xdut.xota.xmip.msky130_fd_pr__nfet_01v8[vdsat] @m.xg16.xdut.xota.xmip.msky130_fd_pr__nfet_01v8[vgs] @m.xg16.xdut.xota.xmip.msky130_fd_pr__nfet_01v8[vth] @m.xg16.xdut.xota.xmin.msky130_fd_pr__nfet_01v8[id] @m.xg16.xdut.xota.xmin.msky130_fd_pr__nfet_01v8[gm] @m.xg16.xdut.xota.xmin.msky130_fd_pr__nfet_01v8[gds] @m.xg16.xdut.xota.xmin.msky130_fd_pr__nfet_01v8[vds] @m.xg16.xdut.xota.xmin.msky130_fd_pr__nfet_01v8[vdsat] @m.xg16.xdut.xota.xmin.msky130_fd_pr__nfet_01v8[vgs] @m.xg16.xdut.xota.xmin.msky130_fd_pr__nfet_01v8[vth] @m.xg16.xdut.xota.xmtail.msky130_fd_pr__nfet_01v8[id] @m.xg16.xdut.xota.xmtail.msky130_fd_pr__nfet_01v8[gm] @m.xg16.xdut.xota.xmtail.msky130_fd_pr__nfet_01v8[gds] @m.xg16.xdut.xota.xmtail.msky130_fd_pr__nfet_01v8[vds] @m.xg16.xdut.xota.xmtail.msky130_fd_pr__nfet_01v8[vdsat] @m.xg16.xdut.xota.xmtail.msky130_fd_pr__nfet_01v8[vgs] @m.xg16.xdut.xota.xmtail.msky130_fd_pr__nfet_01v8[vth] @m.xg16.xdut.xota.xmlp.msky130_fd_pr__pfet_01v8[id] @m.xg16.xdut.xota.xmlp.msky130_fd_pr__pfet_01v8[gm] @m.xg16.xdut.xota.xmlp.msky130_fd_pr__pfet_01v8[gds] @m.xg16.xdut.xota.xmlp.msky130_fd_pr__pfet_01v8[vds] @m.xg16.xdut.xota.xmlp.msky130_fd_pr__pfet_01v8[vdsat] @m.xg16.xdut.xota.xmlp.msky130_fd_pr__pfet_01v8[vgs] @m.xg16.xdut.xota.xmlp.msky130_fd_pr__pfet_01v8[vth] @m.xg16.xdut.xota.xmln.msky130_fd_pr__pfet_01v8[id] @m.xg16.xdut.xota.xmln.msky130_fd_pr__pfet_01v8[gm] @m.xg16.xdut.xota.xmln.msky130_fd_pr__pfet_01v8[gds] @m.xg16.xdut.xota.xmln.msky130_fd_pr__pfet_01v8[vds] @m.xg16.xdut.xota.xmln.msky130_fd_pr__pfet_01v8[vdsat] @m.xg16.xdut.xota.xmln.msky130_fd_pr__pfet_01v8[vgs] @m.xg16.xdut.xota.xmln.msky130_fd_pr__pfet_01v8[vth] @m.xg16.xdut.xota.xmsp.msky130_fd_pr__pfet_01v8[id] @m.xg16.xdut.xota.xmsp.msky130_fd_pr__pfet_01v8[gm] @m.xg16.xdut.xota.xmsp.msky130_fd_pr__pfet_01v8[gds] @m.xg16.xdut.xota.xmsp.msky130_fd_pr__pfet_01v8[vds] @m.xg16.xdut.xota.xmsp.msky130_fd_pr__pfet_01v8[vdsat] @m.xg16.xdut.xota.xmsp.msky130_fd_pr__pfet_01v8[vgs] @m.xg16.xdut.xota.xmsp.msky130_fd_pr__pfet_01v8[vth] @m.xg16.xdut.xota.xmsn.msky130_fd_pr__pfet_01v8[id] @m.xg16.xdut.xota.xmsn.msky130_fd_pr__pfet_01v8[gm] @m.xg16.xdut.xota.xmsn.msky130_fd_pr__pfet_01v8[gds] @m.xg16.xdut.xota.xmsn.msky130_fd_pr__pfet_01v8[vds] @m.xg16.xdut.xota.xmsn.msky130_fd_pr__pfet_01v8[vdsat] @m.xg16.xdut.xota.xmsn.msky130_fd_pr__pfet_01v8[vgs] @m.xg16.xdut.xota.xmsn.msky130_fd_pr__pfet_01v8[vth] @m.xg16.xdut.xota.xmop.msky130_fd_pr__nfet_01v8[id] @m.xg16.xdut.xota.xmop.msky130_fd_pr__nfet_01v8[gm] @m.xg16.xdut.xota.xmop.msky130_fd_pr__nfet_01v8[gds] @m.xg16.xdut.xota.xmop.msky130_fd_pr__nfet_01v8[vds] @m.xg16.xdut.xota.xmop.msky130_fd_pr__nfet_01v8[vdsat] @m.xg16.xdut.xota.xmop.msky130_fd_pr__nfet_01v8[vgs] @m.xg16.xdut.xota.xmop.msky130_fd_pr__nfet_01v8[vth] @m.xg16.xdut.xota.xmon.msky130_fd_pr__nfet_01v8[id] @m.xg16.xdut.xota.xmon.msky130_fd_pr__nfet_01v8[gm] @m.xg16.xdut.xota.xmon.msky130_fd_pr__nfet_01v8[gds] @m.xg16.xdut.xota.xmon.msky130_fd_pr__nfet_01v8[vds] @m.xg16.xdut.xota.xmon.msky130_fd_pr__nfet_01v8[vdsat] @m.xg16.xdut.xota.xmon.msky130_fd_pr__nfet_01v8[vgs] @m.xg16.xdut.xota.xmon.msky130_fd_pr__nfet_01v8[vth] @m.xg16.xdut.xota.xcms.msky130_fd_pr__nfet_01v8[id] @m.xg16.xdut.xota.xcms.msky130_fd_pr__nfet_01v8[gm] @m.xg16.xdut.xota.xcms.msky130_fd_pr__nfet_01v8[gds] @m.xg16.xdut.xota.xcms.msky130_fd_pr__nfet_01v8[vds] @m.xg16.xdut.xota.xcms.msky130_fd_pr__nfet_01v8[vdsat] @m.xg16.xdut.xota.xcms.msky130_fd_pr__nfet_01v8[vgs] @m.xg16.xdut.xota.xcms.msky130_fd_pr__nfet_01v8[vth] @m.xg16.xdut.xota.xcmr.msky130_fd_pr__nfet_01v8[id] @m.xg16.xdut.xota.xcmr.msky130_fd_pr__nfet_01v8[gm] @m.xg16.xdut.xota.xcmr.msky130_fd_pr__nfet_01v8[gds] @m.xg16.xdut.xota.xcmr.msky130_fd_pr__nfet_01v8[vds] @m.xg16.xdut.xota.xcmr.msky130_fd_pr__nfet_01v8[vdsat] @m.xg16.xdut.xota.xcmr.msky130_fd_pr__nfet_01v8[vgs] @m.xg16.xdut.xota.xcmr.msky130_fd_pr__nfet_01v8[vth] @m.xg16.xdut.xota.xcmt.msky130_fd_pr__nfet_01v8[id] @m.xg16.xdut.xota.xcmt.msky130_fd_pr__nfet_01v8[gm] @m.xg16.xdut.xota.xcmt.msky130_fd_pr__nfet_01v8[gds] @m.xg16.xdut.xota.xcmt.msky130_fd_pr__nfet_01v8[vds] @m.xg16.xdut.xota.xcmt.msky130_fd_pr__nfet_01v8[vdsat] @m.xg16.xdut.xota.xcmt.msky130_fd_pr__nfet_01v8[vgs] @m.xg16.xdut.xota.xcmt.msky130_fd_pr__nfet_01v8[vth] @m.xg16.xdut.xota.xbias.xdbn.msky130_fd_pr__nfet_01v8[id] @m.xg16.xdut.xota.xbias.xdbn.msky130_fd_pr__nfet_01v8[gm] @m.xg16.xdut.xota.xbias.xdbn.msky130_fd_pr__nfet_01v8[gds] @m.xg16.xdut.xota.xbias.xdbn.msky130_fd_pr__nfet_01v8[vds] @m.xg16.xdut.xota.xbias.xdbn.msky130_fd_pr__nfet_01v8[vdsat] @m.xg16.xdut.xota.xbias.xdbn.msky130_fd_pr__nfet_01v8[vgs] @m.xg16.xdut.xota.xbias.xdbn.msky130_fd_pr__nfet_01v8[vth] @m.xg16.xdut.xota.xfcs.msky130_fd_pr__nfet_01v8[id] @m.xg16.xdut.xota.xfcs.msky130_fd_pr__nfet_01v8[gm] @m.xg16.xdut.xota.xfcs.msky130_fd_pr__nfet_01v8[gds] @m.xg16.xdut.xota.xfcs.msky130_fd_pr__nfet_01v8[vds] @m.xg16.xdut.xota.xfcs.msky130_fd_pr__nfet_01v8[vdsat] @m.xg16.xdut.xota.xfcs.msky130_fd_pr__nfet_01v8[vgs] @m.xg16.xdut.xota.xfcs.msky130_fd_pr__nfet_01v8[vth] @m.xg16.xdut.xota.xfcr.msky130_fd_pr__nfet_01v8[id] @m.xg16.xdut.xota.xfcr.msky130_fd_pr__nfet_01v8[gm] @m.xg16.xdut.xota.xfcr.msky130_fd_pr__nfet_01v8[gds] @m.xg16.xdut.xota.xfcr.msky130_fd_pr__nfet_01v8[vds] @m.xg16.xdut.xota.xfcr.msky130_fd_pr__nfet_01v8[vdsat] @m.xg16.xdut.xota.xfcr.msky130_fd_pr__nfet_01v8[vgs] @m.xg16.xdut.xota.xfcr.msky130_fd_pr__nfet_01v8[vth] @m.xg16.xdut.xota.xft.msky130_fd_pr__nfet_01v8[id] @m.xg16.xdut.xota.xft.msky130_fd_pr__nfet_01v8[gm] @m.xg16.xdut.xota.xft.msky130_fd_pr__nfet_01v8[gds] @m.xg16.xdut.xota.xft.msky130_fd_pr__nfet_01v8[vds] @m.xg16.xdut.xota.xft.msky130_fd_pr__nfet_01v8[vdsat] @m.xg16.xdut.xota.xft.msky130_fd_pr__nfet_01v8[vgs] @m.xg16.xdut.xota.xft.msky130_fd_pr__nfet_01v8[vth]
dc VSW -.4 .4 .01
wrdata dc.dat v(sw) v(xg1.sp) v(xg1.sn) v(xg1.ip) v(xg1.in) v(xg1.corep) v(xg1.coren) v(xg1.filtp) v(xg1.filtn) v(xg1.hp) v(xg1.hn) v(xg1.xdut.xota.n1) v(xg1.xdut.xota.n2) v(xg1.xdut.xota.tail) v(xg1.xdut.xota.cms) v(xg1.xdut.xota.cmctl) v(xg1.xdut.xota.ds) v(xg1.xdut.xota.bn) v(xg1.xdut.xota.bp) v(xg1.xdut.xota.ncm) v(xg1.xdut.xota.fds) v(xg1.xdut.xota.ftail) i(v.xg1.vddc) i(v.xg1.vcmc) @m.xg1.xdut.xota.xmip.msky130_fd_pr__nfet_01v8[id] @m.xg1.xdut.xota.xmip.msky130_fd_pr__nfet_01v8[gm] @m.xg1.xdut.xota.xmip.msky130_fd_pr__nfet_01v8[gds] @m.xg1.xdut.xota.xmip.msky130_fd_pr__nfet_01v8[vds] @m.xg1.xdut.xota.xmip.msky130_fd_pr__nfet_01v8[vdsat] @m.xg1.xdut.xota.xmip.msky130_fd_pr__nfet_01v8[vgs] @m.xg1.xdut.xota.xmip.msky130_fd_pr__nfet_01v8[vth] @m.xg1.xdut.xota.xmin.msky130_fd_pr__nfet_01v8[id] @m.xg1.xdut.xota.xmin.msky130_fd_pr__nfet_01v8[gm] @m.xg1.xdut.xota.xmin.msky130_fd_pr__nfet_01v8[gds] @m.xg1.xdut.xota.xmin.msky130_fd_pr__nfet_01v8[vds] @m.xg1.xdut.xota.xmin.msky130_fd_pr__nfet_01v8[vdsat] @m.xg1.xdut.xota.xmin.msky130_fd_pr__nfet_01v8[vgs] @m.xg1.xdut.xota.xmin.msky130_fd_pr__nfet_01v8[vth] @m.xg1.xdut.xota.xmtail.msky130_fd_pr__nfet_01v8[id] @m.xg1.xdut.xota.xmtail.msky130_fd_pr__nfet_01v8[gm] @m.xg1.xdut.xota.xmtail.msky130_fd_pr__nfet_01v8[gds] @m.xg1.xdut.xota.xmtail.msky130_fd_pr__nfet_01v8[vds] @m.xg1.xdut.xota.xmtail.msky130_fd_pr__nfet_01v8[vdsat] @m.xg1.xdut.xota.xmtail.msky130_fd_pr__nfet_01v8[vgs] @m.xg1.xdut.xota.xmtail.msky130_fd_pr__nfet_01v8[vth] @m.xg1.xdut.xota.xmlp.msky130_fd_pr__pfet_01v8[id] @m.xg1.xdut.xota.xmlp.msky130_fd_pr__pfet_01v8[gm] @m.xg1.xdut.xota.xmlp.msky130_fd_pr__pfet_01v8[gds] @m.xg1.xdut.xota.xmlp.msky130_fd_pr__pfet_01v8[vds] @m.xg1.xdut.xota.xmlp.msky130_fd_pr__pfet_01v8[vdsat] @m.xg1.xdut.xota.xmlp.msky130_fd_pr__pfet_01v8[vgs] @m.xg1.xdut.xota.xmlp.msky130_fd_pr__pfet_01v8[vth] @m.xg1.xdut.xota.xmln.msky130_fd_pr__pfet_01v8[id] @m.xg1.xdut.xota.xmln.msky130_fd_pr__pfet_01v8[gm] @m.xg1.xdut.xota.xmln.msky130_fd_pr__pfet_01v8[gds] @m.xg1.xdut.xota.xmln.msky130_fd_pr__pfet_01v8[vds] @m.xg1.xdut.xota.xmln.msky130_fd_pr__pfet_01v8[vdsat] @m.xg1.xdut.xota.xmln.msky130_fd_pr__pfet_01v8[vgs] @m.xg1.xdut.xota.xmln.msky130_fd_pr__pfet_01v8[vth] @m.xg1.xdut.xota.xmsp.msky130_fd_pr__pfet_01v8[id] @m.xg1.xdut.xota.xmsp.msky130_fd_pr__pfet_01v8[gm] @m.xg1.xdut.xota.xmsp.msky130_fd_pr__pfet_01v8[gds] @m.xg1.xdut.xota.xmsp.msky130_fd_pr__pfet_01v8[vds] @m.xg1.xdut.xota.xmsp.msky130_fd_pr__pfet_01v8[vdsat] @m.xg1.xdut.xota.xmsp.msky130_fd_pr__pfet_01v8[vgs] @m.xg1.xdut.xota.xmsp.msky130_fd_pr__pfet_01v8[vth] @m.xg1.xdut.xota.xmsn.msky130_fd_pr__pfet_01v8[id] @m.xg1.xdut.xota.xmsn.msky130_fd_pr__pfet_01v8[gm] @m.xg1.xdut.xota.xmsn.msky130_fd_pr__pfet_01v8[gds] @m.xg1.xdut.xota.xmsn.msky130_fd_pr__pfet_01v8[vds] @m.xg1.xdut.xota.xmsn.msky130_fd_pr__pfet_01v8[vdsat] @m.xg1.xdut.xota.xmsn.msky130_fd_pr__pfet_01v8[vgs] @m.xg1.xdut.xota.xmsn.msky130_fd_pr__pfet_01v8[vth] @m.xg1.xdut.xota.xmop.msky130_fd_pr__nfet_01v8[id] @m.xg1.xdut.xota.xmop.msky130_fd_pr__nfet_01v8[gm] @m.xg1.xdut.xota.xmop.msky130_fd_pr__nfet_01v8[gds] @m.xg1.xdut.xota.xmop.msky130_fd_pr__nfet_01v8[vds] @m.xg1.xdut.xota.xmop.msky130_fd_pr__nfet_01v8[vdsat] @m.xg1.xdut.xota.xmop.msky130_fd_pr__nfet_01v8[vgs] @m.xg1.xdut.xota.xmop.msky130_fd_pr__nfet_01v8[vth] @m.xg1.xdut.xota.xmon.msky130_fd_pr__nfet_01v8[id] @m.xg1.xdut.xota.xmon.msky130_fd_pr__nfet_01v8[gm] @m.xg1.xdut.xota.xmon.msky130_fd_pr__nfet_01v8[gds] @m.xg1.xdut.xota.xmon.msky130_fd_pr__nfet_01v8[vds] @m.xg1.xdut.xota.xmon.msky130_fd_pr__nfet_01v8[vdsat] @m.xg1.xdut.xota.xmon.msky130_fd_pr__nfet_01v8[vgs] @m.xg1.xdut.xota.xmon.msky130_fd_pr__nfet_01v8[vth] @m.xg1.xdut.xota.xcms.msky130_fd_pr__nfet_01v8[id] @m.xg1.xdut.xota.xcms.msky130_fd_pr__nfet_01v8[gm] @m.xg1.xdut.xota.xcms.msky130_fd_pr__nfet_01v8[gds] @m.xg1.xdut.xota.xcms.msky130_fd_pr__nfet_01v8[vds] @m.xg1.xdut.xota.xcms.msky130_fd_pr__nfet_01v8[vdsat] @m.xg1.xdut.xota.xcms.msky130_fd_pr__nfet_01v8[vgs] @m.xg1.xdut.xota.xcms.msky130_fd_pr__nfet_01v8[vth] @m.xg1.xdut.xota.xcmr.msky130_fd_pr__nfet_01v8[id] @m.xg1.xdut.xota.xcmr.msky130_fd_pr__nfet_01v8[gm] @m.xg1.xdut.xota.xcmr.msky130_fd_pr__nfet_01v8[gds] @m.xg1.xdut.xota.xcmr.msky130_fd_pr__nfet_01v8[vds] @m.xg1.xdut.xota.xcmr.msky130_fd_pr__nfet_01v8[vdsat] @m.xg1.xdut.xota.xcmr.msky130_fd_pr__nfet_01v8[vgs] @m.xg1.xdut.xota.xcmr.msky130_fd_pr__nfet_01v8[vth] @m.xg1.xdut.xota.xcmt.msky130_fd_pr__nfet_01v8[id] @m.xg1.xdut.xota.xcmt.msky130_fd_pr__nfet_01v8[gm] @m.xg1.xdut.xota.xcmt.msky130_fd_pr__nfet_01v8[gds] @m.xg1.xdut.xota.xcmt.msky130_fd_pr__nfet_01v8[vds] @m.xg1.xdut.xota.xcmt.msky130_fd_pr__nfet_01v8[vdsat] @m.xg1.xdut.xota.xcmt.msky130_fd_pr__nfet_01v8[vgs] @m.xg1.xdut.xota.xcmt.msky130_fd_pr__nfet_01v8[vth] @m.xg1.xdut.xota.xbias.xdbn.msky130_fd_pr__nfet_01v8[id] @m.xg1.xdut.xota.xbias.xdbn.msky130_fd_pr__nfet_01v8[gm] @m.xg1.xdut.xota.xbias.xdbn.msky130_fd_pr__nfet_01v8[gds] @m.xg1.xdut.xota.xbias.xdbn.msky130_fd_pr__nfet_01v8[vds] @m.xg1.xdut.xota.xbias.xdbn.msky130_fd_pr__nfet_01v8[vdsat] @m.xg1.xdut.xota.xbias.xdbn.msky130_fd_pr__nfet_01v8[vgs] @m.xg1.xdut.xota.xbias.xdbn.msky130_fd_pr__nfet_01v8[vth] @m.xg1.xdut.xota.xfcs.msky130_fd_pr__nfet_01v8[id] @m.xg1.xdut.xota.xfcs.msky130_fd_pr__nfet_01v8[gm] @m.xg1.xdut.xota.xfcs.msky130_fd_pr__nfet_01v8[gds] @m.xg1.xdut.xota.xfcs.msky130_fd_pr__nfet_01v8[vds] @m.xg1.xdut.xota.xfcs.msky130_fd_pr__nfet_01v8[vdsat] @m.xg1.xdut.xota.xfcs.msky130_fd_pr__nfet_01v8[vgs] @m.xg1.xdut.xota.xfcs.msky130_fd_pr__nfet_01v8[vth] @m.xg1.xdut.xota.xfcr.msky130_fd_pr__nfet_01v8[id] @m.xg1.xdut.xota.xfcr.msky130_fd_pr__nfet_01v8[gm] @m.xg1.xdut.xota.xfcr.msky130_fd_pr__nfet_01v8[gds] @m.xg1.xdut.xota.xfcr.msky130_fd_pr__nfet_01v8[vds] @m.xg1.xdut.xota.xfcr.msky130_fd_pr__nfet_01v8[vdsat] @m.xg1.xdut.xota.xfcr.msky130_fd_pr__nfet_01v8[vgs] @m.xg1.xdut.xota.xfcr.msky130_fd_pr__nfet_01v8[vth] @m.xg1.xdut.xota.xft.msky130_fd_pr__nfet_01v8[id] @m.xg1.xdut.xota.xft.msky130_fd_pr__nfet_01v8[gm] @m.xg1.xdut.xota.xft.msky130_fd_pr__nfet_01v8[gds] @m.xg1.xdut.xota.xft.msky130_fd_pr__nfet_01v8[vds] @m.xg1.xdut.xota.xft.msky130_fd_pr__nfet_01v8[vdsat] @m.xg1.xdut.xota.xft.msky130_fd_pr__nfet_01v8[vgs] @m.xg1.xdut.xota.xft.msky130_fd_pr__nfet_01v8[vth] v(xg4.sp) v(xg4.sn) v(xg4.ip) v(xg4.in) v(xg4.corep) v(xg4.coren) v(xg4.filtp) v(xg4.filtn) v(xg4.hp) v(xg4.hn) v(xg4.xdut.xota.n1) v(xg4.xdut.xota.n2) v(xg4.xdut.xota.tail) v(xg4.xdut.xota.cms) v(xg4.xdut.xota.cmctl) v(xg4.xdut.xota.ds) v(xg4.xdut.xota.bn) v(xg4.xdut.xota.bp) v(xg4.xdut.xota.ncm) v(xg4.xdut.xota.fds) v(xg4.xdut.xota.ftail) i(v.xg4.vddc) i(v.xg4.vcmc) @m.xg4.xdut.xota.xmip.msky130_fd_pr__nfet_01v8[id] @m.xg4.xdut.xota.xmip.msky130_fd_pr__nfet_01v8[gm] @m.xg4.xdut.xota.xmip.msky130_fd_pr__nfet_01v8[gds] @m.xg4.xdut.xota.xmip.msky130_fd_pr__nfet_01v8[vds] @m.xg4.xdut.xota.xmip.msky130_fd_pr__nfet_01v8[vdsat] @m.xg4.xdut.xota.xmip.msky130_fd_pr__nfet_01v8[vgs] @m.xg4.xdut.xota.xmip.msky130_fd_pr__nfet_01v8[vth] @m.xg4.xdut.xota.xmin.msky130_fd_pr__nfet_01v8[id] @m.xg4.xdut.xota.xmin.msky130_fd_pr__nfet_01v8[gm] @m.xg4.xdut.xota.xmin.msky130_fd_pr__nfet_01v8[gds] @m.xg4.xdut.xota.xmin.msky130_fd_pr__nfet_01v8[vds] @m.xg4.xdut.xota.xmin.msky130_fd_pr__nfet_01v8[vdsat] @m.xg4.xdut.xota.xmin.msky130_fd_pr__nfet_01v8[vgs] @m.xg4.xdut.xota.xmin.msky130_fd_pr__nfet_01v8[vth] @m.xg4.xdut.xota.xmtail.msky130_fd_pr__nfet_01v8[id] @m.xg4.xdut.xota.xmtail.msky130_fd_pr__nfet_01v8[gm] @m.xg4.xdut.xota.xmtail.msky130_fd_pr__nfet_01v8[gds] @m.xg4.xdut.xota.xmtail.msky130_fd_pr__nfet_01v8[vds] @m.xg4.xdut.xota.xmtail.msky130_fd_pr__nfet_01v8[vdsat] @m.xg4.xdut.xota.xmtail.msky130_fd_pr__nfet_01v8[vgs] @m.xg4.xdut.xota.xmtail.msky130_fd_pr__nfet_01v8[vth] @m.xg4.xdut.xota.xmlp.msky130_fd_pr__pfet_01v8[id] @m.xg4.xdut.xota.xmlp.msky130_fd_pr__pfet_01v8[gm] @m.xg4.xdut.xota.xmlp.msky130_fd_pr__pfet_01v8[gds] @m.xg4.xdut.xota.xmlp.msky130_fd_pr__pfet_01v8[vds] @m.xg4.xdut.xota.xmlp.msky130_fd_pr__pfet_01v8[vdsat] @m.xg4.xdut.xota.xmlp.msky130_fd_pr__pfet_01v8[vgs] @m.xg4.xdut.xota.xmlp.msky130_fd_pr__pfet_01v8[vth] @m.xg4.xdut.xota.xmln.msky130_fd_pr__pfet_01v8[id] @m.xg4.xdut.xota.xmln.msky130_fd_pr__pfet_01v8[gm] @m.xg4.xdut.xota.xmln.msky130_fd_pr__pfet_01v8[gds] @m.xg4.xdut.xota.xmln.msky130_fd_pr__pfet_01v8[vds] @m.xg4.xdut.xota.xmln.msky130_fd_pr__pfet_01v8[vdsat] @m.xg4.xdut.xota.xmln.msky130_fd_pr__pfet_01v8[vgs] @m.xg4.xdut.xota.xmln.msky130_fd_pr__pfet_01v8[vth] @m.xg4.xdut.xota.xmsp.msky130_fd_pr__pfet_01v8[id] @m.xg4.xdut.xota.xmsp.msky130_fd_pr__pfet_01v8[gm] @m.xg4.xdut.xota.xmsp.msky130_fd_pr__pfet_01v8[gds] @m.xg4.xdut.xota.xmsp.msky130_fd_pr__pfet_01v8[vds] @m.xg4.xdut.xota.xmsp.msky130_fd_pr__pfet_01v8[vdsat] @m.xg4.xdut.xota.xmsp.msky130_fd_pr__pfet_01v8[vgs] @m.xg4.xdut.xota.xmsp.msky130_fd_pr__pfet_01v8[vth] @m.xg4.xdut.xota.xmsn.msky130_fd_pr__pfet_01v8[id] @m.xg4.xdut.xota.xmsn.msky130_fd_pr__pfet_01v8[gm] @m.xg4.xdut.xota.xmsn.msky130_fd_pr__pfet_01v8[gds] @m.xg4.xdut.xota.xmsn.msky130_fd_pr__pfet_01v8[vds] @m.xg4.xdut.xota.xmsn.msky130_fd_pr__pfet_01v8[vdsat] @m.xg4.xdut.xota.xmsn.msky130_fd_pr__pfet_01v8[vgs] @m.xg4.xdut.xota.xmsn.msky130_fd_pr__pfet_01v8[vth] @m.xg4.xdut.xota.xmop.msky130_fd_pr__nfet_01v8[id] @m.xg4.xdut.xota.xmop.msky130_fd_pr__nfet_01v8[gm] @m.xg4.xdut.xota.xmop.msky130_fd_pr__nfet_01v8[gds] @m.xg4.xdut.xota.xmop.msky130_fd_pr__nfet_01v8[vds] @m.xg4.xdut.xota.xmop.msky130_fd_pr__nfet_01v8[vdsat] @m.xg4.xdut.xota.xmop.msky130_fd_pr__nfet_01v8[vgs] @m.xg4.xdut.xota.xmop.msky130_fd_pr__nfet_01v8[vth] @m.xg4.xdut.xota.xmon.msky130_fd_pr__nfet_01v8[id] @m.xg4.xdut.xota.xmon.msky130_fd_pr__nfet_01v8[gm] @m.xg4.xdut.xota.xmon.msky130_fd_pr__nfet_01v8[gds] @m.xg4.xdut.xota.xmon.msky130_fd_pr__nfet_01v8[vds] @m.xg4.xdut.xota.xmon.msky130_fd_pr__nfet_01v8[vdsat] @m.xg4.xdut.xota.xmon.msky130_fd_pr__nfet_01v8[vgs] @m.xg4.xdut.xota.xmon.msky130_fd_pr__nfet_01v8[vth] @m.xg4.xdut.xota.xcms.msky130_fd_pr__nfet_01v8[id] @m.xg4.xdut.xota.xcms.msky130_fd_pr__nfet_01v8[gm] @m.xg4.xdut.xota.xcms.msky130_fd_pr__nfet_01v8[gds] @m.xg4.xdut.xota.xcms.msky130_fd_pr__nfet_01v8[vds] @m.xg4.xdut.xota.xcms.msky130_fd_pr__nfet_01v8[vdsat] @m.xg4.xdut.xota.xcms.msky130_fd_pr__nfet_01v8[vgs] @m.xg4.xdut.xota.xcms.msky130_fd_pr__nfet_01v8[vth] @m.xg4.xdut.xota.xcmr.msky130_fd_pr__nfet_01v8[id] @m.xg4.xdut.xota.xcmr.msky130_fd_pr__nfet_01v8[gm] @m.xg4.xdut.xota.xcmr.msky130_fd_pr__nfet_01v8[gds] @m.xg4.xdut.xota.xcmr.msky130_fd_pr__nfet_01v8[vds] @m.xg4.xdut.xota.xcmr.msky130_fd_pr__nfet_01v8[vdsat] @m.xg4.xdut.xota.xcmr.msky130_fd_pr__nfet_01v8[vgs] @m.xg4.xdut.xota.xcmr.msky130_fd_pr__nfet_01v8[vth] @m.xg4.xdut.xota.xcmt.msky130_fd_pr__nfet_01v8[id] @m.xg4.xdut.xota.xcmt.msky130_fd_pr__nfet_01v8[gm] @m.xg4.xdut.xota.xcmt.msky130_fd_pr__nfet_01v8[gds] @m.xg4.xdut.xota.xcmt.msky130_fd_pr__nfet_01v8[vds] @m.xg4.xdut.xota.xcmt.msky130_fd_pr__nfet_01v8[vdsat] @m.xg4.xdut.xota.xcmt.msky130_fd_pr__nfet_01v8[vgs] @m.xg4.xdut.xota.xcmt.msky130_fd_pr__nfet_01v8[vth] @m.xg4.xdut.xota.xbias.xdbn.msky130_fd_pr__nfet_01v8[id] @m.xg4.xdut.xota.xbias.xdbn.msky130_fd_pr__nfet_01v8[gm] @m.xg4.xdut.xota.xbias.xdbn.msky130_fd_pr__nfet_01v8[gds] @m.xg4.xdut.xota.xbias.xdbn.msky130_fd_pr__nfet_01v8[vds] @m.xg4.xdut.xota.xbias.xdbn.msky130_fd_pr__nfet_01v8[vdsat] @m.xg4.xdut.xota.xbias.xdbn.msky130_fd_pr__nfet_01v8[vgs] @m.xg4.xdut.xota.xbias.xdbn.msky130_fd_pr__nfet_01v8[vth] @m.xg4.xdut.xota.xfcs.msky130_fd_pr__nfet_01v8[id] @m.xg4.xdut.xota.xfcs.msky130_fd_pr__nfet_01v8[gm] @m.xg4.xdut.xota.xfcs.msky130_fd_pr__nfet_01v8[gds] @m.xg4.xdut.xota.xfcs.msky130_fd_pr__nfet_01v8[vds] @m.xg4.xdut.xota.xfcs.msky130_fd_pr__nfet_01v8[vdsat] @m.xg4.xdut.xota.xfcs.msky130_fd_pr__nfet_01v8[vgs] @m.xg4.xdut.xota.xfcs.msky130_fd_pr__nfet_01v8[vth] @m.xg4.xdut.xota.xfcr.msky130_fd_pr__nfet_01v8[id] @m.xg4.xdut.xota.xfcr.msky130_fd_pr__nfet_01v8[gm] @m.xg4.xdut.xota.xfcr.msky130_fd_pr__nfet_01v8[gds] @m.xg4.xdut.xota.xfcr.msky130_fd_pr__nfet_01v8[vds] @m.xg4.xdut.xota.xfcr.msky130_fd_pr__nfet_01v8[vdsat] @m.xg4.xdut.xota.xfcr.msky130_fd_pr__nfet_01v8[vgs] @m.xg4.xdut.xota.xfcr.msky130_fd_pr__nfet_01v8[vth] @m.xg4.xdut.xota.xft.msky130_fd_pr__nfet_01v8[id] @m.xg4.xdut.xota.xft.msky130_fd_pr__nfet_01v8[gm] @m.xg4.xdut.xota.xft.msky130_fd_pr__nfet_01v8[gds] @m.xg4.xdut.xota.xft.msky130_fd_pr__nfet_01v8[vds] @m.xg4.xdut.xota.xft.msky130_fd_pr__nfet_01v8[vdsat] @m.xg4.xdut.xota.xft.msky130_fd_pr__nfet_01v8[vgs] @m.xg4.xdut.xota.xft.msky130_fd_pr__nfet_01v8[vth] v(xg16.sp) v(xg16.sn) v(xg16.ip) v(xg16.in) v(xg16.corep) v(xg16.coren) v(xg16.filtp) v(xg16.filtn) v(xg16.hp) v(xg16.hn) v(xg16.xdut.xota.n1) v(xg16.xdut.xota.n2) v(xg16.xdut.xota.tail) v(xg16.xdut.xota.cms) v(xg16.xdut.xota.cmctl) v(xg16.xdut.xota.ds) v(xg16.xdut.xota.bn) v(xg16.xdut.xota.bp) v(xg16.xdut.xota.ncm) v(xg16.xdut.xota.fds) v(xg16.xdut.xota.ftail) i(v.xg16.vddc) i(v.xg16.vcmc) @m.xg16.xdut.xota.xmip.msky130_fd_pr__nfet_01v8[id] @m.xg16.xdut.xota.xmip.msky130_fd_pr__nfet_01v8[gm] @m.xg16.xdut.xota.xmip.msky130_fd_pr__nfet_01v8[gds] @m.xg16.xdut.xota.xmip.msky130_fd_pr__nfet_01v8[vds] @m.xg16.xdut.xota.xmip.msky130_fd_pr__nfet_01v8[vdsat] @m.xg16.xdut.xota.xmip.msky130_fd_pr__nfet_01v8[vgs] @m.xg16.xdut.xota.xmip.msky130_fd_pr__nfet_01v8[vth] @m.xg16.xdut.xota.xmin.msky130_fd_pr__nfet_01v8[id] @m.xg16.xdut.xota.xmin.msky130_fd_pr__nfet_01v8[gm] @m.xg16.xdut.xota.xmin.msky130_fd_pr__nfet_01v8[gds] @m.xg16.xdut.xota.xmin.msky130_fd_pr__nfet_01v8[vds] @m.xg16.xdut.xota.xmin.msky130_fd_pr__nfet_01v8[vdsat] @m.xg16.xdut.xota.xmin.msky130_fd_pr__nfet_01v8[vgs] @m.xg16.xdut.xota.xmin.msky130_fd_pr__nfet_01v8[vth] @m.xg16.xdut.xota.xmtail.msky130_fd_pr__nfet_01v8[id] @m.xg16.xdut.xota.xmtail.msky130_fd_pr__nfet_01v8[gm] @m.xg16.xdut.xota.xmtail.msky130_fd_pr__nfet_01v8[gds] @m.xg16.xdut.xota.xmtail.msky130_fd_pr__nfet_01v8[vds] @m.xg16.xdut.xota.xmtail.msky130_fd_pr__nfet_01v8[vdsat] @m.xg16.xdut.xota.xmtail.msky130_fd_pr__nfet_01v8[vgs] @m.xg16.xdut.xota.xmtail.msky130_fd_pr__nfet_01v8[vth] @m.xg16.xdut.xota.xmlp.msky130_fd_pr__pfet_01v8[id] @m.xg16.xdut.xota.xmlp.msky130_fd_pr__pfet_01v8[gm] @m.xg16.xdut.xota.xmlp.msky130_fd_pr__pfet_01v8[gds] @m.xg16.xdut.xota.xmlp.msky130_fd_pr__pfet_01v8[vds] @m.xg16.xdut.xota.xmlp.msky130_fd_pr__pfet_01v8[vdsat] @m.xg16.xdut.xota.xmlp.msky130_fd_pr__pfet_01v8[vgs] @m.xg16.xdut.xota.xmlp.msky130_fd_pr__pfet_01v8[vth] @m.xg16.xdut.xota.xmln.msky130_fd_pr__pfet_01v8[id] @m.xg16.xdut.xota.xmln.msky130_fd_pr__pfet_01v8[gm] @m.xg16.xdut.xota.xmln.msky130_fd_pr__pfet_01v8[gds] @m.xg16.xdut.xota.xmln.msky130_fd_pr__pfet_01v8[vds] @m.xg16.xdut.xota.xmln.msky130_fd_pr__pfet_01v8[vdsat] @m.xg16.xdut.xota.xmln.msky130_fd_pr__pfet_01v8[vgs] @m.xg16.xdut.xota.xmln.msky130_fd_pr__pfet_01v8[vth] @m.xg16.xdut.xota.xmsp.msky130_fd_pr__pfet_01v8[id] @m.xg16.xdut.xota.xmsp.msky130_fd_pr__pfet_01v8[gm] @m.xg16.xdut.xota.xmsp.msky130_fd_pr__pfet_01v8[gds] @m.xg16.xdut.xota.xmsp.msky130_fd_pr__pfet_01v8[vds] @m.xg16.xdut.xota.xmsp.msky130_fd_pr__pfet_01v8[vdsat] @m.xg16.xdut.xota.xmsp.msky130_fd_pr__pfet_01v8[vgs] @m.xg16.xdut.xota.xmsp.msky130_fd_pr__pfet_01v8[vth] @m.xg16.xdut.xota.xmsn.msky130_fd_pr__pfet_01v8[id] @m.xg16.xdut.xota.xmsn.msky130_fd_pr__pfet_01v8[gm] @m.xg16.xdut.xota.xmsn.msky130_fd_pr__pfet_01v8[gds] @m.xg16.xdut.xota.xmsn.msky130_fd_pr__pfet_01v8[vds] @m.xg16.xdut.xota.xmsn.msky130_fd_pr__pfet_01v8[vdsat] @m.xg16.xdut.xota.xmsn.msky130_fd_pr__pfet_01v8[vgs] @m.xg16.xdut.xota.xmsn.msky130_fd_pr__pfet_01v8[vth] @m.xg16.xdut.xota.xmop.msky130_fd_pr__nfet_01v8[id] @m.xg16.xdut.xota.xmop.msky130_fd_pr__nfet_01v8[gm] @m.xg16.xdut.xota.xmop.msky130_fd_pr__nfet_01v8[gds] @m.xg16.xdut.xota.xmop.msky130_fd_pr__nfet_01v8[vds] @m.xg16.xdut.xota.xmop.msky130_fd_pr__nfet_01v8[vdsat] @m.xg16.xdut.xota.xmop.msky130_fd_pr__nfet_01v8[vgs] @m.xg16.xdut.xota.xmop.msky130_fd_pr__nfet_01v8[vth] @m.xg16.xdut.xota.xmon.msky130_fd_pr__nfet_01v8[id] @m.xg16.xdut.xota.xmon.msky130_fd_pr__nfet_01v8[gm] @m.xg16.xdut.xota.xmon.msky130_fd_pr__nfet_01v8[gds] @m.xg16.xdut.xota.xmon.msky130_fd_pr__nfet_01v8[vds] @m.xg16.xdut.xota.xmon.msky130_fd_pr__nfet_01v8[vdsat] @m.xg16.xdut.xota.xmon.msky130_fd_pr__nfet_01v8[vgs] @m.xg16.xdut.xota.xmon.msky130_fd_pr__nfet_01v8[vth] @m.xg16.xdut.xota.xcms.msky130_fd_pr__nfet_01v8[id] @m.xg16.xdut.xota.xcms.msky130_fd_pr__nfet_01v8[gm] @m.xg16.xdut.xota.xcms.msky130_fd_pr__nfet_01v8[gds] @m.xg16.xdut.xota.xcms.msky130_fd_pr__nfet_01v8[vds] @m.xg16.xdut.xota.xcms.msky130_fd_pr__nfet_01v8[vdsat] @m.xg16.xdut.xota.xcms.msky130_fd_pr__nfet_01v8[vgs] @m.xg16.xdut.xota.xcms.msky130_fd_pr__nfet_01v8[vth] @m.xg16.xdut.xota.xcmr.msky130_fd_pr__nfet_01v8[id] @m.xg16.xdut.xota.xcmr.msky130_fd_pr__nfet_01v8[gm] @m.xg16.xdut.xota.xcmr.msky130_fd_pr__nfet_01v8[gds] @m.xg16.xdut.xota.xcmr.msky130_fd_pr__nfet_01v8[vds] @m.xg16.xdut.xota.xcmr.msky130_fd_pr__nfet_01v8[vdsat] @m.xg16.xdut.xota.xcmr.msky130_fd_pr__nfet_01v8[vgs] @m.xg16.xdut.xota.xcmr.msky130_fd_pr__nfet_01v8[vth] @m.xg16.xdut.xota.xcmt.msky130_fd_pr__nfet_01v8[id] @m.xg16.xdut.xota.xcmt.msky130_fd_pr__nfet_01v8[gm] @m.xg16.xdut.xota.xcmt.msky130_fd_pr__nfet_01v8[gds] @m.xg16.xdut.xota.xcmt.msky130_fd_pr__nfet_01v8[vds] @m.xg16.xdut.xota.xcmt.msky130_fd_pr__nfet_01v8[vdsat] @m.xg16.xdut.xota.xcmt.msky130_fd_pr__nfet_01v8[vgs] @m.xg16.xdut.xota.xcmt.msky130_fd_pr__nfet_01v8[vth] @m.xg16.xdut.xota.xbias.xdbn.msky130_fd_pr__nfet_01v8[id] @m.xg16.xdut.xota.xbias.xdbn.msky130_fd_pr__nfet_01v8[gm] @m.xg16.xdut.xota.xbias.xdbn.msky130_fd_pr__nfet_01v8[gds] @m.xg16.xdut.xota.xbias.xdbn.msky130_fd_pr__nfet_01v8[vds] @m.xg16.xdut.xota.xbias.xdbn.msky130_fd_pr__nfet_01v8[vdsat] @m.xg16.xdut.xota.xbias.xdbn.msky130_fd_pr__nfet_01v8[vgs] @m.xg16.xdut.xota.xbias.xdbn.msky130_fd_pr__nfet_01v8[vth] @m.xg16.xdut.xota.xfcs.msky130_fd_pr__nfet_01v8[id] @m.xg16.xdut.xota.xfcs.msky130_fd_pr__nfet_01v8[gm] @m.xg16.xdut.xota.xfcs.msky130_fd_pr__nfet_01v8[gds] @m.xg16.xdut.xota.xfcs.msky130_fd_pr__nfet_01v8[vds] @m.xg16.xdut.xota.xfcs.msky130_fd_pr__nfet_01v8[vdsat] @m.xg16.xdut.xota.xfcs.msky130_fd_pr__nfet_01v8[vgs] @m.xg16.xdut.xota.xfcs.msky130_fd_pr__nfet_01v8[vth] @m.xg16.xdut.xota.xfcr.msky130_fd_pr__nfet_01v8[id] @m.xg16.xdut.xota.xfcr.msky130_fd_pr__nfet_01v8[gm] @m.xg16.xdut.xota.xfcr.msky130_fd_pr__nfet_01v8[gds] @m.xg16.xdut.xota.xfcr.msky130_fd_pr__nfet_01v8[vds] @m.xg16.xdut.xota.xfcr.msky130_fd_pr__nfet_01v8[vdsat] @m.xg16.xdut.xota.xfcr.msky130_fd_pr__nfet_01v8[vgs] @m.xg16.xdut.xota.xfcr.msky130_fd_pr__nfet_01v8[vth] @m.xg16.xdut.xota.xft.msky130_fd_pr__nfet_01v8[id] @m.xg16.xdut.xota.xft.msky130_fd_pr__nfet_01v8[gm] @m.xg16.xdut.xota.xft.msky130_fd_pr__nfet_01v8[gds] @m.xg16.xdut.xota.xft.msky130_fd_pr__nfet_01v8[vds] @m.xg16.xdut.xota.xft.msky130_fd_pr__nfet_01v8[vdsat] @m.xg16.xdut.xota.xft.msky130_fd_pr__nfet_01v8[vgs] @m.xg16.xdut.xota.xft.msky130_fd_pr__nfet_01v8[vth]
tran 5n 40u 0 5n
wrdata transient.dat v(xg1.sp) v(xg1.sn) v(xg1.ip) v(xg1.in) v(xg1.corep) v(xg1.coren) v(xg1.filtp) v(xg1.filtn) v(xg1.hp) v(xg1.hn) v(xg1.xdut.xota.n1) v(xg1.xdut.xota.n2) v(xg1.xdut.xota.tail) v(xg1.xdut.xota.cms) v(xg1.xdut.xota.cmctl) v(xg1.xdut.xota.ds) v(xg1.xdut.xota.bn) v(xg1.xdut.xota.bp) v(xg1.xdut.xota.ncm) v(xg1.xdut.xota.fds) v(xg1.xdut.xota.ftail) i(v.xg1.vddc) i(v.xg1.vcmc) v(xg4.sp) v(xg4.sn) v(xg4.ip) v(xg4.in) v(xg4.corep) v(xg4.coren) v(xg4.filtp) v(xg4.filtn) v(xg4.hp) v(xg4.hn) v(xg4.xdut.xota.n1) v(xg4.xdut.xota.n2) v(xg4.xdut.xota.tail) v(xg4.xdut.xota.cms) v(xg4.xdut.xota.cmctl) v(xg4.xdut.xota.ds) v(xg4.xdut.xota.bn) v(xg4.xdut.xota.bp) v(xg4.xdut.xota.ncm) v(xg4.xdut.xota.fds) v(xg4.xdut.xota.ftail) i(v.xg4.vddc) i(v.xg4.vcmc) v(xg16.sp) v(xg16.sn) v(xg16.ip) v(xg16.in) v(xg16.corep) v(xg16.coren) v(xg16.filtp) v(xg16.filtn) v(xg16.hp) v(xg16.hn) v(xg16.xdut.xota.n1) v(xg16.xdut.xota.n2) v(xg16.xdut.xota.tail) v(xg16.xdut.xota.cms) v(xg16.xdut.xota.cmctl) v(xg16.xdut.xota.ds) v(xg16.xdut.xota.bn) v(xg16.xdut.xota.bp) v(xg16.xdut.xota.ncm) v(xg16.xdut.xota.fds) v(xg16.xdut.xota.ftail) i(v.xg16.vddc) i(v.xg16.vcmc)
quit
.endc
.end
