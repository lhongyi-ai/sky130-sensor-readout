* SKY130 transistor frontend pre-layout experiment; inspect included snapshot for passive types.
.lib /foss/pdks/sky130A/libs.tech/combined/sky130.lib.spice tt
.include /repo/v2/analog/frontend/results/frozen_fdda10/gain_tt_1.8_27_g1_r1_sw/frontend_pdk_snapshot.spice
.temp 27
.options reltol=1e-6 abstol=1e-14 vntol=1e-9 chgtol=1e-18 itl1=200 itl2=200
VDD VDD 0 1.8
VCM VCM 0 0.9
VIP SP 0 dc 0.9 ac 0.5
VIN SN 0 dc 0.9 ac -0.5

RSP SP IP 350
RSN SN IN 350
VSEL0 SEL0 0 0
VSEL1 SEL1 0 0
XPGA IP IN OP ON VDD 0 VCM SEL0 SEL1 sky130_v2_switchable_pga
.control
set noaskquit
set wr_singlescale
set wr_vecnames

op
wrdata op_nodes.dat all
ac dec 20 1 10meg
let od=v(op)-v(on)
let ore=real(od)
let oim=imag(od)
wrdata gain.dat ore oim
quit
.endc
.end
