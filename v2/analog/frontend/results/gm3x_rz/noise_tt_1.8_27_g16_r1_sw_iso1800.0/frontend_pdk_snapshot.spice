* Actual SKY130 MOS + high-poly resistor + MIM capacitor prototype.
* Electrical geometry candidate only: complete layout/DRC/LVS not yet done.
* Three gain configurations are STATIC PARAMETER SETTINGS, not a switched PGA.
* R feedback fixed at 10 kohm; external source resistance must be 350 ohm/leg.
* RG = 10000/G - 350, for G=1,4,16. No hidden ideal current source.

* Nominal TT/27C resistor fit was measured with the installed combined PDK.
* R=72.75744875 + 56.642069825*L for W=5.73 um.
* Long values are divided into physical series units, each <=~175 um.
.subckt frontend_r A B SUB params: R=10000
XR A B SUB sky130_fd_pr__res_high_po_5p73 L={(R-72.75744875)/56.642069825}
.ends frontend_r
.subckt frontend_r100k A B SUB
XR0 A N1 SUB frontend_r R=10000
XR1 N1 N2 SUB frontend_r R=10000
XR2 N2 N3 SUB frontend_r R=10000
XR3 N3 N4 SUB frontend_r R=10000
XR4 N4 N5 SUB frontend_r R=10000
XR5 N5 N6 SUB frontend_r R=10000
XR6 N6 N7 SUB frontend_r R=10000
XR7 N7 N8 SUB frontend_r R=10000
XR8 N8 N9 SUB frontend_r R=10000
XR9 N9 B SUB frontend_r R=10000
.ends frontend_r100k
.subckt frontend_c1p A B
XC A B sky130_fd_pr__cap_mim_m3_1 W=22.215 L=22.215
.ends frontend_c1p
.subckt frontend_c4p A B
XC0 A B frontend_c1p
XC1 A B frontend_c1p
XC2 A B frontend_c1p
XC3 A B frontend_c1p
.ends frontend_c4p
.subckt frontend_c8p A B
XC0 A B frontend_c4p
XC1 A B frontend_c4p
.ends frontend_c8p
.subckt frontend_c24p A B
XC0 A B frontend_c8p
XC1 A B frontend_c8p
XC2 A B frontend_c8p
.ends frontend_c24p

.subckt sky130_v2_frontend INP INN OUTP OUTN VDD VSS VCM
* Resistor-degenerated self-biased beta multiplier and MOS startup injector.
XBP1 BP BP VDD VDD sky130_fd_pr__pfet_01v8 L=1 W=10
XBP2 BN BP VDD VDD sky130_fd_pr__pfet_01v8 L=1 W=10
XBN1 BN BN VSS VSS sky130_fd_pr__nfet_01v8 L=1 W=8
XBN2 BP BN BRS VSS sky130_fd_pr__nfet_01v8 L=1 W=32
XRBIAS BRS VSS VSS frontend_r R=10000
XSTPU START VSS VDD VDD sky130_fd_pr__pfet_01v8 L=10 W=0.42
XSTOFF START BN VSS VSS sky130_fd_pr__nfet_01v8 L=1 W=20
XSTINJ BP START VSS VSS sky130_fd_pr__nfet_01v8 L=2 W=0.5

* Fully differential input stage with cascoded tail.
XINP XP INP TAIL VSS sky130_fd_pr__nfet_01v8 L=2 W=800
XINN XN INN TAIL VSS sky130_fd_pr__nfet_01v8 L=2 W=800
XINP2 XP INP TAIL VSS sky130_fd_pr__nfet_01v8 L=2 W=800
XINN2 XN INN TAIL VSS sky130_fd_pr__nfet_01v8 L=2 W=800
XINP3 XP INP TAIL VSS sky130_fd_pr__nfet_01v8 L=2 W=800
XINN3 XN INN TAIL VSS sky130_fd_pr__nfet_01v8 L=2 W=800
XLP XP CMCTL VDD VDD sky130_fd_pr__pfet_01v8 L=3.2 W=576
XLN XN CMCTL VDD VDD sky130_fd_pr__pfet_01v8 L=3.2 W=576
XTAIL BT BN VSS VSS sky130_fd_pr__nfet_01v8 L=1 W=288
XTCAS TAIL VCM BT VSS sky130_fd_pr__nfet_01v8 L=0.5 W=120

* Two common-source output stages, each with real Rz-MIM compensation.
XOP OUTP XP VSS VSS sky130_fd_pr__nfet_01v8 L=0.8 W=60
XON OUTN XN VSS VSS sky130_fd_pr__nfet_01v8 L=0.8 W=60
XIP OUTP BP VDD VDD sky130_fd_pr__pfet_01v8 L=1 W=400
XIN OUTN BP VDD VDD sky130_fd_pr__pfet_01v8 L=1 W=400
XRZP XP CZP VSS frontend_r R=3600
XRZN XN CZN VSS frontend_r R=3600
XCCP CZP OUTP frontend_c24p
XCCN CZN OUTN frontend_c24p

* Current-output common-mode detector: BOTH PMOS loads diode connected.
* This avoids the unstable extra high-impedance gain node of revision 0.
XRCMP OUTP CMSENSE VSS frontend_r100k
XRCMN OUTN CMSENSE VSS frontend_r100k
XCMREF CMD VCM CMTAIL VSS sky130_fd_pr__nfet_01v8 L=1 W=60
XCMSENSE CMCTL CMSENSE CMTAIL VSS sky130_fd_pr__nfet_01v8 L=1 W=60
XCMPL CMD CMD VDD VDD sky130_fd_pr__pfet_01v8 L=3.2 W=192
XCMPM CMCTL CMCTL VDD VDD sky130_fd_pr__pfet_01v8 L=3.2 W=192
XCMT CMTAIL BN VSS VSS sky130_fd_pr__nfet_01v8 L=1 W=96
XCCM CMCTL VSS frontend_c1p
.ends sky130_v2_frontend

.subckt sky130_v2_pga VINP VINN OUTP OUTN VDD VSS VCM params: RF=10000 RG=2150
XRGP VINP INP VSS frontend_r R={RG}
XRGN VINN INN VSS frontend_r R={RG}
XRFP OUTN INP VSS frontend_r R={RF}
XRFN OUTP INN VSS frontend_r R={RF}
XAMP INP INN OUTP OUTN VDD VSS VCM sky130_v2_frontend
.ends sky130_v2_pga

* Recommended integration boundary: isolated sampler driver. OUTP/OUTN go
* to ADC acquisition switches. Feedback senses core nodes BEFORE isolation.
* GAIN is a static elaboration parameter, not a runtime digital control.
.subckt sky130_v2_sample_driver VINP VINN OUTP OUTN VDD VSS VCM params: GAIN=4
XPGA VINP VINN COREP COREN VDD VSS VCM sky130_v2_pga RF=10000 RG={10000/GAIN-350}
XRIP COREP OUTP VSS frontend_r R=150
XRIN COREN OUTN VSS frontend_r R=150
XCFP OUTP VSS frontend_c4p
XCFN OUTN VSS frontend_c4p
.ends sky130_v2_sample_driver

* Transistor gate decoder and low-Ron transmission-gate gain selectors.
* Code00=1,01=4,10=16; code11 disconnects sensor branches (reserved).
* Select bits must be latched outside this block and held during acquisition.
* Nominal branch lengths compensate the measured ~80-ohm TG on resistance;
* residual gain error is calibrated. This is not PVT-invariant Ron removal.
.subckt frontend_inv A Y VDD VSS
XN Y A VSS VSS sky130_fd_pr__nfet_01v8 L=0.15 W=10
XP Y A VDD VDD sky130_fd_pr__pfet_01v8 L=0.15 W=20
.ends frontend_inv
.subckt frontend_nand A B Y VDD VSS
XN0 Y A N VSS sky130_fd_pr__nfet_01v8 L=0.15 W=4
XN1 N B VSS VSS sky130_fd_pr__nfet_01v8 L=0.15 W=4
XP0 Y A VDD VDD sky130_fd_pr__pfet_01v8 L=0.15 W=4
XP1 Y B VDD VDD sky130_fd_pr__pfet_01v8 L=0.15 W=4
.ends frontend_nand
.subckt frontend_gain_tgate A B EN ENB VDD VSS
XN B EN A VSS sky130_fd_pr__nfet_01v8 L=0.15 W=80
XP B ENB A VDD sky130_fd_pr__pfet_01v8 L=0.15 W=160
.ends frontend_gain_tgate
.subckt sky130_v2_switchable_pga VINP VINN OUTP OUTN VDD VSS VCM SEL0 SEL1
XINV0 SEL0 B0 VDD VSS frontend_inv
XINV1 SEL1 B1 VDD VSS frontend_inv
XNAND1 B0 B1 E1B VDD VSS frontend_nand
XNAND4 SEL0 B1 E4B VDD VSS frontend_nand
XNAND16 B0 SEL1 E16B VDD VSS frontend_nand
XE1 E1B E1 VDD VSS frontend_inv
XE4 E4B E4 VDD VSS frontend_inv
XE16 E16B E16 VDD VSS frontend_inv
XRP1 VINP P1 VSS frontend_r R=9565
XRN1 VINN N1 VSS frontend_r R=9565
XRP4 VINP P4 VSS frontend_r R=2065
XRN4 VINN N4 VSS frontend_r R=2065
XRP16 VINP P16 VSS frontend_r R=190
XRN16 VINN N16 VSS frontend_r R=190
XSP1 P1 INP E1 E1B VDD VSS frontend_gain_tgate
XSN1 N1 INN E1 E1B VDD VSS frontend_gain_tgate
XSP4 P4 INP E4 E4B VDD VSS frontend_gain_tgate
XSN4 N4 INN E4 E4B VDD VSS frontend_gain_tgate
XSP16 P16 INP E16 E16B VDD VSS frontend_gain_tgate
XSN16 N16 INN E16 E16B VDD VSS frontend_gain_tgate
XRFP OUTN INP VSS frontend_r R=10000
XRFN OUTP INN VSS frontend_r R=10000
XAMP INP INN OUTP OUTN VDD VSS VCM sky130_v2_frontend
.ends sky130_v2_switchable_pga

.subckt sky130_v2_switchable_sample_driver VINP VINN OUTP OUTN VDD VSS VCM SEL0 SEL1 params: RISO=1800
XPGA VINP VINN COREP COREN VDD VSS VCM SEL0 SEL1 sky130_v2_switchable_pga
XRIP COREP OUTP VSS frontend_r R={RISO}
XRIN COREN OUTN VSS frontend_r R={RISO}
XCFP OUTP VSS frontend_c4p
XCFN OUTN VSS frontend_c4p
.ends sky130_v2_switchable_sample_driver
