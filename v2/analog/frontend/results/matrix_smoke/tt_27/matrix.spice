* Real frontend acquisition PVT, not full ADC signoff
.lib /foss/pdks/sky130A/libs.tech/combined/sky130.lib.spice tt
.include /repo/v2/analog/frontend/results/matrix_smoke/frontend_pdk_snapshot.spice
.include /repo/v2/analog/frontend/results/matrix_smoke/adc_blocks_snapshot.spice
.temp 27.0

.subckt frontend_case params: SUP=1.8 G=4 S0=1.8 S1=0
VDD VDD 0 {SUP}
VCM VCM 0 {SUP/2}
VIP SP 0 PULSE({SUP/2-0.18/G} {SUP/2+0.18/G} 10u 10n 10n 10u 20u)
VIN SN 0 PULSE({SUP/2+0.18/G} {SUP/2-0.18/G} 10u 10n 10n 10u 20u)
RSP SP IP 350
RSN SN IN 350
VSEL0 SEL0 0 {S0}
VSEL1 SEL1 0 {S1}
XPGA IP IN OP ON VDD 0 VCM SEL0 SEL1 sky130_v2_switchable_pga
VACQ ACQ 0 PULSE(0 {SUP} 10u 1n 1n 2.49u 10u)
BACQB ACQB 0 v={SUP}-v(acq)
VRST RST 0 PULSE(0 {SUP} 8u 1n 1n 1u 10u)
BRSTB RSTB 0 v={SUP}-v(rst)
XRIP OP FILTP 0 frontend_r R=1800
XRIN ON FILTN 0 frontend_r R=1800
XCFP FILTP 0 frontend_c4p
XCFN FILTN 0 frontend_c4p
XTGP FILTP HP ACQ ACQB VDD 0 adc_tgate
XTGN FILTN HN ACQ ACQB VDD 0 adc_tgate
XCP HP VCM adc_mim_bank COUNT=4096
XCN HN VCM adc_mim_bank COUNT=4096
XRSTP VCM HP RST RSTB VDD 0 adc_tgate
XRSTN VCM HN RST RSTB VDD 0 adc_tgate
RLEAKP HP VCM 1g
RLEAKN HN VCM 1g
.ends frontend_case
XCASE0 frontend_case SUP=1.8 G=4 S0=1.8 S1=0
.control
set noaskquit
set wr_singlescale
set wr_vecnames
tran 5n 40u
let d0=v(xcase0.op)-v(xcase0.on)
let h0=v(xcase0.hp)-v(xcase0.hn)
let c0=(v(xcase0.op)+v(xcase0.on))/2
let p0=-v(xcase0.vdd)*i(v.xcase0.vdd)
wrdata case0.dat d0 h0 c0 p0
quit
.endc
.end
