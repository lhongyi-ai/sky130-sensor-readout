Frozen headroom diagnosis: full-range DC and optional capacitive-load step
.lib /foss/pdks/sky130A/libs.tech/combined/sky130.lib.spice tt
.include frontend_pdk_snapshot.spice
.temp 27
.options reltol=1e-6 abstol=1e-14 vntol=1e-9 chgtol=1e-18 itl1=200 itl2=200 method=gear maxord=2
VDD VDD 0 1.8
VCM VCM 0 0.9
VIP SP 0 PWL(0 0.9 2u 0.9 2.01u 0.9500000000000001 5u 0.9500000000000001 5.01u 0.9 8u 0.9 8.01u 0.9450000000000001 13u 0.9450000000000001 13.01u 0.855 18u 0.855 18.01u 0.9)
VCMS CMS 0 PWL(0 0 2u 0 2.01u .1 5u .1 5.01u 0)
BIN SN 0 v=1.8-v(sp)+v(cms)
RSP SP IP 350
RSN SN IN 350
VSEL0 SEL0 0 1.8
VSEL1 SEL1 0 0
XPGA IP IN OP ON VDD 0 VCM SEL0 SEL1 sky130_v2_switchable_pga
XRIP OP FP 0 frontend_r R=2600
XRIN ON FN 0 frontend_r R=2600
XCFP FP 0 frontend_c4p
XCFN FN 0 frontend_c4p
CLP FP 0 81.285p
CLN FN 0 81.285p
.save v(sp) v(sn) v(op) v(on) v(xpga.xamp.xp) v(xpga.xamp.xn) v(xpga.xamp.npc) v(xpga.xamp.nnc) v(xpga.xamp.xerrp.tail) v(xpga.xamp.xerrn.tail) v(xpga.xamp.xerrp.ts) v(xpga.xamp.xerrn.ts) v(xpga.xamp.bn) v(xpga.xamp.bt) v(xpga.xamp.bcasc) v(xpga.xamp.cmctl) i(vdd) i(vcm) @m.xpga.xamp.xerrp.xp1.msky130_fd_pr__nfet_01v8_lvt[id] @m.xpga.xamp.xerrp.xp1.msky130_fd_pr__nfet_01v8_lvt[gm] @m.xpga.xamp.xerrp.xp1.msky130_fd_pr__nfet_01v8_lvt[gds] @m.xpga.xamp.xerrp.xp1.msky130_fd_pr__nfet_01v8_lvt[vds] @m.xpga.xamp.xerrp.xp1.msky130_fd_pr__nfet_01v8_lvt[vdsat] @m.xpga.xamp.xerrp.xp1.msky130_fd_pr__nfet_01v8_lvt[vgs] @m.xpga.xamp.xerrp.xp1.msky130_fd_pr__nfet_01v8_lvt[vth] @m.xpga.xamp.xerrp.xn1.msky130_fd_pr__nfet_01v8_lvt[id] @m.xpga.xamp.xerrp.xn1.msky130_fd_pr__nfet_01v8_lvt[gm] @m.xpga.xamp.xerrp.xn1.msky130_fd_pr__nfet_01v8_lvt[gds] @m.xpga.xamp.xerrp.xn1.msky130_fd_pr__nfet_01v8_lvt[vds] @m.xpga.xamp.xerrp.xn1.msky130_fd_pr__nfet_01v8_lvt[vdsat] @m.xpga.xamp.xerrp.xn1.msky130_fd_pr__nfet_01v8_lvt[vgs] @m.xpga.xamp.xerrp.xn1.msky130_fd_pr__nfet_01v8_lvt[vth] @m.xpga.xamp.xerrp.xt0.msky130_fd_pr__nfet_01v8[id] @m.xpga.xamp.xerrp.xt0.msky130_fd_pr__nfet_01v8[gm] @m.xpga.xamp.xerrp.xt0.msky130_fd_pr__nfet_01v8[gds] @m.xpga.xamp.xerrp.xt0.msky130_fd_pr__nfet_01v8[vds] @m.xpga.xamp.xerrp.xt0.msky130_fd_pr__nfet_01v8[vdsat] @m.xpga.xamp.xerrp.xt0.msky130_fd_pr__nfet_01v8[vgs] @m.xpga.xamp.xerrp.xt0.msky130_fd_pr__nfet_01v8[vth] @m.xpga.xamp.xerrp.xtc0.msky130_fd_pr__nfet_01v8[id] @m.xpga.xamp.xerrp.xtc0.msky130_fd_pr__nfet_01v8[gm] @m.xpga.xamp.xerrp.xtc0.msky130_fd_pr__nfet_01v8[gds] @m.xpga.xamp.xerrp.xtc0.msky130_fd_pr__nfet_01v8[vds] @m.xpga.xamp.xerrp.xtc0.msky130_fd_pr__nfet_01v8[vdsat] @m.xpga.xamp.xerrp.xtc0.msky130_fd_pr__nfet_01v8[vgs] @m.xpga.xamp.xerrp.xtc0.msky130_fd_pr__nfet_01v8[vth] @m.xpga.xamp.xerrn.xp1.msky130_fd_pr__nfet_01v8_lvt[id] @m.xpga.xamp.xerrn.xp1.msky130_fd_pr__nfet_01v8_lvt[gm] @m.xpga.xamp.xerrn.xp1.msky130_fd_pr__nfet_01v8_lvt[gds] @m.xpga.xamp.xerrn.xp1.msky130_fd_pr__nfet_01v8_lvt[vds] @m.xpga.xamp.xerrn.xp1.msky130_fd_pr__nfet_01v8_lvt[vdsat] @m.xpga.xamp.xerrn.xp1.msky130_fd_pr__nfet_01v8_lvt[vgs] @m.xpga.xamp.xerrn.xp1.msky130_fd_pr__nfet_01v8_lvt[vth] @m.xpga.xamp.xerrn.xn1.msky130_fd_pr__nfet_01v8_lvt[id] @m.xpga.xamp.xerrn.xn1.msky130_fd_pr__nfet_01v8_lvt[gm] @m.xpga.xamp.xerrn.xn1.msky130_fd_pr__nfet_01v8_lvt[gds] @m.xpga.xamp.xerrn.xn1.msky130_fd_pr__nfet_01v8_lvt[vds] @m.xpga.xamp.xerrn.xn1.msky130_fd_pr__nfet_01v8_lvt[vdsat] @m.xpga.xamp.xerrn.xn1.msky130_fd_pr__nfet_01v8_lvt[vgs] @m.xpga.xamp.xerrn.xn1.msky130_fd_pr__nfet_01v8_lvt[vth] @m.xpga.xamp.xerrn.xt0.msky130_fd_pr__nfet_01v8[id] @m.xpga.xamp.xerrn.xt0.msky130_fd_pr__nfet_01v8[gm] @m.xpga.xamp.xerrn.xt0.msky130_fd_pr__nfet_01v8[gds] @m.xpga.xamp.xerrn.xt0.msky130_fd_pr__nfet_01v8[vds] @m.xpga.xamp.xerrn.xt0.msky130_fd_pr__nfet_01v8[vdsat] @m.xpga.xamp.xerrn.xt0.msky130_fd_pr__nfet_01v8[vgs] @m.xpga.xamp.xerrn.xt0.msky130_fd_pr__nfet_01v8[vth] @m.xpga.xamp.xerrn.xtc0.msky130_fd_pr__nfet_01v8[id] @m.xpga.xamp.xerrn.xtc0.msky130_fd_pr__nfet_01v8[gm] @m.xpga.xamp.xerrn.xtc0.msky130_fd_pr__nfet_01v8[gds] @m.xpga.xamp.xerrn.xtc0.msky130_fd_pr__nfet_01v8[vds] @m.xpga.xamp.xerrn.xtc0.msky130_fd_pr__nfet_01v8[vdsat] @m.xpga.xamp.xerrn.xtc0.msky130_fd_pr__nfet_01v8[vgs] @m.xpga.xamp.xerrn.xtc0.msky130_fd_pr__nfet_01v8[vth] @m.xpga.xamp.xop.msky130_fd_pr__nfet_01v8[id] @m.xpga.xamp.xop.msky130_fd_pr__nfet_01v8[gm] @m.xpga.xamp.xop.msky130_fd_pr__nfet_01v8[gds] @m.xpga.xamp.xop.msky130_fd_pr__nfet_01v8[vds] @m.xpga.xamp.xop.msky130_fd_pr__nfet_01v8[vdsat] @m.xpga.xamp.xop.msky130_fd_pr__nfet_01v8[vgs] @m.xpga.xamp.xop.msky130_fd_pr__nfet_01v8[vth] @m.xpga.xamp.xon.msky130_fd_pr__nfet_01v8[id] @m.xpga.xamp.xon.msky130_fd_pr__nfet_01v8[gm] @m.xpga.xamp.xon.msky130_fd_pr__nfet_01v8[gds] @m.xpga.xamp.xon.msky130_fd_pr__nfet_01v8[vds] @m.xpga.xamp.xon.msky130_fd_pr__nfet_01v8[vdsat] @m.xpga.xamp.xon.msky130_fd_pr__nfet_01v8[vgs] @m.xpga.xamp.xon.msky130_fd_pr__nfet_01v8[vth] @m.xpga.xamp.xcmref.msky130_fd_pr__nfet_01v8[id] @m.xpga.xamp.xcmref.msky130_fd_pr__nfet_01v8[gm] @m.xpga.xamp.xcmref.msky130_fd_pr__nfet_01v8[gds] @m.xpga.xamp.xcmref.msky130_fd_pr__nfet_01v8[vds] @m.xpga.xamp.xcmref.msky130_fd_pr__nfet_01v8[vdsat] @m.xpga.xamp.xcmref.msky130_fd_pr__nfet_01v8[vgs] @m.xpga.xamp.xcmref.msky130_fd_pr__nfet_01v8[vth] @m.xpga.xamp.xcmsense.msky130_fd_pr__nfet_01v8[id] @m.xpga.xamp.xcmsense.msky130_fd_pr__nfet_01v8[gm] @m.xpga.xamp.xcmsense.msky130_fd_pr__nfet_01v8[gds] @m.xpga.xamp.xcmsense.msky130_fd_pr__nfet_01v8[vds] @m.xpga.xamp.xcmsense.msky130_fd_pr__nfet_01v8[vdsat] @m.xpga.xamp.xcmsense.msky130_fd_pr__nfet_01v8[vgs] @m.xpga.xamp.xcmsense.msky130_fd_pr__nfet_01v8[vth] @m.xpga.xamp.xcmt.msky130_fd_pr__nfet_01v8[id] @m.xpga.xamp.xcmt.msky130_fd_pr__nfet_01v8[gm] @m.xpga.xamp.xcmt.msky130_fd_pr__nfet_01v8[gds] @m.xpga.xamp.xcmt.msky130_fd_pr__nfet_01v8[vds] @m.xpga.xamp.xcmt.msky130_fd_pr__nfet_01v8[vdsat] @m.xpga.xamp.xcmt.msky130_fd_pr__nfet_01v8[vgs] @m.xpga.xamp.xcmt.msky130_fd_pr__nfet_01v8[vth] @m.xpga.xamp.xbn1.msky130_fd_pr__nfet_01v8[id] @m.xpga.xamp.xbn1.msky130_fd_pr__nfet_01v8[gm] @m.xpga.xamp.xbn1.msky130_fd_pr__nfet_01v8[gds] @m.xpga.xamp.xbn1.msky130_fd_pr__nfet_01v8[vds] @m.xpga.xamp.xbn1.msky130_fd_pr__nfet_01v8[vdsat] @m.xpga.xamp.xbn1.msky130_fd_pr__nfet_01v8[vgs] @m.xpga.xamp.xbn1.msky130_fd_pr__nfet_01v8[vth] @m.xpga.xamp.xbtd.msky130_fd_pr__nfet_01v8[id] @m.xpga.xamp.xbtd.msky130_fd_pr__nfet_01v8[gm] @m.xpga.xamp.xbtd.msky130_fd_pr__nfet_01v8[gds] @m.xpga.xamp.xbtd.msky130_fd_pr__nfet_01v8[vds] @m.xpga.xamp.xbtd.msky130_fd_pr__nfet_01v8[vdsat] @m.xpga.xamp.xbtd.msky130_fd_pr__nfet_01v8[vgs] @m.xpga.xamp.xbtd.msky130_fd_pr__nfet_01v8[vth] @m.xpga.xamp.xcasp.msky130_fd_pr__nfet_01v8[id] @m.xpga.xamp.xcasp.msky130_fd_pr__nfet_01v8[gm] @m.xpga.xamp.xcasp.msky130_fd_pr__nfet_01v8[gds] @m.xpga.xamp.xcasp.msky130_fd_pr__nfet_01v8[vds] @m.xpga.xamp.xcasp.msky130_fd_pr__nfet_01v8[vdsat] @m.xpga.xamp.xcasp.msky130_fd_pr__nfet_01v8[vgs] @m.xpga.xamp.xcasp.msky130_fd_pr__nfet_01v8[vth] @m.xpga.xamp.xcasn.msky130_fd_pr__nfet_01v8[id] @m.xpga.xamp.xcasn.msky130_fd_pr__nfet_01v8[gm] @m.xpga.xamp.xcasn.msky130_fd_pr__nfet_01v8[gds] @m.xpga.xamp.xcasn.msky130_fd_pr__nfet_01v8[vds] @m.xpga.xamp.xcasn.msky130_fd_pr__nfet_01v8[vdsat] @m.xpga.xamp.xcasn.msky130_fd_pr__nfet_01v8[vgs] @m.xpga.xamp.xcasn.msky130_fd_pr__nfet_01v8[vth] @m.xpga.xamp.xlp.msky130_fd_pr__pfet_01v8[id] @m.xpga.xamp.xlp.msky130_fd_pr__pfet_01v8[gm] @m.xpga.xamp.xlp.msky130_fd_pr__pfet_01v8[gds] @m.xpga.xamp.xlp.msky130_fd_pr__pfet_01v8[vds] @m.xpga.xamp.xlp.msky130_fd_pr__pfet_01v8[vdsat] @m.xpga.xamp.xlp.msky130_fd_pr__pfet_01v8[vgs] @m.xpga.xamp.xlp.msky130_fd_pr__pfet_01v8[vth] @m.xpga.xamp.xln.msky130_fd_pr__pfet_01v8[id] @m.xpga.xamp.xln.msky130_fd_pr__pfet_01v8[gm] @m.xpga.xamp.xln.msky130_fd_pr__pfet_01v8[gds] @m.xpga.xamp.xln.msky130_fd_pr__pfet_01v8[vds] @m.xpga.xamp.xln.msky130_fd_pr__pfet_01v8[vdsat] @m.xpga.xamp.xln.msky130_fd_pr__pfet_01v8[vgs] @m.xpga.xamp.xln.msky130_fd_pr__pfet_01v8[vth] @m.xpga.xamp.xpcasp.msky130_fd_pr__pfet_01v8[id] @m.xpga.xamp.xpcasp.msky130_fd_pr__pfet_01v8[gm] @m.xpga.xamp.xpcasp.msky130_fd_pr__pfet_01v8[gds] @m.xpga.xamp.xpcasp.msky130_fd_pr__pfet_01v8[vds] @m.xpga.xamp.xpcasp.msky130_fd_pr__pfet_01v8[vdsat] @m.xpga.xamp.xpcasp.msky130_fd_pr__pfet_01v8[vgs] @m.xpga.xamp.xpcasp.msky130_fd_pr__pfet_01v8[vth] @m.xpga.xamp.xpcasn.msky130_fd_pr__pfet_01v8[id] @m.xpga.xamp.xpcasn.msky130_fd_pr__pfet_01v8[gm] @m.xpga.xamp.xpcasn.msky130_fd_pr__pfet_01v8[gds] @m.xpga.xamp.xpcasn.msky130_fd_pr__pfet_01v8[vds] @m.xpga.xamp.xpcasn.msky130_fd_pr__pfet_01v8[vdsat] @m.xpga.xamp.xpcasn.msky130_fd_pr__pfet_01v8[vgs] @m.xpga.xamp.xpcasn.msky130_fd_pr__pfet_01v8[vth] @m.xpga.xamp.xip.msky130_fd_pr__pfet_01v8[id] @m.xpga.xamp.xip.msky130_fd_pr__pfet_01v8[gm] @m.xpga.xamp.xip.msky130_fd_pr__pfet_01v8[gds] @m.xpga.xamp.xip.msky130_fd_pr__pfet_01v8[vds] @m.xpga.xamp.xip.msky130_fd_pr__pfet_01v8[vdsat] @m.xpga.xamp.xip.msky130_fd_pr__pfet_01v8[vgs] @m.xpga.xamp.xip.msky130_fd_pr__pfet_01v8[vth] @m.xpga.xamp.xin.msky130_fd_pr__pfet_01v8[id] @m.xpga.xamp.xin.msky130_fd_pr__pfet_01v8[gm] @m.xpga.xamp.xin.msky130_fd_pr__pfet_01v8[gds] @m.xpga.xamp.xin.msky130_fd_pr__pfet_01v8[vds] @m.xpga.xamp.xin.msky130_fd_pr__pfet_01v8[vdsat] @m.xpga.xamp.xin.msky130_fd_pr__pfet_01v8[vgs] @m.xpga.xamp.xin.msky130_fd_pr__pfet_01v8[vth] @m.xpga.xamp.xbp1.msky130_fd_pr__pfet_01v8[id] @m.xpga.xamp.xbp1.msky130_fd_pr__pfet_01v8[gm] @m.xpga.xamp.xbp1.msky130_fd_pr__pfet_01v8[gds] @m.xpga.xamp.xbp1.msky130_fd_pr__pfet_01v8[vds] @m.xpga.xamp.xbp1.msky130_fd_pr__pfet_01v8[vdsat] @m.xpga.xamp.xbp1.msky130_fd_pr__pfet_01v8[vgs] @m.xpga.xamp.xbp1.msky130_fd_pr__pfet_01v8[vth] v(fp) v(fn)
.control
set num_threads=1
set wr_singlescale
set wr_vecnames
set numdgt=12
op
wrdata op.dat v(sp) v(sn) v(op) v(on) v(xpga.xamp.xp) v(xpga.xamp.xn) v(xpga.xamp.npc) v(xpga.xamp.nnc) v(xpga.xamp.xerrp.tail) v(xpga.xamp.xerrn.tail) v(xpga.xamp.xerrp.ts) v(xpga.xamp.xerrn.ts) v(xpga.xamp.bn) v(xpga.xamp.bt) v(xpga.xamp.bcasc) v(xpga.xamp.cmctl) i(vdd) i(vcm) @m.xpga.xamp.xerrp.xp1.msky130_fd_pr__nfet_01v8_lvt[id] @m.xpga.xamp.xerrp.xp1.msky130_fd_pr__nfet_01v8_lvt[gm] @m.xpga.xamp.xerrp.xp1.msky130_fd_pr__nfet_01v8_lvt[gds] @m.xpga.xamp.xerrp.xp1.msky130_fd_pr__nfet_01v8_lvt[vds] @m.xpga.xamp.xerrp.xp1.msky130_fd_pr__nfet_01v8_lvt[vdsat] @m.xpga.xamp.xerrp.xp1.msky130_fd_pr__nfet_01v8_lvt[vgs] @m.xpga.xamp.xerrp.xp1.msky130_fd_pr__nfet_01v8_lvt[vth] @m.xpga.xamp.xerrp.xn1.msky130_fd_pr__nfet_01v8_lvt[id] @m.xpga.xamp.xerrp.xn1.msky130_fd_pr__nfet_01v8_lvt[gm] @m.xpga.xamp.xerrp.xn1.msky130_fd_pr__nfet_01v8_lvt[gds] @m.xpga.xamp.xerrp.xn1.msky130_fd_pr__nfet_01v8_lvt[vds] @m.xpga.xamp.xerrp.xn1.msky130_fd_pr__nfet_01v8_lvt[vdsat] @m.xpga.xamp.xerrp.xn1.msky130_fd_pr__nfet_01v8_lvt[vgs] @m.xpga.xamp.xerrp.xn1.msky130_fd_pr__nfet_01v8_lvt[vth] @m.xpga.xamp.xerrp.xt0.msky130_fd_pr__nfet_01v8[id] @m.xpga.xamp.xerrp.xt0.msky130_fd_pr__nfet_01v8[gm] @m.xpga.xamp.xerrp.xt0.msky130_fd_pr__nfet_01v8[gds] @m.xpga.xamp.xerrp.xt0.msky130_fd_pr__nfet_01v8[vds] @m.xpga.xamp.xerrp.xt0.msky130_fd_pr__nfet_01v8[vdsat] @m.xpga.xamp.xerrp.xt0.msky130_fd_pr__nfet_01v8[vgs] @m.xpga.xamp.xerrp.xt0.msky130_fd_pr__nfet_01v8[vth] @m.xpga.xamp.xerrp.xtc0.msky130_fd_pr__nfet_01v8[id] @m.xpga.xamp.xerrp.xtc0.msky130_fd_pr__nfet_01v8[gm] @m.xpga.xamp.xerrp.xtc0.msky130_fd_pr__nfet_01v8[gds] @m.xpga.xamp.xerrp.xtc0.msky130_fd_pr__nfet_01v8[vds] @m.xpga.xamp.xerrp.xtc0.msky130_fd_pr__nfet_01v8[vdsat] @m.xpga.xamp.xerrp.xtc0.msky130_fd_pr__nfet_01v8[vgs] @m.xpga.xamp.xerrp.xtc0.msky130_fd_pr__nfet_01v8[vth] @m.xpga.xamp.xerrn.xp1.msky130_fd_pr__nfet_01v8_lvt[id] @m.xpga.xamp.xerrn.xp1.msky130_fd_pr__nfet_01v8_lvt[gm] @m.xpga.xamp.xerrn.xp1.msky130_fd_pr__nfet_01v8_lvt[gds] @m.xpga.xamp.xerrn.xp1.msky130_fd_pr__nfet_01v8_lvt[vds] @m.xpga.xamp.xerrn.xp1.msky130_fd_pr__nfet_01v8_lvt[vdsat] @m.xpga.xamp.xerrn.xp1.msky130_fd_pr__nfet_01v8_lvt[vgs] @m.xpga.xamp.xerrn.xp1.msky130_fd_pr__nfet_01v8_lvt[vth] @m.xpga.xamp.xerrn.xn1.msky130_fd_pr__nfet_01v8_lvt[id] @m.xpga.xamp.xerrn.xn1.msky130_fd_pr__nfet_01v8_lvt[gm] @m.xpga.xamp.xerrn.xn1.msky130_fd_pr__nfet_01v8_lvt[gds] @m.xpga.xamp.xerrn.xn1.msky130_fd_pr__nfet_01v8_lvt[vds] @m.xpga.xamp.xerrn.xn1.msky130_fd_pr__nfet_01v8_lvt[vdsat] @m.xpga.xamp.xerrn.xn1.msky130_fd_pr__nfet_01v8_lvt[vgs] @m.xpga.xamp.xerrn.xn1.msky130_fd_pr__nfet_01v8_lvt[vth] @m.xpga.xamp.xerrn.xt0.msky130_fd_pr__nfet_01v8[id] @m.xpga.xamp.xerrn.xt0.msky130_fd_pr__nfet_01v8[gm] @m.xpga.xamp.xerrn.xt0.msky130_fd_pr__nfet_01v8[gds] @m.xpga.xamp.xerrn.xt0.msky130_fd_pr__nfet_01v8[vds] @m.xpga.xamp.xerrn.xt0.msky130_fd_pr__nfet_01v8[vdsat] @m.xpga.xamp.xerrn.xt0.msky130_fd_pr__nfet_01v8[vgs] @m.xpga.xamp.xerrn.xt0.msky130_fd_pr__nfet_01v8[vth] @m.xpga.xamp.xerrn.xtc0.msky130_fd_pr__nfet_01v8[id] @m.xpga.xamp.xerrn.xtc0.msky130_fd_pr__nfet_01v8[gm] @m.xpga.xamp.xerrn.xtc0.msky130_fd_pr__nfet_01v8[gds] @m.xpga.xamp.xerrn.xtc0.msky130_fd_pr__nfet_01v8[vds] @m.xpga.xamp.xerrn.xtc0.msky130_fd_pr__nfet_01v8[vdsat] @m.xpga.xamp.xerrn.xtc0.msky130_fd_pr__nfet_01v8[vgs] @m.xpga.xamp.xerrn.xtc0.msky130_fd_pr__nfet_01v8[vth] @m.xpga.xamp.xop.msky130_fd_pr__nfet_01v8[id] @m.xpga.xamp.xop.msky130_fd_pr__nfet_01v8[gm] @m.xpga.xamp.xop.msky130_fd_pr__nfet_01v8[gds] @m.xpga.xamp.xop.msky130_fd_pr__nfet_01v8[vds] @m.xpga.xamp.xop.msky130_fd_pr__nfet_01v8[vdsat] @m.xpga.xamp.xop.msky130_fd_pr__nfet_01v8[vgs] @m.xpga.xamp.xop.msky130_fd_pr__nfet_01v8[vth] @m.xpga.xamp.xon.msky130_fd_pr__nfet_01v8[id] @m.xpga.xamp.xon.msky130_fd_pr__nfet_01v8[gm] @m.xpga.xamp.xon.msky130_fd_pr__nfet_01v8[gds] @m.xpga.xamp.xon.msky130_fd_pr__nfet_01v8[vds] @m.xpga.xamp.xon.msky130_fd_pr__nfet_01v8[vdsat] @m.xpga.xamp.xon.msky130_fd_pr__nfet_01v8[vgs] @m.xpga.xamp.xon.msky130_fd_pr__nfet_01v8[vth] @m.xpga.xamp.xcmref.msky130_fd_pr__nfet_01v8[id] @m.xpga.xamp.xcmref.msky130_fd_pr__nfet_01v8[gm] @m.xpga.xamp.xcmref.msky130_fd_pr__nfet_01v8[gds] @m.xpga.xamp.xcmref.msky130_fd_pr__nfet_01v8[vds] @m.xpga.xamp.xcmref.msky130_fd_pr__nfet_01v8[vdsat] @m.xpga.xamp.xcmref.msky130_fd_pr__nfet_01v8[vgs] @m.xpga.xamp.xcmref.msky130_fd_pr__nfet_01v8[vth] @m.xpga.xamp.xcmsense.msky130_fd_pr__nfet_01v8[id] @m.xpga.xamp.xcmsense.msky130_fd_pr__nfet_01v8[gm] @m.xpga.xamp.xcmsense.msky130_fd_pr__nfet_01v8[gds] @m.xpga.xamp.xcmsense.msky130_fd_pr__nfet_01v8[vds] @m.xpga.xamp.xcmsense.msky130_fd_pr__nfet_01v8[vdsat] @m.xpga.xamp.xcmsense.msky130_fd_pr__nfet_01v8[vgs] @m.xpga.xamp.xcmsense.msky130_fd_pr__nfet_01v8[vth] @m.xpga.xamp.xcmt.msky130_fd_pr__nfet_01v8[id] @m.xpga.xamp.xcmt.msky130_fd_pr__nfet_01v8[gm] @m.xpga.xamp.xcmt.msky130_fd_pr__nfet_01v8[gds] @m.xpga.xamp.xcmt.msky130_fd_pr__nfet_01v8[vds] @m.xpga.xamp.xcmt.msky130_fd_pr__nfet_01v8[vdsat] @m.xpga.xamp.xcmt.msky130_fd_pr__nfet_01v8[vgs] @m.xpga.xamp.xcmt.msky130_fd_pr__nfet_01v8[vth] @m.xpga.xamp.xbn1.msky130_fd_pr__nfet_01v8[id] @m.xpga.xamp.xbn1.msky130_fd_pr__nfet_01v8[gm] @m.xpga.xamp.xbn1.msky130_fd_pr__nfet_01v8[gds] @m.xpga.xamp.xbn1.msky130_fd_pr__nfet_01v8[vds] @m.xpga.xamp.xbn1.msky130_fd_pr__nfet_01v8[vdsat] @m.xpga.xamp.xbn1.msky130_fd_pr__nfet_01v8[vgs] @m.xpga.xamp.xbn1.msky130_fd_pr__nfet_01v8[vth] @m.xpga.xamp.xbtd.msky130_fd_pr__nfet_01v8[id] @m.xpga.xamp.xbtd.msky130_fd_pr__nfet_01v8[gm] @m.xpga.xamp.xbtd.msky130_fd_pr__nfet_01v8[gds] @m.xpga.xamp.xbtd.msky130_fd_pr__nfet_01v8[vds] @m.xpga.xamp.xbtd.msky130_fd_pr__nfet_01v8[vdsat] @m.xpga.xamp.xbtd.msky130_fd_pr__nfet_01v8[vgs] @m.xpga.xamp.xbtd.msky130_fd_pr__nfet_01v8[vth] @m.xpga.xamp.xcasp.msky130_fd_pr__nfet_01v8[id] @m.xpga.xamp.xcasp.msky130_fd_pr__nfet_01v8[gm] @m.xpga.xamp.xcasp.msky130_fd_pr__nfet_01v8[gds] @m.xpga.xamp.xcasp.msky130_fd_pr__nfet_01v8[vds] @m.xpga.xamp.xcasp.msky130_fd_pr__nfet_01v8[vdsat] @m.xpga.xamp.xcasp.msky130_fd_pr__nfet_01v8[vgs] @m.xpga.xamp.xcasp.msky130_fd_pr__nfet_01v8[vth] @m.xpga.xamp.xcasn.msky130_fd_pr__nfet_01v8[id] @m.xpga.xamp.xcasn.msky130_fd_pr__nfet_01v8[gm] @m.xpga.xamp.xcasn.msky130_fd_pr__nfet_01v8[gds] @m.xpga.xamp.xcasn.msky130_fd_pr__nfet_01v8[vds] @m.xpga.xamp.xcasn.msky130_fd_pr__nfet_01v8[vdsat] @m.xpga.xamp.xcasn.msky130_fd_pr__nfet_01v8[vgs] @m.xpga.xamp.xcasn.msky130_fd_pr__nfet_01v8[vth] @m.xpga.xamp.xlp.msky130_fd_pr__pfet_01v8[id] @m.xpga.xamp.xlp.msky130_fd_pr__pfet_01v8[gm] @m.xpga.xamp.xlp.msky130_fd_pr__pfet_01v8[gds] @m.xpga.xamp.xlp.msky130_fd_pr__pfet_01v8[vds] @m.xpga.xamp.xlp.msky130_fd_pr__pfet_01v8[vdsat] @m.xpga.xamp.xlp.msky130_fd_pr__pfet_01v8[vgs] @m.xpga.xamp.xlp.msky130_fd_pr__pfet_01v8[vth] @m.xpga.xamp.xln.msky130_fd_pr__pfet_01v8[id] @m.xpga.xamp.xln.msky130_fd_pr__pfet_01v8[gm] @m.xpga.xamp.xln.msky130_fd_pr__pfet_01v8[gds] @m.xpga.xamp.xln.msky130_fd_pr__pfet_01v8[vds] @m.xpga.xamp.xln.msky130_fd_pr__pfet_01v8[vdsat] @m.xpga.xamp.xln.msky130_fd_pr__pfet_01v8[vgs] @m.xpga.xamp.xln.msky130_fd_pr__pfet_01v8[vth] @m.xpga.xamp.xpcasp.msky130_fd_pr__pfet_01v8[id] @m.xpga.xamp.xpcasp.msky130_fd_pr__pfet_01v8[gm] @m.xpga.xamp.xpcasp.msky130_fd_pr__pfet_01v8[gds] @m.xpga.xamp.xpcasp.msky130_fd_pr__pfet_01v8[vds] @m.xpga.xamp.xpcasp.msky130_fd_pr__pfet_01v8[vdsat] @m.xpga.xamp.xpcasp.msky130_fd_pr__pfet_01v8[vgs] @m.xpga.xamp.xpcasp.msky130_fd_pr__pfet_01v8[vth] @m.xpga.xamp.xpcasn.msky130_fd_pr__pfet_01v8[id] @m.xpga.xamp.xpcasn.msky130_fd_pr__pfet_01v8[gm] @m.xpga.xamp.xpcasn.msky130_fd_pr__pfet_01v8[gds] @m.xpga.xamp.xpcasn.msky130_fd_pr__pfet_01v8[vds] @m.xpga.xamp.xpcasn.msky130_fd_pr__pfet_01v8[vdsat] @m.xpga.xamp.xpcasn.msky130_fd_pr__pfet_01v8[vgs] @m.xpga.xamp.xpcasn.msky130_fd_pr__pfet_01v8[vth] @m.xpga.xamp.xip.msky130_fd_pr__pfet_01v8[id] @m.xpga.xamp.xip.msky130_fd_pr__pfet_01v8[gm] @m.xpga.xamp.xip.msky130_fd_pr__pfet_01v8[gds] @m.xpga.xamp.xip.msky130_fd_pr__pfet_01v8[vds] @m.xpga.xamp.xip.msky130_fd_pr__pfet_01v8[vdsat] @m.xpga.xamp.xip.msky130_fd_pr__pfet_01v8[vgs] @m.xpga.xamp.xip.msky130_fd_pr__pfet_01v8[vth] @m.xpga.xamp.xin.msky130_fd_pr__pfet_01v8[id] @m.xpga.xamp.xin.msky130_fd_pr__pfet_01v8[gm] @m.xpga.xamp.xin.msky130_fd_pr__pfet_01v8[gds] @m.xpga.xamp.xin.msky130_fd_pr__pfet_01v8[vds] @m.xpga.xamp.xin.msky130_fd_pr__pfet_01v8[vdsat] @m.xpga.xamp.xin.msky130_fd_pr__pfet_01v8[vgs] @m.xpga.xamp.xin.msky130_fd_pr__pfet_01v8[vth] @m.xpga.xamp.xbp1.msky130_fd_pr__pfet_01v8[id] @m.xpga.xamp.xbp1.msky130_fd_pr__pfet_01v8[gm] @m.xpga.xamp.xbp1.msky130_fd_pr__pfet_01v8[gds] @m.xpga.xamp.xbp1.msky130_fd_pr__pfet_01v8[vds] @m.xpga.xamp.xbp1.msky130_fd_pr__pfet_01v8[vdsat] @m.xpga.xamp.xbp1.msky130_fd_pr__pfet_01v8[vgs] @m.xpga.xamp.xbp1.msky130_fd_pr__pfet_01v8[vth]
dc VIP 0.85 0.95 0.00125
wrdata dc.dat v(sp) v(sn) v(op) v(on) v(xpga.xamp.xp) v(xpga.xamp.xn) v(xpga.xamp.npc) v(xpga.xamp.nnc) v(xpga.xamp.xerrp.tail) v(xpga.xamp.xerrn.tail) v(xpga.xamp.xerrp.ts) v(xpga.xamp.xerrn.ts) v(xpga.xamp.bn) v(xpga.xamp.bt) v(xpga.xamp.bcasc) v(xpga.xamp.cmctl) i(vdd) i(vcm) @m.xpga.xamp.xerrp.xp1.msky130_fd_pr__nfet_01v8_lvt[id] @m.xpga.xamp.xerrp.xp1.msky130_fd_pr__nfet_01v8_lvt[gm] @m.xpga.xamp.xerrp.xp1.msky130_fd_pr__nfet_01v8_lvt[gds] @m.xpga.xamp.xerrp.xp1.msky130_fd_pr__nfet_01v8_lvt[vds] @m.xpga.xamp.xerrp.xp1.msky130_fd_pr__nfet_01v8_lvt[vdsat] @m.xpga.xamp.xerrp.xp1.msky130_fd_pr__nfet_01v8_lvt[vgs] @m.xpga.xamp.xerrp.xp1.msky130_fd_pr__nfet_01v8_lvt[vth] @m.xpga.xamp.xerrp.xn1.msky130_fd_pr__nfet_01v8_lvt[id] @m.xpga.xamp.xerrp.xn1.msky130_fd_pr__nfet_01v8_lvt[gm] @m.xpga.xamp.xerrp.xn1.msky130_fd_pr__nfet_01v8_lvt[gds] @m.xpga.xamp.xerrp.xn1.msky130_fd_pr__nfet_01v8_lvt[vds] @m.xpga.xamp.xerrp.xn1.msky130_fd_pr__nfet_01v8_lvt[vdsat] @m.xpga.xamp.xerrp.xn1.msky130_fd_pr__nfet_01v8_lvt[vgs] @m.xpga.xamp.xerrp.xn1.msky130_fd_pr__nfet_01v8_lvt[vth] @m.xpga.xamp.xerrp.xt0.msky130_fd_pr__nfet_01v8[id] @m.xpga.xamp.xerrp.xt0.msky130_fd_pr__nfet_01v8[gm] @m.xpga.xamp.xerrp.xt0.msky130_fd_pr__nfet_01v8[gds] @m.xpga.xamp.xerrp.xt0.msky130_fd_pr__nfet_01v8[vds] @m.xpga.xamp.xerrp.xt0.msky130_fd_pr__nfet_01v8[vdsat] @m.xpga.xamp.xerrp.xt0.msky130_fd_pr__nfet_01v8[vgs] @m.xpga.xamp.xerrp.xt0.msky130_fd_pr__nfet_01v8[vth] @m.xpga.xamp.xerrp.xtc0.msky130_fd_pr__nfet_01v8[id] @m.xpga.xamp.xerrp.xtc0.msky130_fd_pr__nfet_01v8[gm] @m.xpga.xamp.xerrp.xtc0.msky130_fd_pr__nfet_01v8[gds] @m.xpga.xamp.xerrp.xtc0.msky130_fd_pr__nfet_01v8[vds] @m.xpga.xamp.xerrp.xtc0.msky130_fd_pr__nfet_01v8[vdsat] @m.xpga.xamp.xerrp.xtc0.msky130_fd_pr__nfet_01v8[vgs] @m.xpga.xamp.xerrp.xtc0.msky130_fd_pr__nfet_01v8[vth] @m.xpga.xamp.xerrn.xp1.msky130_fd_pr__nfet_01v8_lvt[id] @m.xpga.xamp.xerrn.xp1.msky130_fd_pr__nfet_01v8_lvt[gm] @m.xpga.xamp.xerrn.xp1.msky130_fd_pr__nfet_01v8_lvt[gds] @m.xpga.xamp.xerrn.xp1.msky130_fd_pr__nfet_01v8_lvt[vds] @m.xpga.xamp.xerrn.xp1.msky130_fd_pr__nfet_01v8_lvt[vdsat] @m.xpga.xamp.xerrn.xp1.msky130_fd_pr__nfet_01v8_lvt[vgs] @m.xpga.xamp.xerrn.xp1.msky130_fd_pr__nfet_01v8_lvt[vth] @m.xpga.xamp.xerrn.xn1.msky130_fd_pr__nfet_01v8_lvt[id] @m.xpga.xamp.xerrn.xn1.msky130_fd_pr__nfet_01v8_lvt[gm] @m.xpga.xamp.xerrn.xn1.msky130_fd_pr__nfet_01v8_lvt[gds] @m.xpga.xamp.xerrn.xn1.msky130_fd_pr__nfet_01v8_lvt[vds] @m.xpga.xamp.xerrn.xn1.msky130_fd_pr__nfet_01v8_lvt[vdsat] @m.xpga.xamp.xerrn.xn1.msky130_fd_pr__nfet_01v8_lvt[vgs] @m.xpga.xamp.xerrn.xn1.msky130_fd_pr__nfet_01v8_lvt[vth] @m.xpga.xamp.xerrn.xt0.msky130_fd_pr__nfet_01v8[id] @m.xpga.xamp.xerrn.xt0.msky130_fd_pr__nfet_01v8[gm] @m.xpga.xamp.xerrn.xt0.msky130_fd_pr__nfet_01v8[gds] @m.xpga.xamp.xerrn.xt0.msky130_fd_pr__nfet_01v8[vds] @m.xpga.xamp.xerrn.xt0.msky130_fd_pr__nfet_01v8[vdsat] @m.xpga.xamp.xerrn.xt0.msky130_fd_pr__nfet_01v8[vgs] @m.xpga.xamp.xerrn.xt0.msky130_fd_pr__nfet_01v8[vth] @m.xpga.xamp.xerrn.xtc0.msky130_fd_pr__nfet_01v8[id] @m.xpga.xamp.xerrn.xtc0.msky130_fd_pr__nfet_01v8[gm] @m.xpga.xamp.xerrn.xtc0.msky130_fd_pr__nfet_01v8[gds] @m.xpga.xamp.xerrn.xtc0.msky130_fd_pr__nfet_01v8[vds] @m.xpga.xamp.xerrn.xtc0.msky130_fd_pr__nfet_01v8[vdsat] @m.xpga.xamp.xerrn.xtc0.msky130_fd_pr__nfet_01v8[vgs] @m.xpga.xamp.xerrn.xtc0.msky130_fd_pr__nfet_01v8[vth] @m.xpga.xamp.xop.msky130_fd_pr__nfet_01v8[id] @m.xpga.xamp.xop.msky130_fd_pr__nfet_01v8[gm] @m.xpga.xamp.xop.msky130_fd_pr__nfet_01v8[gds] @m.xpga.xamp.xop.msky130_fd_pr__nfet_01v8[vds] @m.xpga.xamp.xop.msky130_fd_pr__nfet_01v8[vdsat] @m.xpga.xamp.xop.msky130_fd_pr__nfet_01v8[vgs] @m.xpga.xamp.xop.msky130_fd_pr__nfet_01v8[vth] @m.xpga.xamp.xon.msky130_fd_pr__nfet_01v8[id] @m.xpga.xamp.xon.msky130_fd_pr__nfet_01v8[gm] @m.xpga.xamp.xon.msky130_fd_pr__nfet_01v8[gds] @m.xpga.xamp.xon.msky130_fd_pr__nfet_01v8[vds] @m.xpga.xamp.xon.msky130_fd_pr__nfet_01v8[vdsat] @m.xpga.xamp.xon.msky130_fd_pr__nfet_01v8[vgs] @m.xpga.xamp.xon.msky130_fd_pr__nfet_01v8[vth] @m.xpga.xamp.xcmref.msky130_fd_pr__nfet_01v8[id] @m.xpga.xamp.xcmref.msky130_fd_pr__nfet_01v8[gm] @m.xpga.xamp.xcmref.msky130_fd_pr__nfet_01v8[gds] @m.xpga.xamp.xcmref.msky130_fd_pr__nfet_01v8[vds] @m.xpga.xamp.xcmref.msky130_fd_pr__nfet_01v8[vdsat] @m.xpga.xamp.xcmref.msky130_fd_pr__nfet_01v8[vgs] @m.xpga.xamp.xcmref.msky130_fd_pr__nfet_01v8[vth] @m.xpga.xamp.xcmsense.msky130_fd_pr__nfet_01v8[id] @m.xpga.xamp.xcmsense.msky130_fd_pr__nfet_01v8[gm] @m.xpga.xamp.xcmsense.msky130_fd_pr__nfet_01v8[gds] @m.xpga.xamp.xcmsense.msky130_fd_pr__nfet_01v8[vds] @m.xpga.xamp.xcmsense.msky130_fd_pr__nfet_01v8[vdsat] @m.xpga.xamp.xcmsense.msky130_fd_pr__nfet_01v8[vgs] @m.xpga.xamp.xcmsense.msky130_fd_pr__nfet_01v8[vth] @m.xpga.xamp.xcmt.msky130_fd_pr__nfet_01v8[id] @m.xpga.xamp.xcmt.msky130_fd_pr__nfet_01v8[gm] @m.xpga.xamp.xcmt.msky130_fd_pr__nfet_01v8[gds] @m.xpga.xamp.xcmt.msky130_fd_pr__nfet_01v8[vds] @m.xpga.xamp.xcmt.msky130_fd_pr__nfet_01v8[vdsat] @m.xpga.xamp.xcmt.msky130_fd_pr__nfet_01v8[vgs] @m.xpga.xamp.xcmt.msky130_fd_pr__nfet_01v8[vth] @m.xpga.xamp.xbn1.msky130_fd_pr__nfet_01v8[id] @m.xpga.xamp.xbn1.msky130_fd_pr__nfet_01v8[gm] @m.xpga.xamp.xbn1.msky130_fd_pr__nfet_01v8[gds] @m.xpga.xamp.xbn1.msky130_fd_pr__nfet_01v8[vds] @m.xpga.xamp.xbn1.msky130_fd_pr__nfet_01v8[vdsat] @m.xpga.xamp.xbn1.msky130_fd_pr__nfet_01v8[vgs] @m.xpga.xamp.xbn1.msky130_fd_pr__nfet_01v8[vth] @m.xpga.xamp.xbtd.msky130_fd_pr__nfet_01v8[id] @m.xpga.xamp.xbtd.msky130_fd_pr__nfet_01v8[gm] @m.xpga.xamp.xbtd.msky130_fd_pr__nfet_01v8[gds] @m.xpga.xamp.xbtd.msky130_fd_pr__nfet_01v8[vds] @m.xpga.xamp.xbtd.msky130_fd_pr__nfet_01v8[vdsat] @m.xpga.xamp.xbtd.msky130_fd_pr__nfet_01v8[vgs] @m.xpga.xamp.xbtd.msky130_fd_pr__nfet_01v8[vth] @m.xpga.xamp.xcasp.msky130_fd_pr__nfet_01v8[id] @m.xpga.xamp.xcasp.msky130_fd_pr__nfet_01v8[gm] @m.xpga.xamp.xcasp.msky130_fd_pr__nfet_01v8[gds] @m.xpga.xamp.xcasp.msky130_fd_pr__nfet_01v8[vds] @m.xpga.xamp.xcasp.msky130_fd_pr__nfet_01v8[vdsat] @m.xpga.xamp.xcasp.msky130_fd_pr__nfet_01v8[vgs] @m.xpga.xamp.xcasp.msky130_fd_pr__nfet_01v8[vth] @m.xpga.xamp.xcasn.msky130_fd_pr__nfet_01v8[id] @m.xpga.xamp.xcasn.msky130_fd_pr__nfet_01v8[gm] @m.xpga.xamp.xcasn.msky130_fd_pr__nfet_01v8[gds] @m.xpga.xamp.xcasn.msky130_fd_pr__nfet_01v8[vds] @m.xpga.xamp.xcasn.msky130_fd_pr__nfet_01v8[vdsat] @m.xpga.xamp.xcasn.msky130_fd_pr__nfet_01v8[vgs] @m.xpga.xamp.xcasn.msky130_fd_pr__nfet_01v8[vth] @m.xpga.xamp.xlp.msky130_fd_pr__pfet_01v8[id] @m.xpga.xamp.xlp.msky130_fd_pr__pfet_01v8[gm] @m.xpga.xamp.xlp.msky130_fd_pr__pfet_01v8[gds] @m.xpga.xamp.xlp.msky130_fd_pr__pfet_01v8[vds] @m.xpga.xamp.xlp.msky130_fd_pr__pfet_01v8[vdsat] @m.xpga.xamp.xlp.msky130_fd_pr__pfet_01v8[vgs] @m.xpga.xamp.xlp.msky130_fd_pr__pfet_01v8[vth] @m.xpga.xamp.xln.msky130_fd_pr__pfet_01v8[id] @m.xpga.xamp.xln.msky130_fd_pr__pfet_01v8[gm] @m.xpga.xamp.xln.msky130_fd_pr__pfet_01v8[gds] @m.xpga.xamp.xln.msky130_fd_pr__pfet_01v8[vds] @m.xpga.xamp.xln.msky130_fd_pr__pfet_01v8[vdsat] @m.xpga.xamp.xln.msky130_fd_pr__pfet_01v8[vgs] @m.xpga.xamp.xln.msky130_fd_pr__pfet_01v8[vth] @m.xpga.xamp.xpcasp.msky130_fd_pr__pfet_01v8[id] @m.xpga.xamp.xpcasp.msky130_fd_pr__pfet_01v8[gm] @m.xpga.xamp.xpcasp.msky130_fd_pr__pfet_01v8[gds] @m.xpga.xamp.xpcasp.msky130_fd_pr__pfet_01v8[vds] @m.xpga.xamp.xpcasp.msky130_fd_pr__pfet_01v8[vdsat] @m.xpga.xamp.xpcasp.msky130_fd_pr__pfet_01v8[vgs] @m.xpga.xamp.xpcasp.msky130_fd_pr__pfet_01v8[vth] @m.xpga.xamp.xpcasn.msky130_fd_pr__pfet_01v8[id] @m.xpga.xamp.xpcasn.msky130_fd_pr__pfet_01v8[gm] @m.xpga.xamp.xpcasn.msky130_fd_pr__pfet_01v8[gds] @m.xpga.xamp.xpcasn.msky130_fd_pr__pfet_01v8[vds] @m.xpga.xamp.xpcasn.msky130_fd_pr__pfet_01v8[vdsat] @m.xpga.xamp.xpcasn.msky130_fd_pr__pfet_01v8[vgs] @m.xpga.xamp.xpcasn.msky130_fd_pr__pfet_01v8[vth] @m.xpga.xamp.xip.msky130_fd_pr__pfet_01v8[id] @m.xpga.xamp.xip.msky130_fd_pr__pfet_01v8[gm] @m.xpga.xamp.xip.msky130_fd_pr__pfet_01v8[gds] @m.xpga.xamp.xip.msky130_fd_pr__pfet_01v8[vds] @m.xpga.xamp.xip.msky130_fd_pr__pfet_01v8[vdsat] @m.xpga.xamp.xip.msky130_fd_pr__pfet_01v8[vgs] @m.xpga.xamp.xip.msky130_fd_pr__pfet_01v8[vth] @m.xpga.xamp.xin.msky130_fd_pr__pfet_01v8[id] @m.xpga.xamp.xin.msky130_fd_pr__pfet_01v8[gm] @m.xpga.xamp.xin.msky130_fd_pr__pfet_01v8[gds] @m.xpga.xamp.xin.msky130_fd_pr__pfet_01v8[vds] @m.xpga.xamp.xin.msky130_fd_pr__pfet_01v8[vdsat] @m.xpga.xamp.xin.msky130_fd_pr__pfet_01v8[vgs] @m.xpga.xamp.xin.msky130_fd_pr__pfet_01v8[vth] @m.xpga.xamp.xbp1.msky130_fd_pr__pfet_01v8[id] @m.xpga.xamp.xbp1.msky130_fd_pr__pfet_01v8[gm] @m.xpga.xamp.xbp1.msky130_fd_pr__pfet_01v8[gds] @m.xpga.xamp.xbp1.msky130_fd_pr__pfet_01v8[vds] @m.xpga.xamp.xbp1.msky130_fd_pr__pfet_01v8[vdsat] @m.xpga.xamp.xbp1.msky130_fd_pr__pfet_01v8[vgs] @m.xpga.xamp.xbp1.msky130_fd_pr__pfet_01v8[vth]
tran 5n 25u 0 5n
wrdata transient.dat v(sp) v(sn) v(op) v(on) v(xpga.xamp.xp) v(xpga.xamp.xn) v(xpga.xamp.npc) v(xpga.xamp.nnc) v(xpga.xamp.xerrp.tail) v(xpga.xamp.xerrn.tail) v(xpga.xamp.xerrp.ts) v(xpga.xamp.xerrn.ts) v(xpga.xamp.bn) v(xpga.xamp.bt) v(xpga.xamp.bcasc) v(xpga.xamp.cmctl) i(vdd) i(vcm) @m.xpga.xamp.xerrp.xp1.msky130_fd_pr__nfet_01v8_lvt[id] @m.xpga.xamp.xerrp.xp1.msky130_fd_pr__nfet_01v8_lvt[gm] @m.xpga.xamp.xerrp.xp1.msky130_fd_pr__nfet_01v8_lvt[gds] @m.xpga.xamp.xerrp.xp1.msky130_fd_pr__nfet_01v8_lvt[vds] @m.xpga.xamp.xerrp.xp1.msky130_fd_pr__nfet_01v8_lvt[vdsat] @m.xpga.xamp.xerrp.xp1.msky130_fd_pr__nfet_01v8_lvt[vgs] @m.xpga.xamp.xerrp.xp1.msky130_fd_pr__nfet_01v8_lvt[vth] @m.xpga.xamp.xerrp.xn1.msky130_fd_pr__nfet_01v8_lvt[id] @m.xpga.xamp.xerrp.xn1.msky130_fd_pr__nfet_01v8_lvt[gm] @m.xpga.xamp.xerrp.xn1.msky130_fd_pr__nfet_01v8_lvt[gds] @m.xpga.xamp.xerrp.xn1.msky130_fd_pr__nfet_01v8_lvt[vds] @m.xpga.xamp.xerrp.xn1.msky130_fd_pr__nfet_01v8_lvt[vdsat] @m.xpga.xamp.xerrp.xn1.msky130_fd_pr__nfet_01v8_lvt[vgs] @m.xpga.xamp.xerrp.xn1.msky130_fd_pr__nfet_01v8_lvt[vth] @m.xpga.xamp.xerrp.xt0.msky130_fd_pr__nfet_01v8[id] @m.xpga.xamp.xerrp.xt0.msky130_fd_pr__nfet_01v8[gm] @m.xpga.xamp.xerrp.xt0.msky130_fd_pr__nfet_01v8[gds] @m.xpga.xamp.xerrp.xt0.msky130_fd_pr__nfet_01v8[vds] @m.xpga.xamp.xerrp.xt0.msky130_fd_pr__nfet_01v8[vdsat] @m.xpga.xamp.xerrp.xt0.msky130_fd_pr__nfet_01v8[vgs] @m.xpga.xamp.xerrp.xt0.msky130_fd_pr__nfet_01v8[vth] @m.xpga.xamp.xerrp.xtc0.msky130_fd_pr__nfet_01v8[id] @m.xpga.xamp.xerrp.xtc0.msky130_fd_pr__nfet_01v8[gm] @m.xpga.xamp.xerrp.xtc0.msky130_fd_pr__nfet_01v8[gds] @m.xpga.xamp.xerrp.xtc0.msky130_fd_pr__nfet_01v8[vds] @m.xpga.xamp.xerrp.xtc0.msky130_fd_pr__nfet_01v8[vdsat] @m.xpga.xamp.xerrp.xtc0.msky130_fd_pr__nfet_01v8[vgs] @m.xpga.xamp.xerrp.xtc0.msky130_fd_pr__nfet_01v8[vth] @m.xpga.xamp.xerrn.xp1.msky130_fd_pr__nfet_01v8_lvt[id] @m.xpga.xamp.xerrn.xp1.msky130_fd_pr__nfet_01v8_lvt[gm] @m.xpga.xamp.xerrn.xp1.msky130_fd_pr__nfet_01v8_lvt[gds] @m.xpga.xamp.xerrn.xp1.msky130_fd_pr__nfet_01v8_lvt[vds] @m.xpga.xamp.xerrn.xp1.msky130_fd_pr__nfet_01v8_lvt[vdsat] @m.xpga.xamp.xerrn.xp1.msky130_fd_pr__nfet_01v8_lvt[vgs] @m.xpga.xamp.xerrn.xp1.msky130_fd_pr__nfet_01v8_lvt[vth] @m.xpga.xamp.xerrn.xn1.msky130_fd_pr__nfet_01v8_lvt[id] @m.xpga.xamp.xerrn.xn1.msky130_fd_pr__nfet_01v8_lvt[gm] @m.xpga.xamp.xerrn.xn1.msky130_fd_pr__nfet_01v8_lvt[gds] @m.xpga.xamp.xerrn.xn1.msky130_fd_pr__nfet_01v8_lvt[vds] @m.xpga.xamp.xerrn.xn1.msky130_fd_pr__nfet_01v8_lvt[vdsat] @m.xpga.xamp.xerrn.xn1.msky130_fd_pr__nfet_01v8_lvt[vgs] @m.xpga.xamp.xerrn.xn1.msky130_fd_pr__nfet_01v8_lvt[vth] @m.xpga.xamp.xerrn.xt0.msky130_fd_pr__nfet_01v8[id] @m.xpga.xamp.xerrn.xt0.msky130_fd_pr__nfet_01v8[gm] @m.xpga.xamp.xerrn.xt0.msky130_fd_pr__nfet_01v8[gds] @m.xpga.xamp.xerrn.xt0.msky130_fd_pr__nfet_01v8[vds] @m.xpga.xamp.xerrn.xt0.msky130_fd_pr__nfet_01v8[vdsat] @m.xpga.xamp.xerrn.xt0.msky130_fd_pr__nfet_01v8[vgs] @m.xpga.xamp.xerrn.xt0.msky130_fd_pr__nfet_01v8[vth] @m.xpga.xamp.xerrn.xtc0.msky130_fd_pr__nfet_01v8[id] @m.xpga.xamp.xerrn.xtc0.msky130_fd_pr__nfet_01v8[gm] @m.xpga.xamp.xerrn.xtc0.msky130_fd_pr__nfet_01v8[gds] @m.xpga.xamp.xerrn.xtc0.msky130_fd_pr__nfet_01v8[vds] @m.xpga.xamp.xerrn.xtc0.msky130_fd_pr__nfet_01v8[vdsat] @m.xpga.xamp.xerrn.xtc0.msky130_fd_pr__nfet_01v8[vgs] @m.xpga.xamp.xerrn.xtc0.msky130_fd_pr__nfet_01v8[vth] @m.xpga.xamp.xop.msky130_fd_pr__nfet_01v8[id] @m.xpga.xamp.xop.msky130_fd_pr__nfet_01v8[gm] @m.xpga.xamp.xop.msky130_fd_pr__nfet_01v8[gds] @m.xpga.xamp.xop.msky130_fd_pr__nfet_01v8[vds] @m.xpga.xamp.xop.msky130_fd_pr__nfet_01v8[vdsat] @m.xpga.xamp.xop.msky130_fd_pr__nfet_01v8[vgs] @m.xpga.xamp.xop.msky130_fd_pr__nfet_01v8[vth] @m.xpga.xamp.xon.msky130_fd_pr__nfet_01v8[id] @m.xpga.xamp.xon.msky130_fd_pr__nfet_01v8[gm] @m.xpga.xamp.xon.msky130_fd_pr__nfet_01v8[gds] @m.xpga.xamp.xon.msky130_fd_pr__nfet_01v8[vds] @m.xpga.xamp.xon.msky130_fd_pr__nfet_01v8[vdsat] @m.xpga.xamp.xon.msky130_fd_pr__nfet_01v8[vgs] @m.xpga.xamp.xon.msky130_fd_pr__nfet_01v8[vth] @m.xpga.xamp.xcmref.msky130_fd_pr__nfet_01v8[id] @m.xpga.xamp.xcmref.msky130_fd_pr__nfet_01v8[gm] @m.xpga.xamp.xcmref.msky130_fd_pr__nfet_01v8[gds] @m.xpga.xamp.xcmref.msky130_fd_pr__nfet_01v8[vds] @m.xpga.xamp.xcmref.msky130_fd_pr__nfet_01v8[vdsat] @m.xpga.xamp.xcmref.msky130_fd_pr__nfet_01v8[vgs] @m.xpga.xamp.xcmref.msky130_fd_pr__nfet_01v8[vth] @m.xpga.xamp.xcmsense.msky130_fd_pr__nfet_01v8[id] @m.xpga.xamp.xcmsense.msky130_fd_pr__nfet_01v8[gm] @m.xpga.xamp.xcmsense.msky130_fd_pr__nfet_01v8[gds] @m.xpga.xamp.xcmsense.msky130_fd_pr__nfet_01v8[vds] @m.xpga.xamp.xcmsense.msky130_fd_pr__nfet_01v8[vdsat] @m.xpga.xamp.xcmsense.msky130_fd_pr__nfet_01v8[vgs] @m.xpga.xamp.xcmsense.msky130_fd_pr__nfet_01v8[vth] @m.xpga.xamp.xcmt.msky130_fd_pr__nfet_01v8[id] @m.xpga.xamp.xcmt.msky130_fd_pr__nfet_01v8[gm] @m.xpga.xamp.xcmt.msky130_fd_pr__nfet_01v8[gds] @m.xpga.xamp.xcmt.msky130_fd_pr__nfet_01v8[vds] @m.xpga.xamp.xcmt.msky130_fd_pr__nfet_01v8[vdsat] @m.xpga.xamp.xcmt.msky130_fd_pr__nfet_01v8[vgs] @m.xpga.xamp.xcmt.msky130_fd_pr__nfet_01v8[vth] @m.xpga.xamp.xbn1.msky130_fd_pr__nfet_01v8[id] @m.xpga.xamp.xbn1.msky130_fd_pr__nfet_01v8[gm] @m.xpga.xamp.xbn1.msky130_fd_pr__nfet_01v8[gds] @m.xpga.xamp.xbn1.msky130_fd_pr__nfet_01v8[vds] @m.xpga.xamp.xbn1.msky130_fd_pr__nfet_01v8[vdsat] @m.xpga.xamp.xbn1.msky130_fd_pr__nfet_01v8[vgs] @m.xpga.xamp.xbn1.msky130_fd_pr__nfet_01v8[vth] @m.xpga.xamp.xbtd.msky130_fd_pr__nfet_01v8[id] @m.xpga.xamp.xbtd.msky130_fd_pr__nfet_01v8[gm] @m.xpga.xamp.xbtd.msky130_fd_pr__nfet_01v8[gds] @m.xpga.xamp.xbtd.msky130_fd_pr__nfet_01v8[vds] @m.xpga.xamp.xbtd.msky130_fd_pr__nfet_01v8[vdsat] @m.xpga.xamp.xbtd.msky130_fd_pr__nfet_01v8[vgs] @m.xpga.xamp.xbtd.msky130_fd_pr__nfet_01v8[vth] @m.xpga.xamp.xcasp.msky130_fd_pr__nfet_01v8[id] @m.xpga.xamp.xcasp.msky130_fd_pr__nfet_01v8[gm] @m.xpga.xamp.xcasp.msky130_fd_pr__nfet_01v8[gds] @m.xpga.xamp.xcasp.msky130_fd_pr__nfet_01v8[vds] @m.xpga.xamp.xcasp.msky130_fd_pr__nfet_01v8[vdsat] @m.xpga.xamp.xcasp.msky130_fd_pr__nfet_01v8[vgs] @m.xpga.xamp.xcasp.msky130_fd_pr__nfet_01v8[vth] @m.xpga.xamp.xcasn.msky130_fd_pr__nfet_01v8[id] @m.xpga.xamp.xcasn.msky130_fd_pr__nfet_01v8[gm] @m.xpga.xamp.xcasn.msky130_fd_pr__nfet_01v8[gds] @m.xpga.xamp.xcasn.msky130_fd_pr__nfet_01v8[vds] @m.xpga.xamp.xcasn.msky130_fd_pr__nfet_01v8[vdsat] @m.xpga.xamp.xcasn.msky130_fd_pr__nfet_01v8[vgs] @m.xpga.xamp.xcasn.msky130_fd_pr__nfet_01v8[vth] @m.xpga.xamp.xlp.msky130_fd_pr__pfet_01v8[id] @m.xpga.xamp.xlp.msky130_fd_pr__pfet_01v8[gm] @m.xpga.xamp.xlp.msky130_fd_pr__pfet_01v8[gds] @m.xpga.xamp.xlp.msky130_fd_pr__pfet_01v8[vds] @m.xpga.xamp.xlp.msky130_fd_pr__pfet_01v8[vdsat] @m.xpga.xamp.xlp.msky130_fd_pr__pfet_01v8[vgs] @m.xpga.xamp.xlp.msky130_fd_pr__pfet_01v8[vth] @m.xpga.xamp.xln.msky130_fd_pr__pfet_01v8[id] @m.xpga.xamp.xln.msky130_fd_pr__pfet_01v8[gm] @m.xpga.xamp.xln.msky130_fd_pr__pfet_01v8[gds] @m.xpga.xamp.xln.msky130_fd_pr__pfet_01v8[vds] @m.xpga.xamp.xln.msky130_fd_pr__pfet_01v8[vdsat] @m.xpga.xamp.xln.msky130_fd_pr__pfet_01v8[vgs] @m.xpga.xamp.xln.msky130_fd_pr__pfet_01v8[vth] @m.xpga.xamp.xpcasp.msky130_fd_pr__pfet_01v8[id] @m.xpga.xamp.xpcasp.msky130_fd_pr__pfet_01v8[gm] @m.xpga.xamp.xpcasp.msky130_fd_pr__pfet_01v8[gds] @m.xpga.xamp.xpcasp.msky130_fd_pr__pfet_01v8[vds] @m.xpga.xamp.xpcasp.msky130_fd_pr__pfet_01v8[vdsat] @m.xpga.xamp.xpcasp.msky130_fd_pr__pfet_01v8[vgs] @m.xpga.xamp.xpcasp.msky130_fd_pr__pfet_01v8[vth] @m.xpga.xamp.xpcasn.msky130_fd_pr__pfet_01v8[id] @m.xpga.xamp.xpcasn.msky130_fd_pr__pfet_01v8[gm] @m.xpga.xamp.xpcasn.msky130_fd_pr__pfet_01v8[gds] @m.xpga.xamp.xpcasn.msky130_fd_pr__pfet_01v8[vds] @m.xpga.xamp.xpcasn.msky130_fd_pr__pfet_01v8[vdsat] @m.xpga.xamp.xpcasn.msky130_fd_pr__pfet_01v8[vgs] @m.xpga.xamp.xpcasn.msky130_fd_pr__pfet_01v8[vth] @m.xpga.xamp.xip.msky130_fd_pr__pfet_01v8[id] @m.xpga.xamp.xip.msky130_fd_pr__pfet_01v8[gm] @m.xpga.xamp.xip.msky130_fd_pr__pfet_01v8[gds] @m.xpga.xamp.xip.msky130_fd_pr__pfet_01v8[vds] @m.xpga.xamp.xip.msky130_fd_pr__pfet_01v8[vdsat] @m.xpga.xamp.xip.msky130_fd_pr__pfet_01v8[vgs] @m.xpga.xamp.xip.msky130_fd_pr__pfet_01v8[vth] @m.xpga.xamp.xin.msky130_fd_pr__pfet_01v8[id] @m.xpga.xamp.xin.msky130_fd_pr__pfet_01v8[gm] @m.xpga.xamp.xin.msky130_fd_pr__pfet_01v8[gds] @m.xpga.xamp.xin.msky130_fd_pr__pfet_01v8[vds] @m.xpga.xamp.xin.msky130_fd_pr__pfet_01v8[vdsat] @m.xpga.xamp.xin.msky130_fd_pr__pfet_01v8[vgs] @m.xpga.xamp.xin.msky130_fd_pr__pfet_01v8[vth] @m.xpga.xamp.xbp1.msky130_fd_pr__pfet_01v8[id] @m.xpga.xamp.xbp1.msky130_fd_pr__pfet_01v8[gm] @m.xpga.xamp.xbp1.msky130_fd_pr__pfet_01v8[gds] @m.xpga.xamp.xbp1.msky130_fd_pr__pfet_01v8[vds] @m.xpga.xamp.xbp1.msky130_fd_pr__pfet_01v8[vdsat] @m.xpga.xamp.xbp1.msky130_fd_pr__pfet_01v8[vgs] @m.xpga.xamp.xbp1.msky130_fd_pr__pfet_01v8[vth] v(fp) v(fn)
quit
.endc
.end
