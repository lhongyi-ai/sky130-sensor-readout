* 2026-09-11 bounded dynamic-closure candidate 06.
* True two-input, fully-differential two-stage OTA with continuous resistive
* output-CM sensing.  The PGA is a cross-coupled fully-differential inverting
* loop, so the OTA inputs only see the closed-loop error rather than the full
* sensor differential swing.  Every internal active/passive element is a
* layout-capable SKY130 primitive; VCM is an explicit top-level reference.

* Measured/model-derived approximation for the fixed-width 0.35 um high-po
* primitive at nominal conditions: R ~= 961 + 993*L ohm.  Values used here
* stay above the 0.5 um PCell minimum.  Exact closed-loop gain is calibrated,
* but the same physical ratios are used for all tests and corners.
.subckt rd_hr A B SUB params: R=10000
XR A B SUB sky130_fd_pr__res_high_po_0p35 L={(R-961)/993}
.ends rd_hr

* Legal low-value high-po element for the Miller zero resistor.  The 0.69 um
* PCell model has R ~= 2*389.90 + 491.36*L ohm at nominal conditions.  Thus
* 1.2 kohm uses L=0.855 um, safely above the 0.5 um PCell minimum.
.subckt rd_lr A B SUB params: R=1200
XR A B SUB sky130_fd_pr__res_high_po_0p69 L={(R-779.8)/491.36}
.ends rd_lr

.subckt rd_c1p A B
XC A B sky130_fd_pr__cap_mim_m3_1 W=22.215 L=22.215
.ends rd_c1p

.subckt rd_c4p A B
XC0 A B rd_c1p
XC1 A B rd_c1p
XC2 A B rd_c1p
XC3 A B rd_c1p
.ends rd_c4p

.subckt rd_c16p A B
XC0 A B rd_c4p
XC1 A B rd_c4p
XC2 A B rd_c4p
XC3 A B rd_c4p
.ends rd_c16p

.subckt rd_c8p A B
XC0 A B rd_c4p
XC1 A B rd_c4p
.ends rd_c8p

.subckt rd_inv A Y VDD VSS
XN Y A VSS VSS sky130_fd_pr__nfet_01v8 L=0.15 W=2
XP Y A VDD VDD sky130_fd_pr__pfet_01v8 L=0.15 W=4
.ends rd_inv

.subckt rd_nand A B Y VDD VSS
XN0 Y A N VSS sky130_fd_pr__nfet_01v8 L=0.15 W=2
XN1 N B VSS VSS sky130_fd_pr__nfet_01v8 L=0.15 W=2
XP0 Y A VDD VDD sky130_fd_pr__pfet_01v8 L=0.15 W=4
XP1 Y B VDD VDD sky130_fd_pr__pfet_01v8 L=0.15 W=4
.ends rd_nand

.subckt rd_tgate A B EN ENB VDD VSS
XN B EN A VSS sky130_fd_pr__nfet_01v8 L=0.15 W=12
XP B ENB A VDD sky130_fd_pr__pfet_01v8 L=0.15 W=24
.ends rd_tgate

* Physical resistor/diode bias generator.  The resistors provide startup, so
* this circuit has no zero-current equilibrium and needs no ideal bias source.
.subckt rd_bias BN BP VDD VSS
XRBN VDD BN VSS rd_hr R=24000
XDBN BN BN VSS VSS sky130_fd_pr__nfet_01v8 L=1 W=20
* BP remains a defined compatibility port, but local direct-sense CM feedback
* below now controls the PMOS loads without a second high-gain servo.
XRBP BP BN VSS rd_hr R=1000000
.ends rd_bias

* Fully differential two-stage OTA.
* Both stages use direct-sense continuous-time common-mode feedback.  Each
* equal resistor/capacitor pair forms the physical average; the average voltage
* directly controls matched load devices, leaving no extra high-gain CM servo.
.subckt rd_fdota INP INN OUTP OUTN VDD VSS VCM params: NCMAC=0 OCMAC=0
XBIAS BN BP VDD VSS rd_bias

* First differential stage, approximately 100 uA total at TT nominal.
XMIP N1 INP TAIL VSS sky130_fd_pr__nfet_01v8 L=1 W=80
XMIN N2 INN TAIL VSS sky130_fd_pr__nfet_01v8 L=1 W=80
XMTAIL TAIL BN VSS VSS sky130_fd_pr__nfet_01v8 L=1 W=40
VTESTNCM NCM_GATE NCM dc 0 ac {NCMAC}
XMLP N1 NCM_GATE VDD VDD sky130_fd_pr__pfet_01v8 L=1 W=64
XMLN N2 NCM_GATE VDD VDD sky130_fd_pr__pfet_01v8 L=1 W=64
XRN1 N1 NCM VSS rd_hr R=100000
XRN2 N2 NCM VSS rd_hr R=100000
XCN1 N1 NCM rd_c1p
XCN2 N2 NCM rd_c1p

* Second stage.  Each branch has enough class-A current to settle the real
* 4096-unit sampled CDAC while remaining inside the front-end power budget.
XMSP OUTP N1 VDD VDD sky130_fd_pr__pfet_01v8 L=1 W=180
XMSN OUTN N2 VDD VDD sky130_fd_pr__pfet_01v8 L=1 W=180
XMOP OUTP CMG VSS VSS sky130_fd_pr__nfet_01v8 L=1 W=9
XMON OUTN CMG VSS VSS sky130_fd_pr__nfet_01v8 L=1 W=9

* Physical Miller capacitors and nulling resistors, one matched branch each.
XRZP N1 CZP VSS rd_lr R=1200
XRZN N2 CZN VSS rd_lr R=1200
* Candidate 04 was cleanly damped but G16 crossed its final value only near
* the aperture.  Halving matched Miller C raises differential bandwidth while
* leaving both direct-sense common-mode loops unchanged.
XCCP CZP OUTP rd_c8p
XCCN CZN OUTN rd_c8p

XRCMP OUTP CMS VSS rd_hr R=100000
XRCMN OUTN CMS VSS rd_hr R=100000
XCSMP OUTP CMS rd_c1p
XCSMN OUTN CMS rd_c1p

* Low-gain reference error stage: CMS high versus the external VCM reference
* diverts tail current to the sensed branch and lets CMG rise, strengthening
* both output sinks.  Real 10 kohm source degeneration prevents this reference
* servo from recreating the previous high-gain 2.9 MHz common-mode oscillator.
VTESTOCM CMS_ERROR CMS dc 0 ac {OCMAC}
XCMS DS CMS_ERROR CS VSS sky130_fd_pr__nfet_01v8 L=1 W=20
XCMR CMG VCM CR VSS sky130_fd_pr__nfet_01v8 L=1 W=20
XRSCS CS CTAIL VSS rd_hr R=10000
XRSCR CR CTAIL VSS rd_hr R=10000
XCMT CTAIL BN VSS VSS sky130_fd_pr__nfet_01v8 L=1 W=8
XRDS VDD DS VSS rd_hr R=105000
XRCMG VDD CMG VSS rd_hr R=105000
.ends rd_fdota

* One selectable cross-feedback resistor.  Its unselected end floats behind a
* real transmission gate; no ideal switch or controlled source is hidden.
.subckt rd_fbbranch OUT SUM EN ENB VDD VSS params: RFB=10000
XR OUT N VSS rd_hr R={RFB}
XSW N SUM EN ENB VDD VSS rd_tgate
.ends rd_fbbranch

.subckt sky130_v2_switchable_pga VINP VINN OUTP OUTN VDD VSS VCM SEL0 SEL1 params: DMAC=0 NCMAC=0 OCMAC=0
* Decode 00/01/10 as gain 1/4/16.  11 intentionally selects no branch.
XI0 SEL0 S0B VDD VSS rd_inv
XI1 SEL1 S1B VDD VSS rd_inv
XN1 S0B S1B E1B VDD VSS rd_nand
XN4 SEL0 S1B E4B VDD VSS rd_nand
XN16 S0B SEL1 E16B VDD VSS rd_nand
XIE1 E1B E1 VDD VSS rd_inv
XIE4 E4B E4 VDD VSS rd_inv
XIE16 E16B E16 VDD VSS rd_inv

* Rin is on the sensor side.  Rfb values include the known 350 ohm source
* resistance so nominal source-to-output gains are near 1/4/16 before fitting.
XRINP VINP SUMPOS VSS rd_hr R=10000
XRINN VINN SUMNEG VSS rd_hr R=10000
XFP1 OUTN SUMPOS E1 E1B VDD VSS rd_fbbranch RFB=10350
XFN1 OUTP SUMNEG E1 E1B VDD VSS rd_fbbranch RFB=10350
XFP4 OUTN SUMPOS E4 E4B VDD VSS rd_fbbranch RFB=41400
XFN4 OUTP SUMNEG E4 E4B VDD VSS rd_fbbranch RFB=41400
XFP16 OUTN SUMPOS E16 E16B VDD VSS rd_fbbranch RFB=165600
XFN16 OUTP SUMNEG E16 E16B VDD VSS rd_fbbranch RFB=165600
VTESTP I_SUMPOS SUMPOS dc 0 ac {DMAC*.5}
VTESTN I_SUMNEG SUMNEG dc 0 ac {-DMAC*.5}
XOTA I_SUMPOS I_SUMNEG OUTP OUTN VDD VSS VCM rd_fdota NCMAC={NCMAC} OCMAC={OCMAC}
.ends sky130_v2_switchable_pga

.subckt sky130_v2_switchable_sample_driver VINP VINN OUTP OUTN VDD VSS VCM SEL0 SEL1 params: RISO=1800
XPGA VINP VINN COREP COREN VDD VSS VCM SEL0 SEL1 sky130_v2_switchable_pga
XRIP COREP OUTP VSS rd_hr R={RISO}
XRIN COREN OUTN VSS rd_hr R={RISO}
XCFP OUTP VSS rd_c4p
XCFN OUTN VSS rd_c4p
.ends sky130_v2_switchable_sample_driver
