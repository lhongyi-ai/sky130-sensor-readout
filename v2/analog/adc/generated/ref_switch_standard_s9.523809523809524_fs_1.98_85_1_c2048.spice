* ref_switch_standard_s9.523809523809524_fs_1.98_85_1_c2048
.lib /foss/pdks/sky130A/libs.tech/combined/sky130.lib.spice fs
.include /repo/v2/analog/adc/adc_blocks.spice
.temp 85
.options reltol=1e-5 abstol=1e-14 vntol=1e-8 method=gear klu
.include /repo/v2/analog/adc/adc_reference_candidate.spice
VDD vdd 0 1.98
VSOURCE src 0 PWL(0 0.99 20n 0.99 21n 1.19)
RS src sample 350
VRP srp 0 1.1
VRN srn 0 .7
RRP srp rp 1
RRN srn rn 1
VACQ acq 0 PWL(0 1.98 2.476847754u 1.98 2.477847754u 0)
VCONV conv 0 PWL(0 0 2.50u 0 2.501u 1.98)
VBIT bit 0 0
XSW hold bit acq conv rp rn sample vdd 0 adc_ref_switch WN=8 WP=16
XC hold 0 adc_mim_bank COUNT=2048
.ic v(hold)=0.99

.control
set num_threads=1
set wr_singlescale
set wr_vecnames
set numdgt=12
tran 2n 3.2u uic
wrdata /repo/v2/analog/adc/results/ref_switch_standard_s9.523809523809524_fs_1.98_85_1_c2048.tsv v(src) v(sample) v(hold) v(acq) v(conv) i(vdd)
quit
.endc
.end
