* cdac_mismatch_200
.lib /foss/pdks/sky130A/libs.tech/combined/sky130.lib.spice tt_mm
.include /repo/v2/analog/adc/adc_blocks.spice
.temp 27
.options reltol=1e-5 abstol=1e-14 vntol=1e-8 method=gear klu
Vs0_p_0 s0_p_0 0 DC 0 AC 1
Xs0_p_0 s0_p_0 0 adc_mim_bank COUNT=1
Vs0_p_1 s0_p_1 0 DC 0 AC 1
Xs0_p_1 s0_p_1 0 adc_mim_bank COUNT=2
Vs0_p_2 s0_p_2 0 DC 0 AC 1
Xs0_p_2 s0_p_2 0 adc_mim_bank COUNT=4
Vs0_p_3 s0_p_3 0 DC 0 AC 1
Xs0_p_3 s0_p_3 0 adc_mim_bank COUNT=8
Vs0_p_4 s0_p_4 0 DC 0 AC 1
Xs0_p_4 s0_p_4 0 adc_mim_bank COUNT=16
Vs0_p_5 s0_p_5 0 DC 0 AC 1
Xs0_p_5 s0_p_5 0 adc_mim_bank COUNT=32
Vs0_p_6 s0_p_6 0 DC 0 AC 1
Xs0_p_6 s0_p_6 0 adc_mim_bank COUNT=64
Vs0_p_7 s0_p_7 0 DC 0 AC 1
Xs0_p_7 s0_p_7 0 adc_mim_bank COUNT=128
Vs0_p_8 s0_p_8 0 DC 0 AC 1
Xs0_p_8 s0_p_8 0 adc_mim_bank COUNT=256
Vs0_p_9 s0_p_9 0 DC 0 AC 1
Xs0_p_9 s0_p_9 0 adc_mim_bank COUNT=512
Vs0_p_10 s0_p_10 0 DC 0 AC 1
Xs0_p_10 s0_p_10 0 adc_mim_bank COUNT=1024
Vs0_p_11 s0_p_11 0 DC 0 AC 1
Xs0_p_11 s0_p_11 0 adc_mim_bank COUNT=2048
Vs0_p_12 s0_p_12 0 DC 0 AC 1
Xs0_p_12 s0_p_12 0 adc_mim_bank COUNT=1
Vs0_n_0 s0_n_0 0 DC 0 AC 1
Xs0_n_0 s0_n_0 0 adc_mim_bank COUNT=1
Vs0_n_1 s0_n_1 0 DC 0 AC 1
Xs0_n_1 s0_n_1 0 adc_mim_bank COUNT=2
Vs0_n_2 s0_n_2 0 DC 0 AC 1
Xs0_n_2 s0_n_2 0 adc_mim_bank COUNT=4
Vs0_n_3 s0_n_3 0 DC 0 AC 1
Xs0_n_3 s0_n_3 0 adc_mim_bank COUNT=8
Vs0_n_4 s0_n_4 0 DC 0 AC 1
Xs0_n_4 s0_n_4 0 adc_mim_bank COUNT=16
Vs0_n_5 s0_n_5 0 DC 0 AC 1
Xs0_n_5 s0_n_5 0 adc_mim_bank COUNT=32
Vs0_n_6 s0_n_6 0 DC 0 AC 1
Xs0_n_6 s0_n_6 0 adc_mim_bank COUNT=64
Vs0_n_7 s0_n_7 0 DC 0 AC 1
Xs0_n_7 s0_n_7 0 adc_mim_bank COUNT=128
Vs0_n_8 s0_n_8 0 DC 0 AC 1
Xs0_n_8 s0_n_8 0 adc_mim_bank COUNT=256
Vs0_n_9 s0_n_9 0 DC 0 AC 1
Xs0_n_9 s0_n_9 0 adc_mim_bank COUNT=512
Vs0_n_10 s0_n_10 0 DC 0 AC 1
Xs0_n_10 s0_n_10 0 adc_mim_bank COUNT=1024
Vs0_n_11 s0_n_11 0 DC 0 AC 1
Xs0_n_11 s0_n_11 0 adc_mim_bank COUNT=2048
Vs0_n_12 s0_n_12 0 DC 0 AC 1
Xs0_n_12 s0_n_12 0 adc_mim_bank COUNT=1
Vs1_p_0 s1_p_0 0 DC 0 AC 1
Xs1_p_0 s1_p_0 0 adc_mim_bank COUNT=1
Vs1_p_1 s1_p_1 0 DC 0 AC 1
Xs1_p_1 s1_p_1 0 adc_mim_bank COUNT=2
Vs1_p_2 s1_p_2 0 DC 0 AC 1
Xs1_p_2 s1_p_2 0 adc_mim_bank COUNT=4
Vs1_p_3 s1_p_3 0 DC 0 AC 1
Xs1_p_3 s1_p_3 0 adc_mim_bank COUNT=8
Vs1_p_4 s1_p_4 0 DC 0 AC 1
Xs1_p_4 s1_p_4 0 adc_mim_bank COUNT=16
Vs1_p_5 s1_p_5 0 DC 0 AC 1
Xs1_p_5 s1_p_5 0 adc_mim_bank COUNT=32
Vs1_p_6 s1_p_6 0 DC 0 AC 1
Xs1_p_6 s1_p_6 0 adc_mim_bank COUNT=64
Vs1_p_7 s1_p_7 0 DC 0 AC 1
Xs1_p_7 s1_p_7 0 adc_mim_bank COUNT=128
Vs1_p_8 s1_p_8 0 DC 0 AC 1
Xs1_p_8 s1_p_8 0 adc_mim_bank COUNT=256
Vs1_p_9 s1_p_9 0 DC 0 AC 1
Xs1_p_9 s1_p_9 0 adc_mim_bank COUNT=512
Vs1_p_10 s1_p_10 0 DC 0 AC 1
Xs1_p_10 s1_p_10 0 adc_mim_bank COUNT=1024
Vs1_p_11 s1_p_11 0 DC 0 AC 1
Xs1_p_11 s1_p_11 0 adc_mim_bank COUNT=2048
Vs1_p_12 s1_p_12 0 DC 0 AC 1
Xs1_p_12 s1_p_12 0 adc_mim_bank COUNT=1
Vs1_n_0 s1_n_0 0 DC 0 AC 1
Xs1_n_0 s1_n_0 0 adc_mim_bank COUNT=1
Vs1_n_1 s1_n_1 0 DC 0 AC 1
Xs1_n_1 s1_n_1 0 adc_mim_bank COUNT=2
Vs1_n_2 s1_n_2 0 DC 0 AC 1
Xs1_n_2 s1_n_2 0 adc_mim_bank COUNT=4
Vs1_n_3 s1_n_3 0 DC 0 AC 1
Xs1_n_3 s1_n_3 0 adc_mim_bank COUNT=8
Vs1_n_4 s1_n_4 0 DC 0 AC 1
Xs1_n_4 s1_n_4 0 adc_mim_bank COUNT=16
Vs1_n_5 s1_n_5 0 DC 0 AC 1
Xs1_n_5 s1_n_5 0 adc_mim_bank COUNT=32
Vs1_n_6 s1_n_6 0 DC 0 AC 1
Xs1_n_6 s1_n_6 0 adc_mim_bank COUNT=64
Vs1_n_7 s1_n_7 0 DC 0 AC 1
Xs1_n_7 s1_n_7 0 adc_mim_bank COUNT=128
Vs1_n_8 s1_n_8 0 DC 0 AC 1
Xs1_n_8 s1_n_8 0 adc_mim_bank COUNT=256
Vs1_n_9 s1_n_9 0 DC 0 AC 1
Xs1_n_9 s1_n_9 0 adc_mim_bank COUNT=512
Vs1_n_10 s1_n_10 0 DC 0 AC 1
Xs1_n_10 s1_n_10 0 adc_mim_bank COUNT=1024
Vs1_n_11 s1_n_11 0 DC 0 AC 1
Xs1_n_11 s1_n_11 0 adc_mim_bank COUNT=2048
Vs1_n_12 s1_n_12 0 DC 0 AC 1
Xs1_n_12 s1_n_12 0 adc_mim_bank COUNT=1
Vs2_p_0 s2_p_0 0 DC 0 AC 1
Xs2_p_0 s2_p_0 0 adc_mim_bank COUNT=1
Vs2_p_1 s2_p_1 0 DC 0 AC 1
Xs2_p_1 s2_p_1 0 adc_mim_bank COUNT=2
Vs2_p_2 s2_p_2 0 DC 0 AC 1
Xs2_p_2 s2_p_2 0 adc_mim_bank COUNT=4
Vs2_p_3 s2_p_3 0 DC 0 AC 1
Xs2_p_3 s2_p_3 0 adc_mim_bank COUNT=8
Vs2_p_4 s2_p_4 0 DC 0 AC 1
Xs2_p_4 s2_p_4 0 adc_mim_bank COUNT=16
Vs2_p_5 s2_p_5 0 DC 0 AC 1
Xs2_p_5 s2_p_5 0 adc_mim_bank COUNT=32
Vs2_p_6 s2_p_6 0 DC 0 AC 1
Xs2_p_6 s2_p_6 0 adc_mim_bank COUNT=64
Vs2_p_7 s2_p_7 0 DC 0 AC 1
Xs2_p_7 s2_p_7 0 adc_mim_bank COUNT=128
Vs2_p_8 s2_p_8 0 DC 0 AC 1
Xs2_p_8 s2_p_8 0 adc_mim_bank COUNT=256
Vs2_p_9 s2_p_9 0 DC 0 AC 1
Xs2_p_9 s2_p_9 0 adc_mim_bank COUNT=512
Vs2_p_10 s2_p_10 0 DC 0 AC 1
Xs2_p_10 s2_p_10 0 adc_mim_bank COUNT=1024
Vs2_p_11 s2_p_11 0 DC 0 AC 1
Xs2_p_11 s2_p_11 0 adc_mim_bank COUNT=2048
Vs2_p_12 s2_p_12 0 DC 0 AC 1
Xs2_p_12 s2_p_12 0 adc_mim_bank COUNT=1
Vs2_n_0 s2_n_0 0 DC 0 AC 1
Xs2_n_0 s2_n_0 0 adc_mim_bank COUNT=1
Vs2_n_1 s2_n_1 0 DC 0 AC 1
Xs2_n_1 s2_n_1 0 adc_mim_bank COUNT=2
Vs2_n_2 s2_n_2 0 DC 0 AC 1
Xs2_n_2 s2_n_2 0 adc_mim_bank COUNT=4
Vs2_n_3 s2_n_3 0 DC 0 AC 1
Xs2_n_3 s2_n_3 0 adc_mim_bank COUNT=8
Vs2_n_4 s2_n_4 0 DC 0 AC 1
Xs2_n_4 s2_n_4 0 adc_mim_bank COUNT=16
Vs2_n_5 s2_n_5 0 DC 0 AC 1
Xs2_n_5 s2_n_5 0 adc_mim_bank COUNT=32
Vs2_n_6 s2_n_6 0 DC 0 AC 1
Xs2_n_6 s2_n_6 0 adc_mim_bank COUNT=64
Vs2_n_7 s2_n_7 0 DC 0 AC 1
Xs2_n_7 s2_n_7 0 adc_mim_bank COUNT=128
Vs2_n_8 s2_n_8 0 DC 0 AC 1
Xs2_n_8 s2_n_8 0 adc_mim_bank COUNT=256
Vs2_n_9 s2_n_9 0 DC 0 AC 1
Xs2_n_9 s2_n_9 0 adc_mim_bank COUNT=512
Vs2_n_10 s2_n_10 0 DC 0 AC 1
Xs2_n_10 s2_n_10 0 adc_mim_bank COUNT=1024
Vs2_n_11 s2_n_11 0 DC 0 AC 1
Xs2_n_11 s2_n_11 0 adc_mim_bank COUNT=2048
Vs2_n_12 s2_n_12 0 DC 0 AC 1
Xs2_n_12 s2_n_12 0 adc_mim_bank COUNT=1
Vs3_p_0 s3_p_0 0 DC 0 AC 1
Xs3_p_0 s3_p_0 0 adc_mim_bank COUNT=1
Vs3_p_1 s3_p_1 0 DC 0 AC 1
Xs3_p_1 s3_p_1 0 adc_mim_bank COUNT=2
Vs3_p_2 s3_p_2 0 DC 0 AC 1
Xs3_p_2 s3_p_2 0 adc_mim_bank COUNT=4
Vs3_p_3 s3_p_3 0 DC 0 AC 1
Xs3_p_3 s3_p_3 0 adc_mim_bank COUNT=8
Vs3_p_4 s3_p_4 0 DC 0 AC 1
Xs3_p_4 s3_p_4 0 adc_mim_bank COUNT=16
Vs3_p_5 s3_p_5 0 DC 0 AC 1
Xs3_p_5 s3_p_5 0 adc_mim_bank COUNT=32
Vs3_p_6 s3_p_6 0 DC 0 AC 1
Xs3_p_6 s3_p_6 0 adc_mim_bank COUNT=64
Vs3_p_7 s3_p_7 0 DC 0 AC 1
Xs3_p_7 s3_p_7 0 adc_mim_bank COUNT=128
Vs3_p_8 s3_p_8 0 DC 0 AC 1
Xs3_p_8 s3_p_8 0 adc_mim_bank COUNT=256
Vs3_p_9 s3_p_9 0 DC 0 AC 1
Xs3_p_9 s3_p_9 0 adc_mim_bank COUNT=512
Vs3_p_10 s3_p_10 0 DC 0 AC 1
Xs3_p_10 s3_p_10 0 adc_mim_bank COUNT=1024
Vs3_p_11 s3_p_11 0 DC 0 AC 1
Xs3_p_11 s3_p_11 0 adc_mim_bank COUNT=2048
Vs3_p_12 s3_p_12 0 DC 0 AC 1
Xs3_p_12 s3_p_12 0 adc_mim_bank COUNT=1
Vs3_n_0 s3_n_0 0 DC 0 AC 1
Xs3_n_0 s3_n_0 0 adc_mim_bank COUNT=1
Vs3_n_1 s3_n_1 0 DC 0 AC 1
Xs3_n_1 s3_n_1 0 adc_mim_bank COUNT=2
Vs3_n_2 s3_n_2 0 DC 0 AC 1
Xs3_n_2 s3_n_2 0 adc_mim_bank COUNT=4
Vs3_n_3 s3_n_3 0 DC 0 AC 1
Xs3_n_3 s3_n_3 0 adc_mim_bank COUNT=8
Vs3_n_4 s3_n_4 0 DC 0 AC 1
Xs3_n_4 s3_n_4 0 adc_mim_bank COUNT=16
Vs3_n_5 s3_n_5 0 DC 0 AC 1
Xs3_n_5 s3_n_5 0 adc_mim_bank COUNT=32
Vs3_n_6 s3_n_6 0 DC 0 AC 1
Xs3_n_6 s3_n_6 0 adc_mim_bank COUNT=64
Vs3_n_7 s3_n_7 0 DC 0 AC 1
Xs3_n_7 s3_n_7 0 adc_mim_bank COUNT=128
Vs3_n_8 s3_n_8 0 DC 0 AC 1
Xs3_n_8 s3_n_8 0 adc_mim_bank COUNT=256
Vs3_n_9 s3_n_9 0 DC 0 AC 1
Xs3_n_9 s3_n_9 0 adc_mim_bank COUNT=512
Vs3_n_10 s3_n_10 0 DC 0 AC 1
Xs3_n_10 s3_n_10 0 adc_mim_bank COUNT=1024
Vs3_n_11 s3_n_11 0 DC 0 AC 1
Xs3_n_11 s3_n_11 0 adc_mim_bank COUNT=2048
Vs3_n_12 s3_n_12 0 DC 0 AC 1
Xs3_n_12 s3_n_12 0 adc_mim_bank COUNT=1
Vs4_p_0 s4_p_0 0 DC 0 AC 1
Xs4_p_0 s4_p_0 0 adc_mim_bank COUNT=1
Vs4_p_1 s4_p_1 0 DC 0 AC 1
Xs4_p_1 s4_p_1 0 adc_mim_bank COUNT=2
Vs4_p_2 s4_p_2 0 DC 0 AC 1
Xs4_p_2 s4_p_2 0 adc_mim_bank COUNT=4
Vs4_p_3 s4_p_3 0 DC 0 AC 1
Xs4_p_3 s4_p_3 0 adc_mim_bank COUNT=8
Vs4_p_4 s4_p_4 0 DC 0 AC 1
Xs4_p_4 s4_p_4 0 adc_mim_bank COUNT=16
Vs4_p_5 s4_p_5 0 DC 0 AC 1
Xs4_p_5 s4_p_5 0 adc_mim_bank COUNT=32
Vs4_p_6 s4_p_6 0 DC 0 AC 1
Xs4_p_6 s4_p_6 0 adc_mim_bank COUNT=64
Vs4_p_7 s4_p_7 0 DC 0 AC 1
Xs4_p_7 s4_p_7 0 adc_mim_bank COUNT=128
Vs4_p_8 s4_p_8 0 DC 0 AC 1
Xs4_p_8 s4_p_8 0 adc_mim_bank COUNT=256
Vs4_p_9 s4_p_9 0 DC 0 AC 1
Xs4_p_9 s4_p_9 0 adc_mim_bank COUNT=512
Vs4_p_10 s4_p_10 0 DC 0 AC 1
Xs4_p_10 s4_p_10 0 adc_mim_bank COUNT=1024
Vs4_p_11 s4_p_11 0 DC 0 AC 1
Xs4_p_11 s4_p_11 0 adc_mim_bank COUNT=2048
Vs4_p_12 s4_p_12 0 DC 0 AC 1
Xs4_p_12 s4_p_12 0 adc_mim_bank COUNT=1
Vs4_n_0 s4_n_0 0 DC 0 AC 1
Xs4_n_0 s4_n_0 0 adc_mim_bank COUNT=1
Vs4_n_1 s4_n_1 0 DC 0 AC 1
Xs4_n_1 s4_n_1 0 adc_mim_bank COUNT=2
Vs4_n_2 s4_n_2 0 DC 0 AC 1
Xs4_n_2 s4_n_2 0 adc_mim_bank COUNT=4
Vs4_n_3 s4_n_3 0 DC 0 AC 1
Xs4_n_3 s4_n_3 0 adc_mim_bank COUNT=8
Vs4_n_4 s4_n_4 0 DC 0 AC 1
Xs4_n_4 s4_n_4 0 adc_mim_bank COUNT=16
Vs4_n_5 s4_n_5 0 DC 0 AC 1
Xs4_n_5 s4_n_5 0 adc_mim_bank COUNT=32
Vs4_n_6 s4_n_6 0 DC 0 AC 1
Xs4_n_6 s4_n_6 0 adc_mim_bank COUNT=64
Vs4_n_7 s4_n_7 0 DC 0 AC 1
Xs4_n_7 s4_n_7 0 adc_mim_bank COUNT=128
Vs4_n_8 s4_n_8 0 DC 0 AC 1
Xs4_n_8 s4_n_8 0 adc_mim_bank COUNT=256
Vs4_n_9 s4_n_9 0 DC 0 AC 1
Xs4_n_9 s4_n_9 0 adc_mim_bank COUNT=512
Vs4_n_10 s4_n_10 0 DC 0 AC 1
Xs4_n_10 s4_n_10 0 adc_mim_bank COUNT=1024
Vs4_n_11 s4_n_11 0 DC 0 AC 1
Xs4_n_11 s4_n_11 0 adc_mim_bank COUNT=2048
Vs4_n_12 s4_n_12 0 DC 0 AC 1
Xs4_n_12 s4_n_12 0 adc_mim_bank COUNT=1
Vs5_p_0 s5_p_0 0 DC 0 AC 1
Xs5_p_0 s5_p_0 0 adc_mim_bank COUNT=1
Vs5_p_1 s5_p_1 0 DC 0 AC 1
Xs5_p_1 s5_p_1 0 adc_mim_bank COUNT=2
Vs5_p_2 s5_p_2 0 DC 0 AC 1
Xs5_p_2 s5_p_2 0 adc_mim_bank COUNT=4
Vs5_p_3 s5_p_3 0 DC 0 AC 1
Xs5_p_3 s5_p_3 0 adc_mim_bank COUNT=8
Vs5_p_4 s5_p_4 0 DC 0 AC 1
Xs5_p_4 s5_p_4 0 adc_mim_bank COUNT=16
Vs5_p_5 s5_p_5 0 DC 0 AC 1
Xs5_p_5 s5_p_5 0 adc_mim_bank COUNT=32
Vs5_p_6 s5_p_6 0 DC 0 AC 1
Xs5_p_6 s5_p_6 0 adc_mim_bank COUNT=64
Vs5_p_7 s5_p_7 0 DC 0 AC 1
Xs5_p_7 s5_p_7 0 adc_mim_bank COUNT=128
Vs5_p_8 s5_p_8 0 DC 0 AC 1
Xs5_p_8 s5_p_8 0 adc_mim_bank COUNT=256
Vs5_p_9 s5_p_9 0 DC 0 AC 1
Xs5_p_9 s5_p_9 0 adc_mim_bank COUNT=512
Vs5_p_10 s5_p_10 0 DC 0 AC 1
Xs5_p_10 s5_p_10 0 adc_mim_bank COUNT=1024
Vs5_p_11 s5_p_11 0 DC 0 AC 1
Xs5_p_11 s5_p_11 0 adc_mim_bank COUNT=2048
Vs5_p_12 s5_p_12 0 DC 0 AC 1
Xs5_p_12 s5_p_12 0 adc_mim_bank COUNT=1
Vs5_n_0 s5_n_0 0 DC 0 AC 1
Xs5_n_0 s5_n_0 0 adc_mim_bank COUNT=1
Vs5_n_1 s5_n_1 0 DC 0 AC 1
Xs5_n_1 s5_n_1 0 adc_mim_bank COUNT=2
Vs5_n_2 s5_n_2 0 DC 0 AC 1
Xs5_n_2 s5_n_2 0 adc_mim_bank COUNT=4
Vs5_n_3 s5_n_3 0 DC 0 AC 1
Xs5_n_3 s5_n_3 0 adc_mim_bank COUNT=8
Vs5_n_4 s5_n_4 0 DC 0 AC 1
Xs5_n_4 s5_n_4 0 adc_mim_bank COUNT=16
Vs5_n_5 s5_n_5 0 DC 0 AC 1
Xs5_n_5 s5_n_5 0 adc_mim_bank COUNT=32
Vs5_n_6 s5_n_6 0 DC 0 AC 1
Xs5_n_6 s5_n_6 0 adc_mim_bank COUNT=64
Vs5_n_7 s5_n_7 0 DC 0 AC 1
Xs5_n_7 s5_n_7 0 adc_mim_bank COUNT=128
Vs5_n_8 s5_n_8 0 DC 0 AC 1
Xs5_n_8 s5_n_8 0 adc_mim_bank COUNT=256
Vs5_n_9 s5_n_9 0 DC 0 AC 1
Xs5_n_9 s5_n_9 0 adc_mim_bank COUNT=512
Vs5_n_10 s5_n_10 0 DC 0 AC 1
Xs5_n_10 s5_n_10 0 adc_mim_bank COUNT=1024
Vs5_n_11 s5_n_11 0 DC 0 AC 1
Xs5_n_11 s5_n_11 0 adc_mim_bank COUNT=2048
Vs5_n_12 s5_n_12 0 DC 0 AC 1
Xs5_n_12 s5_n_12 0 adc_mim_bank COUNT=1
Vs6_p_0 s6_p_0 0 DC 0 AC 1
Xs6_p_0 s6_p_0 0 adc_mim_bank COUNT=1
Vs6_p_1 s6_p_1 0 DC 0 AC 1
Xs6_p_1 s6_p_1 0 adc_mim_bank COUNT=2
Vs6_p_2 s6_p_2 0 DC 0 AC 1
Xs6_p_2 s6_p_2 0 adc_mim_bank COUNT=4
Vs6_p_3 s6_p_3 0 DC 0 AC 1
Xs6_p_3 s6_p_3 0 adc_mim_bank COUNT=8
Vs6_p_4 s6_p_4 0 DC 0 AC 1
Xs6_p_4 s6_p_4 0 adc_mim_bank COUNT=16
Vs6_p_5 s6_p_5 0 DC 0 AC 1
Xs6_p_5 s6_p_5 0 adc_mim_bank COUNT=32
Vs6_p_6 s6_p_6 0 DC 0 AC 1
Xs6_p_6 s6_p_6 0 adc_mim_bank COUNT=64
Vs6_p_7 s6_p_7 0 DC 0 AC 1
Xs6_p_7 s6_p_7 0 adc_mim_bank COUNT=128
Vs6_p_8 s6_p_8 0 DC 0 AC 1
Xs6_p_8 s6_p_8 0 adc_mim_bank COUNT=256
Vs6_p_9 s6_p_9 0 DC 0 AC 1
Xs6_p_9 s6_p_9 0 adc_mim_bank COUNT=512
Vs6_p_10 s6_p_10 0 DC 0 AC 1
Xs6_p_10 s6_p_10 0 adc_mim_bank COUNT=1024
Vs6_p_11 s6_p_11 0 DC 0 AC 1
Xs6_p_11 s6_p_11 0 adc_mim_bank COUNT=2048
Vs6_p_12 s6_p_12 0 DC 0 AC 1
Xs6_p_12 s6_p_12 0 adc_mim_bank COUNT=1
Vs6_n_0 s6_n_0 0 DC 0 AC 1
Xs6_n_0 s6_n_0 0 adc_mim_bank COUNT=1
Vs6_n_1 s6_n_1 0 DC 0 AC 1
Xs6_n_1 s6_n_1 0 adc_mim_bank COUNT=2
Vs6_n_2 s6_n_2 0 DC 0 AC 1
Xs6_n_2 s6_n_2 0 adc_mim_bank COUNT=4
Vs6_n_3 s6_n_3 0 DC 0 AC 1
Xs6_n_3 s6_n_3 0 adc_mim_bank COUNT=8
Vs6_n_4 s6_n_4 0 DC 0 AC 1
Xs6_n_4 s6_n_4 0 adc_mim_bank COUNT=16
Vs6_n_5 s6_n_5 0 DC 0 AC 1
Xs6_n_5 s6_n_5 0 adc_mim_bank COUNT=32
Vs6_n_6 s6_n_6 0 DC 0 AC 1
Xs6_n_6 s6_n_6 0 adc_mim_bank COUNT=64
Vs6_n_7 s6_n_7 0 DC 0 AC 1
Xs6_n_7 s6_n_7 0 adc_mim_bank COUNT=128
Vs6_n_8 s6_n_8 0 DC 0 AC 1
Xs6_n_8 s6_n_8 0 adc_mim_bank COUNT=256
Vs6_n_9 s6_n_9 0 DC 0 AC 1
Xs6_n_9 s6_n_9 0 adc_mim_bank COUNT=512
Vs6_n_10 s6_n_10 0 DC 0 AC 1
Xs6_n_10 s6_n_10 0 adc_mim_bank COUNT=1024
Vs6_n_11 s6_n_11 0 DC 0 AC 1
Xs6_n_11 s6_n_11 0 adc_mim_bank COUNT=2048
Vs6_n_12 s6_n_12 0 DC 0 AC 1
Xs6_n_12 s6_n_12 0 adc_mim_bank COUNT=1
Vs7_p_0 s7_p_0 0 DC 0 AC 1
Xs7_p_0 s7_p_0 0 adc_mim_bank COUNT=1
Vs7_p_1 s7_p_1 0 DC 0 AC 1
Xs7_p_1 s7_p_1 0 adc_mim_bank COUNT=2
Vs7_p_2 s7_p_2 0 DC 0 AC 1
Xs7_p_2 s7_p_2 0 adc_mim_bank COUNT=4
Vs7_p_3 s7_p_3 0 DC 0 AC 1
Xs7_p_3 s7_p_3 0 adc_mim_bank COUNT=8
Vs7_p_4 s7_p_4 0 DC 0 AC 1
Xs7_p_4 s7_p_4 0 adc_mim_bank COUNT=16
Vs7_p_5 s7_p_5 0 DC 0 AC 1
Xs7_p_5 s7_p_5 0 adc_mim_bank COUNT=32
Vs7_p_6 s7_p_6 0 DC 0 AC 1
Xs7_p_6 s7_p_6 0 adc_mim_bank COUNT=64
Vs7_p_7 s7_p_7 0 DC 0 AC 1
Xs7_p_7 s7_p_7 0 adc_mim_bank COUNT=128
Vs7_p_8 s7_p_8 0 DC 0 AC 1
Xs7_p_8 s7_p_8 0 adc_mim_bank COUNT=256
Vs7_p_9 s7_p_9 0 DC 0 AC 1
Xs7_p_9 s7_p_9 0 adc_mim_bank COUNT=512
Vs7_p_10 s7_p_10 0 DC 0 AC 1
Xs7_p_10 s7_p_10 0 adc_mim_bank COUNT=1024
Vs7_p_11 s7_p_11 0 DC 0 AC 1
Xs7_p_11 s7_p_11 0 adc_mim_bank COUNT=2048
Vs7_p_12 s7_p_12 0 DC 0 AC 1
Xs7_p_12 s7_p_12 0 adc_mim_bank COUNT=1
Vs7_n_0 s7_n_0 0 DC 0 AC 1
Xs7_n_0 s7_n_0 0 adc_mim_bank COUNT=1
Vs7_n_1 s7_n_1 0 DC 0 AC 1
Xs7_n_1 s7_n_1 0 adc_mim_bank COUNT=2
Vs7_n_2 s7_n_2 0 DC 0 AC 1
Xs7_n_2 s7_n_2 0 adc_mim_bank COUNT=4
Vs7_n_3 s7_n_3 0 DC 0 AC 1
Xs7_n_3 s7_n_3 0 adc_mim_bank COUNT=8
Vs7_n_4 s7_n_4 0 DC 0 AC 1
Xs7_n_4 s7_n_4 0 adc_mim_bank COUNT=16
Vs7_n_5 s7_n_5 0 DC 0 AC 1
Xs7_n_5 s7_n_5 0 adc_mim_bank COUNT=32
Vs7_n_6 s7_n_6 0 DC 0 AC 1
Xs7_n_6 s7_n_6 0 adc_mim_bank COUNT=64
Vs7_n_7 s7_n_7 0 DC 0 AC 1
Xs7_n_7 s7_n_7 0 adc_mim_bank COUNT=128
Vs7_n_8 s7_n_8 0 DC 0 AC 1
Xs7_n_8 s7_n_8 0 adc_mim_bank COUNT=256
Vs7_n_9 s7_n_9 0 DC 0 AC 1
Xs7_n_9 s7_n_9 0 adc_mim_bank COUNT=512
Vs7_n_10 s7_n_10 0 DC 0 AC 1
Xs7_n_10 s7_n_10 0 adc_mim_bank COUNT=1024
Vs7_n_11 s7_n_11 0 DC 0 AC 1
Xs7_n_11 s7_n_11 0 adc_mim_bank COUNT=2048
Vs7_n_12 s7_n_12 0 DC 0 AC 1
Xs7_n_12 s7_n_12 0 adc_mim_bank COUNT=1
Vs8_p_0 s8_p_0 0 DC 0 AC 1
Xs8_p_0 s8_p_0 0 adc_mim_bank COUNT=1
Vs8_p_1 s8_p_1 0 DC 0 AC 1
Xs8_p_1 s8_p_1 0 adc_mim_bank COUNT=2
Vs8_p_2 s8_p_2 0 DC 0 AC 1
Xs8_p_2 s8_p_2 0 adc_mim_bank COUNT=4
Vs8_p_3 s8_p_3 0 DC 0 AC 1
Xs8_p_3 s8_p_3 0 adc_mim_bank COUNT=8
Vs8_p_4 s8_p_4 0 DC 0 AC 1
Xs8_p_4 s8_p_4 0 adc_mim_bank COUNT=16
Vs8_p_5 s8_p_5 0 DC 0 AC 1
Xs8_p_5 s8_p_5 0 adc_mim_bank COUNT=32
Vs8_p_6 s8_p_6 0 DC 0 AC 1
Xs8_p_6 s8_p_6 0 adc_mim_bank COUNT=64
Vs8_p_7 s8_p_7 0 DC 0 AC 1
Xs8_p_7 s8_p_7 0 adc_mim_bank COUNT=128
Vs8_p_8 s8_p_8 0 DC 0 AC 1
Xs8_p_8 s8_p_8 0 adc_mim_bank COUNT=256
Vs8_p_9 s8_p_9 0 DC 0 AC 1
Xs8_p_9 s8_p_9 0 adc_mim_bank COUNT=512
Vs8_p_10 s8_p_10 0 DC 0 AC 1
Xs8_p_10 s8_p_10 0 adc_mim_bank COUNT=1024
Vs8_p_11 s8_p_11 0 DC 0 AC 1
Xs8_p_11 s8_p_11 0 adc_mim_bank COUNT=2048
Vs8_p_12 s8_p_12 0 DC 0 AC 1
Xs8_p_12 s8_p_12 0 adc_mim_bank COUNT=1
Vs8_n_0 s8_n_0 0 DC 0 AC 1
Xs8_n_0 s8_n_0 0 adc_mim_bank COUNT=1
Vs8_n_1 s8_n_1 0 DC 0 AC 1
Xs8_n_1 s8_n_1 0 adc_mim_bank COUNT=2
Vs8_n_2 s8_n_2 0 DC 0 AC 1
Xs8_n_2 s8_n_2 0 adc_mim_bank COUNT=4
Vs8_n_3 s8_n_3 0 DC 0 AC 1
Xs8_n_3 s8_n_3 0 adc_mim_bank COUNT=8
Vs8_n_4 s8_n_4 0 DC 0 AC 1
Xs8_n_4 s8_n_4 0 adc_mim_bank COUNT=16
Vs8_n_5 s8_n_5 0 DC 0 AC 1
Xs8_n_5 s8_n_5 0 adc_mim_bank COUNT=32
Vs8_n_6 s8_n_6 0 DC 0 AC 1
Xs8_n_6 s8_n_6 0 adc_mim_bank COUNT=64
Vs8_n_7 s8_n_7 0 DC 0 AC 1
Xs8_n_7 s8_n_7 0 adc_mim_bank COUNT=128
Vs8_n_8 s8_n_8 0 DC 0 AC 1
Xs8_n_8 s8_n_8 0 adc_mim_bank COUNT=256
Vs8_n_9 s8_n_9 0 DC 0 AC 1
Xs8_n_9 s8_n_9 0 adc_mim_bank COUNT=512
Vs8_n_10 s8_n_10 0 DC 0 AC 1
Xs8_n_10 s8_n_10 0 adc_mim_bank COUNT=1024
Vs8_n_11 s8_n_11 0 DC 0 AC 1
Xs8_n_11 s8_n_11 0 adc_mim_bank COUNT=2048
Vs8_n_12 s8_n_12 0 DC 0 AC 1
Xs8_n_12 s8_n_12 0 adc_mim_bank COUNT=1
Vs9_p_0 s9_p_0 0 DC 0 AC 1
Xs9_p_0 s9_p_0 0 adc_mim_bank COUNT=1
Vs9_p_1 s9_p_1 0 DC 0 AC 1
Xs9_p_1 s9_p_1 0 adc_mim_bank COUNT=2
Vs9_p_2 s9_p_2 0 DC 0 AC 1
Xs9_p_2 s9_p_2 0 adc_mim_bank COUNT=4
Vs9_p_3 s9_p_3 0 DC 0 AC 1
Xs9_p_3 s9_p_3 0 adc_mim_bank COUNT=8
Vs9_p_4 s9_p_4 0 DC 0 AC 1
Xs9_p_4 s9_p_4 0 adc_mim_bank COUNT=16
Vs9_p_5 s9_p_5 0 DC 0 AC 1
Xs9_p_5 s9_p_5 0 adc_mim_bank COUNT=32
Vs9_p_6 s9_p_6 0 DC 0 AC 1
Xs9_p_6 s9_p_6 0 adc_mim_bank COUNT=64
Vs9_p_7 s9_p_7 0 DC 0 AC 1
Xs9_p_7 s9_p_7 0 adc_mim_bank COUNT=128
Vs9_p_8 s9_p_8 0 DC 0 AC 1
Xs9_p_8 s9_p_8 0 adc_mim_bank COUNT=256
Vs9_p_9 s9_p_9 0 DC 0 AC 1
Xs9_p_9 s9_p_9 0 adc_mim_bank COUNT=512
Vs9_p_10 s9_p_10 0 DC 0 AC 1
Xs9_p_10 s9_p_10 0 adc_mim_bank COUNT=1024
Vs9_p_11 s9_p_11 0 DC 0 AC 1
Xs9_p_11 s9_p_11 0 adc_mim_bank COUNT=2048
Vs9_p_12 s9_p_12 0 DC 0 AC 1
Xs9_p_12 s9_p_12 0 adc_mim_bank COUNT=1
Vs9_n_0 s9_n_0 0 DC 0 AC 1
Xs9_n_0 s9_n_0 0 adc_mim_bank COUNT=1
Vs9_n_1 s9_n_1 0 DC 0 AC 1
Xs9_n_1 s9_n_1 0 adc_mim_bank COUNT=2
Vs9_n_2 s9_n_2 0 DC 0 AC 1
Xs9_n_2 s9_n_2 0 adc_mim_bank COUNT=4
Vs9_n_3 s9_n_3 0 DC 0 AC 1
Xs9_n_3 s9_n_3 0 adc_mim_bank COUNT=8
Vs9_n_4 s9_n_4 0 DC 0 AC 1
Xs9_n_4 s9_n_4 0 adc_mim_bank COUNT=16
Vs9_n_5 s9_n_5 0 DC 0 AC 1
Xs9_n_5 s9_n_5 0 adc_mim_bank COUNT=32
Vs9_n_6 s9_n_6 0 DC 0 AC 1
Xs9_n_6 s9_n_6 0 adc_mim_bank COUNT=64
Vs9_n_7 s9_n_7 0 DC 0 AC 1
Xs9_n_7 s9_n_7 0 adc_mim_bank COUNT=128
Vs9_n_8 s9_n_8 0 DC 0 AC 1
Xs9_n_8 s9_n_8 0 adc_mim_bank COUNT=256
Vs9_n_9 s9_n_9 0 DC 0 AC 1
Xs9_n_9 s9_n_9 0 adc_mim_bank COUNT=512
Vs9_n_10 s9_n_10 0 DC 0 AC 1
Xs9_n_10 s9_n_10 0 adc_mim_bank COUNT=1024
Vs9_n_11 s9_n_11 0 DC 0 AC 1
Xs9_n_11 s9_n_11 0 adc_mim_bank COUNT=2048
Vs9_n_12 s9_n_12 0 DC 0 AC 1
Xs9_n_12 s9_n_12 0 adc_mim_bank COUNT=1
Vs10_p_0 s10_p_0 0 DC 0 AC 1
Xs10_p_0 s10_p_0 0 adc_mim_bank COUNT=1
Vs10_p_1 s10_p_1 0 DC 0 AC 1
Xs10_p_1 s10_p_1 0 adc_mim_bank COUNT=2
Vs10_p_2 s10_p_2 0 DC 0 AC 1
Xs10_p_2 s10_p_2 0 adc_mim_bank COUNT=4
Vs10_p_3 s10_p_3 0 DC 0 AC 1
Xs10_p_3 s10_p_3 0 adc_mim_bank COUNT=8
Vs10_p_4 s10_p_4 0 DC 0 AC 1
Xs10_p_4 s10_p_4 0 adc_mim_bank COUNT=16
Vs10_p_5 s10_p_5 0 DC 0 AC 1
Xs10_p_5 s10_p_5 0 adc_mim_bank COUNT=32
Vs10_p_6 s10_p_6 0 DC 0 AC 1
Xs10_p_6 s10_p_6 0 adc_mim_bank COUNT=64
Vs10_p_7 s10_p_7 0 DC 0 AC 1
Xs10_p_7 s10_p_7 0 adc_mim_bank COUNT=128
Vs10_p_8 s10_p_8 0 DC 0 AC 1
Xs10_p_8 s10_p_8 0 adc_mim_bank COUNT=256
Vs10_p_9 s10_p_9 0 DC 0 AC 1
Xs10_p_9 s10_p_9 0 adc_mim_bank COUNT=512
Vs10_p_10 s10_p_10 0 DC 0 AC 1
Xs10_p_10 s10_p_10 0 adc_mim_bank COUNT=1024
Vs10_p_11 s10_p_11 0 DC 0 AC 1
Xs10_p_11 s10_p_11 0 adc_mim_bank COUNT=2048
Vs10_p_12 s10_p_12 0 DC 0 AC 1
Xs10_p_12 s10_p_12 0 adc_mim_bank COUNT=1
Vs10_n_0 s10_n_0 0 DC 0 AC 1
Xs10_n_0 s10_n_0 0 adc_mim_bank COUNT=1
Vs10_n_1 s10_n_1 0 DC 0 AC 1
Xs10_n_1 s10_n_1 0 adc_mim_bank COUNT=2
Vs10_n_2 s10_n_2 0 DC 0 AC 1
Xs10_n_2 s10_n_2 0 adc_mim_bank COUNT=4
Vs10_n_3 s10_n_3 0 DC 0 AC 1
Xs10_n_3 s10_n_3 0 adc_mim_bank COUNT=8
Vs10_n_4 s10_n_4 0 DC 0 AC 1
Xs10_n_4 s10_n_4 0 adc_mim_bank COUNT=16
Vs10_n_5 s10_n_5 0 DC 0 AC 1
Xs10_n_5 s10_n_5 0 adc_mim_bank COUNT=32
Vs10_n_6 s10_n_6 0 DC 0 AC 1
Xs10_n_6 s10_n_6 0 adc_mim_bank COUNT=64
Vs10_n_7 s10_n_7 0 DC 0 AC 1
Xs10_n_7 s10_n_7 0 adc_mim_bank COUNT=128
Vs10_n_8 s10_n_8 0 DC 0 AC 1
Xs10_n_8 s10_n_8 0 adc_mim_bank COUNT=256
Vs10_n_9 s10_n_9 0 DC 0 AC 1
Xs10_n_9 s10_n_9 0 adc_mim_bank COUNT=512
Vs10_n_10 s10_n_10 0 DC 0 AC 1
Xs10_n_10 s10_n_10 0 adc_mim_bank COUNT=1024
Vs10_n_11 s10_n_11 0 DC 0 AC 1
Xs10_n_11 s10_n_11 0 adc_mim_bank COUNT=2048
Vs10_n_12 s10_n_12 0 DC 0 AC 1
Xs10_n_12 s10_n_12 0 adc_mim_bank COUNT=1
Vs11_p_0 s11_p_0 0 DC 0 AC 1
Xs11_p_0 s11_p_0 0 adc_mim_bank COUNT=1
Vs11_p_1 s11_p_1 0 DC 0 AC 1
Xs11_p_1 s11_p_1 0 adc_mim_bank COUNT=2
Vs11_p_2 s11_p_2 0 DC 0 AC 1
Xs11_p_2 s11_p_2 0 adc_mim_bank COUNT=4
Vs11_p_3 s11_p_3 0 DC 0 AC 1
Xs11_p_3 s11_p_3 0 adc_mim_bank COUNT=8
Vs11_p_4 s11_p_4 0 DC 0 AC 1
Xs11_p_4 s11_p_4 0 adc_mim_bank COUNT=16
Vs11_p_5 s11_p_5 0 DC 0 AC 1
Xs11_p_5 s11_p_5 0 adc_mim_bank COUNT=32
Vs11_p_6 s11_p_6 0 DC 0 AC 1
Xs11_p_6 s11_p_6 0 adc_mim_bank COUNT=64
Vs11_p_7 s11_p_7 0 DC 0 AC 1
Xs11_p_7 s11_p_7 0 adc_mim_bank COUNT=128
Vs11_p_8 s11_p_8 0 DC 0 AC 1
Xs11_p_8 s11_p_8 0 adc_mim_bank COUNT=256
Vs11_p_9 s11_p_9 0 DC 0 AC 1
Xs11_p_9 s11_p_9 0 adc_mim_bank COUNT=512
Vs11_p_10 s11_p_10 0 DC 0 AC 1
Xs11_p_10 s11_p_10 0 adc_mim_bank COUNT=1024
Vs11_p_11 s11_p_11 0 DC 0 AC 1
Xs11_p_11 s11_p_11 0 adc_mim_bank COUNT=2048
Vs11_p_12 s11_p_12 0 DC 0 AC 1
Xs11_p_12 s11_p_12 0 adc_mim_bank COUNT=1
Vs11_n_0 s11_n_0 0 DC 0 AC 1
Xs11_n_0 s11_n_0 0 adc_mim_bank COUNT=1
Vs11_n_1 s11_n_1 0 DC 0 AC 1
Xs11_n_1 s11_n_1 0 adc_mim_bank COUNT=2
Vs11_n_2 s11_n_2 0 DC 0 AC 1
Xs11_n_2 s11_n_2 0 adc_mim_bank COUNT=4
Vs11_n_3 s11_n_3 0 DC 0 AC 1
Xs11_n_3 s11_n_3 0 adc_mim_bank COUNT=8
Vs11_n_4 s11_n_4 0 DC 0 AC 1
Xs11_n_4 s11_n_4 0 adc_mim_bank COUNT=16
Vs11_n_5 s11_n_5 0 DC 0 AC 1
Xs11_n_5 s11_n_5 0 adc_mim_bank COUNT=32
Vs11_n_6 s11_n_6 0 DC 0 AC 1
Xs11_n_6 s11_n_6 0 adc_mim_bank COUNT=64
Vs11_n_7 s11_n_7 0 DC 0 AC 1
Xs11_n_7 s11_n_7 0 adc_mim_bank COUNT=128
Vs11_n_8 s11_n_8 0 DC 0 AC 1
Xs11_n_8 s11_n_8 0 adc_mim_bank COUNT=256
Vs11_n_9 s11_n_9 0 DC 0 AC 1
Xs11_n_9 s11_n_9 0 adc_mim_bank COUNT=512
Vs11_n_10 s11_n_10 0 DC 0 AC 1
Xs11_n_10 s11_n_10 0 adc_mim_bank COUNT=1024
Vs11_n_11 s11_n_11 0 DC 0 AC 1
Xs11_n_11 s11_n_11 0 adc_mim_bank COUNT=2048
Vs11_n_12 s11_n_12 0 DC 0 AC 1
Xs11_n_12 s11_n_12 0 adc_mim_bank COUNT=1
Vs12_p_0 s12_p_0 0 DC 0 AC 1
Xs12_p_0 s12_p_0 0 adc_mim_bank COUNT=1
Vs12_p_1 s12_p_1 0 DC 0 AC 1
Xs12_p_1 s12_p_1 0 adc_mim_bank COUNT=2
Vs12_p_2 s12_p_2 0 DC 0 AC 1
Xs12_p_2 s12_p_2 0 adc_mim_bank COUNT=4
Vs12_p_3 s12_p_3 0 DC 0 AC 1
Xs12_p_3 s12_p_3 0 adc_mim_bank COUNT=8
Vs12_p_4 s12_p_4 0 DC 0 AC 1
Xs12_p_4 s12_p_4 0 adc_mim_bank COUNT=16
Vs12_p_5 s12_p_5 0 DC 0 AC 1
Xs12_p_5 s12_p_5 0 adc_mim_bank COUNT=32
Vs12_p_6 s12_p_6 0 DC 0 AC 1
Xs12_p_6 s12_p_6 0 adc_mim_bank COUNT=64
Vs12_p_7 s12_p_7 0 DC 0 AC 1
Xs12_p_7 s12_p_7 0 adc_mim_bank COUNT=128
Vs12_p_8 s12_p_8 0 DC 0 AC 1
Xs12_p_8 s12_p_8 0 adc_mim_bank COUNT=256
Vs12_p_9 s12_p_9 0 DC 0 AC 1
Xs12_p_9 s12_p_9 0 adc_mim_bank COUNT=512
Vs12_p_10 s12_p_10 0 DC 0 AC 1
Xs12_p_10 s12_p_10 0 adc_mim_bank COUNT=1024
Vs12_p_11 s12_p_11 0 DC 0 AC 1
Xs12_p_11 s12_p_11 0 adc_mim_bank COUNT=2048
Vs12_p_12 s12_p_12 0 DC 0 AC 1
Xs12_p_12 s12_p_12 0 adc_mim_bank COUNT=1
Vs12_n_0 s12_n_0 0 DC 0 AC 1
Xs12_n_0 s12_n_0 0 adc_mim_bank COUNT=1
Vs12_n_1 s12_n_1 0 DC 0 AC 1
Xs12_n_1 s12_n_1 0 adc_mim_bank COUNT=2
Vs12_n_2 s12_n_2 0 DC 0 AC 1
Xs12_n_2 s12_n_2 0 adc_mim_bank COUNT=4
Vs12_n_3 s12_n_3 0 DC 0 AC 1
Xs12_n_3 s12_n_3 0 adc_mim_bank COUNT=8
Vs12_n_4 s12_n_4 0 DC 0 AC 1
Xs12_n_4 s12_n_4 0 adc_mim_bank COUNT=16
Vs12_n_5 s12_n_5 0 DC 0 AC 1
Xs12_n_5 s12_n_5 0 adc_mim_bank COUNT=32
Vs12_n_6 s12_n_6 0 DC 0 AC 1
Xs12_n_6 s12_n_6 0 adc_mim_bank COUNT=64
Vs12_n_7 s12_n_7 0 DC 0 AC 1
Xs12_n_7 s12_n_7 0 adc_mim_bank COUNT=128
Vs12_n_8 s12_n_8 0 DC 0 AC 1
Xs12_n_8 s12_n_8 0 adc_mim_bank COUNT=256
Vs12_n_9 s12_n_9 0 DC 0 AC 1
Xs12_n_9 s12_n_9 0 adc_mim_bank COUNT=512
Vs12_n_10 s12_n_10 0 DC 0 AC 1
Xs12_n_10 s12_n_10 0 adc_mim_bank COUNT=1024
Vs12_n_11 s12_n_11 0 DC 0 AC 1
Xs12_n_11 s12_n_11 0 adc_mim_bank COUNT=2048
Vs12_n_12 s12_n_12 0 DC 0 AC 1
Xs12_n_12 s12_n_12 0 adc_mim_bank COUNT=1
Vs13_p_0 s13_p_0 0 DC 0 AC 1
Xs13_p_0 s13_p_0 0 adc_mim_bank COUNT=1
Vs13_p_1 s13_p_1 0 DC 0 AC 1
Xs13_p_1 s13_p_1 0 adc_mim_bank COUNT=2
Vs13_p_2 s13_p_2 0 DC 0 AC 1
Xs13_p_2 s13_p_2 0 adc_mim_bank COUNT=4
Vs13_p_3 s13_p_3 0 DC 0 AC 1
Xs13_p_3 s13_p_3 0 adc_mim_bank COUNT=8
Vs13_p_4 s13_p_4 0 DC 0 AC 1
Xs13_p_4 s13_p_4 0 adc_mim_bank COUNT=16
Vs13_p_5 s13_p_5 0 DC 0 AC 1
Xs13_p_5 s13_p_5 0 adc_mim_bank COUNT=32
Vs13_p_6 s13_p_6 0 DC 0 AC 1
Xs13_p_6 s13_p_6 0 adc_mim_bank COUNT=64
Vs13_p_7 s13_p_7 0 DC 0 AC 1
Xs13_p_7 s13_p_7 0 adc_mim_bank COUNT=128
Vs13_p_8 s13_p_8 0 DC 0 AC 1
Xs13_p_8 s13_p_8 0 adc_mim_bank COUNT=256
Vs13_p_9 s13_p_9 0 DC 0 AC 1
Xs13_p_9 s13_p_9 0 adc_mim_bank COUNT=512
Vs13_p_10 s13_p_10 0 DC 0 AC 1
Xs13_p_10 s13_p_10 0 adc_mim_bank COUNT=1024
Vs13_p_11 s13_p_11 0 DC 0 AC 1
Xs13_p_11 s13_p_11 0 adc_mim_bank COUNT=2048
Vs13_p_12 s13_p_12 0 DC 0 AC 1
Xs13_p_12 s13_p_12 0 adc_mim_bank COUNT=1
Vs13_n_0 s13_n_0 0 DC 0 AC 1
Xs13_n_0 s13_n_0 0 adc_mim_bank COUNT=1
Vs13_n_1 s13_n_1 0 DC 0 AC 1
Xs13_n_1 s13_n_1 0 adc_mim_bank COUNT=2
Vs13_n_2 s13_n_2 0 DC 0 AC 1
Xs13_n_2 s13_n_2 0 adc_mim_bank COUNT=4
Vs13_n_3 s13_n_3 0 DC 0 AC 1
Xs13_n_3 s13_n_3 0 adc_mim_bank COUNT=8
Vs13_n_4 s13_n_4 0 DC 0 AC 1
Xs13_n_4 s13_n_4 0 adc_mim_bank COUNT=16
Vs13_n_5 s13_n_5 0 DC 0 AC 1
Xs13_n_5 s13_n_5 0 adc_mim_bank COUNT=32
Vs13_n_6 s13_n_6 0 DC 0 AC 1
Xs13_n_6 s13_n_6 0 adc_mim_bank COUNT=64
Vs13_n_7 s13_n_7 0 DC 0 AC 1
Xs13_n_7 s13_n_7 0 adc_mim_bank COUNT=128
Vs13_n_8 s13_n_8 0 DC 0 AC 1
Xs13_n_8 s13_n_8 0 adc_mim_bank COUNT=256
Vs13_n_9 s13_n_9 0 DC 0 AC 1
Xs13_n_9 s13_n_9 0 adc_mim_bank COUNT=512
Vs13_n_10 s13_n_10 0 DC 0 AC 1
Xs13_n_10 s13_n_10 0 adc_mim_bank COUNT=1024
Vs13_n_11 s13_n_11 0 DC 0 AC 1
Xs13_n_11 s13_n_11 0 adc_mim_bank COUNT=2048
Vs13_n_12 s13_n_12 0 DC 0 AC 1
Xs13_n_12 s13_n_12 0 adc_mim_bank COUNT=1
Vs14_p_0 s14_p_0 0 DC 0 AC 1
Xs14_p_0 s14_p_0 0 adc_mim_bank COUNT=1
Vs14_p_1 s14_p_1 0 DC 0 AC 1
Xs14_p_1 s14_p_1 0 adc_mim_bank COUNT=2
Vs14_p_2 s14_p_2 0 DC 0 AC 1
Xs14_p_2 s14_p_2 0 adc_mim_bank COUNT=4
Vs14_p_3 s14_p_3 0 DC 0 AC 1
Xs14_p_3 s14_p_3 0 adc_mim_bank COUNT=8
Vs14_p_4 s14_p_4 0 DC 0 AC 1
Xs14_p_4 s14_p_4 0 adc_mim_bank COUNT=16
Vs14_p_5 s14_p_5 0 DC 0 AC 1
Xs14_p_5 s14_p_5 0 adc_mim_bank COUNT=32
Vs14_p_6 s14_p_6 0 DC 0 AC 1
Xs14_p_6 s14_p_6 0 adc_mim_bank COUNT=64
Vs14_p_7 s14_p_7 0 DC 0 AC 1
Xs14_p_7 s14_p_7 0 adc_mim_bank COUNT=128
Vs14_p_8 s14_p_8 0 DC 0 AC 1
Xs14_p_8 s14_p_8 0 adc_mim_bank COUNT=256
Vs14_p_9 s14_p_9 0 DC 0 AC 1
Xs14_p_9 s14_p_9 0 adc_mim_bank COUNT=512
Vs14_p_10 s14_p_10 0 DC 0 AC 1
Xs14_p_10 s14_p_10 0 adc_mim_bank COUNT=1024
Vs14_p_11 s14_p_11 0 DC 0 AC 1
Xs14_p_11 s14_p_11 0 adc_mim_bank COUNT=2048
Vs14_p_12 s14_p_12 0 DC 0 AC 1
Xs14_p_12 s14_p_12 0 adc_mim_bank COUNT=1
Vs14_n_0 s14_n_0 0 DC 0 AC 1
Xs14_n_0 s14_n_0 0 adc_mim_bank COUNT=1
Vs14_n_1 s14_n_1 0 DC 0 AC 1
Xs14_n_1 s14_n_1 0 adc_mim_bank COUNT=2
Vs14_n_2 s14_n_2 0 DC 0 AC 1
Xs14_n_2 s14_n_2 0 adc_mim_bank COUNT=4
Vs14_n_3 s14_n_3 0 DC 0 AC 1
Xs14_n_3 s14_n_3 0 adc_mim_bank COUNT=8
Vs14_n_4 s14_n_4 0 DC 0 AC 1
Xs14_n_4 s14_n_4 0 adc_mim_bank COUNT=16
Vs14_n_5 s14_n_5 0 DC 0 AC 1
Xs14_n_5 s14_n_5 0 adc_mim_bank COUNT=32
Vs14_n_6 s14_n_6 0 DC 0 AC 1
Xs14_n_6 s14_n_6 0 adc_mim_bank COUNT=64
Vs14_n_7 s14_n_7 0 DC 0 AC 1
Xs14_n_7 s14_n_7 0 adc_mim_bank COUNT=128
Vs14_n_8 s14_n_8 0 DC 0 AC 1
Xs14_n_8 s14_n_8 0 adc_mim_bank COUNT=256
Vs14_n_9 s14_n_9 0 DC 0 AC 1
Xs14_n_9 s14_n_9 0 adc_mim_bank COUNT=512
Vs14_n_10 s14_n_10 0 DC 0 AC 1
Xs14_n_10 s14_n_10 0 adc_mim_bank COUNT=1024
Vs14_n_11 s14_n_11 0 DC 0 AC 1
Xs14_n_11 s14_n_11 0 adc_mim_bank COUNT=2048
Vs14_n_12 s14_n_12 0 DC 0 AC 1
Xs14_n_12 s14_n_12 0 adc_mim_bank COUNT=1
Vs15_p_0 s15_p_0 0 DC 0 AC 1
Xs15_p_0 s15_p_0 0 adc_mim_bank COUNT=1
Vs15_p_1 s15_p_1 0 DC 0 AC 1
Xs15_p_1 s15_p_1 0 adc_mim_bank COUNT=2
Vs15_p_2 s15_p_2 0 DC 0 AC 1
Xs15_p_2 s15_p_2 0 adc_mim_bank COUNT=4
Vs15_p_3 s15_p_3 0 DC 0 AC 1
Xs15_p_3 s15_p_3 0 adc_mim_bank COUNT=8
Vs15_p_4 s15_p_4 0 DC 0 AC 1
Xs15_p_4 s15_p_4 0 adc_mim_bank COUNT=16
Vs15_p_5 s15_p_5 0 DC 0 AC 1
Xs15_p_5 s15_p_5 0 adc_mim_bank COUNT=32
Vs15_p_6 s15_p_6 0 DC 0 AC 1
Xs15_p_6 s15_p_6 0 adc_mim_bank COUNT=64
Vs15_p_7 s15_p_7 0 DC 0 AC 1
Xs15_p_7 s15_p_7 0 adc_mim_bank COUNT=128
Vs15_p_8 s15_p_8 0 DC 0 AC 1
Xs15_p_8 s15_p_8 0 adc_mim_bank COUNT=256
Vs15_p_9 s15_p_9 0 DC 0 AC 1
Xs15_p_9 s15_p_9 0 adc_mim_bank COUNT=512
Vs15_p_10 s15_p_10 0 DC 0 AC 1
Xs15_p_10 s15_p_10 0 adc_mim_bank COUNT=1024
Vs15_p_11 s15_p_11 0 DC 0 AC 1
Xs15_p_11 s15_p_11 0 adc_mim_bank COUNT=2048
Vs15_p_12 s15_p_12 0 DC 0 AC 1
Xs15_p_12 s15_p_12 0 adc_mim_bank COUNT=1
Vs15_n_0 s15_n_0 0 DC 0 AC 1
Xs15_n_0 s15_n_0 0 adc_mim_bank COUNT=1
Vs15_n_1 s15_n_1 0 DC 0 AC 1
Xs15_n_1 s15_n_1 0 adc_mim_bank COUNT=2
Vs15_n_2 s15_n_2 0 DC 0 AC 1
Xs15_n_2 s15_n_2 0 adc_mim_bank COUNT=4
Vs15_n_3 s15_n_3 0 DC 0 AC 1
Xs15_n_3 s15_n_3 0 adc_mim_bank COUNT=8
Vs15_n_4 s15_n_4 0 DC 0 AC 1
Xs15_n_4 s15_n_4 0 adc_mim_bank COUNT=16
Vs15_n_5 s15_n_5 0 DC 0 AC 1
Xs15_n_5 s15_n_5 0 adc_mim_bank COUNT=32
Vs15_n_6 s15_n_6 0 DC 0 AC 1
Xs15_n_6 s15_n_6 0 adc_mim_bank COUNT=64
Vs15_n_7 s15_n_7 0 DC 0 AC 1
Xs15_n_7 s15_n_7 0 adc_mim_bank COUNT=128
Vs15_n_8 s15_n_8 0 DC 0 AC 1
Xs15_n_8 s15_n_8 0 adc_mim_bank COUNT=256
Vs15_n_9 s15_n_9 0 DC 0 AC 1
Xs15_n_9 s15_n_9 0 adc_mim_bank COUNT=512
Vs15_n_10 s15_n_10 0 DC 0 AC 1
Xs15_n_10 s15_n_10 0 adc_mim_bank COUNT=1024
Vs15_n_11 s15_n_11 0 DC 0 AC 1
Xs15_n_11 s15_n_11 0 adc_mim_bank COUNT=2048
Vs15_n_12 s15_n_12 0 DC 0 AC 1
Xs15_n_12 s15_n_12 0 adc_mim_bank COUNT=1
Vs16_p_0 s16_p_0 0 DC 0 AC 1
Xs16_p_0 s16_p_0 0 adc_mim_bank COUNT=1
Vs16_p_1 s16_p_1 0 DC 0 AC 1
Xs16_p_1 s16_p_1 0 adc_mim_bank COUNT=2
Vs16_p_2 s16_p_2 0 DC 0 AC 1
Xs16_p_2 s16_p_2 0 adc_mim_bank COUNT=4
Vs16_p_3 s16_p_3 0 DC 0 AC 1
Xs16_p_3 s16_p_3 0 adc_mim_bank COUNT=8
Vs16_p_4 s16_p_4 0 DC 0 AC 1
Xs16_p_4 s16_p_4 0 adc_mim_bank COUNT=16
Vs16_p_5 s16_p_5 0 DC 0 AC 1
Xs16_p_5 s16_p_5 0 adc_mim_bank COUNT=32
Vs16_p_6 s16_p_6 0 DC 0 AC 1
Xs16_p_6 s16_p_6 0 adc_mim_bank COUNT=64
Vs16_p_7 s16_p_7 0 DC 0 AC 1
Xs16_p_7 s16_p_7 0 adc_mim_bank COUNT=128
Vs16_p_8 s16_p_8 0 DC 0 AC 1
Xs16_p_8 s16_p_8 0 adc_mim_bank COUNT=256
Vs16_p_9 s16_p_9 0 DC 0 AC 1
Xs16_p_9 s16_p_9 0 adc_mim_bank COUNT=512
Vs16_p_10 s16_p_10 0 DC 0 AC 1
Xs16_p_10 s16_p_10 0 adc_mim_bank COUNT=1024
Vs16_p_11 s16_p_11 0 DC 0 AC 1
Xs16_p_11 s16_p_11 0 adc_mim_bank COUNT=2048
Vs16_p_12 s16_p_12 0 DC 0 AC 1
Xs16_p_12 s16_p_12 0 adc_mim_bank COUNT=1
Vs16_n_0 s16_n_0 0 DC 0 AC 1
Xs16_n_0 s16_n_0 0 adc_mim_bank COUNT=1
Vs16_n_1 s16_n_1 0 DC 0 AC 1
Xs16_n_1 s16_n_1 0 adc_mim_bank COUNT=2
Vs16_n_2 s16_n_2 0 DC 0 AC 1
Xs16_n_2 s16_n_2 0 adc_mim_bank COUNT=4
Vs16_n_3 s16_n_3 0 DC 0 AC 1
Xs16_n_3 s16_n_3 0 adc_mim_bank COUNT=8
Vs16_n_4 s16_n_4 0 DC 0 AC 1
Xs16_n_4 s16_n_4 0 adc_mim_bank COUNT=16
Vs16_n_5 s16_n_5 0 DC 0 AC 1
Xs16_n_5 s16_n_5 0 adc_mim_bank COUNT=32
Vs16_n_6 s16_n_6 0 DC 0 AC 1
Xs16_n_6 s16_n_6 0 adc_mim_bank COUNT=64
Vs16_n_7 s16_n_7 0 DC 0 AC 1
Xs16_n_7 s16_n_7 0 adc_mim_bank COUNT=128
Vs16_n_8 s16_n_8 0 DC 0 AC 1
Xs16_n_8 s16_n_8 0 adc_mim_bank COUNT=256
Vs16_n_9 s16_n_9 0 DC 0 AC 1
Xs16_n_9 s16_n_9 0 adc_mim_bank COUNT=512
Vs16_n_10 s16_n_10 0 DC 0 AC 1
Xs16_n_10 s16_n_10 0 adc_mim_bank COUNT=1024
Vs16_n_11 s16_n_11 0 DC 0 AC 1
Xs16_n_11 s16_n_11 0 adc_mim_bank COUNT=2048
Vs16_n_12 s16_n_12 0 DC 0 AC 1
Xs16_n_12 s16_n_12 0 adc_mim_bank COUNT=1
Vs17_p_0 s17_p_0 0 DC 0 AC 1
Xs17_p_0 s17_p_0 0 adc_mim_bank COUNT=1
Vs17_p_1 s17_p_1 0 DC 0 AC 1
Xs17_p_1 s17_p_1 0 adc_mim_bank COUNT=2
Vs17_p_2 s17_p_2 0 DC 0 AC 1
Xs17_p_2 s17_p_2 0 adc_mim_bank COUNT=4
Vs17_p_3 s17_p_3 0 DC 0 AC 1
Xs17_p_3 s17_p_3 0 adc_mim_bank COUNT=8
Vs17_p_4 s17_p_4 0 DC 0 AC 1
Xs17_p_4 s17_p_4 0 adc_mim_bank COUNT=16
Vs17_p_5 s17_p_5 0 DC 0 AC 1
Xs17_p_5 s17_p_5 0 adc_mim_bank COUNT=32
Vs17_p_6 s17_p_6 0 DC 0 AC 1
Xs17_p_6 s17_p_6 0 adc_mim_bank COUNT=64
Vs17_p_7 s17_p_7 0 DC 0 AC 1
Xs17_p_7 s17_p_7 0 adc_mim_bank COUNT=128
Vs17_p_8 s17_p_8 0 DC 0 AC 1
Xs17_p_8 s17_p_8 0 adc_mim_bank COUNT=256
Vs17_p_9 s17_p_9 0 DC 0 AC 1
Xs17_p_9 s17_p_9 0 adc_mim_bank COUNT=512
Vs17_p_10 s17_p_10 0 DC 0 AC 1
Xs17_p_10 s17_p_10 0 adc_mim_bank COUNT=1024
Vs17_p_11 s17_p_11 0 DC 0 AC 1
Xs17_p_11 s17_p_11 0 adc_mim_bank COUNT=2048
Vs17_p_12 s17_p_12 0 DC 0 AC 1
Xs17_p_12 s17_p_12 0 adc_mim_bank COUNT=1
Vs17_n_0 s17_n_0 0 DC 0 AC 1
Xs17_n_0 s17_n_0 0 adc_mim_bank COUNT=1
Vs17_n_1 s17_n_1 0 DC 0 AC 1
Xs17_n_1 s17_n_1 0 adc_mim_bank COUNT=2
Vs17_n_2 s17_n_2 0 DC 0 AC 1
Xs17_n_2 s17_n_2 0 adc_mim_bank COUNT=4
Vs17_n_3 s17_n_3 0 DC 0 AC 1
Xs17_n_3 s17_n_3 0 adc_mim_bank COUNT=8
Vs17_n_4 s17_n_4 0 DC 0 AC 1
Xs17_n_4 s17_n_4 0 adc_mim_bank COUNT=16
Vs17_n_5 s17_n_5 0 DC 0 AC 1
Xs17_n_5 s17_n_5 0 adc_mim_bank COUNT=32
Vs17_n_6 s17_n_6 0 DC 0 AC 1
Xs17_n_6 s17_n_6 0 adc_mim_bank COUNT=64
Vs17_n_7 s17_n_7 0 DC 0 AC 1
Xs17_n_7 s17_n_7 0 adc_mim_bank COUNT=128
Vs17_n_8 s17_n_8 0 DC 0 AC 1
Xs17_n_8 s17_n_8 0 adc_mim_bank COUNT=256
Vs17_n_9 s17_n_9 0 DC 0 AC 1
Xs17_n_9 s17_n_9 0 adc_mim_bank COUNT=512
Vs17_n_10 s17_n_10 0 DC 0 AC 1
Xs17_n_10 s17_n_10 0 adc_mim_bank COUNT=1024
Vs17_n_11 s17_n_11 0 DC 0 AC 1
Xs17_n_11 s17_n_11 0 adc_mim_bank COUNT=2048
Vs17_n_12 s17_n_12 0 DC 0 AC 1
Xs17_n_12 s17_n_12 0 adc_mim_bank COUNT=1
Vs18_p_0 s18_p_0 0 DC 0 AC 1
Xs18_p_0 s18_p_0 0 adc_mim_bank COUNT=1
Vs18_p_1 s18_p_1 0 DC 0 AC 1
Xs18_p_1 s18_p_1 0 adc_mim_bank COUNT=2
Vs18_p_2 s18_p_2 0 DC 0 AC 1
Xs18_p_2 s18_p_2 0 adc_mim_bank COUNT=4
Vs18_p_3 s18_p_3 0 DC 0 AC 1
Xs18_p_3 s18_p_3 0 adc_mim_bank COUNT=8
Vs18_p_4 s18_p_4 0 DC 0 AC 1
Xs18_p_4 s18_p_4 0 adc_mim_bank COUNT=16
Vs18_p_5 s18_p_5 0 DC 0 AC 1
Xs18_p_5 s18_p_5 0 adc_mim_bank COUNT=32
Vs18_p_6 s18_p_6 0 DC 0 AC 1
Xs18_p_6 s18_p_6 0 adc_mim_bank COUNT=64
Vs18_p_7 s18_p_7 0 DC 0 AC 1
Xs18_p_7 s18_p_7 0 adc_mim_bank COUNT=128
Vs18_p_8 s18_p_8 0 DC 0 AC 1
Xs18_p_8 s18_p_8 0 adc_mim_bank COUNT=256
Vs18_p_9 s18_p_9 0 DC 0 AC 1
Xs18_p_9 s18_p_9 0 adc_mim_bank COUNT=512
Vs18_p_10 s18_p_10 0 DC 0 AC 1
Xs18_p_10 s18_p_10 0 adc_mim_bank COUNT=1024
Vs18_p_11 s18_p_11 0 DC 0 AC 1
Xs18_p_11 s18_p_11 0 adc_mim_bank COUNT=2048
Vs18_p_12 s18_p_12 0 DC 0 AC 1
Xs18_p_12 s18_p_12 0 adc_mim_bank COUNT=1
Vs18_n_0 s18_n_0 0 DC 0 AC 1
Xs18_n_0 s18_n_0 0 adc_mim_bank COUNT=1
Vs18_n_1 s18_n_1 0 DC 0 AC 1
Xs18_n_1 s18_n_1 0 adc_mim_bank COUNT=2
Vs18_n_2 s18_n_2 0 DC 0 AC 1
Xs18_n_2 s18_n_2 0 adc_mim_bank COUNT=4
Vs18_n_3 s18_n_3 0 DC 0 AC 1
Xs18_n_3 s18_n_3 0 adc_mim_bank COUNT=8
Vs18_n_4 s18_n_4 0 DC 0 AC 1
Xs18_n_4 s18_n_4 0 adc_mim_bank COUNT=16
Vs18_n_5 s18_n_5 0 DC 0 AC 1
Xs18_n_5 s18_n_5 0 adc_mim_bank COUNT=32
Vs18_n_6 s18_n_6 0 DC 0 AC 1
Xs18_n_6 s18_n_6 0 adc_mim_bank COUNT=64
Vs18_n_7 s18_n_7 0 DC 0 AC 1
Xs18_n_7 s18_n_7 0 adc_mim_bank COUNT=128
Vs18_n_8 s18_n_8 0 DC 0 AC 1
Xs18_n_8 s18_n_8 0 adc_mim_bank COUNT=256
Vs18_n_9 s18_n_9 0 DC 0 AC 1
Xs18_n_9 s18_n_9 0 adc_mim_bank COUNT=512
Vs18_n_10 s18_n_10 0 DC 0 AC 1
Xs18_n_10 s18_n_10 0 adc_mim_bank COUNT=1024
Vs18_n_11 s18_n_11 0 DC 0 AC 1
Xs18_n_11 s18_n_11 0 adc_mim_bank COUNT=2048
Vs18_n_12 s18_n_12 0 DC 0 AC 1
Xs18_n_12 s18_n_12 0 adc_mim_bank COUNT=1
Vs19_p_0 s19_p_0 0 DC 0 AC 1
Xs19_p_0 s19_p_0 0 adc_mim_bank COUNT=1
Vs19_p_1 s19_p_1 0 DC 0 AC 1
Xs19_p_1 s19_p_1 0 adc_mim_bank COUNT=2
Vs19_p_2 s19_p_2 0 DC 0 AC 1
Xs19_p_2 s19_p_2 0 adc_mim_bank COUNT=4
Vs19_p_3 s19_p_3 0 DC 0 AC 1
Xs19_p_3 s19_p_3 0 adc_mim_bank COUNT=8
Vs19_p_4 s19_p_4 0 DC 0 AC 1
Xs19_p_4 s19_p_4 0 adc_mim_bank COUNT=16
Vs19_p_5 s19_p_5 0 DC 0 AC 1
Xs19_p_5 s19_p_5 0 adc_mim_bank COUNT=32
Vs19_p_6 s19_p_6 0 DC 0 AC 1
Xs19_p_6 s19_p_6 0 adc_mim_bank COUNT=64
Vs19_p_7 s19_p_7 0 DC 0 AC 1
Xs19_p_7 s19_p_7 0 adc_mim_bank COUNT=128
Vs19_p_8 s19_p_8 0 DC 0 AC 1
Xs19_p_8 s19_p_8 0 adc_mim_bank COUNT=256
Vs19_p_9 s19_p_9 0 DC 0 AC 1
Xs19_p_9 s19_p_9 0 adc_mim_bank COUNT=512
Vs19_p_10 s19_p_10 0 DC 0 AC 1
Xs19_p_10 s19_p_10 0 adc_mim_bank COUNT=1024
Vs19_p_11 s19_p_11 0 DC 0 AC 1
Xs19_p_11 s19_p_11 0 adc_mim_bank COUNT=2048
Vs19_p_12 s19_p_12 0 DC 0 AC 1
Xs19_p_12 s19_p_12 0 adc_mim_bank COUNT=1
Vs19_n_0 s19_n_0 0 DC 0 AC 1
Xs19_n_0 s19_n_0 0 adc_mim_bank COUNT=1
Vs19_n_1 s19_n_1 0 DC 0 AC 1
Xs19_n_1 s19_n_1 0 adc_mim_bank COUNT=2
Vs19_n_2 s19_n_2 0 DC 0 AC 1
Xs19_n_2 s19_n_2 0 adc_mim_bank COUNT=4
Vs19_n_3 s19_n_3 0 DC 0 AC 1
Xs19_n_3 s19_n_3 0 adc_mim_bank COUNT=8
Vs19_n_4 s19_n_4 0 DC 0 AC 1
Xs19_n_4 s19_n_4 0 adc_mim_bank COUNT=16
Vs19_n_5 s19_n_5 0 DC 0 AC 1
Xs19_n_5 s19_n_5 0 adc_mim_bank COUNT=32
Vs19_n_6 s19_n_6 0 DC 0 AC 1
Xs19_n_6 s19_n_6 0 adc_mim_bank COUNT=64
Vs19_n_7 s19_n_7 0 DC 0 AC 1
Xs19_n_7 s19_n_7 0 adc_mim_bank COUNT=128
Vs19_n_8 s19_n_8 0 DC 0 AC 1
Xs19_n_8 s19_n_8 0 adc_mim_bank COUNT=256
Vs19_n_9 s19_n_9 0 DC 0 AC 1
Xs19_n_9 s19_n_9 0 adc_mim_bank COUNT=512
Vs19_n_10 s19_n_10 0 DC 0 AC 1
Xs19_n_10 s19_n_10 0 adc_mim_bank COUNT=1024
Vs19_n_11 s19_n_11 0 DC 0 AC 1
Xs19_n_11 s19_n_11 0 adc_mim_bank COUNT=2048
Vs19_n_12 s19_n_12 0 DC 0 AC 1
Xs19_n_12 s19_n_12 0 adc_mim_bank COUNT=1
Vs20_p_0 s20_p_0 0 DC 0 AC 1
Xs20_p_0 s20_p_0 0 adc_mim_bank COUNT=1
Vs20_p_1 s20_p_1 0 DC 0 AC 1
Xs20_p_1 s20_p_1 0 adc_mim_bank COUNT=2
Vs20_p_2 s20_p_2 0 DC 0 AC 1
Xs20_p_2 s20_p_2 0 adc_mim_bank COUNT=4
Vs20_p_3 s20_p_3 0 DC 0 AC 1
Xs20_p_3 s20_p_3 0 adc_mim_bank COUNT=8
Vs20_p_4 s20_p_4 0 DC 0 AC 1
Xs20_p_4 s20_p_4 0 adc_mim_bank COUNT=16
Vs20_p_5 s20_p_5 0 DC 0 AC 1
Xs20_p_5 s20_p_5 0 adc_mim_bank COUNT=32
Vs20_p_6 s20_p_6 0 DC 0 AC 1
Xs20_p_6 s20_p_6 0 adc_mim_bank COUNT=64
Vs20_p_7 s20_p_7 0 DC 0 AC 1
Xs20_p_7 s20_p_7 0 adc_mim_bank COUNT=128
Vs20_p_8 s20_p_8 0 DC 0 AC 1
Xs20_p_8 s20_p_8 0 adc_mim_bank COUNT=256
Vs20_p_9 s20_p_9 0 DC 0 AC 1
Xs20_p_9 s20_p_9 0 adc_mim_bank COUNT=512
Vs20_p_10 s20_p_10 0 DC 0 AC 1
Xs20_p_10 s20_p_10 0 adc_mim_bank COUNT=1024
Vs20_p_11 s20_p_11 0 DC 0 AC 1
Xs20_p_11 s20_p_11 0 adc_mim_bank COUNT=2048
Vs20_p_12 s20_p_12 0 DC 0 AC 1
Xs20_p_12 s20_p_12 0 adc_mim_bank COUNT=1
Vs20_n_0 s20_n_0 0 DC 0 AC 1
Xs20_n_0 s20_n_0 0 adc_mim_bank COUNT=1
Vs20_n_1 s20_n_1 0 DC 0 AC 1
Xs20_n_1 s20_n_1 0 adc_mim_bank COUNT=2
Vs20_n_2 s20_n_2 0 DC 0 AC 1
Xs20_n_2 s20_n_2 0 adc_mim_bank COUNT=4
Vs20_n_3 s20_n_3 0 DC 0 AC 1
Xs20_n_3 s20_n_3 0 adc_mim_bank COUNT=8
Vs20_n_4 s20_n_4 0 DC 0 AC 1
Xs20_n_4 s20_n_4 0 adc_mim_bank COUNT=16
Vs20_n_5 s20_n_5 0 DC 0 AC 1
Xs20_n_5 s20_n_5 0 adc_mim_bank COUNT=32
Vs20_n_6 s20_n_6 0 DC 0 AC 1
Xs20_n_6 s20_n_6 0 adc_mim_bank COUNT=64
Vs20_n_7 s20_n_7 0 DC 0 AC 1
Xs20_n_7 s20_n_7 0 adc_mim_bank COUNT=128
Vs20_n_8 s20_n_8 0 DC 0 AC 1
Xs20_n_8 s20_n_8 0 adc_mim_bank COUNT=256
Vs20_n_9 s20_n_9 0 DC 0 AC 1
Xs20_n_9 s20_n_9 0 adc_mim_bank COUNT=512
Vs20_n_10 s20_n_10 0 DC 0 AC 1
Xs20_n_10 s20_n_10 0 adc_mim_bank COUNT=1024
Vs20_n_11 s20_n_11 0 DC 0 AC 1
Xs20_n_11 s20_n_11 0 adc_mim_bank COUNT=2048
Vs20_n_12 s20_n_12 0 DC 0 AC 1
Xs20_n_12 s20_n_12 0 adc_mim_bank COUNT=1
Vs21_p_0 s21_p_0 0 DC 0 AC 1
Xs21_p_0 s21_p_0 0 adc_mim_bank COUNT=1
Vs21_p_1 s21_p_1 0 DC 0 AC 1
Xs21_p_1 s21_p_1 0 adc_mim_bank COUNT=2
Vs21_p_2 s21_p_2 0 DC 0 AC 1
Xs21_p_2 s21_p_2 0 adc_mim_bank COUNT=4
Vs21_p_3 s21_p_3 0 DC 0 AC 1
Xs21_p_3 s21_p_3 0 adc_mim_bank COUNT=8
Vs21_p_4 s21_p_4 0 DC 0 AC 1
Xs21_p_4 s21_p_4 0 adc_mim_bank COUNT=16
Vs21_p_5 s21_p_5 0 DC 0 AC 1
Xs21_p_5 s21_p_5 0 adc_mim_bank COUNT=32
Vs21_p_6 s21_p_6 0 DC 0 AC 1
Xs21_p_6 s21_p_6 0 adc_mim_bank COUNT=64
Vs21_p_7 s21_p_7 0 DC 0 AC 1
Xs21_p_7 s21_p_7 0 adc_mim_bank COUNT=128
Vs21_p_8 s21_p_8 0 DC 0 AC 1
Xs21_p_8 s21_p_8 0 adc_mim_bank COUNT=256
Vs21_p_9 s21_p_9 0 DC 0 AC 1
Xs21_p_9 s21_p_9 0 adc_mim_bank COUNT=512
Vs21_p_10 s21_p_10 0 DC 0 AC 1
Xs21_p_10 s21_p_10 0 adc_mim_bank COUNT=1024
Vs21_p_11 s21_p_11 0 DC 0 AC 1
Xs21_p_11 s21_p_11 0 adc_mim_bank COUNT=2048
Vs21_p_12 s21_p_12 0 DC 0 AC 1
Xs21_p_12 s21_p_12 0 adc_mim_bank COUNT=1
Vs21_n_0 s21_n_0 0 DC 0 AC 1
Xs21_n_0 s21_n_0 0 adc_mim_bank COUNT=1
Vs21_n_1 s21_n_1 0 DC 0 AC 1
Xs21_n_1 s21_n_1 0 adc_mim_bank COUNT=2
Vs21_n_2 s21_n_2 0 DC 0 AC 1
Xs21_n_2 s21_n_2 0 adc_mim_bank COUNT=4
Vs21_n_3 s21_n_3 0 DC 0 AC 1
Xs21_n_3 s21_n_3 0 adc_mim_bank COUNT=8
Vs21_n_4 s21_n_4 0 DC 0 AC 1
Xs21_n_4 s21_n_4 0 adc_mim_bank COUNT=16
Vs21_n_5 s21_n_5 0 DC 0 AC 1
Xs21_n_5 s21_n_5 0 adc_mim_bank COUNT=32
Vs21_n_6 s21_n_6 0 DC 0 AC 1
Xs21_n_6 s21_n_6 0 adc_mim_bank COUNT=64
Vs21_n_7 s21_n_7 0 DC 0 AC 1
Xs21_n_7 s21_n_7 0 adc_mim_bank COUNT=128
Vs21_n_8 s21_n_8 0 DC 0 AC 1
Xs21_n_8 s21_n_8 0 adc_mim_bank COUNT=256
Vs21_n_9 s21_n_9 0 DC 0 AC 1
Xs21_n_9 s21_n_9 0 adc_mim_bank COUNT=512
Vs21_n_10 s21_n_10 0 DC 0 AC 1
Xs21_n_10 s21_n_10 0 adc_mim_bank COUNT=1024
Vs21_n_11 s21_n_11 0 DC 0 AC 1
Xs21_n_11 s21_n_11 0 adc_mim_bank COUNT=2048
Vs21_n_12 s21_n_12 0 DC 0 AC 1
Xs21_n_12 s21_n_12 0 adc_mim_bank COUNT=1
Vs22_p_0 s22_p_0 0 DC 0 AC 1
Xs22_p_0 s22_p_0 0 adc_mim_bank COUNT=1
Vs22_p_1 s22_p_1 0 DC 0 AC 1
Xs22_p_1 s22_p_1 0 adc_mim_bank COUNT=2
Vs22_p_2 s22_p_2 0 DC 0 AC 1
Xs22_p_2 s22_p_2 0 adc_mim_bank COUNT=4
Vs22_p_3 s22_p_3 0 DC 0 AC 1
Xs22_p_3 s22_p_3 0 adc_mim_bank COUNT=8
Vs22_p_4 s22_p_4 0 DC 0 AC 1
Xs22_p_4 s22_p_4 0 adc_mim_bank COUNT=16
Vs22_p_5 s22_p_5 0 DC 0 AC 1
Xs22_p_5 s22_p_5 0 adc_mim_bank COUNT=32
Vs22_p_6 s22_p_6 0 DC 0 AC 1
Xs22_p_6 s22_p_6 0 adc_mim_bank COUNT=64
Vs22_p_7 s22_p_7 0 DC 0 AC 1
Xs22_p_7 s22_p_7 0 adc_mim_bank COUNT=128
Vs22_p_8 s22_p_8 0 DC 0 AC 1
Xs22_p_8 s22_p_8 0 adc_mim_bank COUNT=256
Vs22_p_9 s22_p_9 0 DC 0 AC 1
Xs22_p_9 s22_p_9 0 adc_mim_bank COUNT=512
Vs22_p_10 s22_p_10 0 DC 0 AC 1
Xs22_p_10 s22_p_10 0 adc_mim_bank COUNT=1024
Vs22_p_11 s22_p_11 0 DC 0 AC 1
Xs22_p_11 s22_p_11 0 adc_mim_bank COUNT=2048
Vs22_p_12 s22_p_12 0 DC 0 AC 1
Xs22_p_12 s22_p_12 0 adc_mim_bank COUNT=1
Vs22_n_0 s22_n_0 0 DC 0 AC 1
Xs22_n_0 s22_n_0 0 adc_mim_bank COUNT=1
Vs22_n_1 s22_n_1 0 DC 0 AC 1
Xs22_n_1 s22_n_1 0 adc_mim_bank COUNT=2
Vs22_n_2 s22_n_2 0 DC 0 AC 1
Xs22_n_2 s22_n_2 0 adc_mim_bank COUNT=4
Vs22_n_3 s22_n_3 0 DC 0 AC 1
Xs22_n_3 s22_n_3 0 adc_mim_bank COUNT=8
Vs22_n_4 s22_n_4 0 DC 0 AC 1
Xs22_n_4 s22_n_4 0 adc_mim_bank COUNT=16
Vs22_n_5 s22_n_5 0 DC 0 AC 1
Xs22_n_5 s22_n_5 0 adc_mim_bank COUNT=32
Vs22_n_6 s22_n_6 0 DC 0 AC 1
Xs22_n_6 s22_n_6 0 adc_mim_bank COUNT=64
Vs22_n_7 s22_n_7 0 DC 0 AC 1
Xs22_n_7 s22_n_7 0 adc_mim_bank COUNT=128
Vs22_n_8 s22_n_8 0 DC 0 AC 1
Xs22_n_8 s22_n_8 0 adc_mim_bank COUNT=256
Vs22_n_9 s22_n_9 0 DC 0 AC 1
Xs22_n_9 s22_n_9 0 adc_mim_bank COUNT=512
Vs22_n_10 s22_n_10 0 DC 0 AC 1
Xs22_n_10 s22_n_10 0 adc_mim_bank COUNT=1024
Vs22_n_11 s22_n_11 0 DC 0 AC 1
Xs22_n_11 s22_n_11 0 adc_mim_bank COUNT=2048
Vs22_n_12 s22_n_12 0 DC 0 AC 1
Xs22_n_12 s22_n_12 0 adc_mim_bank COUNT=1
Vs23_p_0 s23_p_0 0 DC 0 AC 1
Xs23_p_0 s23_p_0 0 adc_mim_bank COUNT=1
Vs23_p_1 s23_p_1 0 DC 0 AC 1
Xs23_p_1 s23_p_1 0 adc_mim_bank COUNT=2
Vs23_p_2 s23_p_2 0 DC 0 AC 1
Xs23_p_2 s23_p_2 0 adc_mim_bank COUNT=4
Vs23_p_3 s23_p_3 0 DC 0 AC 1
Xs23_p_3 s23_p_3 0 adc_mim_bank COUNT=8
Vs23_p_4 s23_p_4 0 DC 0 AC 1
Xs23_p_4 s23_p_4 0 adc_mim_bank COUNT=16
Vs23_p_5 s23_p_5 0 DC 0 AC 1
Xs23_p_5 s23_p_5 0 adc_mim_bank COUNT=32
Vs23_p_6 s23_p_6 0 DC 0 AC 1
Xs23_p_6 s23_p_6 0 adc_mim_bank COUNT=64
Vs23_p_7 s23_p_7 0 DC 0 AC 1
Xs23_p_7 s23_p_7 0 adc_mim_bank COUNT=128
Vs23_p_8 s23_p_8 0 DC 0 AC 1
Xs23_p_8 s23_p_8 0 adc_mim_bank COUNT=256
Vs23_p_9 s23_p_9 0 DC 0 AC 1
Xs23_p_9 s23_p_9 0 adc_mim_bank COUNT=512
Vs23_p_10 s23_p_10 0 DC 0 AC 1
Xs23_p_10 s23_p_10 0 adc_mim_bank COUNT=1024
Vs23_p_11 s23_p_11 0 DC 0 AC 1
Xs23_p_11 s23_p_11 0 adc_mim_bank COUNT=2048
Vs23_p_12 s23_p_12 0 DC 0 AC 1
Xs23_p_12 s23_p_12 0 adc_mim_bank COUNT=1
Vs23_n_0 s23_n_0 0 DC 0 AC 1
Xs23_n_0 s23_n_0 0 adc_mim_bank COUNT=1
Vs23_n_1 s23_n_1 0 DC 0 AC 1
Xs23_n_1 s23_n_1 0 adc_mim_bank COUNT=2
Vs23_n_2 s23_n_2 0 DC 0 AC 1
Xs23_n_2 s23_n_2 0 adc_mim_bank COUNT=4
Vs23_n_3 s23_n_3 0 DC 0 AC 1
Xs23_n_3 s23_n_3 0 adc_mim_bank COUNT=8
Vs23_n_4 s23_n_4 0 DC 0 AC 1
Xs23_n_4 s23_n_4 0 adc_mim_bank COUNT=16
Vs23_n_5 s23_n_5 0 DC 0 AC 1
Xs23_n_5 s23_n_5 0 adc_mim_bank COUNT=32
Vs23_n_6 s23_n_6 0 DC 0 AC 1
Xs23_n_6 s23_n_6 0 adc_mim_bank COUNT=64
Vs23_n_7 s23_n_7 0 DC 0 AC 1
Xs23_n_7 s23_n_7 0 adc_mim_bank COUNT=128
Vs23_n_8 s23_n_8 0 DC 0 AC 1
Xs23_n_8 s23_n_8 0 adc_mim_bank COUNT=256
Vs23_n_9 s23_n_9 0 DC 0 AC 1
Xs23_n_9 s23_n_9 0 adc_mim_bank COUNT=512
Vs23_n_10 s23_n_10 0 DC 0 AC 1
Xs23_n_10 s23_n_10 0 adc_mim_bank COUNT=1024
Vs23_n_11 s23_n_11 0 DC 0 AC 1
Xs23_n_11 s23_n_11 0 adc_mim_bank COUNT=2048
Vs23_n_12 s23_n_12 0 DC 0 AC 1
Xs23_n_12 s23_n_12 0 adc_mim_bank COUNT=1
Vs24_p_0 s24_p_0 0 DC 0 AC 1
Xs24_p_0 s24_p_0 0 adc_mim_bank COUNT=1
Vs24_p_1 s24_p_1 0 DC 0 AC 1
Xs24_p_1 s24_p_1 0 adc_mim_bank COUNT=2
Vs24_p_2 s24_p_2 0 DC 0 AC 1
Xs24_p_2 s24_p_2 0 adc_mim_bank COUNT=4
Vs24_p_3 s24_p_3 0 DC 0 AC 1
Xs24_p_3 s24_p_3 0 adc_mim_bank COUNT=8
Vs24_p_4 s24_p_4 0 DC 0 AC 1
Xs24_p_4 s24_p_4 0 adc_mim_bank COUNT=16
Vs24_p_5 s24_p_5 0 DC 0 AC 1
Xs24_p_5 s24_p_5 0 adc_mim_bank COUNT=32
Vs24_p_6 s24_p_6 0 DC 0 AC 1
Xs24_p_6 s24_p_6 0 adc_mim_bank COUNT=64
Vs24_p_7 s24_p_7 0 DC 0 AC 1
Xs24_p_7 s24_p_7 0 adc_mim_bank COUNT=128
Vs24_p_8 s24_p_8 0 DC 0 AC 1
Xs24_p_8 s24_p_8 0 adc_mim_bank COUNT=256
Vs24_p_9 s24_p_9 0 DC 0 AC 1
Xs24_p_9 s24_p_9 0 adc_mim_bank COUNT=512
Vs24_p_10 s24_p_10 0 DC 0 AC 1
Xs24_p_10 s24_p_10 0 adc_mim_bank COUNT=1024
Vs24_p_11 s24_p_11 0 DC 0 AC 1
Xs24_p_11 s24_p_11 0 adc_mim_bank COUNT=2048
Vs24_p_12 s24_p_12 0 DC 0 AC 1
Xs24_p_12 s24_p_12 0 adc_mim_bank COUNT=1
Vs24_n_0 s24_n_0 0 DC 0 AC 1
Xs24_n_0 s24_n_0 0 adc_mim_bank COUNT=1
Vs24_n_1 s24_n_1 0 DC 0 AC 1
Xs24_n_1 s24_n_1 0 adc_mim_bank COUNT=2
Vs24_n_2 s24_n_2 0 DC 0 AC 1
Xs24_n_2 s24_n_2 0 adc_mim_bank COUNT=4
Vs24_n_3 s24_n_3 0 DC 0 AC 1
Xs24_n_3 s24_n_3 0 adc_mim_bank COUNT=8
Vs24_n_4 s24_n_4 0 DC 0 AC 1
Xs24_n_4 s24_n_4 0 adc_mim_bank COUNT=16
Vs24_n_5 s24_n_5 0 DC 0 AC 1
Xs24_n_5 s24_n_5 0 adc_mim_bank COUNT=32
Vs24_n_6 s24_n_6 0 DC 0 AC 1
Xs24_n_6 s24_n_6 0 adc_mim_bank COUNT=64
Vs24_n_7 s24_n_7 0 DC 0 AC 1
Xs24_n_7 s24_n_7 0 adc_mim_bank COUNT=128
Vs24_n_8 s24_n_8 0 DC 0 AC 1
Xs24_n_8 s24_n_8 0 adc_mim_bank COUNT=256
Vs24_n_9 s24_n_9 0 DC 0 AC 1
Xs24_n_9 s24_n_9 0 adc_mim_bank COUNT=512
Vs24_n_10 s24_n_10 0 DC 0 AC 1
Xs24_n_10 s24_n_10 0 adc_mim_bank COUNT=1024
Vs24_n_11 s24_n_11 0 DC 0 AC 1
Xs24_n_11 s24_n_11 0 adc_mim_bank COUNT=2048
Vs24_n_12 s24_n_12 0 DC 0 AC 1
Xs24_n_12 s24_n_12 0 adc_mim_bank COUNT=1
Vs25_p_0 s25_p_0 0 DC 0 AC 1
Xs25_p_0 s25_p_0 0 adc_mim_bank COUNT=1
Vs25_p_1 s25_p_1 0 DC 0 AC 1
Xs25_p_1 s25_p_1 0 adc_mim_bank COUNT=2
Vs25_p_2 s25_p_2 0 DC 0 AC 1
Xs25_p_2 s25_p_2 0 adc_mim_bank COUNT=4
Vs25_p_3 s25_p_3 0 DC 0 AC 1
Xs25_p_3 s25_p_3 0 adc_mim_bank COUNT=8
Vs25_p_4 s25_p_4 0 DC 0 AC 1
Xs25_p_4 s25_p_4 0 adc_mim_bank COUNT=16
Vs25_p_5 s25_p_5 0 DC 0 AC 1
Xs25_p_5 s25_p_5 0 adc_mim_bank COUNT=32
Vs25_p_6 s25_p_6 0 DC 0 AC 1
Xs25_p_6 s25_p_6 0 adc_mim_bank COUNT=64
Vs25_p_7 s25_p_7 0 DC 0 AC 1
Xs25_p_7 s25_p_7 0 adc_mim_bank COUNT=128
Vs25_p_8 s25_p_8 0 DC 0 AC 1
Xs25_p_8 s25_p_8 0 adc_mim_bank COUNT=256
Vs25_p_9 s25_p_9 0 DC 0 AC 1
Xs25_p_9 s25_p_9 0 adc_mim_bank COUNT=512
Vs25_p_10 s25_p_10 0 DC 0 AC 1
Xs25_p_10 s25_p_10 0 adc_mim_bank COUNT=1024
Vs25_p_11 s25_p_11 0 DC 0 AC 1
Xs25_p_11 s25_p_11 0 adc_mim_bank COUNT=2048
Vs25_p_12 s25_p_12 0 DC 0 AC 1
Xs25_p_12 s25_p_12 0 adc_mim_bank COUNT=1
Vs25_n_0 s25_n_0 0 DC 0 AC 1
Xs25_n_0 s25_n_0 0 adc_mim_bank COUNT=1
Vs25_n_1 s25_n_1 0 DC 0 AC 1
Xs25_n_1 s25_n_1 0 adc_mim_bank COUNT=2
Vs25_n_2 s25_n_2 0 DC 0 AC 1
Xs25_n_2 s25_n_2 0 adc_mim_bank COUNT=4
Vs25_n_3 s25_n_3 0 DC 0 AC 1
Xs25_n_3 s25_n_3 0 adc_mim_bank COUNT=8
Vs25_n_4 s25_n_4 0 DC 0 AC 1
Xs25_n_4 s25_n_4 0 adc_mim_bank COUNT=16
Vs25_n_5 s25_n_5 0 DC 0 AC 1
Xs25_n_5 s25_n_5 0 adc_mim_bank COUNT=32
Vs25_n_6 s25_n_6 0 DC 0 AC 1
Xs25_n_6 s25_n_6 0 adc_mim_bank COUNT=64
Vs25_n_7 s25_n_7 0 DC 0 AC 1
Xs25_n_7 s25_n_7 0 adc_mim_bank COUNT=128
Vs25_n_8 s25_n_8 0 DC 0 AC 1
Xs25_n_8 s25_n_8 0 adc_mim_bank COUNT=256
Vs25_n_9 s25_n_9 0 DC 0 AC 1
Xs25_n_9 s25_n_9 0 adc_mim_bank COUNT=512
Vs25_n_10 s25_n_10 0 DC 0 AC 1
Xs25_n_10 s25_n_10 0 adc_mim_bank COUNT=1024
Vs25_n_11 s25_n_11 0 DC 0 AC 1
Xs25_n_11 s25_n_11 0 adc_mim_bank COUNT=2048
Vs25_n_12 s25_n_12 0 DC 0 AC 1
Xs25_n_12 s25_n_12 0 adc_mim_bank COUNT=1
Vs26_p_0 s26_p_0 0 DC 0 AC 1
Xs26_p_0 s26_p_0 0 adc_mim_bank COUNT=1
Vs26_p_1 s26_p_1 0 DC 0 AC 1
Xs26_p_1 s26_p_1 0 adc_mim_bank COUNT=2
Vs26_p_2 s26_p_2 0 DC 0 AC 1
Xs26_p_2 s26_p_2 0 adc_mim_bank COUNT=4
Vs26_p_3 s26_p_3 0 DC 0 AC 1
Xs26_p_3 s26_p_3 0 adc_mim_bank COUNT=8
Vs26_p_4 s26_p_4 0 DC 0 AC 1
Xs26_p_4 s26_p_4 0 adc_mim_bank COUNT=16
Vs26_p_5 s26_p_5 0 DC 0 AC 1
Xs26_p_5 s26_p_5 0 adc_mim_bank COUNT=32
Vs26_p_6 s26_p_6 0 DC 0 AC 1
Xs26_p_6 s26_p_6 0 adc_mim_bank COUNT=64
Vs26_p_7 s26_p_7 0 DC 0 AC 1
Xs26_p_7 s26_p_7 0 adc_mim_bank COUNT=128
Vs26_p_8 s26_p_8 0 DC 0 AC 1
Xs26_p_8 s26_p_8 0 adc_mim_bank COUNT=256
Vs26_p_9 s26_p_9 0 DC 0 AC 1
Xs26_p_9 s26_p_9 0 adc_mim_bank COUNT=512
Vs26_p_10 s26_p_10 0 DC 0 AC 1
Xs26_p_10 s26_p_10 0 adc_mim_bank COUNT=1024
Vs26_p_11 s26_p_11 0 DC 0 AC 1
Xs26_p_11 s26_p_11 0 adc_mim_bank COUNT=2048
Vs26_p_12 s26_p_12 0 DC 0 AC 1
Xs26_p_12 s26_p_12 0 adc_mim_bank COUNT=1
Vs26_n_0 s26_n_0 0 DC 0 AC 1
Xs26_n_0 s26_n_0 0 adc_mim_bank COUNT=1
Vs26_n_1 s26_n_1 0 DC 0 AC 1
Xs26_n_1 s26_n_1 0 adc_mim_bank COUNT=2
Vs26_n_2 s26_n_2 0 DC 0 AC 1
Xs26_n_2 s26_n_2 0 adc_mim_bank COUNT=4
Vs26_n_3 s26_n_3 0 DC 0 AC 1
Xs26_n_3 s26_n_3 0 adc_mim_bank COUNT=8
Vs26_n_4 s26_n_4 0 DC 0 AC 1
Xs26_n_4 s26_n_4 0 adc_mim_bank COUNT=16
Vs26_n_5 s26_n_5 0 DC 0 AC 1
Xs26_n_5 s26_n_5 0 adc_mim_bank COUNT=32
Vs26_n_6 s26_n_6 0 DC 0 AC 1
Xs26_n_6 s26_n_6 0 adc_mim_bank COUNT=64
Vs26_n_7 s26_n_7 0 DC 0 AC 1
Xs26_n_7 s26_n_7 0 adc_mim_bank COUNT=128
Vs26_n_8 s26_n_8 0 DC 0 AC 1
Xs26_n_8 s26_n_8 0 adc_mim_bank COUNT=256
Vs26_n_9 s26_n_9 0 DC 0 AC 1
Xs26_n_9 s26_n_9 0 adc_mim_bank COUNT=512
Vs26_n_10 s26_n_10 0 DC 0 AC 1
Xs26_n_10 s26_n_10 0 adc_mim_bank COUNT=1024
Vs26_n_11 s26_n_11 0 DC 0 AC 1
Xs26_n_11 s26_n_11 0 adc_mim_bank COUNT=2048
Vs26_n_12 s26_n_12 0 DC 0 AC 1
Xs26_n_12 s26_n_12 0 adc_mim_bank COUNT=1
Vs27_p_0 s27_p_0 0 DC 0 AC 1
Xs27_p_0 s27_p_0 0 adc_mim_bank COUNT=1
Vs27_p_1 s27_p_1 0 DC 0 AC 1
Xs27_p_1 s27_p_1 0 adc_mim_bank COUNT=2
Vs27_p_2 s27_p_2 0 DC 0 AC 1
Xs27_p_2 s27_p_2 0 adc_mim_bank COUNT=4
Vs27_p_3 s27_p_3 0 DC 0 AC 1
Xs27_p_3 s27_p_3 0 adc_mim_bank COUNT=8
Vs27_p_4 s27_p_4 0 DC 0 AC 1
Xs27_p_4 s27_p_4 0 adc_mim_bank COUNT=16
Vs27_p_5 s27_p_5 0 DC 0 AC 1
Xs27_p_5 s27_p_5 0 adc_mim_bank COUNT=32
Vs27_p_6 s27_p_6 0 DC 0 AC 1
Xs27_p_6 s27_p_6 0 adc_mim_bank COUNT=64
Vs27_p_7 s27_p_7 0 DC 0 AC 1
Xs27_p_7 s27_p_7 0 adc_mim_bank COUNT=128
Vs27_p_8 s27_p_8 0 DC 0 AC 1
Xs27_p_8 s27_p_8 0 adc_mim_bank COUNT=256
Vs27_p_9 s27_p_9 0 DC 0 AC 1
Xs27_p_9 s27_p_9 0 adc_mim_bank COUNT=512
Vs27_p_10 s27_p_10 0 DC 0 AC 1
Xs27_p_10 s27_p_10 0 adc_mim_bank COUNT=1024
Vs27_p_11 s27_p_11 0 DC 0 AC 1
Xs27_p_11 s27_p_11 0 adc_mim_bank COUNT=2048
Vs27_p_12 s27_p_12 0 DC 0 AC 1
Xs27_p_12 s27_p_12 0 adc_mim_bank COUNT=1
Vs27_n_0 s27_n_0 0 DC 0 AC 1
Xs27_n_0 s27_n_0 0 adc_mim_bank COUNT=1
Vs27_n_1 s27_n_1 0 DC 0 AC 1
Xs27_n_1 s27_n_1 0 adc_mim_bank COUNT=2
Vs27_n_2 s27_n_2 0 DC 0 AC 1
Xs27_n_2 s27_n_2 0 adc_mim_bank COUNT=4
Vs27_n_3 s27_n_3 0 DC 0 AC 1
Xs27_n_3 s27_n_3 0 adc_mim_bank COUNT=8
Vs27_n_4 s27_n_4 0 DC 0 AC 1
Xs27_n_4 s27_n_4 0 adc_mim_bank COUNT=16
Vs27_n_5 s27_n_5 0 DC 0 AC 1
Xs27_n_5 s27_n_5 0 adc_mim_bank COUNT=32
Vs27_n_6 s27_n_6 0 DC 0 AC 1
Xs27_n_6 s27_n_6 0 adc_mim_bank COUNT=64
Vs27_n_7 s27_n_7 0 DC 0 AC 1
Xs27_n_7 s27_n_7 0 adc_mim_bank COUNT=128
Vs27_n_8 s27_n_8 0 DC 0 AC 1
Xs27_n_8 s27_n_8 0 adc_mim_bank COUNT=256
Vs27_n_9 s27_n_9 0 DC 0 AC 1
Xs27_n_9 s27_n_9 0 adc_mim_bank COUNT=512
Vs27_n_10 s27_n_10 0 DC 0 AC 1
Xs27_n_10 s27_n_10 0 adc_mim_bank COUNT=1024
Vs27_n_11 s27_n_11 0 DC 0 AC 1
Xs27_n_11 s27_n_11 0 adc_mim_bank COUNT=2048
Vs27_n_12 s27_n_12 0 DC 0 AC 1
Xs27_n_12 s27_n_12 0 adc_mim_bank COUNT=1
Vs28_p_0 s28_p_0 0 DC 0 AC 1
Xs28_p_0 s28_p_0 0 adc_mim_bank COUNT=1
Vs28_p_1 s28_p_1 0 DC 0 AC 1
Xs28_p_1 s28_p_1 0 adc_mim_bank COUNT=2
Vs28_p_2 s28_p_2 0 DC 0 AC 1
Xs28_p_2 s28_p_2 0 adc_mim_bank COUNT=4
Vs28_p_3 s28_p_3 0 DC 0 AC 1
Xs28_p_3 s28_p_3 0 adc_mim_bank COUNT=8
Vs28_p_4 s28_p_4 0 DC 0 AC 1
Xs28_p_4 s28_p_4 0 adc_mim_bank COUNT=16
Vs28_p_5 s28_p_5 0 DC 0 AC 1
Xs28_p_5 s28_p_5 0 adc_mim_bank COUNT=32
Vs28_p_6 s28_p_6 0 DC 0 AC 1
Xs28_p_6 s28_p_6 0 adc_mim_bank COUNT=64
Vs28_p_7 s28_p_7 0 DC 0 AC 1
Xs28_p_7 s28_p_7 0 adc_mim_bank COUNT=128
Vs28_p_8 s28_p_8 0 DC 0 AC 1
Xs28_p_8 s28_p_8 0 adc_mim_bank COUNT=256
Vs28_p_9 s28_p_9 0 DC 0 AC 1
Xs28_p_9 s28_p_9 0 adc_mim_bank COUNT=512
Vs28_p_10 s28_p_10 0 DC 0 AC 1
Xs28_p_10 s28_p_10 0 adc_mim_bank COUNT=1024
Vs28_p_11 s28_p_11 0 DC 0 AC 1
Xs28_p_11 s28_p_11 0 adc_mim_bank COUNT=2048
Vs28_p_12 s28_p_12 0 DC 0 AC 1
Xs28_p_12 s28_p_12 0 adc_mim_bank COUNT=1
Vs28_n_0 s28_n_0 0 DC 0 AC 1
Xs28_n_0 s28_n_0 0 adc_mim_bank COUNT=1
Vs28_n_1 s28_n_1 0 DC 0 AC 1
Xs28_n_1 s28_n_1 0 adc_mim_bank COUNT=2
Vs28_n_2 s28_n_2 0 DC 0 AC 1
Xs28_n_2 s28_n_2 0 adc_mim_bank COUNT=4
Vs28_n_3 s28_n_3 0 DC 0 AC 1
Xs28_n_3 s28_n_3 0 adc_mim_bank COUNT=8
Vs28_n_4 s28_n_4 0 DC 0 AC 1
Xs28_n_4 s28_n_4 0 adc_mim_bank COUNT=16
Vs28_n_5 s28_n_5 0 DC 0 AC 1
Xs28_n_5 s28_n_5 0 adc_mim_bank COUNT=32
Vs28_n_6 s28_n_6 0 DC 0 AC 1
Xs28_n_6 s28_n_6 0 adc_mim_bank COUNT=64
Vs28_n_7 s28_n_7 0 DC 0 AC 1
Xs28_n_7 s28_n_7 0 adc_mim_bank COUNT=128
Vs28_n_8 s28_n_8 0 DC 0 AC 1
Xs28_n_8 s28_n_8 0 adc_mim_bank COUNT=256
Vs28_n_9 s28_n_9 0 DC 0 AC 1
Xs28_n_9 s28_n_9 0 adc_mim_bank COUNT=512
Vs28_n_10 s28_n_10 0 DC 0 AC 1
Xs28_n_10 s28_n_10 0 adc_mim_bank COUNT=1024
Vs28_n_11 s28_n_11 0 DC 0 AC 1
Xs28_n_11 s28_n_11 0 adc_mim_bank COUNT=2048
Vs28_n_12 s28_n_12 0 DC 0 AC 1
Xs28_n_12 s28_n_12 0 adc_mim_bank COUNT=1
Vs29_p_0 s29_p_0 0 DC 0 AC 1
Xs29_p_0 s29_p_0 0 adc_mim_bank COUNT=1
Vs29_p_1 s29_p_1 0 DC 0 AC 1
Xs29_p_1 s29_p_1 0 adc_mim_bank COUNT=2
Vs29_p_2 s29_p_2 0 DC 0 AC 1
Xs29_p_2 s29_p_2 0 adc_mim_bank COUNT=4
Vs29_p_3 s29_p_3 0 DC 0 AC 1
Xs29_p_3 s29_p_3 0 adc_mim_bank COUNT=8
Vs29_p_4 s29_p_4 0 DC 0 AC 1
Xs29_p_4 s29_p_4 0 adc_mim_bank COUNT=16
Vs29_p_5 s29_p_5 0 DC 0 AC 1
Xs29_p_5 s29_p_5 0 adc_mim_bank COUNT=32
Vs29_p_6 s29_p_6 0 DC 0 AC 1
Xs29_p_6 s29_p_6 0 adc_mim_bank COUNT=64
Vs29_p_7 s29_p_7 0 DC 0 AC 1
Xs29_p_7 s29_p_7 0 adc_mim_bank COUNT=128
Vs29_p_8 s29_p_8 0 DC 0 AC 1
Xs29_p_8 s29_p_8 0 adc_mim_bank COUNT=256
Vs29_p_9 s29_p_9 0 DC 0 AC 1
Xs29_p_9 s29_p_9 0 adc_mim_bank COUNT=512
Vs29_p_10 s29_p_10 0 DC 0 AC 1
Xs29_p_10 s29_p_10 0 adc_mim_bank COUNT=1024
Vs29_p_11 s29_p_11 0 DC 0 AC 1
Xs29_p_11 s29_p_11 0 adc_mim_bank COUNT=2048
Vs29_p_12 s29_p_12 0 DC 0 AC 1
Xs29_p_12 s29_p_12 0 adc_mim_bank COUNT=1
Vs29_n_0 s29_n_0 0 DC 0 AC 1
Xs29_n_0 s29_n_0 0 adc_mim_bank COUNT=1
Vs29_n_1 s29_n_1 0 DC 0 AC 1
Xs29_n_1 s29_n_1 0 adc_mim_bank COUNT=2
Vs29_n_2 s29_n_2 0 DC 0 AC 1
Xs29_n_2 s29_n_2 0 adc_mim_bank COUNT=4
Vs29_n_3 s29_n_3 0 DC 0 AC 1
Xs29_n_3 s29_n_3 0 adc_mim_bank COUNT=8
Vs29_n_4 s29_n_4 0 DC 0 AC 1
Xs29_n_4 s29_n_4 0 adc_mim_bank COUNT=16
Vs29_n_5 s29_n_5 0 DC 0 AC 1
Xs29_n_5 s29_n_5 0 adc_mim_bank COUNT=32
Vs29_n_6 s29_n_6 0 DC 0 AC 1
Xs29_n_6 s29_n_6 0 adc_mim_bank COUNT=64
Vs29_n_7 s29_n_7 0 DC 0 AC 1
Xs29_n_7 s29_n_7 0 adc_mim_bank COUNT=128
Vs29_n_8 s29_n_8 0 DC 0 AC 1
Xs29_n_8 s29_n_8 0 adc_mim_bank COUNT=256
Vs29_n_9 s29_n_9 0 DC 0 AC 1
Xs29_n_9 s29_n_9 0 adc_mim_bank COUNT=512
Vs29_n_10 s29_n_10 0 DC 0 AC 1
Xs29_n_10 s29_n_10 0 adc_mim_bank COUNT=1024
Vs29_n_11 s29_n_11 0 DC 0 AC 1
Xs29_n_11 s29_n_11 0 adc_mim_bank COUNT=2048
Vs29_n_12 s29_n_12 0 DC 0 AC 1
Xs29_n_12 s29_n_12 0 adc_mim_bank COUNT=1
Vs30_p_0 s30_p_0 0 DC 0 AC 1
Xs30_p_0 s30_p_0 0 adc_mim_bank COUNT=1
Vs30_p_1 s30_p_1 0 DC 0 AC 1
Xs30_p_1 s30_p_1 0 adc_mim_bank COUNT=2
Vs30_p_2 s30_p_2 0 DC 0 AC 1
Xs30_p_2 s30_p_2 0 adc_mim_bank COUNT=4
Vs30_p_3 s30_p_3 0 DC 0 AC 1
Xs30_p_3 s30_p_3 0 adc_mim_bank COUNT=8
Vs30_p_4 s30_p_4 0 DC 0 AC 1
Xs30_p_4 s30_p_4 0 adc_mim_bank COUNT=16
Vs30_p_5 s30_p_5 0 DC 0 AC 1
Xs30_p_5 s30_p_5 0 adc_mim_bank COUNT=32
Vs30_p_6 s30_p_6 0 DC 0 AC 1
Xs30_p_6 s30_p_6 0 adc_mim_bank COUNT=64
Vs30_p_7 s30_p_7 0 DC 0 AC 1
Xs30_p_7 s30_p_7 0 adc_mim_bank COUNT=128
Vs30_p_8 s30_p_8 0 DC 0 AC 1
Xs30_p_8 s30_p_8 0 adc_mim_bank COUNT=256
Vs30_p_9 s30_p_9 0 DC 0 AC 1
Xs30_p_9 s30_p_9 0 adc_mim_bank COUNT=512
Vs30_p_10 s30_p_10 0 DC 0 AC 1
Xs30_p_10 s30_p_10 0 adc_mim_bank COUNT=1024
Vs30_p_11 s30_p_11 0 DC 0 AC 1
Xs30_p_11 s30_p_11 0 adc_mim_bank COUNT=2048
Vs30_p_12 s30_p_12 0 DC 0 AC 1
Xs30_p_12 s30_p_12 0 adc_mim_bank COUNT=1
Vs30_n_0 s30_n_0 0 DC 0 AC 1
Xs30_n_0 s30_n_0 0 adc_mim_bank COUNT=1
Vs30_n_1 s30_n_1 0 DC 0 AC 1
Xs30_n_1 s30_n_1 0 adc_mim_bank COUNT=2
Vs30_n_2 s30_n_2 0 DC 0 AC 1
Xs30_n_2 s30_n_2 0 adc_mim_bank COUNT=4
Vs30_n_3 s30_n_3 0 DC 0 AC 1
Xs30_n_3 s30_n_3 0 adc_mim_bank COUNT=8
Vs30_n_4 s30_n_4 0 DC 0 AC 1
Xs30_n_4 s30_n_4 0 adc_mim_bank COUNT=16
Vs30_n_5 s30_n_5 0 DC 0 AC 1
Xs30_n_5 s30_n_5 0 adc_mim_bank COUNT=32
Vs30_n_6 s30_n_6 0 DC 0 AC 1
Xs30_n_6 s30_n_6 0 adc_mim_bank COUNT=64
Vs30_n_7 s30_n_7 0 DC 0 AC 1
Xs30_n_7 s30_n_7 0 adc_mim_bank COUNT=128
Vs30_n_8 s30_n_8 0 DC 0 AC 1
Xs30_n_8 s30_n_8 0 adc_mim_bank COUNT=256
Vs30_n_9 s30_n_9 0 DC 0 AC 1
Xs30_n_9 s30_n_9 0 adc_mim_bank COUNT=512
Vs30_n_10 s30_n_10 0 DC 0 AC 1
Xs30_n_10 s30_n_10 0 adc_mim_bank COUNT=1024
Vs30_n_11 s30_n_11 0 DC 0 AC 1
Xs30_n_11 s30_n_11 0 adc_mim_bank COUNT=2048
Vs30_n_12 s30_n_12 0 DC 0 AC 1
Xs30_n_12 s30_n_12 0 adc_mim_bank COUNT=1
Vs31_p_0 s31_p_0 0 DC 0 AC 1
Xs31_p_0 s31_p_0 0 adc_mim_bank COUNT=1
Vs31_p_1 s31_p_1 0 DC 0 AC 1
Xs31_p_1 s31_p_1 0 adc_mim_bank COUNT=2
Vs31_p_2 s31_p_2 0 DC 0 AC 1
Xs31_p_2 s31_p_2 0 adc_mim_bank COUNT=4
Vs31_p_3 s31_p_3 0 DC 0 AC 1
Xs31_p_3 s31_p_3 0 adc_mim_bank COUNT=8
Vs31_p_4 s31_p_4 0 DC 0 AC 1
Xs31_p_4 s31_p_4 0 adc_mim_bank COUNT=16
Vs31_p_5 s31_p_5 0 DC 0 AC 1
Xs31_p_5 s31_p_5 0 adc_mim_bank COUNT=32
Vs31_p_6 s31_p_6 0 DC 0 AC 1
Xs31_p_6 s31_p_6 0 adc_mim_bank COUNT=64
Vs31_p_7 s31_p_7 0 DC 0 AC 1
Xs31_p_7 s31_p_7 0 adc_mim_bank COUNT=128
Vs31_p_8 s31_p_8 0 DC 0 AC 1
Xs31_p_8 s31_p_8 0 adc_mim_bank COUNT=256
Vs31_p_9 s31_p_9 0 DC 0 AC 1
Xs31_p_9 s31_p_9 0 adc_mim_bank COUNT=512
Vs31_p_10 s31_p_10 0 DC 0 AC 1
Xs31_p_10 s31_p_10 0 adc_mim_bank COUNT=1024
Vs31_p_11 s31_p_11 0 DC 0 AC 1
Xs31_p_11 s31_p_11 0 adc_mim_bank COUNT=2048
Vs31_p_12 s31_p_12 0 DC 0 AC 1
Xs31_p_12 s31_p_12 0 adc_mim_bank COUNT=1
Vs31_n_0 s31_n_0 0 DC 0 AC 1
Xs31_n_0 s31_n_0 0 adc_mim_bank COUNT=1
Vs31_n_1 s31_n_1 0 DC 0 AC 1
Xs31_n_1 s31_n_1 0 adc_mim_bank COUNT=2
Vs31_n_2 s31_n_2 0 DC 0 AC 1
Xs31_n_2 s31_n_2 0 adc_mim_bank COUNT=4
Vs31_n_3 s31_n_3 0 DC 0 AC 1
Xs31_n_3 s31_n_3 0 adc_mim_bank COUNT=8
Vs31_n_4 s31_n_4 0 DC 0 AC 1
Xs31_n_4 s31_n_4 0 adc_mim_bank COUNT=16
Vs31_n_5 s31_n_5 0 DC 0 AC 1
Xs31_n_5 s31_n_5 0 adc_mim_bank COUNT=32
Vs31_n_6 s31_n_6 0 DC 0 AC 1
Xs31_n_6 s31_n_6 0 adc_mim_bank COUNT=64
Vs31_n_7 s31_n_7 0 DC 0 AC 1
Xs31_n_7 s31_n_7 0 adc_mim_bank COUNT=128
Vs31_n_8 s31_n_8 0 DC 0 AC 1
Xs31_n_8 s31_n_8 0 adc_mim_bank COUNT=256
Vs31_n_9 s31_n_9 0 DC 0 AC 1
Xs31_n_9 s31_n_9 0 adc_mim_bank COUNT=512
Vs31_n_10 s31_n_10 0 DC 0 AC 1
Xs31_n_10 s31_n_10 0 adc_mim_bank COUNT=1024
Vs31_n_11 s31_n_11 0 DC 0 AC 1
Xs31_n_11 s31_n_11 0 adc_mim_bank COUNT=2048
Vs31_n_12 s31_n_12 0 DC 0 AC 1
Xs31_n_12 s31_n_12 0 adc_mim_bank COUNT=1
Vs32_p_0 s32_p_0 0 DC 0 AC 1
Xs32_p_0 s32_p_0 0 adc_mim_bank COUNT=1
Vs32_p_1 s32_p_1 0 DC 0 AC 1
Xs32_p_1 s32_p_1 0 adc_mim_bank COUNT=2
Vs32_p_2 s32_p_2 0 DC 0 AC 1
Xs32_p_2 s32_p_2 0 adc_mim_bank COUNT=4
Vs32_p_3 s32_p_3 0 DC 0 AC 1
Xs32_p_3 s32_p_3 0 adc_mim_bank COUNT=8
Vs32_p_4 s32_p_4 0 DC 0 AC 1
Xs32_p_4 s32_p_4 0 adc_mim_bank COUNT=16
Vs32_p_5 s32_p_5 0 DC 0 AC 1
Xs32_p_5 s32_p_5 0 adc_mim_bank COUNT=32
Vs32_p_6 s32_p_6 0 DC 0 AC 1
Xs32_p_6 s32_p_6 0 adc_mim_bank COUNT=64
Vs32_p_7 s32_p_7 0 DC 0 AC 1
Xs32_p_7 s32_p_7 0 adc_mim_bank COUNT=128
Vs32_p_8 s32_p_8 0 DC 0 AC 1
Xs32_p_8 s32_p_8 0 adc_mim_bank COUNT=256
Vs32_p_9 s32_p_9 0 DC 0 AC 1
Xs32_p_9 s32_p_9 0 adc_mim_bank COUNT=512
Vs32_p_10 s32_p_10 0 DC 0 AC 1
Xs32_p_10 s32_p_10 0 adc_mim_bank COUNT=1024
Vs32_p_11 s32_p_11 0 DC 0 AC 1
Xs32_p_11 s32_p_11 0 adc_mim_bank COUNT=2048
Vs32_p_12 s32_p_12 0 DC 0 AC 1
Xs32_p_12 s32_p_12 0 adc_mim_bank COUNT=1
Vs32_n_0 s32_n_0 0 DC 0 AC 1
Xs32_n_0 s32_n_0 0 adc_mim_bank COUNT=1
Vs32_n_1 s32_n_1 0 DC 0 AC 1
Xs32_n_1 s32_n_1 0 adc_mim_bank COUNT=2
Vs32_n_2 s32_n_2 0 DC 0 AC 1
Xs32_n_2 s32_n_2 0 adc_mim_bank COUNT=4
Vs32_n_3 s32_n_3 0 DC 0 AC 1
Xs32_n_3 s32_n_3 0 adc_mim_bank COUNT=8
Vs32_n_4 s32_n_4 0 DC 0 AC 1
Xs32_n_4 s32_n_4 0 adc_mim_bank COUNT=16
Vs32_n_5 s32_n_5 0 DC 0 AC 1
Xs32_n_5 s32_n_5 0 adc_mim_bank COUNT=32
Vs32_n_6 s32_n_6 0 DC 0 AC 1
Xs32_n_6 s32_n_6 0 adc_mim_bank COUNT=64
Vs32_n_7 s32_n_7 0 DC 0 AC 1
Xs32_n_7 s32_n_7 0 adc_mim_bank COUNT=128
Vs32_n_8 s32_n_8 0 DC 0 AC 1
Xs32_n_8 s32_n_8 0 adc_mim_bank COUNT=256
Vs32_n_9 s32_n_9 0 DC 0 AC 1
Xs32_n_9 s32_n_9 0 adc_mim_bank COUNT=512
Vs32_n_10 s32_n_10 0 DC 0 AC 1
Xs32_n_10 s32_n_10 0 adc_mim_bank COUNT=1024
Vs32_n_11 s32_n_11 0 DC 0 AC 1
Xs32_n_11 s32_n_11 0 adc_mim_bank COUNT=2048
Vs32_n_12 s32_n_12 0 DC 0 AC 1
Xs32_n_12 s32_n_12 0 adc_mim_bank COUNT=1
Vs33_p_0 s33_p_0 0 DC 0 AC 1
Xs33_p_0 s33_p_0 0 adc_mim_bank COUNT=1
Vs33_p_1 s33_p_1 0 DC 0 AC 1
Xs33_p_1 s33_p_1 0 adc_mim_bank COUNT=2
Vs33_p_2 s33_p_2 0 DC 0 AC 1
Xs33_p_2 s33_p_2 0 adc_mim_bank COUNT=4
Vs33_p_3 s33_p_3 0 DC 0 AC 1
Xs33_p_3 s33_p_3 0 adc_mim_bank COUNT=8
Vs33_p_4 s33_p_4 0 DC 0 AC 1
Xs33_p_4 s33_p_4 0 adc_mim_bank COUNT=16
Vs33_p_5 s33_p_5 0 DC 0 AC 1
Xs33_p_5 s33_p_5 0 adc_mim_bank COUNT=32
Vs33_p_6 s33_p_6 0 DC 0 AC 1
Xs33_p_6 s33_p_6 0 adc_mim_bank COUNT=64
Vs33_p_7 s33_p_7 0 DC 0 AC 1
Xs33_p_7 s33_p_7 0 adc_mim_bank COUNT=128
Vs33_p_8 s33_p_8 0 DC 0 AC 1
Xs33_p_8 s33_p_8 0 adc_mim_bank COUNT=256
Vs33_p_9 s33_p_9 0 DC 0 AC 1
Xs33_p_9 s33_p_9 0 adc_mim_bank COUNT=512
Vs33_p_10 s33_p_10 0 DC 0 AC 1
Xs33_p_10 s33_p_10 0 adc_mim_bank COUNT=1024
Vs33_p_11 s33_p_11 0 DC 0 AC 1
Xs33_p_11 s33_p_11 0 adc_mim_bank COUNT=2048
Vs33_p_12 s33_p_12 0 DC 0 AC 1
Xs33_p_12 s33_p_12 0 adc_mim_bank COUNT=1
Vs33_n_0 s33_n_0 0 DC 0 AC 1
Xs33_n_0 s33_n_0 0 adc_mim_bank COUNT=1
Vs33_n_1 s33_n_1 0 DC 0 AC 1
Xs33_n_1 s33_n_1 0 adc_mim_bank COUNT=2
Vs33_n_2 s33_n_2 0 DC 0 AC 1
Xs33_n_2 s33_n_2 0 adc_mim_bank COUNT=4
Vs33_n_3 s33_n_3 0 DC 0 AC 1
Xs33_n_3 s33_n_3 0 adc_mim_bank COUNT=8
Vs33_n_4 s33_n_4 0 DC 0 AC 1
Xs33_n_4 s33_n_4 0 adc_mim_bank COUNT=16
Vs33_n_5 s33_n_5 0 DC 0 AC 1
Xs33_n_5 s33_n_5 0 adc_mim_bank COUNT=32
Vs33_n_6 s33_n_6 0 DC 0 AC 1
Xs33_n_6 s33_n_6 0 adc_mim_bank COUNT=64
Vs33_n_7 s33_n_7 0 DC 0 AC 1
Xs33_n_7 s33_n_7 0 adc_mim_bank COUNT=128
Vs33_n_8 s33_n_8 0 DC 0 AC 1
Xs33_n_8 s33_n_8 0 adc_mim_bank COUNT=256
Vs33_n_9 s33_n_9 0 DC 0 AC 1
Xs33_n_9 s33_n_9 0 adc_mim_bank COUNT=512
Vs33_n_10 s33_n_10 0 DC 0 AC 1
Xs33_n_10 s33_n_10 0 adc_mim_bank COUNT=1024
Vs33_n_11 s33_n_11 0 DC 0 AC 1
Xs33_n_11 s33_n_11 0 adc_mim_bank COUNT=2048
Vs33_n_12 s33_n_12 0 DC 0 AC 1
Xs33_n_12 s33_n_12 0 adc_mim_bank COUNT=1
Vs34_p_0 s34_p_0 0 DC 0 AC 1
Xs34_p_0 s34_p_0 0 adc_mim_bank COUNT=1
Vs34_p_1 s34_p_1 0 DC 0 AC 1
Xs34_p_1 s34_p_1 0 adc_mim_bank COUNT=2
Vs34_p_2 s34_p_2 0 DC 0 AC 1
Xs34_p_2 s34_p_2 0 adc_mim_bank COUNT=4
Vs34_p_3 s34_p_3 0 DC 0 AC 1
Xs34_p_3 s34_p_3 0 adc_mim_bank COUNT=8
Vs34_p_4 s34_p_4 0 DC 0 AC 1
Xs34_p_4 s34_p_4 0 adc_mim_bank COUNT=16
Vs34_p_5 s34_p_5 0 DC 0 AC 1
Xs34_p_5 s34_p_5 0 adc_mim_bank COUNT=32
Vs34_p_6 s34_p_6 0 DC 0 AC 1
Xs34_p_6 s34_p_6 0 adc_mim_bank COUNT=64
Vs34_p_7 s34_p_7 0 DC 0 AC 1
Xs34_p_7 s34_p_7 0 adc_mim_bank COUNT=128
Vs34_p_8 s34_p_8 0 DC 0 AC 1
Xs34_p_8 s34_p_8 0 adc_mim_bank COUNT=256
Vs34_p_9 s34_p_9 0 DC 0 AC 1
Xs34_p_9 s34_p_9 0 adc_mim_bank COUNT=512
Vs34_p_10 s34_p_10 0 DC 0 AC 1
Xs34_p_10 s34_p_10 0 adc_mim_bank COUNT=1024
Vs34_p_11 s34_p_11 0 DC 0 AC 1
Xs34_p_11 s34_p_11 0 adc_mim_bank COUNT=2048
Vs34_p_12 s34_p_12 0 DC 0 AC 1
Xs34_p_12 s34_p_12 0 adc_mim_bank COUNT=1
Vs34_n_0 s34_n_0 0 DC 0 AC 1
Xs34_n_0 s34_n_0 0 adc_mim_bank COUNT=1
Vs34_n_1 s34_n_1 0 DC 0 AC 1
Xs34_n_1 s34_n_1 0 adc_mim_bank COUNT=2
Vs34_n_2 s34_n_2 0 DC 0 AC 1
Xs34_n_2 s34_n_2 0 adc_mim_bank COUNT=4
Vs34_n_3 s34_n_3 0 DC 0 AC 1
Xs34_n_3 s34_n_3 0 adc_mim_bank COUNT=8
Vs34_n_4 s34_n_4 0 DC 0 AC 1
Xs34_n_4 s34_n_4 0 adc_mim_bank COUNT=16
Vs34_n_5 s34_n_5 0 DC 0 AC 1
Xs34_n_5 s34_n_5 0 adc_mim_bank COUNT=32
Vs34_n_6 s34_n_6 0 DC 0 AC 1
Xs34_n_6 s34_n_6 0 adc_mim_bank COUNT=64
Vs34_n_7 s34_n_7 0 DC 0 AC 1
Xs34_n_7 s34_n_7 0 adc_mim_bank COUNT=128
Vs34_n_8 s34_n_8 0 DC 0 AC 1
Xs34_n_8 s34_n_8 0 adc_mim_bank COUNT=256
Vs34_n_9 s34_n_9 0 DC 0 AC 1
Xs34_n_9 s34_n_9 0 adc_mim_bank COUNT=512
Vs34_n_10 s34_n_10 0 DC 0 AC 1
Xs34_n_10 s34_n_10 0 adc_mim_bank COUNT=1024
Vs34_n_11 s34_n_11 0 DC 0 AC 1
Xs34_n_11 s34_n_11 0 adc_mim_bank COUNT=2048
Vs34_n_12 s34_n_12 0 DC 0 AC 1
Xs34_n_12 s34_n_12 0 adc_mim_bank COUNT=1
Vs35_p_0 s35_p_0 0 DC 0 AC 1
Xs35_p_0 s35_p_0 0 adc_mim_bank COUNT=1
Vs35_p_1 s35_p_1 0 DC 0 AC 1
Xs35_p_1 s35_p_1 0 adc_mim_bank COUNT=2
Vs35_p_2 s35_p_2 0 DC 0 AC 1
Xs35_p_2 s35_p_2 0 adc_mim_bank COUNT=4
Vs35_p_3 s35_p_3 0 DC 0 AC 1
Xs35_p_3 s35_p_3 0 adc_mim_bank COUNT=8
Vs35_p_4 s35_p_4 0 DC 0 AC 1
Xs35_p_4 s35_p_4 0 adc_mim_bank COUNT=16
Vs35_p_5 s35_p_5 0 DC 0 AC 1
Xs35_p_5 s35_p_5 0 adc_mim_bank COUNT=32
Vs35_p_6 s35_p_6 0 DC 0 AC 1
Xs35_p_6 s35_p_6 0 adc_mim_bank COUNT=64
Vs35_p_7 s35_p_7 0 DC 0 AC 1
Xs35_p_7 s35_p_7 0 adc_mim_bank COUNT=128
Vs35_p_8 s35_p_8 0 DC 0 AC 1
Xs35_p_8 s35_p_8 0 adc_mim_bank COUNT=256
Vs35_p_9 s35_p_9 0 DC 0 AC 1
Xs35_p_9 s35_p_9 0 adc_mim_bank COUNT=512
Vs35_p_10 s35_p_10 0 DC 0 AC 1
Xs35_p_10 s35_p_10 0 adc_mim_bank COUNT=1024
Vs35_p_11 s35_p_11 0 DC 0 AC 1
Xs35_p_11 s35_p_11 0 adc_mim_bank COUNT=2048
Vs35_p_12 s35_p_12 0 DC 0 AC 1
Xs35_p_12 s35_p_12 0 adc_mim_bank COUNT=1
Vs35_n_0 s35_n_0 0 DC 0 AC 1
Xs35_n_0 s35_n_0 0 adc_mim_bank COUNT=1
Vs35_n_1 s35_n_1 0 DC 0 AC 1
Xs35_n_1 s35_n_1 0 adc_mim_bank COUNT=2
Vs35_n_2 s35_n_2 0 DC 0 AC 1
Xs35_n_2 s35_n_2 0 adc_mim_bank COUNT=4
Vs35_n_3 s35_n_3 0 DC 0 AC 1
Xs35_n_3 s35_n_3 0 adc_mim_bank COUNT=8
Vs35_n_4 s35_n_4 0 DC 0 AC 1
Xs35_n_4 s35_n_4 0 adc_mim_bank COUNT=16
Vs35_n_5 s35_n_5 0 DC 0 AC 1
Xs35_n_5 s35_n_5 0 adc_mim_bank COUNT=32
Vs35_n_6 s35_n_6 0 DC 0 AC 1
Xs35_n_6 s35_n_6 0 adc_mim_bank COUNT=64
Vs35_n_7 s35_n_7 0 DC 0 AC 1
Xs35_n_7 s35_n_7 0 adc_mim_bank COUNT=128
Vs35_n_8 s35_n_8 0 DC 0 AC 1
Xs35_n_8 s35_n_8 0 adc_mim_bank COUNT=256
Vs35_n_9 s35_n_9 0 DC 0 AC 1
Xs35_n_9 s35_n_9 0 adc_mim_bank COUNT=512
Vs35_n_10 s35_n_10 0 DC 0 AC 1
Xs35_n_10 s35_n_10 0 adc_mim_bank COUNT=1024
Vs35_n_11 s35_n_11 0 DC 0 AC 1
Xs35_n_11 s35_n_11 0 adc_mim_bank COUNT=2048
Vs35_n_12 s35_n_12 0 DC 0 AC 1
Xs35_n_12 s35_n_12 0 adc_mim_bank COUNT=1
Vs36_p_0 s36_p_0 0 DC 0 AC 1
Xs36_p_0 s36_p_0 0 adc_mim_bank COUNT=1
Vs36_p_1 s36_p_1 0 DC 0 AC 1
Xs36_p_1 s36_p_1 0 adc_mim_bank COUNT=2
Vs36_p_2 s36_p_2 0 DC 0 AC 1
Xs36_p_2 s36_p_2 0 adc_mim_bank COUNT=4
Vs36_p_3 s36_p_3 0 DC 0 AC 1
Xs36_p_3 s36_p_3 0 adc_mim_bank COUNT=8
Vs36_p_4 s36_p_4 0 DC 0 AC 1
Xs36_p_4 s36_p_4 0 adc_mim_bank COUNT=16
Vs36_p_5 s36_p_5 0 DC 0 AC 1
Xs36_p_5 s36_p_5 0 adc_mim_bank COUNT=32
Vs36_p_6 s36_p_6 0 DC 0 AC 1
Xs36_p_6 s36_p_6 0 adc_mim_bank COUNT=64
Vs36_p_7 s36_p_7 0 DC 0 AC 1
Xs36_p_7 s36_p_7 0 adc_mim_bank COUNT=128
Vs36_p_8 s36_p_8 0 DC 0 AC 1
Xs36_p_8 s36_p_8 0 adc_mim_bank COUNT=256
Vs36_p_9 s36_p_9 0 DC 0 AC 1
Xs36_p_9 s36_p_9 0 adc_mim_bank COUNT=512
Vs36_p_10 s36_p_10 0 DC 0 AC 1
Xs36_p_10 s36_p_10 0 adc_mim_bank COUNT=1024
Vs36_p_11 s36_p_11 0 DC 0 AC 1
Xs36_p_11 s36_p_11 0 adc_mim_bank COUNT=2048
Vs36_p_12 s36_p_12 0 DC 0 AC 1
Xs36_p_12 s36_p_12 0 adc_mim_bank COUNT=1
Vs36_n_0 s36_n_0 0 DC 0 AC 1
Xs36_n_0 s36_n_0 0 adc_mim_bank COUNT=1
Vs36_n_1 s36_n_1 0 DC 0 AC 1
Xs36_n_1 s36_n_1 0 adc_mim_bank COUNT=2
Vs36_n_2 s36_n_2 0 DC 0 AC 1
Xs36_n_2 s36_n_2 0 adc_mim_bank COUNT=4
Vs36_n_3 s36_n_3 0 DC 0 AC 1
Xs36_n_3 s36_n_3 0 adc_mim_bank COUNT=8
Vs36_n_4 s36_n_4 0 DC 0 AC 1
Xs36_n_4 s36_n_4 0 adc_mim_bank COUNT=16
Vs36_n_5 s36_n_5 0 DC 0 AC 1
Xs36_n_5 s36_n_5 0 adc_mim_bank COUNT=32
Vs36_n_6 s36_n_6 0 DC 0 AC 1
Xs36_n_6 s36_n_6 0 adc_mim_bank COUNT=64
Vs36_n_7 s36_n_7 0 DC 0 AC 1
Xs36_n_7 s36_n_7 0 adc_mim_bank COUNT=128
Vs36_n_8 s36_n_8 0 DC 0 AC 1
Xs36_n_8 s36_n_8 0 adc_mim_bank COUNT=256
Vs36_n_9 s36_n_9 0 DC 0 AC 1
Xs36_n_9 s36_n_9 0 adc_mim_bank COUNT=512
Vs36_n_10 s36_n_10 0 DC 0 AC 1
Xs36_n_10 s36_n_10 0 adc_mim_bank COUNT=1024
Vs36_n_11 s36_n_11 0 DC 0 AC 1
Xs36_n_11 s36_n_11 0 adc_mim_bank COUNT=2048
Vs36_n_12 s36_n_12 0 DC 0 AC 1
Xs36_n_12 s36_n_12 0 adc_mim_bank COUNT=1
Vs37_p_0 s37_p_0 0 DC 0 AC 1
Xs37_p_0 s37_p_0 0 adc_mim_bank COUNT=1
Vs37_p_1 s37_p_1 0 DC 0 AC 1
Xs37_p_1 s37_p_1 0 adc_mim_bank COUNT=2
Vs37_p_2 s37_p_2 0 DC 0 AC 1
Xs37_p_2 s37_p_2 0 adc_mim_bank COUNT=4
Vs37_p_3 s37_p_3 0 DC 0 AC 1
Xs37_p_3 s37_p_3 0 adc_mim_bank COUNT=8
Vs37_p_4 s37_p_4 0 DC 0 AC 1
Xs37_p_4 s37_p_4 0 adc_mim_bank COUNT=16
Vs37_p_5 s37_p_5 0 DC 0 AC 1
Xs37_p_5 s37_p_5 0 adc_mim_bank COUNT=32
Vs37_p_6 s37_p_6 0 DC 0 AC 1
Xs37_p_6 s37_p_6 0 adc_mim_bank COUNT=64
Vs37_p_7 s37_p_7 0 DC 0 AC 1
Xs37_p_7 s37_p_7 0 adc_mim_bank COUNT=128
Vs37_p_8 s37_p_8 0 DC 0 AC 1
Xs37_p_8 s37_p_8 0 adc_mim_bank COUNT=256
Vs37_p_9 s37_p_9 0 DC 0 AC 1
Xs37_p_9 s37_p_9 0 adc_mim_bank COUNT=512
Vs37_p_10 s37_p_10 0 DC 0 AC 1
Xs37_p_10 s37_p_10 0 adc_mim_bank COUNT=1024
Vs37_p_11 s37_p_11 0 DC 0 AC 1
Xs37_p_11 s37_p_11 0 adc_mim_bank COUNT=2048
Vs37_p_12 s37_p_12 0 DC 0 AC 1
Xs37_p_12 s37_p_12 0 adc_mim_bank COUNT=1
Vs37_n_0 s37_n_0 0 DC 0 AC 1
Xs37_n_0 s37_n_0 0 adc_mim_bank COUNT=1
Vs37_n_1 s37_n_1 0 DC 0 AC 1
Xs37_n_1 s37_n_1 0 adc_mim_bank COUNT=2
Vs37_n_2 s37_n_2 0 DC 0 AC 1
Xs37_n_2 s37_n_2 0 adc_mim_bank COUNT=4
Vs37_n_3 s37_n_3 0 DC 0 AC 1
Xs37_n_3 s37_n_3 0 adc_mim_bank COUNT=8
Vs37_n_4 s37_n_4 0 DC 0 AC 1
Xs37_n_4 s37_n_4 0 adc_mim_bank COUNT=16
Vs37_n_5 s37_n_5 0 DC 0 AC 1
Xs37_n_5 s37_n_5 0 adc_mim_bank COUNT=32
Vs37_n_6 s37_n_6 0 DC 0 AC 1
Xs37_n_6 s37_n_6 0 adc_mim_bank COUNT=64
Vs37_n_7 s37_n_7 0 DC 0 AC 1
Xs37_n_7 s37_n_7 0 adc_mim_bank COUNT=128
Vs37_n_8 s37_n_8 0 DC 0 AC 1
Xs37_n_8 s37_n_8 0 adc_mim_bank COUNT=256
Vs37_n_9 s37_n_9 0 DC 0 AC 1
Xs37_n_9 s37_n_9 0 adc_mim_bank COUNT=512
Vs37_n_10 s37_n_10 0 DC 0 AC 1
Xs37_n_10 s37_n_10 0 adc_mim_bank COUNT=1024
Vs37_n_11 s37_n_11 0 DC 0 AC 1
Xs37_n_11 s37_n_11 0 adc_mim_bank COUNT=2048
Vs37_n_12 s37_n_12 0 DC 0 AC 1
Xs37_n_12 s37_n_12 0 adc_mim_bank COUNT=1
Vs38_p_0 s38_p_0 0 DC 0 AC 1
Xs38_p_0 s38_p_0 0 adc_mim_bank COUNT=1
Vs38_p_1 s38_p_1 0 DC 0 AC 1
Xs38_p_1 s38_p_1 0 adc_mim_bank COUNT=2
Vs38_p_2 s38_p_2 0 DC 0 AC 1
Xs38_p_2 s38_p_2 0 adc_mim_bank COUNT=4
Vs38_p_3 s38_p_3 0 DC 0 AC 1
Xs38_p_3 s38_p_3 0 adc_mim_bank COUNT=8
Vs38_p_4 s38_p_4 0 DC 0 AC 1
Xs38_p_4 s38_p_4 0 adc_mim_bank COUNT=16
Vs38_p_5 s38_p_5 0 DC 0 AC 1
Xs38_p_5 s38_p_5 0 adc_mim_bank COUNT=32
Vs38_p_6 s38_p_6 0 DC 0 AC 1
Xs38_p_6 s38_p_6 0 adc_mim_bank COUNT=64
Vs38_p_7 s38_p_7 0 DC 0 AC 1
Xs38_p_7 s38_p_7 0 adc_mim_bank COUNT=128
Vs38_p_8 s38_p_8 0 DC 0 AC 1
Xs38_p_8 s38_p_8 0 adc_mim_bank COUNT=256
Vs38_p_9 s38_p_9 0 DC 0 AC 1
Xs38_p_9 s38_p_9 0 adc_mim_bank COUNT=512
Vs38_p_10 s38_p_10 0 DC 0 AC 1
Xs38_p_10 s38_p_10 0 adc_mim_bank COUNT=1024
Vs38_p_11 s38_p_11 0 DC 0 AC 1
Xs38_p_11 s38_p_11 0 adc_mim_bank COUNT=2048
Vs38_p_12 s38_p_12 0 DC 0 AC 1
Xs38_p_12 s38_p_12 0 adc_mim_bank COUNT=1
Vs38_n_0 s38_n_0 0 DC 0 AC 1
Xs38_n_0 s38_n_0 0 adc_mim_bank COUNT=1
Vs38_n_1 s38_n_1 0 DC 0 AC 1
Xs38_n_1 s38_n_1 0 adc_mim_bank COUNT=2
Vs38_n_2 s38_n_2 0 DC 0 AC 1
Xs38_n_2 s38_n_2 0 adc_mim_bank COUNT=4
Vs38_n_3 s38_n_3 0 DC 0 AC 1
Xs38_n_3 s38_n_3 0 adc_mim_bank COUNT=8
Vs38_n_4 s38_n_4 0 DC 0 AC 1
Xs38_n_4 s38_n_4 0 adc_mim_bank COUNT=16
Vs38_n_5 s38_n_5 0 DC 0 AC 1
Xs38_n_5 s38_n_5 0 adc_mim_bank COUNT=32
Vs38_n_6 s38_n_6 0 DC 0 AC 1
Xs38_n_6 s38_n_6 0 adc_mim_bank COUNT=64
Vs38_n_7 s38_n_7 0 DC 0 AC 1
Xs38_n_7 s38_n_7 0 adc_mim_bank COUNT=128
Vs38_n_8 s38_n_8 0 DC 0 AC 1
Xs38_n_8 s38_n_8 0 adc_mim_bank COUNT=256
Vs38_n_9 s38_n_9 0 DC 0 AC 1
Xs38_n_9 s38_n_9 0 adc_mim_bank COUNT=512
Vs38_n_10 s38_n_10 0 DC 0 AC 1
Xs38_n_10 s38_n_10 0 adc_mim_bank COUNT=1024
Vs38_n_11 s38_n_11 0 DC 0 AC 1
Xs38_n_11 s38_n_11 0 adc_mim_bank COUNT=2048
Vs38_n_12 s38_n_12 0 DC 0 AC 1
Xs38_n_12 s38_n_12 0 adc_mim_bank COUNT=1
Vs39_p_0 s39_p_0 0 DC 0 AC 1
Xs39_p_0 s39_p_0 0 adc_mim_bank COUNT=1
Vs39_p_1 s39_p_1 0 DC 0 AC 1
Xs39_p_1 s39_p_1 0 adc_mim_bank COUNT=2
Vs39_p_2 s39_p_2 0 DC 0 AC 1
Xs39_p_2 s39_p_2 0 adc_mim_bank COUNT=4
Vs39_p_3 s39_p_3 0 DC 0 AC 1
Xs39_p_3 s39_p_3 0 adc_mim_bank COUNT=8
Vs39_p_4 s39_p_4 0 DC 0 AC 1
Xs39_p_4 s39_p_4 0 adc_mim_bank COUNT=16
Vs39_p_5 s39_p_5 0 DC 0 AC 1
Xs39_p_5 s39_p_5 0 adc_mim_bank COUNT=32
Vs39_p_6 s39_p_6 0 DC 0 AC 1
Xs39_p_6 s39_p_6 0 adc_mim_bank COUNT=64
Vs39_p_7 s39_p_7 0 DC 0 AC 1
Xs39_p_7 s39_p_7 0 adc_mim_bank COUNT=128
Vs39_p_8 s39_p_8 0 DC 0 AC 1
Xs39_p_8 s39_p_8 0 adc_mim_bank COUNT=256
Vs39_p_9 s39_p_9 0 DC 0 AC 1
Xs39_p_9 s39_p_9 0 adc_mim_bank COUNT=512
Vs39_p_10 s39_p_10 0 DC 0 AC 1
Xs39_p_10 s39_p_10 0 adc_mim_bank COUNT=1024
Vs39_p_11 s39_p_11 0 DC 0 AC 1
Xs39_p_11 s39_p_11 0 adc_mim_bank COUNT=2048
Vs39_p_12 s39_p_12 0 DC 0 AC 1
Xs39_p_12 s39_p_12 0 adc_mim_bank COUNT=1
Vs39_n_0 s39_n_0 0 DC 0 AC 1
Xs39_n_0 s39_n_0 0 adc_mim_bank COUNT=1
Vs39_n_1 s39_n_1 0 DC 0 AC 1
Xs39_n_1 s39_n_1 0 adc_mim_bank COUNT=2
Vs39_n_2 s39_n_2 0 DC 0 AC 1
Xs39_n_2 s39_n_2 0 adc_mim_bank COUNT=4
Vs39_n_3 s39_n_3 0 DC 0 AC 1
Xs39_n_3 s39_n_3 0 adc_mim_bank COUNT=8
Vs39_n_4 s39_n_4 0 DC 0 AC 1
Xs39_n_4 s39_n_4 0 adc_mim_bank COUNT=16
Vs39_n_5 s39_n_5 0 DC 0 AC 1
Xs39_n_5 s39_n_5 0 adc_mim_bank COUNT=32
Vs39_n_6 s39_n_6 0 DC 0 AC 1
Xs39_n_6 s39_n_6 0 adc_mim_bank COUNT=64
Vs39_n_7 s39_n_7 0 DC 0 AC 1
Xs39_n_7 s39_n_7 0 adc_mim_bank COUNT=128
Vs39_n_8 s39_n_8 0 DC 0 AC 1
Xs39_n_8 s39_n_8 0 adc_mim_bank COUNT=256
Vs39_n_9 s39_n_9 0 DC 0 AC 1
Xs39_n_9 s39_n_9 0 adc_mim_bank COUNT=512
Vs39_n_10 s39_n_10 0 DC 0 AC 1
Xs39_n_10 s39_n_10 0 adc_mim_bank COUNT=1024
Vs39_n_11 s39_n_11 0 DC 0 AC 1
Xs39_n_11 s39_n_11 0 adc_mim_bank COUNT=2048
Vs39_n_12 s39_n_12 0 DC 0 AC 1
Xs39_n_12 s39_n_12 0 adc_mim_bank COUNT=1
Vs40_p_0 s40_p_0 0 DC 0 AC 1
Xs40_p_0 s40_p_0 0 adc_mim_bank COUNT=1
Vs40_p_1 s40_p_1 0 DC 0 AC 1
Xs40_p_1 s40_p_1 0 adc_mim_bank COUNT=2
Vs40_p_2 s40_p_2 0 DC 0 AC 1
Xs40_p_2 s40_p_2 0 adc_mim_bank COUNT=4
Vs40_p_3 s40_p_3 0 DC 0 AC 1
Xs40_p_3 s40_p_3 0 adc_mim_bank COUNT=8
Vs40_p_4 s40_p_4 0 DC 0 AC 1
Xs40_p_4 s40_p_4 0 adc_mim_bank COUNT=16
Vs40_p_5 s40_p_5 0 DC 0 AC 1
Xs40_p_5 s40_p_5 0 adc_mim_bank COUNT=32
Vs40_p_6 s40_p_6 0 DC 0 AC 1
Xs40_p_6 s40_p_6 0 adc_mim_bank COUNT=64
Vs40_p_7 s40_p_7 0 DC 0 AC 1
Xs40_p_7 s40_p_7 0 adc_mim_bank COUNT=128
Vs40_p_8 s40_p_8 0 DC 0 AC 1
Xs40_p_8 s40_p_8 0 adc_mim_bank COUNT=256
Vs40_p_9 s40_p_9 0 DC 0 AC 1
Xs40_p_9 s40_p_9 0 adc_mim_bank COUNT=512
Vs40_p_10 s40_p_10 0 DC 0 AC 1
Xs40_p_10 s40_p_10 0 adc_mim_bank COUNT=1024
Vs40_p_11 s40_p_11 0 DC 0 AC 1
Xs40_p_11 s40_p_11 0 adc_mim_bank COUNT=2048
Vs40_p_12 s40_p_12 0 DC 0 AC 1
Xs40_p_12 s40_p_12 0 adc_mim_bank COUNT=1
Vs40_n_0 s40_n_0 0 DC 0 AC 1
Xs40_n_0 s40_n_0 0 adc_mim_bank COUNT=1
Vs40_n_1 s40_n_1 0 DC 0 AC 1
Xs40_n_1 s40_n_1 0 adc_mim_bank COUNT=2
Vs40_n_2 s40_n_2 0 DC 0 AC 1
Xs40_n_2 s40_n_2 0 adc_mim_bank COUNT=4
Vs40_n_3 s40_n_3 0 DC 0 AC 1
Xs40_n_3 s40_n_3 0 adc_mim_bank COUNT=8
Vs40_n_4 s40_n_4 0 DC 0 AC 1
Xs40_n_4 s40_n_4 0 adc_mim_bank COUNT=16
Vs40_n_5 s40_n_5 0 DC 0 AC 1
Xs40_n_5 s40_n_5 0 adc_mim_bank COUNT=32
Vs40_n_6 s40_n_6 0 DC 0 AC 1
Xs40_n_6 s40_n_6 0 adc_mim_bank COUNT=64
Vs40_n_7 s40_n_7 0 DC 0 AC 1
Xs40_n_7 s40_n_7 0 adc_mim_bank COUNT=128
Vs40_n_8 s40_n_8 0 DC 0 AC 1
Xs40_n_8 s40_n_8 0 adc_mim_bank COUNT=256
Vs40_n_9 s40_n_9 0 DC 0 AC 1
Xs40_n_9 s40_n_9 0 adc_mim_bank COUNT=512
Vs40_n_10 s40_n_10 0 DC 0 AC 1
Xs40_n_10 s40_n_10 0 adc_mim_bank COUNT=1024
Vs40_n_11 s40_n_11 0 DC 0 AC 1
Xs40_n_11 s40_n_11 0 adc_mim_bank COUNT=2048
Vs40_n_12 s40_n_12 0 DC 0 AC 1
Xs40_n_12 s40_n_12 0 adc_mim_bank COUNT=1
Vs41_p_0 s41_p_0 0 DC 0 AC 1
Xs41_p_0 s41_p_0 0 adc_mim_bank COUNT=1
Vs41_p_1 s41_p_1 0 DC 0 AC 1
Xs41_p_1 s41_p_1 0 adc_mim_bank COUNT=2
Vs41_p_2 s41_p_2 0 DC 0 AC 1
Xs41_p_2 s41_p_2 0 adc_mim_bank COUNT=4
Vs41_p_3 s41_p_3 0 DC 0 AC 1
Xs41_p_3 s41_p_3 0 adc_mim_bank COUNT=8
Vs41_p_4 s41_p_4 0 DC 0 AC 1
Xs41_p_4 s41_p_4 0 adc_mim_bank COUNT=16
Vs41_p_5 s41_p_5 0 DC 0 AC 1
Xs41_p_5 s41_p_5 0 adc_mim_bank COUNT=32
Vs41_p_6 s41_p_6 0 DC 0 AC 1
Xs41_p_6 s41_p_6 0 adc_mim_bank COUNT=64
Vs41_p_7 s41_p_7 0 DC 0 AC 1
Xs41_p_7 s41_p_7 0 adc_mim_bank COUNT=128
Vs41_p_8 s41_p_8 0 DC 0 AC 1
Xs41_p_8 s41_p_8 0 adc_mim_bank COUNT=256
Vs41_p_9 s41_p_9 0 DC 0 AC 1
Xs41_p_9 s41_p_9 0 adc_mim_bank COUNT=512
Vs41_p_10 s41_p_10 0 DC 0 AC 1
Xs41_p_10 s41_p_10 0 adc_mim_bank COUNT=1024
Vs41_p_11 s41_p_11 0 DC 0 AC 1
Xs41_p_11 s41_p_11 0 adc_mim_bank COUNT=2048
Vs41_p_12 s41_p_12 0 DC 0 AC 1
Xs41_p_12 s41_p_12 0 adc_mim_bank COUNT=1
Vs41_n_0 s41_n_0 0 DC 0 AC 1
Xs41_n_0 s41_n_0 0 adc_mim_bank COUNT=1
Vs41_n_1 s41_n_1 0 DC 0 AC 1
Xs41_n_1 s41_n_1 0 adc_mim_bank COUNT=2
Vs41_n_2 s41_n_2 0 DC 0 AC 1
Xs41_n_2 s41_n_2 0 adc_mim_bank COUNT=4
Vs41_n_3 s41_n_3 0 DC 0 AC 1
Xs41_n_3 s41_n_3 0 adc_mim_bank COUNT=8
Vs41_n_4 s41_n_4 0 DC 0 AC 1
Xs41_n_4 s41_n_4 0 adc_mim_bank COUNT=16
Vs41_n_5 s41_n_5 0 DC 0 AC 1
Xs41_n_5 s41_n_5 0 adc_mim_bank COUNT=32
Vs41_n_6 s41_n_6 0 DC 0 AC 1
Xs41_n_6 s41_n_6 0 adc_mim_bank COUNT=64
Vs41_n_7 s41_n_7 0 DC 0 AC 1
Xs41_n_7 s41_n_7 0 adc_mim_bank COUNT=128
Vs41_n_8 s41_n_8 0 DC 0 AC 1
Xs41_n_8 s41_n_8 0 adc_mim_bank COUNT=256
Vs41_n_9 s41_n_9 0 DC 0 AC 1
Xs41_n_9 s41_n_9 0 adc_mim_bank COUNT=512
Vs41_n_10 s41_n_10 0 DC 0 AC 1
Xs41_n_10 s41_n_10 0 adc_mim_bank COUNT=1024
Vs41_n_11 s41_n_11 0 DC 0 AC 1
Xs41_n_11 s41_n_11 0 adc_mim_bank COUNT=2048
Vs41_n_12 s41_n_12 0 DC 0 AC 1
Xs41_n_12 s41_n_12 0 adc_mim_bank COUNT=1
Vs42_p_0 s42_p_0 0 DC 0 AC 1
Xs42_p_0 s42_p_0 0 adc_mim_bank COUNT=1
Vs42_p_1 s42_p_1 0 DC 0 AC 1
Xs42_p_1 s42_p_1 0 adc_mim_bank COUNT=2
Vs42_p_2 s42_p_2 0 DC 0 AC 1
Xs42_p_2 s42_p_2 0 adc_mim_bank COUNT=4
Vs42_p_3 s42_p_3 0 DC 0 AC 1
Xs42_p_3 s42_p_3 0 adc_mim_bank COUNT=8
Vs42_p_4 s42_p_4 0 DC 0 AC 1
Xs42_p_4 s42_p_4 0 adc_mim_bank COUNT=16
Vs42_p_5 s42_p_5 0 DC 0 AC 1
Xs42_p_5 s42_p_5 0 adc_mim_bank COUNT=32
Vs42_p_6 s42_p_6 0 DC 0 AC 1
Xs42_p_6 s42_p_6 0 adc_mim_bank COUNT=64
Vs42_p_7 s42_p_7 0 DC 0 AC 1
Xs42_p_7 s42_p_7 0 adc_mim_bank COUNT=128
Vs42_p_8 s42_p_8 0 DC 0 AC 1
Xs42_p_8 s42_p_8 0 adc_mim_bank COUNT=256
Vs42_p_9 s42_p_9 0 DC 0 AC 1
Xs42_p_9 s42_p_9 0 adc_mim_bank COUNT=512
Vs42_p_10 s42_p_10 0 DC 0 AC 1
Xs42_p_10 s42_p_10 0 adc_mim_bank COUNT=1024
Vs42_p_11 s42_p_11 0 DC 0 AC 1
Xs42_p_11 s42_p_11 0 adc_mim_bank COUNT=2048
Vs42_p_12 s42_p_12 0 DC 0 AC 1
Xs42_p_12 s42_p_12 0 adc_mim_bank COUNT=1
Vs42_n_0 s42_n_0 0 DC 0 AC 1
Xs42_n_0 s42_n_0 0 adc_mim_bank COUNT=1
Vs42_n_1 s42_n_1 0 DC 0 AC 1
Xs42_n_1 s42_n_1 0 adc_mim_bank COUNT=2
Vs42_n_2 s42_n_2 0 DC 0 AC 1
Xs42_n_2 s42_n_2 0 adc_mim_bank COUNT=4
Vs42_n_3 s42_n_3 0 DC 0 AC 1
Xs42_n_3 s42_n_3 0 adc_mim_bank COUNT=8
Vs42_n_4 s42_n_4 0 DC 0 AC 1
Xs42_n_4 s42_n_4 0 adc_mim_bank COUNT=16
Vs42_n_5 s42_n_5 0 DC 0 AC 1
Xs42_n_5 s42_n_5 0 adc_mim_bank COUNT=32
Vs42_n_6 s42_n_6 0 DC 0 AC 1
Xs42_n_6 s42_n_6 0 adc_mim_bank COUNT=64
Vs42_n_7 s42_n_7 0 DC 0 AC 1
Xs42_n_7 s42_n_7 0 adc_mim_bank COUNT=128
Vs42_n_8 s42_n_8 0 DC 0 AC 1
Xs42_n_8 s42_n_8 0 adc_mim_bank COUNT=256
Vs42_n_9 s42_n_9 0 DC 0 AC 1
Xs42_n_9 s42_n_9 0 adc_mim_bank COUNT=512
Vs42_n_10 s42_n_10 0 DC 0 AC 1
Xs42_n_10 s42_n_10 0 adc_mim_bank COUNT=1024
Vs42_n_11 s42_n_11 0 DC 0 AC 1
Xs42_n_11 s42_n_11 0 adc_mim_bank COUNT=2048
Vs42_n_12 s42_n_12 0 DC 0 AC 1
Xs42_n_12 s42_n_12 0 adc_mim_bank COUNT=1
Vs43_p_0 s43_p_0 0 DC 0 AC 1
Xs43_p_0 s43_p_0 0 adc_mim_bank COUNT=1
Vs43_p_1 s43_p_1 0 DC 0 AC 1
Xs43_p_1 s43_p_1 0 adc_mim_bank COUNT=2
Vs43_p_2 s43_p_2 0 DC 0 AC 1
Xs43_p_2 s43_p_2 0 adc_mim_bank COUNT=4
Vs43_p_3 s43_p_3 0 DC 0 AC 1
Xs43_p_3 s43_p_3 0 adc_mim_bank COUNT=8
Vs43_p_4 s43_p_4 0 DC 0 AC 1
Xs43_p_4 s43_p_4 0 adc_mim_bank COUNT=16
Vs43_p_5 s43_p_5 0 DC 0 AC 1
Xs43_p_5 s43_p_5 0 adc_mim_bank COUNT=32
Vs43_p_6 s43_p_6 0 DC 0 AC 1
Xs43_p_6 s43_p_6 0 adc_mim_bank COUNT=64
Vs43_p_7 s43_p_7 0 DC 0 AC 1
Xs43_p_7 s43_p_7 0 adc_mim_bank COUNT=128
Vs43_p_8 s43_p_8 0 DC 0 AC 1
Xs43_p_8 s43_p_8 0 adc_mim_bank COUNT=256
Vs43_p_9 s43_p_9 0 DC 0 AC 1
Xs43_p_9 s43_p_9 0 adc_mim_bank COUNT=512
Vs43_p_10 s43_p_10 0 DC 0 AC 1
Xs43_p_10 s43_p_10 0 adc_mim_bank COUNT=1024
Vs43_p_11 s43_p_11 0 DC 0 AC 1
Xs43_p_11 s43_p_11 0 adc_mim_bank COUNT=2048
Vs43_p_12 s43_p_12 0 DC 0 AC 1
Xs43_p_12 s43_p_12 0 adc_mim_bank COUNT=1
Vs43_n_0 s43_n_0 0 DC 0 AC 1
Xs43_n_0 s43_n_0 0 adc_mim_bank COUNT=1
Vs43_n_1 s43_n_1 0 DC 0 AC 1
Xs43_n_1 s43_n_1 0 adc_mim_bank COUNT=2
Vs43_n_2 s43_n_2 0 DC 0 AC 1
Xs43_n_2 s43_n_2 0 adc_mim_bank COUNT=4
Vs43_n_3 s43_n_3 0 DC 0 AC 1
Xs43_n_3 s43_n_3 0 adc_mim_bank COUNT=8
Vs43_n_4 s43_n_4 0 DC 0 AC 1
Xs43_n_4 s43_n_4 0 adc_mim_bank COUNT=16
Vs43_n_5 s43_n_5 0 DC 0 AC 1
Xs43_n_5 s43_n_5 0 adc_mim_bank COUNT=32
Vs43_n_6 s43_n_6 0 DC 0 AC 1
Xs43_n_6 s43_n_6 0 adc_mim_bank COUNT=64
Vs43_n_7 s43_n_7 0 DC 0 AC 1
Xs43_n_7 s43_n_7 0 adc_mim_bank COUNT=128
Vs43_n_8 s43_n_8 0 DC 0 AC 1
Xs43_n_8 s43_n_8 0 adc_mim_bank COUNT=256
Vs43_n_9 s43_n_9 0 DC 0 AC 1
Xs43_n_9 s43_n_9 0 adc_mim_bank COUNT=512
Vs43_n_10 s43_n_10 0 DC 0 AC 1
Xs43_n_10 s43_n_10 0 adc_mim_bank COUNT=1024
Vs43_n_11 s43_n_11 0 DC 0 AC 1
Xs43_n_11 s43_n_11 0 adc_mim_bank COUNT=2048
Vs43_n_12 s43_n_12 0 DC 0 AC 1
Xs43_n_12 s43_n_12 0 adc_mim_bank COUNT=1
Vs44_p_0 s44_p_0 0 DC 0 AC 1
Xs44_p_0 s44_p_0 0 adc_mim_bank COUNT=1
Vs44_p_1 s44_p_1 0 DC 0 AC 1
Xs44_p_1 s44_p_1 0 adc_mim_bank COUNT=2
Vs44_p_2 s44_p_2 0 DC 0 AC 1
Xs44_p_2 s44_p_2 0 adc_mim_bank COUNT=4
Vs44_p_3 s44_p_3 0 DC 0 AC 1
Xs44_p_3 s44_p_3 0 adc_mim_bank COUNT=8
Vs44_p_4 s44_p_4 0 DC 0 AC 1
Xs44_p_4 s44_p_4 0 adc_mim_bank COUNT=16
Vs44_p_5 s44_p_5 0 DC 0 AC 1
Xs44_p_5 s44_p_5 0 adc_mim_bank COUNT=32
Vs44_p_6 s44_p_6 0 DC 0 AC 1
Xs44_p_6 s44_p_6 0 adc_mim_bank COUNT=64
Vs44_p_7 s44_p_7 0 DC 0 AC 1
Xs44_p_7 s44_p_7 0 adc_mim_bank COUNT=128
Vs44_p_8 s44_p_8 0 DC 0 AC 1
Xs44_p_8 s44_p_8 0 adc_mim_bank COUNT=256
Vs44_p_9 s44_p_9 0 DC 0 AC 1
Xs44_p_9 s44_p_9 0 adc_mim_bank COUNT=512
Vs44_p_10 s44_p_10 0 DC 0 AC 1
Xs44_p_10 s44_p_10 0 adc_mim_bank COUNT=1024
Vs44_p_11 s44_p_11 0 DC 0 AC 1
Xs44_p_11 s44_p_11 0 adc_mim_bank COUNT=2048
Vs44_p_12 s44_p_12 0 DC 0 AC 1
Xs44_p_12 s44_p_12 0 adc_mim_bank COUNT=1
Vs44_n_0 s44_n_0 0 DC 0 AC 1
Xs44_n_0 s44_n_0 0 adc_mim_bank COUNT=1
Vs44_n_1 s44_n_1 0 DC 0 AC 1
Xs44_n_1 s44_n_1 0 adc_mim_bank COUNT=2
Vs44_n_2 s44_n_2 0 DC 0 AC 1
Xs44_n_2 s44_n_2 0 adc_mim_bank COUNT=4
Vs44_n_3 s44_n_3 0 DC 0 AC 1
Xs44_n_3 s44_n_3 0 adc_mim_bank COUNT=8
Vs44_n_4 s44_n_4 0 DC 0 AC 1
Xs44_n_4 s44_n_4 0 adc_mim_bank COUNT=16
Vs44_n_5 s44_n_5 0 DC 0 AC 1
Xs44_n_5 s44_n_5 0 adc_mim_bank COUNT=32
Vs44_n_6 s44_n_6 0 DC 0 AC 1
Xs44_n_6 s44_n_6 0 adc_mim_bank COUNT=64
Vs44_n_7 s44_n_7 0 DC 0 AC 1
Xs44_n_7 s44_n_7 0 adc_mim_bank COUNT=128
Vs44_n_8 s44_n_8 0 DC 0 AC 1
Xs44_n_8 s44_n_8 0 adc_mim_bank COUNT=256
Vs44_n_9 s44_n_9 0 DC 0 AC 1
Xs44_n_9 s44_n_9 0 adc_mim_bank COUNT=512
Vs44_n_10 s44_n_10 0 DC 0 AC 1
Xs44_n_10 s44_n_10 0 adc_mim_bank COUNT=1024
Vs44_n_11 s44_n_11 0 DC 0 AC 1
Xs44_n_11 s44_n_11 0 adc_mim_bank COUNT=2048
Vs44_n_12 s44_n_12 0 DC 0 AC 1
Xs44_n_12 s44_n_12 0 adc_mim_bank COUNT=1
Vs45_p_0 s45_p_0 0 DC 0 AC 1
Xs45_p_0 s45_p_0 0 adc_mim_bank COUNT=1
Vs45_p_1 s45_p_1 0 DC 0 AC 1
Xs45_p_1 s45_p_1 0 adc_mim_bank COUNT=2
Vs45_p_2 s45_p_2 0 DC 0 AC 1
Xs45_p_2 s45_p_2 0 adc_mim_bank COUNT=4
Vs45_p_3 s45_p_3 0 DC 0 AC 1
Xs45_p_3 s45_p_3 0 adc_mim_bank COUNT=8
Vs45_p_4 s45_p_4 0 DC 0 AC 1
Xs45_p_4 s45_p_4 0 adc_mim_bank COUNT=16
Vs45_p_5 s45_p_5 0 DC 0 AC 1
Xs45_p_5 s45_p_5 0 adc_mim_bank COUNT=32
Vs45_p_6 s45_p_6 0 DC 0 AC 1
Xs45_p_6 s45_p_6 0 adc_mim_bank COUNT=64
Vs45_p_7 s45_p_7 0 DC 0 AC 1
Xs45_p_7 s45_p_7 0 adc_mim_bank COUNT=128
Vs45_p_8 s45_p_8 0 DC 0 AC 1
Xs45_p_8 s45_p_8 0 adc_mim_bank COUNT=256
Vs45_p_9 s45_p_9 0 DC 0 AC 1
Xs45_p_9 s45_p_9 0 adc_mim_bank COUNT=512
Vs45_p_10 s45_p_10 0 DC 0 AC 1
Xs45_p_10 s45_p_10 0 adc_mim_bank COUNT=1024
Vs45_p_11 s45_p_11 0 DC 0 AC 1
Xs45_p_11 s45_p_11 0 adc_mim_bank COUNT=2048
Vs45_p_12 s45_p_12 0 DC 0 AC 1
Xs45_p_12 s45_p_12 0 adc_mim_bank COUNT=1
Vs45_n_0 s45_n_0 0 DC 0 AC 1
Xs45_n_0 s45_n_0 0 adc_mim_bank COUNT=1
Vs45_n_1 s45_n_1 0 DC 0 AC 1
Xs45_n_1 s45_n_1 0 adc_mim_bank COUNT=2
Vs45_n_2 s45_n_2 0 DC 0 AC 1
Xs45_n_2 s45_n_2 0 adc_mim_bank COUNT=4
Vs45_n_3 s45_n_3 0 DC 0 AC 1
Xs45_n_3 s45_n_3 0 adc_mim_bank COUNT=8
Vs45_n_4 s45_n_4 0 DC 0 AC 1
Xs45_n_4 s45_n_4 0 adc_mim_bank COUNT=16
Vs45_n_5 s45_n_5 0 DC 0 AC 1
Xs45_n_5 s45_n_5 0 adc_mim_bank COUNT=32
Vs45_n_6 s45_n_6 0 DC 0 AC 1
Xs45_n_6 s45_n_6 0 adc_mim_bank COUNT=64
Vs45_n_7 s45_n_7 0 DC 0 AC 1
Xs45_n_7 s45_n_7 0 adc_mim_bank COUNT=128
Vs45_n_8 s45_n_8 0 DC 0 AC 1
Xs45_n_8 s45_n_8 0 adc_mim_bank COUNT=256
Vs45_n_9 s45_n_9 0 DC 0 AC 1
Xs45_n_9 s45_n_9 0 adc_mim_bank COUNT=512
Vs45_n_10 s45_n_10 0 DC 0 AC 1
Xs45_n_10 s45_n_10 0 adc_mim_bank COUNT=1024
Vs45_n_11 s45_n_11 0 DC 0 AC 1
Xs45_n_11 s45_n_11 0 adc_mim_bank COUNT=2048
Vs45_n_12 s45_n_12 0 DC 0 AC 1
Xs45_n_12 s45_n_12 0 adc_mim_bank COUNT=1
Vs46_p_0 s46_p_0 0 DC 0 AC 1
Xs46_p_0 s46_p_0 0 adc_mim_bank COUNT=1
Vs46_p_1 s46_p_1 0 DC 0 AC 1
Xs46_p_1 s46_p_1 0 adc_mim_bank COUNT=2
Vs46_p_2 s46_p_2 0 DC 0 AC 1
Xs46_p_2 s46_p_2 0 adc_mim_bank COUNT=4
Vs46_p_3 s46_p_3 0 DC 0 AC 1
Xs46_p_3 s46_p_3 0 adc_mim_bank COUNT=8
Vs46_p_4 s46_p_4 0 DC 0 AC 1
Xs46_p_4 s46_p_4 0 adc_mim_bank COUNT=16
Vs46_p_5 s46_p_5 0 DC 0 AC 1
Xs46_p_5 s46_p_5 0 adc_mim_bank COUNT=32
Vs46_p_6 s46_p_6 0 DC 0 AC 1
Xs46_p_6 s46_p_6 0 adc_mim_bank COUNT=64
Vs46_p_7 s46_p_7 0 DC 0 AC 1
Xs46_p_7 s46_p_7 0 adc_mim_bank COUNT=128
Vs46_p_8 s46_p_8 0 DC 0 AC 1
Xs46_p_8 s46_p_8 0 adc_mim_bank COUNT=256
Vs46_p_9 s46_p_9 0 DC 0 AC 1
Xs46_p_9 s46_p_9 0 adc_mim_bank COUNT=512
Vs46_p_10 s46_p_10 0 DC 0 AC 1
Xs46_p_10 s46_p_10 0 adc_mim_bank COUNT=1024
Vs46_p_11 s46_p_11 0 DC 0 AC 1
Xs46_p_11 s46_p_11 0 adc_mim_bank COUNT=2048
Vs46_p_12 s46_p_12 0 DC 0 AC 1
Xs46_p_12 s46_p_12 0 adc_mim_bank COUNT=1
Vs46_n_0 s46_n_0 0 DC 0 AC 1
Xs46_n_0 s46_n_0 0 adc_mim_bank COUNT=1
Vs46_n_1 s46_n_1 0 DC 0 AC 1
Xs46_n_1 s46_n_1 0 adc_mim_bank COUNT=2
Vs46_n_2 s46_n_2 0 DC 0 AC 1
Xs46_n_2 s46_n_2 0 adc_mim_bank COUNT=4
Vs46_n_3 s46_n_3 0 DC 0 AC 1
Xs46_n_3 s46_n_3 0 adc_mim_bank COUNT=8
Vs46_n_4 s46_n_4 0 DC 0 AC 1
Xs46_n_4 s46_n_4 0 adc_mim_bank COUNT=16
Vs46_n_5 s46_n_5 0 DC 0 AC 1
Xs46_n_5 s46_n_5 0 adc_mim_bank COUNT=32
Vs46_n_6 s46_n_6 0 DC 0 AC 1
Xs46_n_6 s46_n_6 0 adc_mim_bank COUNT=64
Vs46_n_7 s46_n_7 0 DC 0 AC 1
Xs46_n_7 s46_n_7 0 adc_mim_bank COUNT=128
Vs46_n_8 s46_n_8 0 DC 0 AC 1
Xs46_n_8 s46_n_8 0 adc_mim_bank COUNT=256
Vs46_n_9 s46_n_9 0 DC 0 AC 1
Xs46_n_9 s46_n_9 0 adc_mim_bank COUNT=512
Vs46_n_10 s46_n_10 0 DC 0 AC 1
Xs46_n_10 s46_n_10 0 adc_mim_bank COUNT=1024
Vs46_n_11 s46_n_11 0 DC 0 AC 1
Xs46_n_11 s46_n_11 0 adc_mim_bank COUNT=2048
Vs46_n_12 s46_n_12 0 DC 0 AC 1
Xs46_n_12 s46_n_12 0 adc_mim_bank COUNT=1
Vs47_p_0 s47_p_0 0 DC 0 AC 1
Xs47_p_0 s47_p_0 0 adc_mim_bank COUNT=1
Vs47_p_1 s47_p_1 0 DC 0 AC 1
Xs47_p_1 s47_p_1 0 adc_mim_bank COUNT=2
Vs47_p_2 s47_p_2 0 DC 0 AC 1
Xs47_p_2 s47_p_2 0 adc_mim_bank COUNT=4
Vs47_p_3 s47_p_3 0 DC 0 AC 1
Xs47_p_3 s47_p_3 0 adc_mim_bank COUNT=8
Vs47_p_4 s47_p_4 0 DC 0 AC 1
Xs47_p_4 s47_p_4 0 adc_mim_bank COUNT=16
Vs47_p_5 s47_p_5 0 DC 0 AC 1
Xs47_p_5 s47_p_5 0 adc_mim_bank COUNT=32
Vs47_p_6 s47_p_6 0 DC 0 AC 1
Xs47_p_6 s47_p_6 0 adc_mim_bank COUNT=64
Vs47_p_7 s47_p_7 0 DC 0 AC 1
Xs47_p_7 s47_p_7 0 adc_mim_bank COUNT=128
Vs47_p_8 s47_p_8 0 DC 0 AC 1
Xs47_p_8 s47_p_8 0 adc_mim_bank COUNT=256
Vs47_p_9 s47_p_9 0 DC 0 AC 1
Xs47_p_9 s47_p_9 0 adc_mim_bank COUNT=512
Vs47_p_10 s47_p_10 0 DC 0 AC 1
Xs47_p_10 s47_p_10 0 adc_mim_bank COUNT=1024
Vs47_p_11 s47_p_11 0 DC 0 AC 1
Xs47_p_11 s47_p_11 0 adc_mim_bank COUNT=2048
Vs47_p_12 s47_p_12 0 DC 0 AC 1
Xs47_p_12 s47_p_12 0 adc_mim_bank COUNT=1
Vs47_n_0 s47_n_0 0 DC 0 AC 1
Xs47_n_0 s47_n_0 0 adc_mim_bank COUNT=1
Vs47_n_1 s47_n_1 0 DC 0 AC 1
Xs47_n_1 s47_n_1 0 adc_mim_bank COUNT=2
Vs47_n_2 s47_n_2 0 DC 0 AC 1
Xs47_n_2 s47_n_2 0 adc_mim_bank COUNT=4
Vs47_n_3 s47_n_3 0 DC 0 AC 1
Xs47_n_3 s47_n_3 0 adc_mim_bank COUNT=8
Vs47_n_4 s47_n_4 0 DC 0 AC 1
Xs47_n_4 s47_n_4 0 adc_mim_bank COUNT=16
Vs47_n_5 s47_n_5 0 DC 0 AC 1
Xs47_n_5 s47_n_5 0 adc_mim_bank COUNT=32
Vs47_n_6 s47_n_6 0 DC 0 AC 1
Xs47_n_6 s47_n_6 0 adc_mim_bank COUNT=64
Vs47_n_7 s47_n_7 0 DC 0 AC 1
Xs47_n_7 s47_n_7 0 adc_mim_bank COUNT=128
Vs47_n_8 s47_n_8 0 DC 0 AC 1
Xs47_n_8 s47_n_8 0 adc_mim_bank COUNT=256
Vs47_n_9 s47_n_9 0 DC 0 AC 1
Xs47_n_9 s47_n_9 0 adc_mim_bank COUNT=512
Vs47_n_10 s47_n_10 0 DC 0 AC 1
Xs47_n_10 s47_n_10 0 adc_mim_bank COUNT=1024
Vs47_n_11 s47_n_11 0 DC 0 AC 1
Xs47_n_11 s47_n_11 0 adc_mim_bank COUNT=2048
Vs47_n_12 s47_n_12 0 DC 0 AC 1
Xs47_n_12 s47_n_12 0 adc_mim_bank COUNT=1
Vs48_p_0 s48_p_0 0 DC 0 AC 1
Xs48_p_0 s48_p_0 0 adc_mim_bank COUNT=1
Vs48_p_1 s48_p_1 0 DC 0 AC 1
Xs48_p_1 s48_p_1 0 adc_mim_bank COUNT=2
Vs48_p_2 s48_p_2 0 DC 0 AC 1
Xs48_p_2 s48_p_2 0 adc_mim_bank COUNT=4
Vs48_p_3 s48_p_3 0 DC 0 AC 1
Xs48_p_3 s48_p_3 0 adc_mim_bank COUNT=8
Vs48_p_4 s48_p_4 0 DC 0 AC 1
Xs48_p_4 s48_p_4 0 adc_mim_bank COUNT=16
Vs48_p_5 s48_p_5 0 DC 0 AC 1
Xs48_p_5 s48_p_5 0 adc_mim_bank COUNT=32
Vs48_p_6 s48_p_6 0 DC 0 AC 1
Xs48_p_6 s48_p_6 0 adc_mim_bank COUNT=64
Vs48_p_7 s48_p_7 0 DC 0 AC 1
Xs48_p_7 s48_p_7 0 adc_mim_bank COUNT=128
Vs48_p_8 s48_p_8 0 DC 0 AC 1
Xs48_p_8 s48_p_8 0 adc_mim_bank COUNT=256
Vs48_p_9 s48_p_9 0 DC 0 AC 1
Xs48_p_9 s48_p_9 0 adc_mim_bank COUNT=512
Vs48_p_10 s48_p_10 0 DC 0 AC 1
Xs48_p_10 s48_p_10 0 adc_mim_bank COUNT=1024
Vs48_p_11 s48_p_11 0 DC 0 AC 1
Xs48_p_11 s48_p_11 0 adc_mim_bank COUNT=2048
Vs48_p_12 s48_p_12 0 DC 0 AC 1
Xs48_p_12 s48_p_12 0 adc_mim_bank COUNT=1
Vs48_n_0 s48_n_0 0 DC 0 AC 1
Xs48_n_0 s48_n_0 0 adc_mim_bank COUNT=1
Vs48_n_1 s48_n_1 0 DC 0 AC 1
Xs48_n_1 s48_n_1 0 adc_mim_bank COUNT=2
Vs48_n_2 s48_n_2 0 DC 0 AC 1
Xs48_n_2 s48_n_2 0 adc_mim_bank COUNT=4
Vs48_n_3 s48_n_3 0 DC 0 AC 1
Xs48_n_3 s48_n_3 0 adc_mim_bank COUNT=8
Vs48_n_4 s48_n_4 0 DC 0 AC 1
Xs48_n_4 s48_n_4 0 adc_mim_bank COUNT=16
Vs48_n_5 s48_n_5 0 DC 0 AC 1
Xs48_n_5 s48_n_5 0 adc_mim_bank COUNT=32
Vs48_n_6 s48_n_6 0 DC 0 AC 1
Xs48_n_6 s48_n_6 0 adc_mim_bank COUNT=64
Vs48_n_7 s48_n_7 0 DC 0 AC 1
Xs48_n_7 s48_n_7 0 adc_mim_bank COUNT=128
Vs48_n_8 s48_n_8 0 DC 0 AC 1
Xs48_n_8 s48_n_8 0 adc_mim_bank COUNT=256
Vs48_n_9 s48_n_9 0 DC 0 AC 1
Xs48_n_9 s48_n_9 0 adc_mim_bank COUNT=512
Vs48_n_10 s48_n_10 0 DC 0 AC 1
Xs48_n_10 s48_n_10 0 adc_mim_bank COUNT=1024
Vs48_n_11 s48_n_11 0 DC 0 AC 1
Xs48_n_11 s48_n_11 0 adc_mim_bank COUNT=2048
Vs48_n_12 s48_n_12 0 DC 0 AC 1
Xs48_n_12 s48_n_12 0 adc_mim_bank COUNT=1
Vs49_p_0 s49_p_0 0 DC 0 AC 1
Xs49_p_0 s49_p_0 0 adc_mim_bank COUNT=1
Vs49_p_1 s49_p_1 0 DC 0 AC 1
Xs49_p_1 s49_p_1 0 adc_mim_bank COUNT=2
Vs49_p_2 s49_p_2 0 DC 0 AC 1
Xs49_p_2 s49_p_2 0 adc_mim_bank COUNT=4
Vs49_p_3 s49_p_3 0 DC 0 AC 1
Xs49_p_3 s49_p_3 0 adc_mim_bank COUNT=8
Vs49_p_4 s49_p_4 0 DC 0 AC 1
Xs49_p_4 s49_p_4 0 adc_mim_bank COUNT=16
Vs49_p_5 s49_p_5 0 DC 0 AC 1
Xs49_p_5 s49_p_5 0 adc_mim_bank COUNT=32
Vs49_p_6 s49_p_6 0 DC 0 AC 1
Xs49_p_6 s49_p_6 0 adc_mim_bank COUNT=64
Vs49_p_7 s49_p_7 0 DC 0 AC 1
Xs49_p_7 s49_p_7 0 adc_mim_bank COUNT=128
Vs49_p_8 s49_p_8 0 DC 0 AC 1
Xs49_p_8 s49_p_8 0 adc_mim_bank COUNT=256
Vs49_p_9 s49_p_9 0 DC 0 AC 1
Xs49_p_9 s49_p_9 0 adc_mim_bank COUNT=512
Vs49_p_10 s49_p_10 0 DC 0 AC 1
Xs49_p_10 s49_p_10 0 adc_mim_bank COUNT=1024
Vs49_p_11 s49_p_11 0 DC 0 AC 1
Xs49_p_11 s49_p_11 0 adc_mim_bank COUNT=2048
Vs49_p_12 s49_p_12 0 DC 0 AC 1
Xs49_p_12 s49_p_12 0 adc_mim_bank COUNT=1
Vs49_n_0 s49_n_0 0 DC 0 AC 1
Xs49_n_0 s49_n_0 0 adc_mim_bank COUNT=1
Vs49_n_1 s49_n_1 0 DC 0 AC 1
Xs49_n_1 s49_n_1 0 adc_mim_bank COUNT=2
Vs49_n_2 s49_n_2 0 DC 0 AC 1
Xs49_n_2 s49_n_2 0 adc_mim_bank COUNT=4
Vs49_n_3 s49_n_3 0 DC 0 AC 1
Xs49_n_3 s49_n_3 0 adc_mim_bank COUNT=8
Vs49_n_4 s49_n_4 0 DC 0 AC 1
Xs49_n_4 s49_n_4 0 adc_mim_bank COUNT=16
Vs49_n_5 s49_n_5 0 DC 0 AC 1
Xs49_n_5 s49_n_5 0 adc_mim_bank COUNT=32
Vs49_n_6 s49_n_6 0 DC 0 AC 1
Xs49_n_6 s49_n_6 0 adc_mim_bank COUNT=64
Vs49_n_7 s49_n_7 0 DC 0 AC 1
Xs49_n_7 s49_n_7 0 adc_mim_bank COUNT=128
Vs49_n_8 s49_n_8 0 DC 0 AC 1
Xs49_n_8 s49_n_8 0 adc_mim_bank COUNT=256
Vs49_n_9 s49_n_9 0 DC 0 AC 1
Xs49_n_9 s49_n_9 0 adc_mim_bank COUNT=512
Vs49_n_10 s49_n_10 0 DC 0 AC 1
Xs49_n_10 s49_n_10 0 adc_mim_bank COUNT=1024
Vs49_n_11 s49_n_11 0 DC 0 AC 1
Xs49_n_11 s49_n_11 0 adc_mim_bank COUNT=2048
Vs49_n_12 s49_n_12 0 DC 0 AC 1
Xs49_n_12 s49_n_12 0 adc_mim_bank COUNT=1
Vs50_p_0 s50_p_0 0 DC 0 AC 1
Xs50_p_0 s50_p_0 0 adc_mim_bank COUNT=1
Vs50_p_1 s50_p_1 0 DC 0 AC 1
Xs50_p_1 s50_p_1 0 adc_mim_bank COUNT=2
Vs50_p_2 s50_p_2 0 DC 0 AC 1
Xs50_p_2 s50_p_2 0 adc_mim_bank COUNT=4
Vs50_p_3 s50_p_3 0 DC 0 AC 1
Xs50_p_3 s50_p_3 0 adc_mim_bank COUNT=8
Vs50_p_4 s50_p_4 0 DC 0 AC 1
Xs50_p_4 s50_p_4 0 adc_mim_bank COUNT=16
Vs50_p_5 s50_p_5 0 DC 0 AC 1
Xs50_p_5 s50_p_5 0 adc_mim_bank COUNT=32
Vs50_p_6 s50_p_6 0 DC 0 AC 1
Xs50_p_6 s50_p_6 0 adc_mim_bank COUNT=64
Vs50_p_7 s50_p_7 0 DC 0 AC 1
Xs50_p_7 s50_p_7 0 adc_mim_bank COUNT=128
Vs50_p_8 s50_p_8 0 DC 0 AC 1
Xs50_p_8 s50_p_8 0 adc_mim_bank COUNT=256
Vs50_p_9 s50_p_9 0 DC 0 AC 1
Xs50_p_9 s50_p_9 0 adc_mim_bank COUNT=512
Vs50_p_10 s50_p_10 0 DC 0 AC 1
Xs50_p_10 s50_p_10 0 adc_mim_bank COUNT=1024
Vs50_p_11 s50_p_11 0 DC 0 AC 1
Xs50_p_11 s50_p_11 0 adc_mim_bank COUNT=2048
Vs50_p_12 s50_p_12 0 DC 0 AC 1
Xs50_p_12 s50_p_12 0 adc_mim_bank COUNT=1
Vs50_n_0 s50_n_0 0 DC 0 AC 1
Xs50_n_0 s50_n_0 0 adc_mim_bank COUNT=1
Vs50_n_1 s50_n_1 0 DC 0 AC 1
Xs50_n_1 s50_n_1 0 adc_mim_bank COUNT=2
Vs50_n_2 s50_n_2 0 DC 0 AC 1
Xs50_n_2 s50_n_2 0 adc_mim_bank COUNT=4
Vs50_n_3 s50_n_3 0 DC 0 AC 1
Xs50_n_3 s50_n_3 0 adc_mim_bank COUNT=8
Vs50_n_4 s50_n_4 0 DC 0 AC 1
Xs50_n_4 s50_n_4 0 adc_mim_bank COUNT=16
Vs50_n_5 s50_n_5 0 DC 0 AC 1
Xs50_n_5 s50_n_5 0 adc_mim_bank COUNT=32
Vs50_n_6 s50_n_6 0 DC 0 AC 1
Xs50_n_6 s50_n_6 0 adc_mim_bank COUNT=64
Vs50_n_7 s50_n_7 0 DC 0 AC 1
Xs50_n_7 s50_n_7 0 adc_mim_bank COUNT=128
Vs50_n_8 s50_n_8 0 DC 0 AC 1
Xs50_n_8 s50_n_8 0 adc_mim_bank COUNT=256
Vs50_n_9 s50_n_9 0 DC 0 AC 1
Xs50_n_9 s50_n_9 0 adc_mim_bank COUNT=512
Vs50_n_10 s50_n_10 0 DC 0 AC 1
Xs50_n_10 s50_n_10 0 adc_mim_bank COUNT=1024
Vs50_n_11 s50_n_11 0 DC 0 AC 1
Xs50_n_11 s50_n_11 0 adc_mim_bank COUNT=2048
Vs50_n_12 s50_n_12 0 DC 0 AC 1
Xs50_n_12 s50_n_12 0 adc_mim_bank COUNT=1
Vs51_p_0 s51_p_0 0 DC 0 AC 1
Xs51_p_0 s51_p_0 0 adc_mim_bank COUNT=1
Vs51_p_1 s51_p_1 0 DC 0 AC 1
Xs51_p_1 s51_p_1 0 adc_mim_bank COUNT=2
Vs51_p_2 s51_p_2 0 DC 0 AC 1
Xs51_p_2 s51_p_2 0 adc_mim_bank COUNT=4
Vs51_p_3 s51_p_3 0 DC 0 AC 1
Xs51_p_3 s51_p_3 0 adc_mim_bank COUNT=8
Vs51_p_4 s51_p_4 0 DC 0 AC 1
Xs51_p_4 s51_p_4 0 adc_mim_bank COUNT=16
Vs51_p_5 s51_p_5 0 DC 0 AC 1
Xs51_p_5 s51_p_5 0 adc_mim_bank COUNT=32
Vs51_p_6 s51_p_6 0 DC 0 AC 1
Xs51_p_6 s51_p_6 0 adc_mim_bank COUNT=64
Vs51_p_7 s51_p_7 0 DC 0 AC 1
Xs51_p_7 s51_p_7 0 adc_mim_bank COUNT=128
Vs51_p_8 s51_p_8 0 DC 0 AC 1
Xs51_p_8 s51_p_8 0 adc_mim_bank COUNT=256
Vs51_p_9 s51_p_9 0 DC 0 AC 1
Xs51_p_9 s51_p_9 0 adc_mim_bank COUNT=512
Vs51_p_10 s51_p_10 0 DC 0 AC 1
Xs51_p_10 s51_p_10 0 adc_mim_bank COUNT=1024
Vs51_p_11 s51_p_11 0 DC 0 AC 1
Xs51_p_11 s51_p_11 0 adc_mim_bank COUNT=2048
Vs51_p_12 s51_p_12 0 DC 0 AC 1
Xs51_p_12 s51_p_12 0 adc_mim_bank COUNT=1
Vs51_n_0 s51_n_0 0 DC 0 AC 1
Xs51_n_0 s51_n_0 0 adc_mim_bank COUNT=1
Vs51_n_1 s51_n_1 0 DC 0 AC 1
Xs51_n_1 s51_n_1 0 adc_mim_bank COUNT=2
Vs51_n_2 s51_n_2 0 DC 0 AC 1
Xs51_n_2 s51_n_2 0 adc_mim_bank COUNT=4
Vs51_n_3 s51_n_3 0 DC 0 AC 1
Xs51_n_3 s51_n_3 0 adc_mim_bank COUNT=8
Vs51_n_4 s51_n_4 0 DC 0 AC 1
Xs51_n_4 s51_n_4 0 adc_mim_bank COUNT=16
Vs51_n_5 s51_n_5 0 DC 0 AC 1
Xs51_n_5 s51_n_5 0 adc_mim_bank COUNT=32
Vs51_n_6 s51_n_6 0 DC 0 AC 1
Xs51_n_6 s51_n_6 0 adc_mim_bank COUNT=64
Vs51_n_7 s51_n_7 0 DC 0 AC 1
Xs51_n_7 s51_n_7 0 adc_mim_bank COUNT=128
Vs51_n_8 s51_n_8 0 DC 0 AC 1
Xs51_n_8 s51_n_8 0 adc_mim_bank COUNT=256
Vs51_n_9 s51_n_9 0 DC 0 AC 1
Xs51_n_9 s51_n_9 0 adc_mim_bank COUNT=512
Vs51_n_10 s51_n_10 0 DC 0 AC 1
Xs51_n_10 s51_n_10 0 adc_mim_bank COUNT=1024
Vs51_n_11 s51_n_11 0 DC 0 AC 1
Xs51_n_11 s51_n_11 0 adc_mim_bank COUNT=2048
Vs51_n_12 s51_n_12 0 DC 0 AC 1
Xs51_n_12 s51_n_12 0 adc_mim_bank COUNT=1
Vs52_p_0 s52_p_0 0 DC 0 AC 1
Xs52_p_0 s52_p_0 0 adc_mim_bank COUNT=1
Vs52_p_1 s52_p_1 0 DC 0 AC 1
Xs52_p_1 s52_p_1 0 adc_mim_bank COUNT=2
Vs52_p_2 s52_p_2 0 DC 0 AC 1
Xs52_p_2 s52_p_2 0 adc_mim_bank COUNT=4
Vs52_p_3 s52_p_3 0 DC 0 AC 1
Xs52_p_3 s52_p_3 0 adc_mim_bank COUNT=8
Vs52_p_4 s52_p_4 0 DC 0 AC 1
Xs52_p_4 s52_p_4 0 adc_mim_bank COUNT=16
Vs52_p_5 s52_p_5 0 DC 0 AC 1
Xs52_p_5 s52_p_5 0 adc_mim_bank COUNT=32
Vs52_p_6 s52_p_6 0 DC 0 AC 1
Xs52_p_6 s52_p_6 0 adc_mim_bank COUNT=64
Vs52_p_7 s52_p_7 0 DC 0 AC 1
Xs52_p_7 s52_p_7 0 adc_mim_bank COUNT=128
Vs52_p_8 s52_p_8 0 DC 0 AC 1
Xs52_p_8 s52_p_8 0 adc_mim_bank COUNT=256
Vs52_p_9 s52_p_9 0 DC 0 AC 1
Xs52_p_9 s52_p_9 0 adc_mim_bank COUNT=512
Vs52_p_10 s52_p_10 0 DC 0 AC 1
Xs52_p_10 s52_p_10 0 adc_mim_bank COUNT=1024
Vs52_p_11 s52_p_11 0 DC 0 AC 1
Xs52_p_11 s52_p_11 0 adc_mim_bank COUNT=2048
Vs52_p_12 s52_p_12 0 DC 0 AC 1
Xs52_p_12 s52_p_12 0 adc_mim_bank COUNT=1
Vs52_n_0 s52_n_0 0 DC 0 AC 1
Xs52_n_0 s52_n_0 0 adc_mim_bank COUNT=1
Vs52_n_1 s52_n_1 0 DC 0 AC 1
Xs52_n_1 s52_n_1 0 adc_mim_bank COUNT=2
Vs52_n_2 s52_n_2 0 DC 0 AC 1
Xs52_n_2 s52_n_2 0 adc_mim_bank COUNT=4
Vs52_n_3 s52_n_3 0 DC 0 AC 1
Xs52_n_3 s52_n_3 0 adc_mim_bank COUNT=8
Vs52_n_4 s52_n_4 0 DC 0 AC 1
Xs52_n_4 s52_n_4 0 adc_mim_bank COUNT=16
Vs52_n_5 s52_n_5 0 DC 0 AC 1
Xs52_n_5 s52_n_5 0 adc_mim_bank COUNT=32
Vs52_n_6 s52_n_6 0 DC 0 AC 1
Xs52_n_6 s52_n_6 0 adc_mim_bank COUNT=64
Vs52_n_7 s52_n_7 0 DC 0 AC 1
Xs52_n_7 s52_n_7 0 adc_mim_bank COUNT=128
Vs52_n_8 s52_n_8 0 DC 0 AC 1
Xs52_n_8 s52_n_8 0 adc_mim_bank COUNT=256
Vs52_n_9 s52_n_9 0 DC 0 AC 1
Xs52_n_9 s52_n_9 0 adc_mim_bank COUNT=512
Vs52_n_10 s52_n_10 0 DC 0 AC 1
Xs52_n_10 s52_n_10 0 adc_mim_bank COUNT=1024
Vs52_n_11 s52_n_11 0 DC 0 AC 1
Xs52_n_11 s52_n_11 0 adc_mim_bank COUNT=2048
Vs52_n_12 s52_n_12 0 DC 0 AC 1
Xs52_n_12 s52_n_12 0 adc_mim_bank COUNT=1
Vs53_p_0 s53_p_0 0 DC 0 AC 1
Xs53_p_0 s53_p_0 0 adc_mim_bank COUNT=1
Vs53_p_1 s53_p_1 0 DC 0 AC 1
Xs53_p_1 s53_p_1 0 adc_mim_bank COUNT=2
Vs53_p_2 s53_p_2 0 DC 0 AC 1
Xs53_p_2 s53_p_2 0 adc_mim_bank COUNT=4
Vs53_p_3 s53_p_3 0 DC 0 AC 1
Xs53_p_3 s53_p_3 0 adc_mim_bank COUNT=8
Vs53_p_4 s53_p_4 0 DC 0 AC 1
Xs53_p_4 s53_p_4 0 adc_mim_bank COUNT=16
Vs53_p_5 s53_p_5 0 DC 0 AC 1
Xs53_p_5 s53_p_5 0 adc_mim_bank COUNT=32
Vs53_p_6 s53_p_6 0 DC 0 AC 1
Xs53_p_6 s53_p_6 0 adc_mim_bank COUNT=64
Vs53_p_7 s53_p_7 0 DC 0 AC 1
Xs53_p_7 s53_p_7 0 adc_mim_bank COUNT=128
Vs53_p_8 s53_p_8 0 DC 0 AC 1
Xs53_p_8 s53_p_8 0 adc_mim_bank COUNT=256
Vs53_p_9 s53_p_9 0 DC 0 AC 1
Xs53_p_9 s53_p_9 0 adc_mim_bank COUNT=512
Vs53_p_10 s53_p_10 0 DC 0 AC 1
Xs53_p_10 s53_p_10 0 adc_mim_bank COUNT=1024
Vs53_p_11 s53_p_11 0 DC 0 AC 1
Xs53_p_11 s53_p_11 0 adc_mim_bank COUNT=2048
Vs53_p_12 s53_p_12 0 DC 0 AC 1
Xs53_p_12 s53_p_12 0 adc_mim_bank COUNT=1
Vs53_n_0 s53_n_0 0 DC 0 AC 1
Xs53_n_0 s53_n_0 0 adc_mim_bank COUNT=1
Vs53_n_1 s53_n_1 0 DC 0 AC 1
Xs53_n_1 s53_n_1 0 adc_mim_bank COUNT=2
Vs53_n_2 s53_n_2 0 DC 0 AC 1
Xs53_n_2 s53_n_2 0 adc_mim_bank COUNT=4
Vs53_n_3 s53_n_3 0 DC 0 AC 1
Xs53_n_3 s53_n_3 0 adc_mim_bank COUNT=8
Vs53_n_4 s53_n_4 0 DC 0 AC 1
Xs53_n_4 s53_n_4 0 adc_mim_bank COUNT=16
Vs53_n_5 s53_n_5 0 DC 0 AC 1
Xs53_n_5 s53_n_5 0 adc_mim_bank COUNT=32
Vs53_n_6 s53_n_6 0 DC 0 AC 1
Xs53_n_6 s53_n_6 0 adc_mim_bank COUNT=64
Vs53_n_7 s53_n_7 0 DC 0 AC 1
Xs53_n_7 s53_n_7 0 adc_mim_bank COUNT=128
Vs53_n_8 s53_n_8 0 DC 0 AC 1
Xs53_n_8 s53_n_8 0 adc_mim_bank COUNT=256
Vs53_n_9 s53_n_9 0 DC 0 AC 1
Xs53_n_9 s53_n_9 0 adc_mim_bank COUNT=512
Vs53_n_10 s53_n_10 0 DC 0 AC 1
Xs53_n_10 s53_n_10 0 adc_mim_bank COUNT=1024
Vs53_n_11 s53_n_11 0 DC 0 AC 1
Xs53_n_11 s53_n_11 0 adc_mim_bank COUNT=2048
Vs53_n_12 s53_n_12 0 DC 0 AC 1
Xs53_n_12 s53_n_12 0 adc_mim_bank COUNT=1
Vs54_p_0 s54_p_0 0 DC 0 AC 1
Xs54_p_0 s54_p_0 0 adc_mim_bank COUNT=1
Vs54_p_1 s54_p_1 0 DC 0 AC 1
Xs54_p_1 s54_p_1 0 adc_mim_bank COUNT=2
Vs54_p_2 s54_p_2 0 DC 0 AC 1
Xs54_p_2 s54_p_2 0 adc_mim_bank COUNT=4
Vs54_p_3 s54_p_3 0 DC 0 AC 1
Xs54_p_3 s54_p_3 0 adc_mim_bank COUNT=8
Vs54_p_4 s54_p_4 0 DC 0 AC 1
Xs54_p_4 s54_p_4 0 adc_mim_bank COUNT=16
Vs54_p_5 s54_p_5 0 DC 0 AC 1
Xs54_p_5 s54_p_5 0 adc_mim_bank COUNT=32
Vs54_p_6 s54_p_6 0 DC 0 AC 1
Xs54_p_6 s54_p_6 0 adc_mim_bank COUNT=64
Vs54_p_7 s54_p_7 0 DC 0 AC 1
Xs54_p_7 s54_p_7 0 adc_mim_bank COUNT=128
Vs54_p_8 s54_p_8 0 DC 0 AC 1
Xs54_p_8 s54_p_8 0 adc_mim_bank COUNT=256
Vs54_p_9 s54_p_9 0 DC 0 AC 1
Xs54_p_9 s54_p_9 0 adc_mim_bank COUNT=512
Vs54_p_10 s54_p_10 0 DC 0 AC 1
Xs54_p_10 s54_p_10 0 adc_mim_bank COUNT=1024
Vs54_p_11 s54_p_11 0 DC 0 AC 1
Xs54_p_11 s54_p_11 0 adc_mim_bank COUNT=2048
Vs54_p_12 s54_p_12 0 DC 0 AC 1
Xs54_p_12 s54_p_12 0 adc_mim_bank COUNT=1
Vs54_n_0 s54_n_0 0 DC 0 AC 1
Xs54_n_0 s54_n_0 0 adc_mim_bank COUNT=1
Vs54_n_1 s54_n_1 0 DC 0 AC 1
Xs54_n_1 s54_n_1 0 adc_mim_bank COUNT=2
Vs54_n_2 s54_n_2 0 DC 0 AC 1
Xs54_n_2 s54_n_2 0 adc_mim_bank COUNT=4
Vs54_n_3 s54_n_3 0 DC 0 AC 1
Xs54_n_3 s54_n_3 0 adc_mim_bank COUNT=8
Vs54_n_4 s54_n_4 0 DC 0 AC 1
Xs54_n_4 s54_n_4 0 adc_mim_bank COUNT=16
Vs54_n_5 s54_n_5 0 DC 0 AC 1
Xs54_n_5 s54_n_5 0 adc_mim_bank COUNT=32
Vs54_n_6 s54_n_6 0 DC 0 AC 1
Xs54_n_6 s54_n_6 0 adc_mim_bank COUNT=64
Vs54_n_7 s54_n_7 0 DC 0 AC 1
Xs54_n_7 s54_n_7 0 adc_mim_bank COUNT=128
Vs54_n_8 s54_n_8 0 DC 0 AC 1
Xs54_n_8 s54_n_8 0 adc_mim_bank COUNT=256
Vs54_n_9 s54_n_9 0 DC 0 AC 1
Xs54_n_9 s54_n_9 0 adc_mim_bank COUNT=512
Vs54_n_10 s54_n_10 0 DC 0 AC 1
Xs54_n_10 s54_n_10 0 adc_mim_bank COUNT=1024
Vs54_n_11 s54_n_11 0 DC 0 AC 1
Xs54_n_11 s54_n_11 0 adc_mim_bank COUNT=2048
Vs54_n_12 s54_n_12 0 DC 0 AC 1
Xs54_n_12 s54_n_12 0 adc_mim_bank COUNT=1
Vs55_p_0 s55_p_0 0 DC 0 AC 1
Xs55_p_0 s55_p_0 0 adc_mim_bank COUNT=1
Vs55_p_1 s55_p_1 0 DC 0 AC 1
Xs55_p_1 s55_p_1 0 adc_mim_bank COUNT=2
Vs55_p_2 s55_p_2 0 DC 0 AC 1
Xs55_p_2 s55_p_2 0 adc_mim_bank COUNT=4
Vs55_p_3 s55_p_3 0 DC 0 AC 1
Xs55_p_3 s55_p_3 0 adc_mim_bank COUNT=8
Vs55_p_4 s55_p_4 0 DC 0 AC 1
Xs55_p_4 s55_p_4 0 adc_mim_bank COUNT=16
Vs55_p_5 s55_p_5 0 DC 0 AC 1
Xs55_p_5 s55_p_5 0 adc_mim_bank COUNT=32
Vs55_p_6 s55_p_6 0 DC 0 AC 1
Xs55_p_6 s55_p_6 0 adc_mim_bank COUNT=64
Vs55_p_7 s55_p_7 0 DC 0 AC 1
Xs55_p_7 s55_p_7 0 adc_mim_bank COUNT=128
Vs55_p_8 s55_p_8 0 DC 0 AC 1
Xs55_p_8 s55_p_8 0 adc_mim_bank COUNT=256
Vs55_p_9 s55_p_9 0 DC 0 AC 1
Xs55_p_9 s55_p_9 0 adc_mim_bank COUNT=512
Vs55_p_10 s55_p_10 0 DC 0 AC 1
Xs55_p_10 s55_p_10 0 adc_mim_bank COUNT=1024
Vs55_p_11 s55_p_11 0 DC 0 AC 1
Xs55_p_11 s55_p_11 0 adc_mim_bank COUNT=2048
Vs55_p_12 s55_p_12 0 DC 0 AC 1
Xs55_p_12 s55_p_12 0 adc_mim_bank COUNT=1
Vs55_n_0 s55_n_0 0 DC 0 AC 1
Xs55_n_0 s55_n_0 0 adc_mim_bank COUNT=1
Vs55_n_1 s55_n_1 0 DC 0 AC 1
Xs55_n_1 s55_n_1 0 adc_mim_bank COUNT=2
Vs55_n_2 s55_n_2 0 DC 0 AC 1
Xs55_n_2 s55_n_2 0 adc_mim_bank COUNT=4
Vs55_n_3 s55_n_3 0 DC 0 AC 1
Xs55_n_3 s55_n_3 0 adc_mim_bank COUNT=8
Vs55_n_4 s55_n_4 0 DC 0 AC 1
Xs55_n_4 s55_n_4 0 adc_mim_bank COUNT=16
Vs55_n_5 s55_n_5 0 DC 0 AC 1
Xs55_n_5 s55_n_5 0 adc_mim_bank COUNT=32
Vs55_n_6 s55_n_6 0 DC 0 AC 1
Xs55_n_6 s55_n_6 0 adc_mim_bank COUNT=64
Vs55_n_7 s55_n_7 0 DC 0 AC 1
Xs55_n_7 s55_n_7 0 adc_mim_bank COUNT=128
Vs55_n_8 s55_n_8 0 DC 0 AC 1
Xs55_n_8 s55_n_8 0 adc_mim_bank COUNT=256
Vs55_n_9 s55_n_9 0 DC 0 AC 1
Xs55_n_9 s55_n_9 0 adc_mim_bank COUNT=512
Vs55_n_10 s55_n_10 0 DC 0 AC 1
Xs55_n_10 s55_n_10 0 adc_mim_bank COUNT=1024
Vs55_n_11 s55_n_11 0 DC 0 AC 1
Xs55_n_11 s55_n_11 0 adc_mim_bank COUNT=2048
Vs55_n_12 s55_n_12 0 DC 0 AC 1
Xs55_n_12 s55_n_12 0 adc_mim_bank COUNT=1
Vs56_p_0 s56_p_0 0 DC 0 AC 1
Xs56_p_0 s56_p_0 0 adc_mim_bank COUNT=1
Vs56_p_1 s56_p_1 0 DC 0 AC 1
Xs56_p_1 s56_p_1 0 adc_mim_bank COUNT=2
Vs56_p_2 s56_p_2 0 DC 0 AC 1
Xs56_p_2 s56_p_2 0 adc_mim_bank COUNT=4
Vs56_p_3 s56_p_3 0 DC 0 AC 1
Xs56_p_3 s56_p_3 0 adc_mim_bank COUNT=8
Vs56_p_4 s56_p_4 0 DC 0 AC 1
Xs56_p_4 s56_p_4 0 adc_mim_bank COUNT=16
Vs56_p_5 s56_p_5 0 DC 0 AC 1
Xs56_p_5 s56_p_5 0 adc_mim_bank COUNT=32
Vs56_p_6 s56_p_6 0 DC 0 AC 1
Xs56_p_6 s56_p_6 0 adc_mim_bank COUNT=64
Vs56_p_7 s56_p_7 0 DC 0 AC 1
Xs56_p_7 s56_p_7 0 adc_mim_bank COUNT=128
Vs56_p_8 s56_p_8 0 DC 0 AC 1
Xs56_p_8 s56_p_8 0 adc_mim_bank COUNT=256
Vs56_p_9 s56_p_9 0 DC 0 AC 1
Xs56_p_9 s56_p_9 0 adc_mim_bank COUNT=512
Vs56_p_10 s56_p_10 0 DC 0 AC 1
Xs56_p_10 s56_p_10 0 adc_mim_bank COUNT=1024
Vs56_p_11 s56_p_11 0 DC 0 AC 1
Xs56_p_11 s56_p_11 0 adc_mim_bank COUNT=2048
Vs56_p_12 s56_p_12 0 DC 0 AC 1
Xs56_p_12 s56_p_12 0 adc_mim_bank COUNT=1
Vs56_n_0 s56_n_0 0 DC 0 AC 1
Xs56_n_0 s56_n_0 0 adc_mim_bank COUNT=1
Vs56_n_1 s56_n_1 0 DC 0 AC 1
Xs56_n_1 s56_n_1 0 adc_mim_bank COUNT=2
Vs56_n_2 s56_n_2 0 DC 0 AC 1
Xs56_n_2 s56_n_2 0 adc_mim_bank COUNT=4
Vs56_n_3 s56_n_3 0 DC 0 AC 1
Xs56_n_3 s56_n_3 0 adc_mim_bank COUNT=8
Vs56_n_4 s56_n_4 0 DC 0 AC 1
Xs56_n_4 s56_n_4 0 adc_mim_bank COUNT=16
Vs56_n_5 s56_n_5 0 DC 0 AC 1
Xs56_n_5 s56_n_5 0 adc_mim_bank COUNT=32
Vs56_n_6 s56_n_6 0 DC 0 AC 1
Xs56_n_6 s56_n_6 0 adc_mim_bank COUNT=64
Vs56_n_7 s56_n_7 0 DC 0 AC 1
Xs56_n_7 s56_n_7 0 adc_mim_bank COUNT=128
Vs56_n_8 s56_n_8 0 DC 0 AC 1
Xs56_n_8 s56_n_8 0 adc_mim_bank COUNT=256
Vs56_n_9 s56_n_9 0 DC 0 AC 1
Xs56_n_9 s56_n_9 0 adc_mim_bank COUNT=512
Vs56_n_10 s56_n_10 0 DC 0 AC 1
Xs56_n_10 s56_n_10 0 adc_mim_bank COUNT=1024
Vs56_n_11 s56_n_11 0 DC 0 AC 1
Xs56_n_11 s56_n_11 0 adc_mim_bank COUNT=2048
Vs56_n_12 s56_n_12 0 DC 0 AC 1
Xs56_n_12 s56_n_12 0 adc_mim_bank COUNT=1
Vs57_p_0 s57_p_0 0 DC 0 AC 1
Xs57_p_0 s57_p_0 0 adc_mim_bank COUNT=1
Vs57_p_1 s57_p_1 0 DC 0 AC 1
Xs57_p_1 s57_p_1 0 adc_mim_bank COUNT=2
Vs57_p_2 s57_p_2 0 DC 0 AC 1
Xs57_p_2 s57_p_2 0 adc_mim_bank COUNT=4
Vs57_p_3 s57_p_3 0 DC 0 AC 1
Xs57_p_3 s57_p_3 0 adc_mim_bank COUNT=8
Vs57_p_4 s57_p_4 0 DC 0 AC 1
Xs57_p_4 s57_p_4 0 adc_mim_bank COUNT=16
Vs57_p_5 s57_p_5 0 DC 0 AC 1
Xs57_p_5 s57_p_5 0 adc_mim_bank COUNT=32
Vs57_p_6 s57_p_6 0 DC 0 AC 1
Xs57_p_6 s57_p_6 0 adc_mim_bank COUNT=64
Vs57_p_7 s57_p_7 0 DC 0 AC 1
Xs57_p_7 s57_p_7 0 adc_mim_bank COUNT=128
Vs57_p_8 s57_p_8 0 DC 0 AC 1
Xs57_p_8 s57_p_8 0 adc_mim_bank COUNT=256
Vs57_p_9 s57_p_9 0 DC 0 AC 1
Xs57_p_9 s57_p_9 0 adc_mim_bank COUNT=512
Vs57_p_10 s57_p_10 0 DC 0 AC 1
Xs57_p_10 s57_p_10 0 adc_mim_bank COUNT=1024
Vs57_p_11 s57_p_11 0 DC 0 AC 1
Xs57_p_11 s57_p_11 0 adc_mim_bank COUNT=2048
Vs57_p_12 s57_p_12 0 DC 0 AC 1
Xs57_p_12 s57_p_12 0 adc_mim_bank COUNT=1
Vs57_n_0 s57_n_0 0 DC 0 AC 1
Xs57_n_0 s57_n_0 0 adc_mim_bank COUNT=1
Vs57_n_1 s57_n_1 0 DC 0 AC 1
Xs57_n_1 s57_n_1 0 adc_mim_bank COUNT=2
Vs57_n_2 s57_n_2 0 DC 0 AC 1
Xs57_n_2 s57_n_2 0 adc_mim_bank COUNT=4
Vs57_n_3 s57_n_3 0 DC 0 AC 1
Xs57_n_3 s57_n_3 0 adc_mim_bank COUNT=8
Vs57_n_4 s57_n_4 0 DC 0 AC 1
Xs57_n_4 s57_n_4 0 adc_mim_bank COUNT=16
Vs57_n_5 s57_n_5 0 DC 0 AC 1
Xs57_n_5 s57_n_5 0 adc_mim_bank COUNT=32
Vs57_n_6 s57_n_6 0 DC 0 AC 1
Xs57_n_6 s57_n_6 0 adc_mim_bank COUNT=64
Vs57_n_7 s57_n_7 0 DC 0 AC 1
Xs57_n_7 s57_n_7 0 adc_mim_bank COUNT=128
Vs57_n_8 s57_n_8 0 DC 0 AC 1
Xs57_n_8 s57_n_8 0 adc_mim_bank COUNT=256
Vs57_n_9 s57_n_9 0 DC 0 AC 1
Xs57_n_9 s57_n_9 0 adc_mim_bank COUNT=512
Vs57_n_10 s57_n_10 0 DC 0 AC 1
Xs57_n_10 s57_n_10 0 adc_mim_bank COUNT=1024
Vs57_n_11 s57_n_11 0 DC 0 AC 1
Xs57_n_11 s57_n_11 0 adc_mim_bank COUNT=2048
Vs57_n_12 s57_n_12 0 DC 0 AC 1
Xs57_n_12 s57_n_12 0 adc_mim_bank COUNT=1
Vs58_p_0 s58_p_0 0 DC 0 AC 1
Xs58_p_0 s58_p_0 0 adc_mim_bank COUNT=1
Vs58_p_1 s58_p_1 0 DC 0 AC 1
Xs58_p_1 s58_p_1 0 adc_mim_bank COUNT=2
Vs58_p_2 s58_p_2 0 DC 0 AC 1
Xs58_p_2 s58_p_2 0 adc_mim_bank COUNT=4
Vs58_p_3 s58_p_3 0 DC 0 AC 1
Xs58_p_3 s58_p_3 0 adc_mim_bank COUNT=8
Vs58_p_4 s58_p_4 0 DC 0 AC 1
Xs58_p_4 s58_p_4 0 adc_mim_bank COUNT=16
Vs58_p_5 s58_p_5 0 DC 0 AC 1
Xs58_p_5 s58_p_5 0 adc_mim_bank COUNT=32
Vs58_p_6 s58_p_6 0 DC 0 AC 1
Xs58_p_6 s58_p_6 0 adc_mim_bank COUNT=64
Vs58_p_7 s58_p_7 0 DC 0 AC 1
Xs58_p_7 s58_p_7 0 adc_mim_bank COUNT=128
Vs58_p_8 s58_p_8 0 DC 0 AC 1
Xs58_p_8 s58_p_8 0 adc_mim_bank COUNT=256
Vs58_p_9 s58_p_9 0 DC 0 AC 1
Xs58_p_9 s58_p_9 0 adc_mim_bank COUNT=512
Vs58_p_10 s58_p_10 0 DC 0 AC 1
Xs58_p_10 s58_p_10 0 adc_mim_bank COUNT=1024
Vs58_p_11 s58_p_11 0 DC 0 AC 1
Xs58_p_11 s58_p_11 0 adc_mim_bank COUNT=2048
Vs58_p_12 s58_p_12 0 DC 0 AC 1
Xs58_p_12 s58_p_12 0 adc_mim_bank COUNT=1
Vs58_n_0 s58_n_0 0 DC 0 AC 1
Xs58_n_0 s58_n_0 0 adc_mim_bank COUNT=1
Vs58_n_1 s58_n_1 0 DC 0 AC 1
Xs58_n_1 s58_n_1 0 adc_mim_bank COUNT=2
Vs58_n_2 s58_n_2 0 DC 0 AC 1
Xs58_n_2 s58_n_2 0 adc_mim_bank COUNT=4
Vs58_n_3 s58_n_3 0 DC 0 AC 1
Xs58_n_3 s58_n_3 0 adc_mim_bank COUNT=8
Vs58_n_4 s58_n_4 0 DC 0 AC 1
Xs58_n_4 s58_n_4 0 adc_mim_bank COUNT=16
Vs58_n_5 s58_n_5 0 DC 0 AC 1
Xs58_n_5 s58_n_5 0 adc_mim_bank COUNT=32
Vs58_n_6 s58_n_6 0 DC 0 AC 1
Xs58_n_6 s58_n_6 0 adc_mim_bank COUNT=64
Vs58_n_7 s58_n_7 0 DC 0 AC 1
Xs58_n_7 s58_n_7 0 adc_mim_bank COUNT=128
Vs58_n_8 s58_n_8 0 DC 0 AC 1
Xs58_n_8 s58_n_8 0 adc_mim_bank COUNT=256
Vs58_n_9 s58_n_9 0 DC 0 AC 1
Xs58_n_9 s58_n_9 0 adc_mim_bank COUNT=512
Vs58_n_10 s58_n_10 0 DC 0 AC 1
Xs58_n_10 s58_n_10 0 adc_mim_bank COUNT=1024
Vs58_n_11 s58_n_11 0 DC 0 AC 1
Xs58_n_11 s58_n_11 0 adc_mim_bank COUNT=2048
Vs58_n_12 s58_n_12 0 DC 0 AC 1
Xs58_n_12 s58_n_12 0 adc_mim_bank COUNT=1
Vs59_p_0 s59_p_0 0 DC 0 AC 1
Xs59_p_0 s59_p_0 0 adc_mim_bank COUNT=1
Vs59_p_1 s59_p_1 0 DC 0 AC 1
Xs59_p_1 s59_p_1 0 adc_mim_bank COUNT=2
Vs59_p_2 s59_p_2 0 DC 0 AC 1
Xs59_p_2 s59_p_2 0 adc_mim_bank COUNT=4
Vs59_p_3 s59_p_3 0 DC 0 AC 1
Xs59_p_3 s59_p_3 0 adc_mim_bank COUNT=8
Vs59_p_4 s59_p_4 0 DC 0 AC 1
Xs59_p_4 s59_p_4 0 adc_mim_bank COUNT=16
Vs59_p_5 s59_p_5 0 DC 0 AC 1
Xs59_p_5 s59_p_5 0 adc_mim_bank COUNT=32
Vs59_p_6 s59_p_6 0 DC 0 AC 1
Xs59_p_6 s59_p_6 0 adc_mim_bank COUNT=64
Vs59_p_7 s59_p_7 0 DC 0 AC 1
Xs59_p_7 s59_p_7 0 adc_mim_bank COUNT=128
Vs59_p_8 s59_p_8 0 DC 0 AC 1
Xs59_p_8 s59_p_8 0 adc_mim_bank COUNT=256
Vs59_p_9 s59_p_9 0 DC 0 AC 1
Xs59_p_9 s59_p_9 0 adc_mim_bank COUNT=512
Vs59_p_10 s59_p_10 0 DC 0 AC 1
Xs59_p_10 s59_p_10 0 adc_mim_bank COUNT=1024
Vs59_p_11 s59_p_11 0 DC 0 AC 1
Xs59_p_11 s59_p_11 0 adc_mim_bank COUNT=2048
Vs59_p_12 s59_p_12 0 DC 0 AC 1
Xs59_p_12 s59_p_12 0 adc_mim_bank COUNT=1
Vs59_n_0 s59_n_0 0 DC 0 AC 1
Xs59_n_0 s59_n_0 0 adc_mim_bank COUNT=1
Vs59_n_1 s59_n_1 0 DC 0 AC 1
Xs59_n_1 s59_n_1 0 adc_mim_bank COUNT=2
Vs59_n_2 s59_n_2 0 DC 0 AC 1
Xs59_n_2 s59_n_2 0 adc_mim_bank COUNT=4
Vs59_n_3 s59_n_3 0 DC 0 AC 1
Xs59_n_3 s59_n_3 0 adc_mim_bank COUNT=8
Vs59_n_4 s59_n_4 0 DC 0 AC 1
Xs59_n_4 s59_n_4 0 adc_mim_bank COUNT=16
Vs59_n_5 s59_n_5 0 DC 0 AC 1
Xs59_n_5 s59_n_5 0 adc_mim_bank COUNT=32
Vs59_n_6 s59_n_6 0 DC 0 AC 1
Xs59_n_6 s59_n_6 0 adc_mim_bank COUNT=64
Vs59_n_7 s59_n_7 0 DC 0 AC 1
Xs59_n_7 s59_n_7 0 adc_mim_bank COUNT=128
Vs59_n_8 s59_n_8 0 DC 0 AC 1
Xs59_n_8 s59_n_8 0 adc_mim_bank COUNT=256
Vs59_n_9 s59_n_9 0 DC 0 AC 1
Xs59_n_9 s59_n_9 0 adc_mim_bank COUNT=512
Vs59_n_10 s59_n_10 0 DC 0 AC 1
Xs59_n_10 s59_n_10 0 adc_mim_bank COUNT=1024
Vs59_n_11 s59_n_11 0 DC 0 AC 1
Xs59_n_11 s59_n_11 0 adc_mim_bank COUNT=2048
Vs59_n_12 s59_n_12 0 DC 0 AC 1
Xs59_n_12 s59_n_12 0 adc_mim_bank COUNT=1
Vs60_p_0 s60_p_0 0 DC 0 AC 1
Xs60_p_0 s60_p_0 0 adc_mim_bank COUNT=1
Vs60_p_1 s60_p_1 0 DC 0 AC 1
Xs60_p_1 s60_p_1 0 adc_mim_bank COUNT=2
Vs60_p_2 s60_p_2 0 DC 0 AC 1
Xs60_p_2 s60_p_2 0 adc_mim_bank COUNT=4
Vs60_p_3 s60_p_3 0 DC 0 AC 1
Xs60_p_3 s60_p_3 0 adc_mim_bank COUNT=8
Vs60_p_4 s60_p_4 0 DC 0 AC 1
Xs60_p_4 s60_p_4 0 adc_mim_bank COUNT=16
Vs60_p_5 s60_p_5 0 DC 0 AC 1
Xs60_p_5 s60_p_5 0 adc_mim_bank COUNT=32
Vs60_p_6 s60_p_6 0 DC 0 AC 1
Xs60_p_6 s60_p_6 0 adc_mim_bank COUNT=64
Vs60_p_7 s60_p_7 0 DC 0 AC 1
Xs60_p_7 s60_p_7 0 adc_mim_bank COUNT=128
Vs60_p_8 s60_p_8 0 DC 0 AC 1
Xs60_p_8 s60_p_8 0 adc_mim_bank COUNT=256
Vs60_p_9 s60_p_9 0 DC 0 AC 1
Xs60_p_9 s60_p_9 0 adc_mim_bank COUNT=512
Vs60_p_10 s60_p_10 0 DC 0 AC 1
Xs60_p_10 s60_p_10 0 adc_mim_bank COUNT=1024
Vs60_p_11 s60_p_11 0 DC 0 AC 1
Xs60_p_11 s60_p_11 0 adc_mim_bank COUNT=2048
Vs60_p_12 s60_p_12 0 DC 0 AC 1
Xs60_p_12 s60_p_12 0 adc_mim_bank COUNT=1
Vs60_n_0 s60_n_0 0 DC 0 AC 1
Xs60_n_0 s60_n_0 0 adc_mim_bank COUNT=1
Vs60_n_1 s60_n_1 0 DC 0 AC 1
Xs60_n_1 s60_n_1 0 adc_mim_bank COUNT=2
Vs60_n_2 s60_n_2 0 DC 0 AC 1
Xs60_n_2 s60_n_2 0 adc_mim_bank COUNT=4
Vs60_n_3 s60_n_3 0 DC 0 AC 1
Xs60_n_3 s60_n_3 0 adc_mim_bank COUNT=8
Vs60_n_4 s60_n_4 0 DC 0 AC 1
Xs60_n_4 s60_n_4 0 adc_mim_bank COUNT=16
Vs60_n_5 s60_n_5 0 DC 0 AC 1
Xs60_n_5 s60_n_5 0 adc_mim_bank COUNT=32
Vs60_n_6 s60_n_6 0 DC 0 AC 1
Xs60_n_6 s60_n_6 0 adc_mim_bank COUNT=64
Vs60_n_7 s60_n_7 0 DC 0 AC 1
Xs60_n_7 s60_n_7 0 adc_mim_bank COUNT=128
Vs60_n_8 s60_n_8 0 DC 0 AC 1
Xs60_n_8 s60_n_8 0 adc_mim_bank COUNT=256
Vs60_n_9 s60_n_9 0 DC 0 AC 1
Xs60_n_9 s60_n_9 0 adc_mim_bank COUNT=512
Vs60_n_10 s60_n_10 0 DC 0 AC 1
Xs60_n_10 s60_n_10 0 adc_mim_bank COUNT=1024
Vs60_n_11 s60_n_11 0 DC 0 AC 1
Xs60_n_11 s60_n_11 0 adc_mim_bank COUNT=2048
Vs60_n_12 s60_n_12 0 DC 0 AC 1
Xs60_n_12 s60_n_12 0 adc_mim_bank COUNT=1
Vs61_p_0 s61_p_0 0 DC 0 AC 1
Xs61_p_0 s61_p_0 0 adc_mim_bank COUNT=1
Vs61_p_1 s61_p_1 0 DC 0 AC 1
Xs61_p_1 s61_p_1 0 adc_mim_bank COUNT=2
Vs61_p_2 s61_p_2 0 DC 0 AC 1
Xs61_p_2 s61_p_2 0 adc_mim_bank COUNT=4
Vs61_p_3 s61_p_3 0 DC 0 AC 1
Xs61_p_3 s61_p_3 0 adc_mim_bank COUNT=8
Vs61_p_4 s61_p_4 0 DC 0 AC 1
Xs61_p_4 s61_p_4 0 adc_mim_bank COUNT=16
Vs61_p_5 s61_p_5 0 DC 0 AC 1
Xs61_p_5 s61_p_5 0 adc_mim_bank COUNT=32
Vs61_p_6 s61_p_6 0 DC 0 AC 1
Xs61_p_6 s61_p_6 0 adc_mim_bank COUNT=64
Vs61_p_7 s61_p_7 0 DC 0 AC 1
Xs61_p_7 s61_p_7 0 adc_mim_bank COUNT=128
Vs61_p_8 s61_p_8 0 DC 0 AC 1
Xs61_p_8 s61_p_8 0 adc_mim_bank COUNT=256
Vs61_p_9 s61_p_9 0 DC 0 AC 1
Xs61_p_9 s61_p_9 0 adc_mim_bank COUNT=512
Vs61_p_10 s61_p_10 0 DC 0 AC 1
Xs61_p_10 s61_p_10 0 adc_mim_bank COUNT=1024
Vs61_p_11 s61_p_11 0 DC 0 AC 1
Xs61_p_11 s61_p_11 0 adc_mim_bank COUNT=2048
Vs61_p_12 s61_p_12 0 DC 0 AC 1
Xs61_p_12 s61_p_12 0 adc_mim_bank COUNT=1
Vs61_n_0 s61_n_0 0 DC 0 AC 1
Xs61_n_0 s61_n_0 0 adc_mim_bank COUNT=1
Vs61_n_1 s61_n_1 0 DC 0 AC 1
Xs61_n_1 s61_n_1 0 adc_mim_bank COUNT=2
Vs61_n_2 s61_n_2 0 DC 0 AC 1
Xs61_n_2 s61_n_2 0 adc_mim_bank COUNT=4
Vs61_n_3 s61_n_3 0 DC 0 AC 1
Xs61_n_3 s61_n_3 0 adc_mim_bank COUNT=8
Vs61_n_4 s61_n_4 0 DC 0 AC 1
Xs61_n_4 s61_n_4 0 adc_mim_bank COUNT=16
Vs61_n_5 s61_n_5 0 DC 0 AC 1
Xs61_n_5 s61_n_5 0 adc_mim_bank COUNT=32
Vs61_n_6 s61_n_6 0 DC 0 AC 1
Xs61_n_6 s61_n_6 0 adc_mim_bank COUNT=64
Vs61_n_7 s61_n_7 0 DC 0 AC 1
Xs61_n_7 s61_n_7 0 adc_mim_bank COUNT=128
Vs61_n_8 s61_n_8 0 DC 0 AC 1
Xs61_n_8 s61_n_8 0 adc_mim_bank COUNT=256
Vs61_n_9 s61_n_9 0 DC 0 AC 1
Xs61_n_9 s61_n_9 0 adc_mim_bank COUNT=512
Vs61_n_10 s61_n_10 0 DC 0 AC 1
Xs61_n_10 s61_n_10 0 adc_mim_bank COUNT=1024
Vs61_n_11 s61_n_11 0 DC 0 AC 1
Xs61_n_11 s61_n_11 0 adc_mim_bank COUNT=2048
Vs61_n_12 s61_n_12 0 DC 0 AC 1
Xs61_n_12 s61_n_12 0 adc_mim_bank COUNT=1
Vs62_p_0 s62_p_0 0 DC 0 AC 1
Xs62_p_0 s62_p_0 0 adc_mim_bank COUNT=1
Vs62_p_1 s62_p_1 0 DC 0 AC 1
Xs62_p_1 s62_p_1 0 adc_mim_bank COUNT=2
Vs62_p_2 s62_p_2 0 DC 0 AC 1
Xs62_p_2 s62_p_2 0 adc_mim_bank COUNT=4
Vs62_p_3 s62_p_3 0 DC 0 AC 1
Xs62_p_3 s62_p_3 0 adc_mim_bank COUNT=8
Vs62_p_4 s62_p_4 0 DC 0 AC 1
Xs62_p_4 s62_p_4 0 adc_mim_bank COUNT=16
Vs62_p_5 s62_p_5 0 DC 0 AC 1
Xs62_p_5 s62_p_5 0 adc_mim_bank COUNT=32
Vs62_p_6 s62_p_6 0 DC 0 AC 1
Xs62_p_6 s62_p_6 0 adc_mim_bank COUNT=64
Vs62_p_7 s62_p_7 0 DC 0 AC 1
Xs62_p_7 s62_p_7 0 adc_mim_bank COUNT=128
Vs62_p_8 s62_p_8 0 DC 0 AC 1
Xs62_p_8 s62_p_8 0 adc_mim_bank COUNT=256
Vs62_p_9 s62_p_9 0 DC 0 AC 1
Xs62_p_9 s62_p_9 0 adc_mim_bank COUNT=512
Vs62_p_10 s62_p_10 0 DC 0 AC 1
Xs62_p_10 s62_p_10 0 adc_mim_bank COUNT=1024
Vs62_p_11 s62_p_11 0 DC 0 AC 1
Xs62_p_11 s62_p_11 0 adc_mim_bank COUNT=2048
Vs62_p_12 s62_p_12 0 DC 0 AC 1
Xs62_p_12 s62_p_12 0 adc_mim_bank COUNT=1
Vs62_n_0 s62_n_0 0 DC 0 AC 1
Xs62_n_0 s62_n_0 0 adc_mim_bank COUNT=1
Vs62_n_1 s62_n_1 0 DC 0 AC 1
Xs62_n_1 s62_n_1 0 adc_mim_bank COUNT=2
Vs62_n_2 s62_n_2 0 DC 0 AC 1
Xs62_n_2 s62_n_2 0 adc_mim_bank COUNT=4
Vs62_n_3 s62_n_3 0 DC 0 AC 1
Xs62_n_3 s62_n_3 0 adc_mim_bank COUNT=8
Vs62_n_4 s62_n_4 0 DC 0 AC 1
Xs62_n_4 s62_n_4 0 adc_mim_bank COUNT=16
Vs62_n_5 s62_n_5 0 DC 0 AC 1
Xs62_n_5 s62_n_5 0 adc_mim_bank COUNT=32
Vs62_n_6 s62_n_6 0 DC 0 AC 1
Xs62_n_6 s62_n_6 0 adc_mim_bank COUNT=64
Vs62_n_7 s62_n_7 0 DC 0 AC 1
Xs62_n_7 s62_n_7 0 adc_mim_bank COUNT=128
Vs62_n_8 s62_n_8 0 DC 0 AC 1
Xs62_n_8 s62_n_8 0 adc_mim_bank COUNT=256
Vs62_n_9 s62_n_9 0 DC 0 AC 1
Xs62_n_9 s62_n_9 0 adc_mim_bank COUNT=512
Vs62_n_10 s62_n_10 0 DC 0 AC 1
Xs62_n_10 s62_n_10 0 adc_mim_bank COUNT=1024
Vs62_n_11 s62_n_11 0 DC 0 AC 1
Xs62_n_11 s62_n_11 0 adc_mim_bank COUNT=2048
Vs62_n_12 s62_n_12 0 DC 0 AC 1
Xs62_n_12 s62_n_12 0 adc_mim_bank COUNT=1
Vs63_p_0 s63_p_0 0 DC 0 AC 1
Xs63_p_0 s63_p_0 0 adc_mim_bank COUNT=1
Vs63_p_1 s63_p_1 0 DC 0 AC 1
Xs63_p_1 s63_p_1 0 adc_mim_bank COUNT=2
Vs63_p_2 s63_p_2 0 DC 0 AC 1
Xs63_p_2 s63_p_2 0 adc_mim_bank COUNT=4
Vs63_p_3 s63_p_3 0 DC 0 AC 1
Xs63_p_3 s63_p_3 0 adc_mim_bank COUNT=8
Vs63_p_4 s63_p_4 0 DC 0 AC 1
Xs63_p_4 s63_p_4 0 adc_mim_bank COUNT=16
Vs63_p_5 s63_p_5 0 DC 0 AC 1
Xs63_p_5 s63_p_5 0 adc_mim_bank COUNT=32
Vs63_p_6 s63_p_6 0 DC 0 AC 1
Xs63_p_6 s63_p_6 0 adc_mim_bank COUNT=64
Vs63_p_7 s63_p_7 0 DC 0 AC 1
Xs63_p_7 s63_p_7 0 adc_mim_bank COUNT=128
Vs63_p_8 s63_p_8 0 DC 0 AC 1
Xs63_p_8 s63_p_8 0 adc_mim_bank COUNT=256
Vs63_p_9 s63_p_9 0 DC 0 AC 1
Xs63_p_9 s63_p_9 0 adc_mim_bank COUNT=512
Vs63_p_10 s63_p_10 0 DC 0 AC 1
Xs63_p_10 s63_p_10 0 adc_mim_bank COUNT=1024
Vs63_p_11 s63_p_11 0 DC 0 AC 1
Xs63_p_11 s63_p_11 0 adc_mim_bank COUNT=2048
Vs63_p_12 s63_p_12 0 DC 0 AC 1
Xs63_p_12 s63_p_12 0 adc_mim_bank COUNT=1
Vs63_n_0 s63_n_0 0 DC 0 AC 1
Xs63_n_0 s63_n_0 0 adc_mim_bank COUNT=1
Vs63_n_1 s63_n_1 0 DC 0 AC 1
Xs63_n_1 s63_n_1 0 adc_mim_bank COUNT=2
Vs63_n_2 s63_n_2 0 DC 0 AC 1
Xs63_n_2 s63_n_2 0 adc_mim_bank COUNT=4
Vs63_n_3 s63_n_3 0 DC 0 AC 1
Xs63_n_3 s63_n_3 0 adc_mim_bank COUNT=8
Vs63_n_4 s63_n_4 0 DC 0 AC 1
Xs63_n_4 s63_n_4 0 adc_mim_bank COUNT=16
Vs63_n_5 s63_n_5 0 DC 0 AC 1
Xs63_n_5 s63_n_5 0 adc_mim_bank COUNT=32
Vs63_n_6 s63_n_6 0 DC 0 AC 1
Xs63_n_6 s63_n_6 0 adc_mim_bank COUNT=64
Vs63_n_7 s63_n_7 0 DC 0 AC 1
Xs63_n_7 s63_n_7 0 adc_mim_bank COUNT=128
Vs63_n_8 s63_n_8 0 DC 0 AC 1
Xs63_n_8 s63_n_8 0 adc_mim_bank COUNT=256
Vs63_n_9 s63_n_9 0 DC 0 AC 1
Xs63_n_9 s63_n_9 0 adc_mim_bank COUNT=512
Vs63_n_10 s63_n_10 0 DC 0 AC 1
Xs63_n_10 s63_n_10 0 adc_mim_bank COUNT=1024
Vs63_n_11 s63_n_11 0 DC 0 AC 1
Xs63_n_11 s63_n_11 0 adc_mim_bank COUNT=2048
Vs63_n_12 s63_n_12 0 DC 0 AC 1
Xs63_n_12 s63_n_12 0 adc_mim_bank COUNT=1
Vs64_p_0 s64_p_0 0 DC 0 AC 1
Xs64_p_0 s64_p_0 0 adc_mim_bank COUNT=1
Vs64_p_1 s64_p_1 0 DC 0 AC 1
Xs64_p_1 s64_p_1 0 adc_mim_bank COUNT=2
Vs64_p_2 s64_p_2 0 DC 0 AC 1
Xs64_p_2 s64_p_2 0 adc_mim_bank COUNT=4
Vs64_p_3 s64_p_3 0 DC 0 AC 1
Xs64_p_3 s64_p_3 0 adc_mim_bank COUNT=8
Vs64_p_4 s64_p_4 0 DC 0 AC 1
Xs64_p_4 s64_p_4 0 adc_mim_bank COUNT=16
Vs64_p_5 s64_p_5 0 DC 0 AC 1
Xs64_p_5 s64_p_5 0 adc_mim_bank COUNT=32
Vs64_p_6 s64_p_6 0 DC 0 AC 1
Xs64_p_6 s64_p_6 0 adc_mim_bank COUNT=64
Vs64_p_7 s64_p_7 0 DC 0 AC 1
Xs64_p_7 s64_p_7 0 adc_mim_bank COUNT=128
Vs64_p_8 s64_p_8 0 DC 0 AC 1
Xs64_p_8 s64_p_8 0 adc_mim_bank COUNT=256
Vs64_p_9 s64_p_9 0 DC 0 AC 1
Xs64_p_9 s64_p_9 0 adc_mim_bank COUNT=512
Vs64_p_10 s64_p_10 0 DC 0 AC 1
Xs64_p_10 s64_p_10 0 adc_mim_bank COUNT=1024
Vs64_p_11 s64_p_11 0 DC 0 AC 1
Xs64_p_11 s64_p_11 0 adc_mim_bank COUNT=2048
Vs64_p_12 s64_p_12 0 DC 0 AC 1
Xs64_p_12 s64_p_12 0 adc_mim_bank COUNT=1
Vs64_n_0 s64_n_0 0 DC 0 AC 1
Xs64_n_0 s64_n_0 0 adc_mim_bank COUNT=1
Vs64_n_1 s64_n_1 0 DC 0 AC 1
Xs64_n_1 s64_n_1 0 adc_mim_bank COUNT=2
Vs64_n_2 s64_n_2 0 DC 0 AC 1
Xs64_n_2 s64_n_2 0 adc_mim_bank COUNT=4
Vs64_n_3 s64_n_3 0 DC 0 AC 1
Xs64_n_3 s64_n_3 0 adc_mim_bank COUNT=8
Vs64_n_4 s64_n_4 0 DC 0 AC 1
Xs64_n_4 s64_n_4 0 adc_mim_bank COUNT=16
Vs64_n_5 s64_n_5 0 DC 0 AC 1
Xs64_n_5 s64_n_5 0 adc_mim_bank COUNT=32
Vs64_n_6 s64_n_6 0 DC 0 AC 1
Xs64_n_6 s64_n_6 0 adc_mim_bank COUNT=64
Vs64_n_7 s64_n_7 0 DC 0 AC 1
Xs64_n_7 s64_n_7 0 adc_mim_bank COUNT=128
Vs64_n_8 s64_n_8 0 DC 0 AC 1
Xs64_n_8 s64_n_8 0 adc_mim_bank COUNT=256
Vs64_n_9 s64_n_9 0 DC 0 AC 1
Xs64_n_9 s64_n_9 0 adc_mim_bank COUNT=512
Vs64_n_10 s64_n_10 0 DC 0 AC 1
Xs64_n_10 s64_n_10 0 adc_mim_bank COUNT=1024
Vs64_n_11 s64_n_11 0 DC 0 AC 1
Xs64_n_11 s64_n_11 0 adc_mim_bank COUNT=2048
Vs64_n_12 s64_n_12 0 DC 0 AC 1
Xs64_n_12 s64_n_12 0 adc_mim_bank COUNT=1
Vs65_p_0 s65_p_0 0 DC 0 AC 1
Xs65_p_0 s65_p_0 0 adc_mim_bank COUNT=1
Vs65_p_1 s65_p_1 0 DC 0 AC 1
Xs65_p_1 s65_p_1 0 adc_mim_bank COUNT=2
Vs65_p_2 s65_p_2 0 DC 0 AC 1
Xs65_p_2 s65_p_2 0 adc_mim_bank COUNT=4
Vs65_p_3 s65_p_3 0 DC 0 AC 1
Xs65_p_3 s65_p_3 0 adc_mim_bank COUNT=8
Vs65_p_4 s65_p_4 0 DC 0 AC 1
Xs65_p_4 s65_p_4 0 adc_mim_bank COUNT=16
Vs65_p_5 s65_p_5 0 DC 0 AC 1
Xs65_p_5 s65_p_5 0 adc_mim_bank COUNT=32
Vs65_p_6 s65_p_6 0 DC 0 AC 1
Xs65_p_6 s65_p_6 0 adc_mim_bank COUNT=64
Vs65_p_7 s65_p_7 0 DC 0 AC 1
Xs65_p_7 s65_p_7 0 adc_mim_bank COUNT=128
Vs65_p_8 s65_p_8 0 DC 0 AC 1
Xs65_p_8 s65_p_8 0 adc_mim_bank COUNT=256
Vs65_p_9 s65_p_9 0 DC 0 AC 1
Xs65_p_9 s65_p_9 0 adc_mim_bank COUNT=512
Vs65_p_10 s65_p_10 0 DC 0 AC 1
Xs65_p_10 s65_p_10 0 adc_mim_bank COUNT=1024
Vs65_p_11 s65_p_11 0 DC 0 AC 1
Xs65_p_11 s65_p_11 0 adc_mim_bank COUNT=2048
Vs65_p_12 s65_p_12 0 DC 0 AC 1
Xs65_p_12 s65_p_12 0 adc_mim_bank COUNT=1
Vs65_n_0 s65_n_0 0 DC 0 AC 1
Xs65_n_0 s65_n_0 0 adc_mim_bank COUNT=1
Vs65_n_1 s65_n_1 0 DC 0 AC 1
Xs65_n_1 s65_n_1 0 adc_mim_bank COUNT=2
Vs65_n_2 s65_n_2 0 DC 0 AC 1
Xs65_n_2 s65_n_2 0 adc_mim_bank COUNT=4
Vs65_n_3 s65_n_3 0 DC 0 AC 1
Xs65_n_3 s65_n_3 0 adc_mim_bank COUNT=8
Vs65_n_4 s65_n_4 0 DC 0 AC 1
Xs65_n_4 s65_n_4 0 adc_mim_bank COUNT=16
Vs65_n_5 s65_n_5 0 DC 0 AC 1
Xs65_n_5 s65_n_5 0 adc_mim_bank COUNT=32
Vs65_n_6 s65_n_6 0 DC 0 AC 1
Xs65_n_6 s65_n_6 0 adc_mim_bank COUNT=64
Vs65_n_7 s65_n_7 0 DC 0 AC 1
Xs65_n_7 s65_n_7 0 adc_mim_bank COUNT=128
Vs65_n_8 s65_n_8 0 DC 0 AC 1
Xs65_n_8 s65_n_8 0 adc_mim_bank COUNT=256
Vs65_n_9 s65_n_9 0 DC 0 AC 1
Xs65_n_9 s65_n_9 0 adc_mim_bank COUNT=512
Vs65_n_10 s65_n_10 0 DC 0 AC 1
Xs65_n_10 s65_n_10 0 adc_mim_bank COUNT=1024
Vs65_n_11 s65_n_11 0 DC 0 AC 1
Xs65_n_11 s65_n_11 0 adc_mim_bank COUNT=2048
Vs65_n_12 s65_n_12 0 DC 0 AC 1
Xs65_n_12 s65_n_12 0 adc_mim_bank COUNT=1
Vs66_p_0 s66_p_0 0 DC 0 AC 1
Xs66_p_0 s66_p_0 0 adc_mim_bank COUNT=1
Vs66_p_1 s66_p_1 0 DC 0 AC 1
Xs66_p_1 s66_p_1 0 adc_mim_bank COUNT=2
Vs66_p_2 s66_p_2 0 DC 0 AC 1
Xs66_p_2 s66_p_2 0 adc_mim_bank COUNT=4
Vs66_p_3 s66_p_3 0 DC 0 AC 1
Xs66_p_3 s66_p_3 0 adc_mim_bank COUNT=8
Vs66_p_4 s66_p_4 0 DC 0 AC 1
Xs66_p_4 s66_p_4 0 adc_mim_bank COUNT=16
Vs66_p_5 s66_p_5 0 DC 0 AC 1
Xs66_p_5 s66_p_5 0 adc_mim_bank COUNT=32
Vs66_p_6 s66_p_6 0 DC 0 AC 1
Xs66_p_6 s66_p_6 0 adc_mim_bank COUNT=64
Vs66_p_7 s66_p_7 0 DC 0 AC 1
Xs66_p_7 s66_p_7 0 adc_mim_bank COUNT=128
Vs66_p_8 s66_p_8 0 DC 0 AC 1
Xs66_p_8 s66_p_8 0 adc_mim_bank COUNT=256
Vs66_p_9 s66_p_9 0 DC 0 AC 1
Xs66_p_9 s66_p_9 0 adc_mim_bank COUNT=512
Vs66_p_10 s66_p_10 0 DC 0 AC 1
Xs66_p_10 s66_p_10 0 adc_mim_bank COUNT=1024
Vs66_p_11 s66_p_11 0 DC 0 AC 1
Xs66_p_11 s66_p_11 0 adc_mim_bank COUNT=2048
Vs66_p_12 s66_p_12 0 DC 0 AC 1
Xs66_p_12 s66_p_12 0 adc_mim_bank COUNT=1
Vs66_n_0 s66_n_0 0 DC 0 AC 1
Xs66_n_0 s66_n_0 0 adc_mim_bank COUNT=1
Vs66_n_1 s66_n_1 0 DC 0 AC 1
Xs66_n_1 s66_n_1 0 adc_mim_bank COUNT=2
Vs66_n_2 s66_n_2 0 DC 0 AC 1
Xs66_n_2 s66_n_2 0 adc_mim_bank COUNT=4
Vs66_n_3 s66_n_3 0 DC 0 AC 1
Xs66_n_3 s66_n_3 0 adc_mim_bank COUNT=8
Vs66_n_4 s66_n_4 0 DC 0 AC 1
Xs66_n_4 s66_n_4 0 adc_mim_bank COUNT=16
Vs66_n_5 s66_n_5 0 DC 0 AC 1
Xs66_n_5 s66_n_5 0 adc_mim_bank COUNT=32
Vs66_n_6 s66_n_6 0 DC 0 AC 1
Xs66_n_6 s66_n_6 0 adc_mim_bank COUNT=64
Vs66_n_7 s66_n_7 0 DC 0 AC 1
Xs66_n_7 s66_n_7 0 adc_mim_bank COUNT=128
Vs66_n_8 s66_n_8 0 DC 0 AC 1
Xs66_n_8 s66_n_8 0 adc_mim_bank COUNT=256
Vs66_n_9 s66_n_9 0 DC 0 AC 1
Xs66_n_9 s66_n_9 0 adc_mim_bank COUNT=512
Vs66_n_10 s66_n_10 0 DC 0 AC 1
Xs66_n_10 s66_n_10 0 adc_mim_bank COUNT=1024
Vs66_n_11 s66_n_11 0 DC 0 AC 1
Xs66_n_11 s66_n_11 0 adc_mim_bank COUNT=2048
Vs66_n_12 s66_n_12 0 DC 0 AC 1
Xs66_n_12 s66_n_12 0 adc_mim_bank COUNT=1
Vs67_p_0 s67_p_0 0 DC 0 AC 1
Xs67_p_0 s67_p_0 0 adc_mim_bank COUNT=1
Vs67_p_1 s67_p_1 0 DC 0 AC 1
Xs67_p_1 s67_p_1 0 adc_mim_bank COUNT=2
Vs67_p_2 s67_p_2 0 DC 0 AC 1
Xs67_p_2 s67_p_2 0 adc_mim_bank COUNT=4
Vs67_p_3 s67_p_3 0 DC 0 AC 1
Xs67_p_3 s67_p_3 0 adc_mim_bank COUNT=8
Vs67_p_4 s67_p_4 0 DC 0 AC 1
Xs67_p_4 s67_p_4 0 adc_mim_bank COUNT=16
Vs67_p_5 s67_p_5 0 DC 0 AC 1
Xs67_p_5 s67_p_5 0 adc_mim_bank COUNT=32
Vs67_p_6 s67_p_6 0 DC 0 AC 1
Xs67_p_6 s67_p_6 0 adc_mim_bank COUNT=64
Vs67_p_7 s67_p_7 0 DC 0 AC 1
Xs67_p_7 s67_p_7 0 adc_mim_bank COUNT=128
Vs67_p_8 s67_p_8 0 DC 0 AC 1
Xs67_p_8 s67_p_8 0 adc_mim_bank COUNT=256
Vs67_p_9 s67_p_9 0 DC 0 AC 1
Xs67_p_9 s67_p_9 0 adc_mim_bank COUNT=512
Vs67_p_10 s67_p_10 0 DC 0 AC 1
Xs67_p_10 s67_p_10 0 adc_mim_bank COUNT=1024
Vs67_p_11 s67_p_11 0 DC 0 AC 1
Xs67_p_11 s67_p_11 0 adc_mim_bank COUNT=2048
Vs67_p_12 s67_p_12 0 DC 0 AC 1
Xs67_p_12 s67_p_12 0 adc_mim_bank COUNT=1
Vs67_n_0 s67_n_0 0 DC 0 AC 1
Xs67_n_0 s67_n_0 0 adc_mim_bank COUNT=1
Vs67_n_1 s67_n_1 0 DC 0 AC 1
Xs67_n_1 s67_n_1 0 adc_mim_bank COUNT=2
Vs67_n_2 s67_n_2 0 DC 0 AC 1
Xs67_n_2 s67_n_2 0 adc_mim_bank COUNT=4
Vs67_n_3 s67_n_3 0 DC 0 AC 1
Xs67_n_3 s67_n_3 0 adc_mim_bank COUNT=8
Vs67_n_4 s67_n_4 0 DC 0 AC 1
Xs67_n_4 s67_n_4 0 adc_mim_bank COUNT=16
Vs67_n_5 s67_n_5 0 DC 0 AC 1
Xs67_n_5 s67_n_5 0 adc_mim_bank COUNT=32
Vs67_n_6 s67_n_6 0 DC 0 AC 1
Xs67_n_6 s67_n_6 0 adc_mim_bank COUNT=64
Vs67_n_7 s67_n_7 0 DC 0 AC 1
Xs67_n_7 s67_n_7 0 adc_mim_bank COUNT=128
Vs67_n_8 s67_n_8 0 DC 0 AC 1
Xs67_n_8 s67_n_8 0 adc_mim_bank COUNT=256
Vs67_n_9 s67_n_9 0 DC 0 AC 1
Xs67_n_9 s67_n_9 0 adc_mim_bank COUNT=512
Vs67_n_10 s67_n_10 0 DC 0 AC 1
Xs67_n_10 s67_n_10 0 adc_mim_bank COUNT=1024
Vs67_n_11 s67_n_11 0 DC 0 AC 1
Xs67_n_11 s67_n_11 0 adc_mim_bank COUNT=2048
Vs67_n_12 s67_n_12 0 DC 0 AC 1
Xs67_n_12 s67_n_12 0 adc_mim_bank COUNT=1
Vs68_p_0 s68_p_0 0 DC 0 AC 1
Xs68_p_0 s68_p_0 0 adc_mim_bank COUNT=1
Vs68_p_1 s68_p_1 0 DC 0 AC 1
Xs68_p_1 s68_p_1 0 adc_mim_bank COUNT=2
Vs68_p_2 s68_p_2 0 DC 0 AC 1
Xs68_p_2 s68_p_2 0 adc_mim_bank COUNT=4
Vs68_p_3 s68_p_3 0 DC 0 AC 1
Xs68_p_3 s68_p_3 0 adc_mim_bank COUNT=8
Vs68_p_4 s68_p_4 0 DC 0 AC 1
Xs68_p_4 s68_p_4 0 adc_mim_bank COUNT=16
Vs68_p_5 s68_p_5 0 DC 0 AC 1
Xs68_p_5 s68_p_5 0 adc_mim_bank COUNT=32
Vs68_p_6 s68_p_6 0 DC 0 AC 1
Xs68_p_6 s68_p_6 0 adc_mim_bank COUNT=64
Vs68_p_7 s68_p_7 0 DC 0 AC 1
Xs68_p_7 s68_p_7 0 adc_mim_bank COUNT=128
Vs68_p_8 s68_p_8 0 DC 0 AC 1
Xs68_p_8 s68_p_8 0 adc_mim_bank COUNT=256
Vs68_p_9 s68_p_9 0 DC 0 AC 1
Xs68_p_9 s68_p_9 0 adc_mim_bank COUNT=512
Vs68_p_10 s68_p_10 0 DC 0 AC 1
Xs68_p_10 s68_p_10 0 adc_mim_bank COUNT=1024
Vs68_p_11 s68_p_11 0 DC 0 AC 1
Xs68_p_11 s68_p_11 0 adc_mim_bank COUNT=2048
Vs68_p_12 s68_p_12 0 DC 0 AC 1
Xs68_p_12 s68_p_12 0 adc_mim_bank COUNT=1
Vs68_n_0 s68_n_0 0 DC 0 AC 1
Xs68_n_0 s68_n_0 0 adc_mim_bank COUNT=1
Vs68_n_1 s68_n_1 0 DC 0 AC 1
Xs68_n_1 s68_n_1 0 adc_mim_bank COUNT=2
Vs68_n_2 s68_n_2 0 DC 0 AC 1
Xs68_n_2 s68_n_2 0 adc_mim_bank COUNT=4
Vs68_n_3 s68_n_3 0 DC 0 AC 1
Xs68_n_3 s68_n_3 0 adc_mim_bank COUNT=8
Vs68_n_4 s68_n_4 0 DC 0 AC 1
Xs68_n_4 s68_n_4 0 adc_mim_bank COUNT=16
Vs68_n_5 s68_n_5 0 DC 0 AC 1
Xs68_n_5 s68_n_5 0 adc_mim_bank COUNT=32
Vs68_n_6 s68_n_6 0 DC 0 AC 1
Xs68_n_6 s68_n_6 0 adc_mim_bank COUNT=64
Vs68_n_7 s68_n_7 0 DC 0 AC 1
Xs68_n_7 s68_n_7 0 adc_mim_bank COUNT=128
Vs68_n_8 s68_n_8 0 DC 0 AC 1
Xs68_n_8 s68_n_8 0 adc_mim_bank COUNT=256
Vs68_n_9 s68_n_9 0 DC 0 AC 1
Xs68_n_9 s68_n_9 0 adc_mim_bank COUNT=512
Vs68_n_10 s68_n_10 0 DC 0 AC 1
Xs68_n_10 s68_n_10 0 adc_mim_bank COUNT=1024
Vs68_n_11 s68_n_11 0 DC 0 AC 1
Xs68_n_11 s68_n_11 0 adc_mim_bank COUNT=2048
Vs68_n_12 s68_n_12 0 DC 0 AC 1
Xs68_n_12 s68_n_12 0 adc_mim_bank COUNT=1
Vs69_p_0 s69_p_0 0 DC 0 AC 1
Xs69_p_0 s69_p_0 0 adc_mim_bank COUNT=1
Vs69_p_1 s69_p_1 0 DC 0 AC 1
Xs69_p_1 s69_p_1 0 adc_mim_bank COUNT=2
Vs69_p_2 s69_p_2 0 DC 0 AC 1
Xs69_p_2 s69_p_2 0 adc_mim_bank COUNT=4
Vs69_p_3 s69_p_3 0 DC 0 AC 1
Xs69_p_3 s69_p_3 0 adc_mim_bank COUNT=8
Vs69_p_4 s69_p_4 0 DC 0 AC 1
Xs69_p_4 s69_p_4 0 adc_mim_bank COUNT=16
Vs69_p_5 s69_p_5 0 DC 0 AC 1
Xs69_p_5 s69_p_5 0 adc_mim_bank COUNT=32
Vs69_p_6 s69_p_6 0 DC 0 AC 1
Xs69_p_6 s69_p_6 0 adc_mim_bank COUNT=64
Vs69_p_7 s69_p_7 0 DC 0 AC 1
Xs69_p_7 s69_p_7 0 adc_mim_bank COUNT=128
Vs69_p_8 s69_p_8 0 DC 0 AC 1
Xs69_p_8 s69_p_8 0 adc_mim_bank COUNT=256
Vs69_p_9 s69_p_9 0 DC 0 AC 1
Xs69_p_9 s69_p_9 0 adc_mim_bank COUNT=512
Vs69_p_10 s69_p_10 0 DC 0 AC 1
Xs69_p_10 s69_p_10 0 adc_mim_bank COUNT=1024
Vs69_p_11 s69_p_11 0 DC 0 AC 1
Xs69_p_11 s69_p_11 0 adc_mim_bank COUNT=2048
Vs69_p_12 s69_p_12 0 DC 0 AC 1
Xs69_p_12 s69_p_12 0 adc_mim_bank COUNT=1
Vs69_n_0 s69_n_0 0 DC 0 AC 1
Xs69_n_0 s69_n_0 0 adc_mim_bank COUNT=1
Vs69_n_1 s69_n_1 0 DC 0 AC 1
Xs69_n_1 s69_n_1 0 adc_mim_bank COUNT=2
Vs69_n_2 s69_n_2 0 DC 0 AC 1
Xs69_n_2 s69_n_2 0 adc_mim_bank COUNT=4
Vs69_n_3 s69_n_3 0 DC 0 AC 1
Xs69_n_3 s69_n_3 0 adc_mim_bank COUNT=8
Vs69_n_4 s69_n_4 0 DC 0 AC 1
Xs69_n_4 s69_n_4 0 adc_mim_bank COUNT=16
Vs69_n_5 s69_n_5 0 DC 0 AC 1
Xs69_n_5 s69_n_5 0 adc_mim_bank COUNT=32
Vs69_n_6 s69_n_6 0 DC 0 AC 1
Xs69_n_6 s69_n_6 0 adc_mim_bank COUNT=64
Vs69_n_7 s69_n_7 0 DC 0 AC 1
Xs69_n_7 s69_n_7 0 adc_mim_bank COUNT=128
Vs69_n_8 s69_n_8 0 DC 0 AC 1
Xs69_n_8 s69_n_8 0 adc_mim_bank COUNT=256
Vs69_n_9 s69_n_9 0 DC 0 AC 1
Xs69_n_9 s69_n_9 0 adc_mim_bank COUNT=512
Vs69_n_10 s69_n_10 0 DC 0 AC 1
Xs69_n_10 s69_n_10 0 adc_mim_bank COUNT=1024
Vs69_n_11 s69_n_11 0 DC 0 AC 1
Xs69_n_11 s69_n_11 0 adc_mim_bank COUNT=2048
Vs69_n_12 s69_n_12 0 DC 0 AC 1
Xs69_n_12 s69_n_12 0 adc_mim_bank COUNT=1
Vs70_p_0 s70_p_0 0 DC 0 AC 1
Xs70_p_0 s70_p_0 0 adc_mim_bank COUNT=1
Vs70_p_1 s70_p_1 0 DC 0 AC 1
Xs70_p_1 s70_p_1 0 adc_mim_bank COUNT=2
Vs70_p_2 s70_p_2 0 DC 0 AC 1
Xs70_p_2 s70_p_2 0 adc_mim_bank COUNT=4
Vs70_p_3 s70_p_3 0 DC 0 AC 1
Xs70_p_3 s70_p_3 0 adc_mim_bank COUNT=8
Vs70_p_4 s70_p_4 0 DC 0 AC 1
Xs70_p_4 s70_p_4 0 adc_mim_bank COUNT=16
Vs70_p_5 s70_p_5 0 DC 0 AC 1
Xs70_p_5 s70_p_5 0 adc_mim_bank COUNT=32
Vs70_p_6 s70_p_6 0 DC 0 AC 1
Xs70_p_6 s70_p_6 0 adc_mim_bank COUNT=64
Vs70_p_7 s70_p_7 0 DC 0 AC 1
Xs70_p_7 s70_p_7 0 adc_mim_bank COUNT=128
Vs70_p_8 s70_p_8 0 DC 0 AC 1
Xs70_p_8 s70_p_8 0 adc_mim_bank COUNT=256
Vs70_p_9 s70_p_9 0 DC 0 AC 1
Xs70_p_9 s70_p_9 0 adc_mim_bank COUNT=512
Vs70_p_10 s70_p_10 0 DC 0 AC 1
Xs70_p_10 s70_p_10 0 adc_mim_bank COUNT=1024
Vs70_p_11 s70_p_11 0 DC 0 AC 1
Xs70_p_11 s70_p_11 0 adc_mim_bank COUNT=2048
Vs70_p_12 s70_p_12 0 DC 0 AC 1
Xs70_p_12 s70_p_12 0 adc_mim_bank COUNT=1
Vs70_n_0 s70_n_0 0 DC 0 AC 1
Xs70_n_0 s70_n_0 0 adc_mim_bank COUNT=1
Vs70_n_1 s70_n_1 0 DC 0 AC 1
Xs70_n_1 s70_n_1 0 adc_mim_bank COUNT=2
Vs70_n_2 s70_n_2 0 DC 0 AC 1
Xs70_n_2 s70_n_2 0 adc_mim_bank COUNT=4
Vs70_n_3 s70_n_3 0 DC 0 AC 1
Xs70_n_3 s70_n_3 0 adc_mim_bank COUNT=8
Vs70_n_4 s70_n_4 0 DC 0 AC 1
Xs70_n_4 s70_n_4 0 adc_mim_bank COUNT=16
Vs70_n_5 s70_n_5 0 DC 0 AC 1
Xs70_n_5 s70_n_5 0 adc_mim_bank COUNT=32
Vs70_n_6 s70_n_6 0 DC 0 AC 1
Xs70_n_6 s70_n_6 0 adc_mim_bank COUNT=64
Vs70_n_7 s70_n_7 0 DC 0 AC 1
Xs70_n_7 s70_n_7 0 adc_mim_bank COUNT=128
Vs70_n_8 s70_n_8 0 DC 0 AC 1
Xs70_n_8 s70_n_8 0 adc_mim_bank COUNT=256
Vs70_n_9 s70_n_9 0 DC 0 AC 1
Xs70_n_9 s70_n_9 0 adc_mim_bank COUNT=512
Vs70_n_10 s70_n_10 0 DC 0 AC 1
Xs70_n_10 s70_n_10 0 adc_mim_bank COUNT=1024
Vs70_n_11 s70_n_11 0 DC 0 AC 1
Xs70_n_11 s70_n_11 0 adc_mim_bank COUNT=2048
Vs70_n_12 s70_n_12 0 DC 0 AC 1
Xs70_n_12 s70_n_12 0 adc_mim_bank COUNT=1
Vs71_p_0 s71_p_0 0 DC 0 AC 1
Xs71_p_0 s71_p_0 0 adc_mim_bank COUNT=1
Vs71_p_1 s71_p_1 0 DC 0 AC 1
Xs71_p_1 s71_p_1 0 adc_mim_bank COUNT=2
Vs71_p_2 s71_p_2 0 DC 0 AC 1
Xs71_p_2 s71_p_2 0 adc_mim_bank COUNT=4
Vs71_p_3 s71_p_3 0 DC 0 AC 1
Xs71_p_3 s71_p_3 0 adc_mim_bank COUNT=8
Vs71_p_4 s71_p_4 0 DC 0 AC 1
Xs71_p_4 s71_p_4 0 adc_mim_bank COUNT=16
Vs71_p_5 s71_p_5 0 DC 0 AC 1
Xs71_p_5 s71_p_5 0 adc_mim_bank COUNT=32
Vs71_p_6 s71_p_6 0 DC 0 AC 1
Xs71_p_6 s71_p_6 0 adc_mim_bank COUNT=64
Vs71_p_7 s71_p_7 0 DC 0 AC 1
Xs71_p_7 s71_p_7 0 adc_mim_bank COUNT=128
Vs71_p_8 s71_p_8 0 DC 0 AC 1
Xs71_p_8 s71_p_8 0 adc_mim_bank COUNT=256
Vs71_p_9 s71_p_9 0 DC 0 AC 1
Xs71_p_9 s71_p_9 0 adc_mim_bank COUNT=512
Vs71_p_10 s71_p_10 0 DC 0 AC 1
Xs71_p_10 s71_p_10 0 adc_mim_bank COUNT=1024
Vs71_p_11 s71_p_11 0 DC 0 AC 1
Xs71_p_11 s71_p_11 0 adc_mim_bank COUNT=2048
Vs71_p_12 s71_p_12 0 DC 0 AC 1
Xs71_p_12 s71_p_12 0 adc_mim_bank COUNT=1
Vs71_n_0 s71_n_0 0 DC 0 AC 1
Xs71_n_0 s71_n_0 0 adc_mim_bank COUNT=1
Vs71_n_1 s71_n_1 0 DC 0 AC 1
Xs71_n_1 s71_n_1 0 adc_mim_bank COUNT=2
Vs71_n_2 s71_n_2 0 DC 0 AC 1
Xs71_n_2 s71_n_2 0 adc_mim_bank COUNT=4
Vs71_n_3 s71_n_3 0 DC 0 AC 1
Xs71_n_3 s71_n_3 0 adc_mim_bank COUNT=8
Vs71_n_4 s71_n_4 0 DC 0 AC 1
Xs71_n_4 s71_n_4 0 adc_mim_bank COUNT=16
Vs71_n_5 s71_n_5 0 DC 0 AC 1
Xs71_n_5 s71_n_5 0 adc_mim_bank COUNT=32
Vs71_n_6 s71_n_6 0 DC 0 AC 1
Xs71_n_6 s71_n_6 0 adc_mim_bank COUNT=64
Vs71_n_7 s71_n_7 0 DC 0 AC 1
Xs71_n_7 s71_n_7 0 adc_mim_bank COUNT=128
Vs71_n_8 s71_n_8 0 DC 0 AC 1
Xs71_n_8 s71_n_8 0 adc_mim_bank COUNT=256
Vs71_n_9 s71_n_9 0 DC 0 AC 1
Xs71_n_9 s71_n_9 0 adc_mim_bank COUNT=512
Vs71_n_10 s71_n_10 0 DC 0 AC 1
Xs71_n_10 s71_n_10 0 adc_mim_bank COUNT=1024
Vs71_n_11 s71_n_11 0 DC 0 AC 1
Xs71_n_11 s71_n_11 0 adc_mim_bank COUNT=2048
Vs71_n_12 s71_n_12 0 DC 0 AC 1
Xs71_n_12 s71_n_12 0 adc_mim_bank COUNT=1
Vs72_p_0 s72_p_0 0 DC 0 AC 1
Xs72_p_0 s72_p_0 0 adc_mim_bank COUNT=1
Vs72_p_1 s72_p_1 0 DC 0 AC 1
Xs72_p_1 s72_p_1 0 adc_mim_bank COUNT=2
Vs72_p_2 s72_p_2 0 DC 0 AC 1
Xs72_p_2 s72_p_2 0 adc_mim_bank COUNT=4
Vs72_p_3 s72_p_3 0 DC 0 AC 1
Xs72_p_3 s72_p_3 0 adc_mim_bank COUNT=8
Vs72_p_4 s72_p_4 0 DC 0 AC 1
Xs72_p_4 s72_p_4 0 adc_mim_bank COUNT=16
Vs72_p_5 s72_p_5 0 DC 0 AC 1
Xs72_p_5 s72_p_5 0 adc_mim_bank COUNT=32
Vs72_p_6 s72_p_6 0 DC 0 AC 1
Xs72_p_6 s72_p_6 0 adc_mim_bank COUNT=64
Vs72_p_7 s72_p_7 0 DC 0 AC 1
Xs72_p_7 s72_p_7 0 adc_mim_bank COUNT=128
Vs72_p_8 s72_p_8 0 DC 0 AC 1
Xs72_p_8 s72_p_8 0 adc_mim_bank COUNT=256
Vs72_p_9 s72_p_9 0 DC 0 AC 1
Xs72_p_9 s72_p_9 0 adc_mim_bank COUNT=512
Vs72_p_10 s72_p_10 0 DC 0 AC 1
Xs72_p_10 s72_p_10 0 adc_mim_bank COUNT=1024
Vs72_p_11 s72_p_11 0 DC 0 AC 1
Xs72_p_11 s72_p_11 0 adc_mim_bank COUNT=2048
Vs72_p_12 s72_p_12 0 DC 0 AC 1
Xs72_p_12 s72_p_12 0 adc_mim_bank COUNT=1
Vs72_n_0 s72_n_0 0 DC 0 AC 1
Xs72_n_0 s72_n_0 0 adc_mim_bank COUNT=1
Vs72_n_1 s72_n_1 0 DC 0 AC 1
Xs72_n_1 s72_n_1 0 adc_mim_bank COUNT=2
Vs72_n_2 s72_n_2 0 DC 0 AC 1
Xs72_n_2 s72_n_2 0 adc_mim_bank COUNT=4
Vs72_n_3 s72_n_3 0 DC 0 AC 1
Xs72_n_3 s72_n_3 0 adc_mim_bank COUNT=8
Vs72_n_4 s72_n_4 0 DC 0 AC 1
Xs72_n_4 s72_n_4 0 adc_mim_bank COUNT=16
Vs72_n_5 s72_n_5 0 DC 0 AC 1
Xs72_n_5 s72_n_5 0 adc_mim_bank COUNT=32
Vs72_n_6 s72_n_6 0 DC 0 AC 1
Xs72_n_6 s72_n_6 0 adc_mim_bank COUNT=64
Vs72_n_7 s72_n_7 0 DC 0 AC 1
Xs72_n_7 s72_n_7 0 adc_mim_bank COUNT=128
Vs72_n_8 s72_n_8 0 DC 0 AC 1
Xs72_n_8 s72_n_8 0 adc_mim_bank COUNT=256
Vs72_n_9 s72_n_9 0 DC 0 AC 1
Xs72_n_9 s72_n_9 0 adc_mim_bank COUNT=512
Vs72_n_10 s72_n_10 0 DC 0 AC 1
Xs72_n_10 s72_n_10 0 adc_mim_bank COUNT=1024
Vs72_n_11 s72_n_11 0 DC 0 AC 1
Xs72_n_11 s72_n_11 0 adc_mim_bank COUNT=2048
Vs72_n_12 s72_n_12 0 DC 0 AC 1
Xs72_n_12 s72_n_12 0 adc_mim_bank COUNT=1
Vs73_p_0 s73_p_0 0 DC 0 AC 1
Xs73_p_0 s73_p_0 0 adc_mim_bank COUNT=1
Vs73_p_1 s73_p_1 0 DC 0 AC 1
Xs73_p_1 s73_p_1 0 adc_mim_bank COUNT=2
Vs73_p_2 s73_p_2 0 DC 0 AC 1
Xs73_p_2 s73_p_2 0 adc_mim_bank COUNT=4
Vs73_p_3 s73_p_3 0 DC 0 AC 1
Xs73_p_3 s73_p_3 0 adc_mim_bank COUNT=8
Vs73_p_4 s73_p_4 0 DC 0 AC 1
Xs73_p_4 s73_p_4 0 adc_mim_bank COUNT=16
Vs73_p_5 s73_p_5 0 DC 0 AC 1
Xs73_p_5 s73_p_5 0 adc_mim_bank COUNT=32
Vs73_p_6 s73_p_6 0 DC 0 AC 1
Xs73_p_6 s73_p_6 0 adc_mim_bank COUNT=64
Vs73_p_7 s73_p_7 0 DC 0 AC 1
Xs73_p_7 s73_p_7 0 adc_mim_bank COUNT=128
Vs73_p_8 s73_p_8 0 DC 0 AC 1
Xs73_p_8 s73_p_8 0 adc_mim_bank COUNT=256
Vs73_p_9 s73_p_9 0 DC 0 AC 1
Xs73_p_9 s73_p_9 0 adc_mim_bank COUNT=512
Vs73_p_10 s73_p_10 0 DC 0 AC 1
Xs73_p_10 s73_p_10 0 adc_mim_bank COUNT=1024
Vs73_p_11 s73_p_11 0 DC 0 AC 1
Xs73_p_11 s73_p_11 0 adc_mim_bank COUNT=2048
Vs73_p_12 s73_p_12 0 DC 0 AC 1
Xs73_p_12 s73_p_12 0 adc_mim_bank COUNT=1
Vs73_n_0 s73_n_0 0 DC 0 AC 1
Xs73_n_0 s73_n_0 0 adc_mim_bank COUNT=1
Vs73_n_1 s73_n_1 0 DC 0 AC 1
Xs73_n_1 s73_n_1 0 adc_mim_bank COUNT=2
Vs73_n_2 s73_n_2 0 DC 0 AC 1
Xs73_n_2 s73_n_2 0 adc_mim_bank COUNT=4
Vs73_n_3 s73_n_3 0 DC 0 AC 1
Xs73_n_3 s73_n_3 0 adc_mim_bank COUNT=8
Vs73_n_4 s73_n_4 0 DC 0 AC 1
Xs73_n_4 s73_n_4 0 adc_mim_bank COUNT=16
Vs73_n_5 s73_n_5 0 DC 0 AC 1
Xs73_n_5 s73_n_5 0 adc_mim_bank COUNT=32
Vs73_n_6 s73_n_6 0 DC 0 AC 1
Xs73_n_6 s73_n_6 0 adc_mim_bank COUNT=64
Vs73_n_7 s73_n_7 0 DC 0 AC 1
Xs73_n_7 s73_n_7 0 adc_mim_bank COUNT=128
Vs73_n_8 s73_n_8 0 DC 0 AC 1
Xs73_n_8 s73_n_8 0 adc_mim_bank COUNT=256
Vs73_n_9 s73_n_9 0 DC 0 AC 1
Xs73_n_9 s73_n_9 0 adc_mim_bank COUNT=512
Vs73_n_10 s73_n_10 0 DC 0 AC 1
Xs73_n_10 s73_n_10 0 adc_mim_bank COUNT=1024
Vs73_n_11 s73_n_11 0 DC 0 AC 1
Xs73_n_11 s73_n_11 0 adc_mim_bank COUNT=2048
Vs73_n_12 s73_n_12 0 DC 0 AC 1
Xs73_n_12 s73_n_12 0 adc_mim_bank COUNT=1
Vs74_p_0 s74_p_0 0 DC 0 AC 1
Xs74_p_0 s74_p_0 0 adc_mim_bank COUNT=1
Vs74_p_1 s74_p_1 0 DC 0 AC 1
Xs74_p_1 s74_p_1 0 adc_mim_bank COUNT=2
Vs74_p_2 s74_p_2 0 DC 0 AC 1
Xs74_p_2 s74_p_2 0 adc_mim_bank COUNT=4
Vs74_p_3 s74_p_3 0 DC 0 AC 1
Xs74_p_3 s74_p_3 0 adc_mim_bank COUNT=8
Vs74_p_4 s74_p_4 0 DC 0 AC 1
Xs74_p_4 s74_p_4 0 adc_mim_bank COUNT=16
Vs74_p_5 s74_p_5 0 DC 0 AC 1
Xs74_p_5 s74_p_5 0 adc_mim_bank COUNT=32
Vs74_p_6 s74_p_6 0 DC 0 AC 1
Xs74_p_6 s74_p_6 0 adc_mim_bank COUNT=64
Vs74_p_7 s74_p_7 0 DC 0 AC 1
Xs74_p_7 s74_p_7 0 adc_mim_bank COUNT=128
Vs74_p_8 s74_p_8 0 DC 0 AC 1
Xs74_p_8 s74_p_8 0 adc_mim_bank COUNT=256
Vs74_p_9 s74_p_9 0 DC 0 AC 1
Xs74_p_9 s74_p_9 0 adc_mim_bank COUNT=512
Vs74_p_10 s74_p_10 0 DC 0 AC 1
Xs74_p_10 s74_p_10 0 adc_mim_bank COUNT=1024
Vs74_p_11 s74_p_11 0 DC 0 AC 1
Xs74_p_11 s74_p_11 0 adc_mim_bank COUNT=2048
Vs74_p_12 s74_p_12 0 DC 0 AC 1
Xs74_p_12 s74_p_12 0 adc_mim_bank COUNT=1
Vs74_n_0 s74_n_0 0 DC 0 AC 1
Xs74_n_0 s74_n_0 0 adc_mim_bank COUNT=1
Vs74_n_1 s74_n_1 0 DC 0 AC 1
Xs74_n_1 s74_n_1 0 adc_mim_bank COUNT=2
Vs74_n_2 s74_n_2 0 DC 0 AC 1
Xs74_n_2 s74_n_2 0 adc_mim_bank COUNT=4
Vs74_n_3 s74_n_3 0 DC 0 AC 1
Xs74_n_3 s74_n_3 0 adc_mim_bank COUNT=8
Vs74_n_4 s74_n_4 0 DC 0 AC 1
Xs74_n_4 s74_n_4 0 adc_mim_bank COUNT=16
Vs74_n_5 s74_n_5 0 DC 0 AC 1
Xs74_n_5 s74_n_5 0 adc_mim_bank COUNT=32
Vs74_n_6 s74_n_6 0 DC 0 AC 1
Xs74_n_6 s74_n_6 0 adc_mim_bank COUNT=64
Vs74_n_7 s74_n_7 0 DC 0 AC 1
Xs74_n_7 s74_n_7 0 adc_mim_bank COUNT=128
Vs74_n_8 s74_n_8 0 DC 0 AC 1
Xs74_n_8 s74_n_8 0 adc_mim_bank COUNT=256
Vs74_n_9 s74_n_9 0 DC 0 AC 1
Xs74_n_9 s74_n_9 0 adc_mim_bank COUNT=512
Vs74_n_10 s74_n_10 0 DC 0 AC 1
Xs74_n_10 s74_n_10 0 adc_mim_bank COUNT=1024
Vs74_n_11 s74_n_11 0 DC 0 AC 1
Xs74_n_11 s74_n_11 0 adc_mim_bank COUNT=2048
Vs74_n_12 s74_n_12 0 DC 0 AC 1
Xs74_n_12 s74_n_12 0 adc_mim_bank COUNT=1
Vs75_p_0 s75_p_0 0 DC 0 AC 1
Xs75_p_0 s75_p_0 0 adc_mim_bank COUNT=1
Vs75_p_1 s75_p_1 0 DC 0 AC 1
Xs75_p_1 s75_p_1 0 adc_mim_bank COUNT=2
Vs75_p_2 s75_p_2 0 DC 0 AC 1
Xs75_p_2 s75_p_2 0 adc_mim_bank COUNT=4
Vs75_p_3 s75_p_3 0 DC 0 AC 1
Xs75_p_3 s75_p_3 0 adc_mim_bank COUNT=8
Vs75_p_4 s75_p_4 0 DC 0 AC 1
Xs75_p_4 s75_p_4 0 adc_mim_bank COUNT=16
Vs75_p_5 s75_p_5 0 DC 0 AC 1
Xs75_p_5 s75_p_5 0 adc_mim_bank COUNT=32
Vs75_p_6 s75_p_6 0 DC 0 AC 1
Xs75_p_6 s75_p_6 0 adc_mim_bank COUNT=64
Vs75_p_7 s75_p_7 0 DC 0 AC 1
Xs75_p_7 s75_p_7 0 adc_mim_bank COUNT=128
Vs75_p_8 s75_p_8 0 DC 0 AC 1
Xs75_p_8 s75_p_8 0 adc_mim_bank COUNT=256
Vs75_p_9 s75_p_9 0 DC 0 AC 1
Xs75_p_9 s75_p_9 0 adc_mim_bank COUNT=512
Vs75_p_10 s75_p_10 0 DC 0 AC 1
Xs75_p_10 s75_p_10 0 adc_mim_bank COUNT=1024
Vs75_p_11 s75_p_11 0 DC 0 AC 1
Xs75_p_11 s75_p_11 0 adc_mim_bank COUNT=2048
Vs75_p_12 s75_p_12 0 DC 0 AC 1
Xs75_p_12 s75_p_12 0 adc_mim_bank COUNT=1
Vs75_n_0 s75_n_0 0 DC 0 AC 1
Xs75_n_0 s75_n_0 0 adc_mim_bank COUNT=1
Vs75_n_1 s75_n_1 0 DC 0 AC 1
Xs75_n_1 s75_n_1 0 adc_mim_bank COUNT=2
Vs75_n_2 s75_n_2 0 DC 0 AC 1
Xs75_n_2 s75_n_2 0 adc_mim_bank COUNT=4
Vs75_n_3 s75_n_3 0 DC 0 AC 1
Xs75_n_3 s75_n_3 0 adc_mim_bank COUNT=8
Vs75_n_4 s75_n_4 0 DC 0 AC 1
Xs75_n_4 s75_n_4 0 adc_mim_bank COUNT=16
Vs75_n_5 s75_n_5 0 DC 0 AC 1
Xs75_n_5 s75_n_5 0 adc_mim_bank COUNT=32
Vs75_n_6 s75_n_6 0 DC 0 AC 1
Xs75_n_6 s75_n_6 0 adc_mim_bank COUNT=64
Vs75_n_7 s75_n_7 0 DC 0 AC 1
Xs75_n_7 s75_n_7 0 adc_mim_bank COUNT=128
Vs75_n_8 s75_n_8 0 DC 0 AC 1
Xs75_n_8 s75_n_8 0 adc_mim_bank COUNT=256
Vs75_n_9 s75_n_9 0 DC 0 AC 1
Xs75_n_9 s75_n_9 0 adc_mim_bank COUNT=512
Vs75_n_10 s75_n_10 0 DC 0 AC 1
Xs75_n_10 s75_n_10 0 adc_mim_bank COUNT=1024
Vs75_n_11 s75_n_11 0 DC 0 AC 1
Xs75_n_11 s75_n_11 0 adc_mim_bank COUNT=2048
Vs75_n_12 s75_n_12 0 DC 0 AC 1
Xs75_n_12 s75_n_12 0 adc_mim_bank COUNT=1
Vs76_p_0 s76_p_0 0 DC 0 AC 1
Xs76_p_0 s76_p_0 0 adc_mim_bank COUNT=1
Vs76_p_1 s76_p_1 0 DC 0 AC 1
Xs76_p_1 s76_p_1 0 adc_mim_bank COUNT=2
Vs76_p_2 s76_p_2 0 DC 0 AC 1
Xs76_p_2 s76_p_2 0 adc_mim_bank COUNT=4
Vs76_p_3 s76_p_3 0 DC 0 AC 1
Xs76_p_3 s76_p_3 0 adc_mim_bank COUNT=8
Vs76_p_4 s76_p_4 0 DC 0 AC 1
Xs76_p_4 s76_p_4 0 adc_mim_bank COUNT=16
Vs76_p_5 s76_p_5 0 DC 0 AC 1
Xs76_p_5 s76_p_5 0 adc_mim_bank COUNT=32
Vs76_p_6 s76_p_6 0 DC 0 AC 1
Xs76_p_6 s76_p_6 0 adc_mim_bank COUNT=64
Vs76_p_7 s76_p_7 0 DC 0 AC 1
Xs76_p_7 s76_p_7 0 adc_mim_bank COUNT=128
Vs76_p_8 s76_p_8 0 DC 0 AC 1
Xs76_p_8 s76_p_8 0 adc_mim_bank COUNT=256
Vs76_p_9 s76_p_9 0 DC 0 AC 1
Xs76_p_9 s76_p_9 0 adc_mim_bank COUNT=512
Vs76_p_10 s76_p_10 0 DC 0 AC 1
Xs76_p_10 s76_p_10 0 adc_mim_bank COUNT=1024
Vs76_p_11 s76_p_11 0 DC 0 AC 1
Xs76_p_11 s76_p_11 0 adc_mim_bank COUNT=2048
Vs76_p_12 s76_p_12 0 DC 0 AC 1
Xs76_p_12 s76_p_12 0 adc_mim_bank COUNT=1
Vs76_n_0 s76_n_0 0 DC 0 AC 1
Xs76_n_0 s76_n_0 0 adc_mim_bank COUNT=1
Vs76_n_1 s76_n_1 0 DC 0 AC 1
Xs76_n_1 s76_n_1 0 adc_mim_bank COUNT=2
Vs76_n_2 s76_n_2 0 DC 0 AC 1
Xs76_n_2 s76_n_2 0 adc_mim_bank COUNT=4
Vs76_n_3 s76_n_3 0 DC 0 AC 1
Xs76_n_3 s76_n_3 0 adc_mim_bank COUNT=8
Vs76_n_4 s76_n_4 0 DC 0 AC 1
Xs76_n_4 s76_n_4 0 adc_mim_bank COUNT=16
Vs76_n_5 s76_n_5 0 DC 0 AC 1
Xs76_n_5 s76_n_5 0 adc_mim_bank COUNT=32
Vs76_n_6 s76_n_6 0 DC 0 AC 1
Xs76_n_6 s76_n_6 0 adc_mim_bank COUNT=64
Vs76_n_7 s76_n_7 0 DC 0 AC 1
Xs76_n_7 s76_n_7 0 adc_mim_bank COUNT=128
Vs76_n_8 s76_n_8 0 DC 0 AC 1
Xs76_n_8 s76_n_8 0 adc_mim_bank COUNT=256
Vs76_n_9 s76_n_9 0 DC 0 AC 1
Xs76_n_9 s76_n_9 0 adc_mim_bank COUNT=512
Vs76_n_10 s76_n_10 0 DC 0 AC 1
Xs76_n_10 s76_n_10 0 adc_mim_bank COUNT=1024
Vs76_n_11 s76_n_11 0 DC 0 AC 1
Xs76_n_11 s76_n_11 0 adc_mim_bank COUNT=2048
Vs76_n_12 s76_n_12 0 DC 0 AC 1
Xs76_n_12 s76_n_12 0 adc_mim_bank COUNT=1
Vs77_p_0 s77_p_0 0 DC 0 AC 1
Xs77_p_0 s77_p_0 0 adc_mim_bank COUNT=1
Vs77_p_1 s77_p_1 0 DC 0 AC 1
Xs77_p_1 s77_p_1 0 adc_mim_bank COUNT=2
Vs77_p_2 s77_p_2 0 DC 0 AC 1
Xs77_p_2 s77_p_2 0 adc_mim_bank COUNT=4
Vs77_p_3 s77_p_3 0 DC 0 AC 1
Xs77_p_3 s77_p_3 0 adc_mim_bank COUNT=8
Vs77_p_4 s77_p_4 0 DC 0 AC 1
Xs77_p_4 s77_p_4 0 adc_mim_bank COUNT=16
Vs77_p_5 s77_p_5 0 DC 0 AC 1
Xs77_p_5 s77_p_5 0 adc_mim_bank COUNT=32
Vs77_p_6 s77_p_6 0 DC 0 AC 1
Xs77_p_6 s77_p_6 0 adc_mim_bank COUNT=64
Vs77_p_7 s77_p_7 0 DC 0 AC 1
Xs77_p_7 s77_p_7 0 adc_mim_bank COUNT=128
Vs77_p_8 s77_p_8 0 DC 0 AC 1
Xs77_p_8 s77_p_8 0 adc_mim_bank COUNT=256
Vs77_p_9 s77_p_9 0 DC 0 AC 1
Xs77_p_9 s77_p_9 0 adc_mim_bank COUNT=512
Vs77_p_10 s77_p_10 0 DC 0 AC 1
Xs77_p_10 s77_p_10 0 adc_mim_bank COUNT=1024
Vs77_p_11 s77_p_11 0 DC 0 AC 1
Xs77_p_11 s77_p_11 0 adc_mim_bank COUNT=2048
Vs77_p_12 s77_p_12 0 DC 0 AC 1
Xs77_p_12 s77_p_12 0 adc_mim_bank COUNT=1
Vs77_n_0 s77_n_0 0 DC 0 AC 1
Xs77_n_0 s77_n_0 0 adc_mim_bank COUNT=1
Vs77_n_1 s77_n_1 0 DC 0 AC 1
Xs77_n_1 s77_n_1 0 adc_mim_bank COUNT=2
Vs77_n_2 s77_n_2 0 DC 0 AC 1
Xs77_n_2 s77_n_2 0 adc_mim_bank COUNT=4
Vs77_n_3 s77_n_3 0 DC 0 AC 1
Xs77_n_3 s77_n_3 0 adc_mim_bank COUNT=8
Vs77_n_4 s77_n_4 0 DC 0 AC 1
Xs77_n_4 s77_n_4 0 adc_mim_bank COUNT=16
Vs77_n_5 s77_n_5 0 DC 0 AC 1
Xs77_n_5 s77_n_5 0 adc_mim_bank COUNT=32
Vs77_n_6 s77_n_6 0 DC 0 AC 1
Xs77_n_6 s77_n_6 0 adc_mim_bank COUNT=64
Vs77_n_7 s77_n_7 0 DC 0 AC 1
Xs77_n_7 s77_n_7 0 adc_mim_bank COUNT=128
Vs77_n_8 s77_n_8 0 DC 0 AC 1
Xs77_n_8 s77_n_8 0 adc_mim_bank COUNT=256
Vs77_n_9 s77_n_9 0 DC 0 AC 1
Xs77_n_9 s77_n_9 0 adc_mim_bank COUNT=512
Vs77_n_10 s77_n_10 0 DC 0 AC 1
Xs77_n_10 s77_n_10 0 adc_mim_bank COUNT=1024
Vs77_n_11 s77_n_11 0 DC 0 AC 1
Xs77_n_11 s77_n_11 0 adc_mim_bank COUNT=2048
Vs77_n_12 s77_n_12 0 DC 0 AC 1
Xs77_n_12 s77_n_12 0 adc_mim_bank COUNT=1
Vs78_p_0 s78_p_0 0 DC 0 AC 1
Xs78_p_0 s78_p_0 0 adc_mim_bank COUNT=1
Vs78_p_1 s78_p_1 0 DC 0 AC 1
Xs78_p_1 s78_p_1 0 adc_mim_bank COUNT=2
Vs78_p_2 s78_p_2 0 DC 0 AC 1
Xs78_p_2 s78_p_2 0 adc_mim_bank COUNT=4
Vs78_p_3 s78_p_3 0 DC 0 AC 1
Xs78_p_3 s78_p_3 0 adc_mim_bank COUNT=8
Vs78_p_4 s78_p_4 0 DC 0 AC 1
Xs78_p_4 s78_p_4 0 adc_mim_bank COUNT=16
Vs78_p_5 s78_p_5 0 DC 0 AC 1
Xs78_p_5 s78_p_5 0 adc_mim_bank COUNT=32
Vs78_p_6 s78_p_6 0 DC 0 AC 1
Xs78_p_6 s78_p_6 0 adc_mim_bank COUNT=64
Vs78_p_7 s78_p_7 0 DC 0 AC 1
Xs78_p_7 s78_p_7 0 adc_mim_bank COUNT=128
Vs78_p_8 s78_p_8 0 DC 0 AC 1
Xs78_p_8 s78_p_8 0 adc_mim_bank COUNT=256
Vs78_p_9 s78_p_9 0 DC 0 AC 1
Xs78_p_9 s78_p_9 0 adc_mim_bank COUNT=512
Vs78_p_10 s78_p_10 0 DC 0 AC 1
Xs78_p_10 s78_p_10 0 adc_mim_bank COUNT=1024
Vs78_p_11 s78_p_11 0 DC 0 AC 1
Xs78_p_11 s78_p_11 0 adc_mim_bank COUNT=2048
Vs78_p_12 s78_p_12 0 DC 0 AC 1
Xs78_p_12 s78_p_12 0 adc_mim_bank COUNT=1
Vs78_n_0 s78_n_0 0 DC 0 AC 1
Xs78_n_0 s78_n_0 0 adc_mim_bank COUNT=1
Vs78_n_1 s78_n_1 0 DC 0 AC 1
Xs78_n_1 s78_n_1 0 adc_mim_bank COUNT=2
Vs78_n_2 s78_n_2 0 DC 0 AC 1
Xs78_n_2 s78_n_2 0 adc_mim_bank COUNT=4
Vs78_n_3 s78_n_3 0 DC 0 AC 1
Xs78_n_3 s78_n_3 0 adc_mim_bank COUNT=8
Vs78_n_4 s78_n_4 0 DC 0 AC 1
Xs78_n_4 s78_n_4 0 adc_mim_bank COUNT=16
Vs78_n_5 s78_n_5 0 DC 0 AC 1
Xs78_n_5 s78_n_5 0 adc_mim_bank COUNT=32
Vs78_n_6 s78_n_6 0 DC 0 AC 1
Xs78_n_6 s78_n_6 0 adc_mim_bank COUNT=64
Vs78_n_7 s78_n_7 0 DC 0 AC 1
Xs78_n_7 s78_n_7 0 adc_mim_bank COUNT=128
Vs78_n_8 s78_n_8 0 DC 0 AC 1
Xs78_n_8 s78_n_8 0 adc_mim_bank COUNT=256
Vs78_n_9 s78_n_9 0 DC 0 AC 1
Xs78_n_9 s78_n_9 0 adc_mim_bank COUNT=512
Vs78_n_10 s78_n_10 0 DC 0 AC 1
Xs78_n_10 s78_n_10 0 adc_mim_bank COUNT=1024
Vs78_n_11 s78_n_11 0 DC 0 AC 1
Xs78_n_11 s78_n_11 0 adc_mim_bank COUNT=2048
Vs78_n_12 s78_n_12 0 DC 0 AC 1
Xs78_n_12 s78_n_12 0 adc_mim_bank COUNT=1
Vs79_p_0 s79_p_0 0 DC 0 AC 1
Xs79_p_0 s79_p_0 0 adc_mim_bank COUNT=1
Vs79_p_1 s79_p_1 0 DC 0 AC 1
Xs79_p_1 s79_p_1 0 adc_mim_bank COUNT=2
Vs79_p_2 s79_p_2 0 DC 0 AC 1
Xs79_p_2 s79_p_2 0 adc_mim_bank COUNT=4
Vs79_p_3 s79_p_3 0 DC 0 AC 1
Xs79_p_3 s79_p_3 0 adc_mim_bank COUNT=8
Vs79_p_4 s79_p_4 0 DC 0 AC 1
Xs79_p_4 s79_p_4 0 adc_mim_bank COUNT=16
Vs79_p_5 s79_p_5 0 DC 0 AC 1
Xs79_p_5 s79_p_5 0 adc_mim_bank COUNT=32
Vs79_p_6 s79_p_6 0 DC 0 AC 1
Xs79_p_6 s79_p_6 0 adc_mim_bank COUNT=64
Vs79_p_7 s79_p_7 0 DC 0 AC 1
Xs79_p_7 s79_p_7 0 adc_mim_bank COUNT=128
Vs79_p_8 s79_p_8 0 DC 0 AC 1
Xs79_p_8 s79_p_8 0 adc_mim_bank COUNT=256
Vs79_p_9 s79_p_9 0 DC 0 AC 1
Xs79_p_9 s79_p_9 0 adc_mim_bank COUNT=512
Vs79_p_10 s79_p_10 0 DC 0 AC 1
Xs79_p_10 s79_p_10 0 adc_mim_bank COUNT=1024
Vs79_p_11 s79_p_11 0 DC 0 AC 1
Xs79_p_11 s79_p_11 0 adc_mim_bank COUNT=2048
Vs79_p_12 s79_p_12 0 DC 0 AC 1
Xs79_p_12 s79_p_12 0 adc_mim_bank COUNT=1
Vs79_n_0 s79_n_0 0 DC 0 AC 1
Xs79_n_0 s79_n_0 0 adc_mim_bank COUNT=1
Vs79_n_1 s79_n_1 0 DC 0 AC 1
Xs79_n_1 s79_n_1 0 adc_mim_bank COUNT=2
Vs79_n_2 s79_n_2 0 DC 0 AC 1
Xs79_n_2 s79_n_2 0 adc_mim_bank COUNT=4
Vs79_n_3 s79_n_3 0 DC 0 AC 1
Xs79_n_3 s79_n_3 0 adc_mim_bank COUNT=8
Vs79_n_4 s79_n_4 0 DC 0 AC 1
Xs79_n_4 s79_n_4 0 adc_mim_bank COUNT=16
Vs79_n_5 s79_n_5 0 DC 0 AC 1
Xs79_n_5 s79_n_5 0 adc_mim_bank COUNT=32
Vs79_n_6 s79_n_6 0 DC 0 AC 1
Xs79_n_6 s79_n_6 0 adc_mim_bank COUNT=64
Vs79_n_7 s79_n_7 0 DC 0 AC 1
Xs79_n_7 s79_n_7 0 adc_mim_bank COUNT=128
Vs79_n_8 s79_n_8 0 DC 0 AC 1
Xs79_n_8 s79_n_8 0 adc_mim_bank COUNT=256
Vs79_n_9 s79_n_9 0 DC 0 AC 1
Xs79_n_9 s79_n_9 0 adc_mim_bank COUNT=512
Vs79_n_10 s79_n_10 0 DC 0 AC 1
Xs79_n_10 s79_n_10 0 adc_mim_bank COUNT=1024
Vs79_n_11 s79_n_11 0 DC 0 AC 1
Xs79_n_11 s79_n_11 0 adc_mim_bank COUNT=2048
Vs79_n_12 s79_n_12 0 DC 0 AC 1
Xs79_n_12 s79_n_12 0 adc_mim_bank COUNT=1
Vs80_p_0 s80_p_0 0 DC 0 AC 1
Xs80_p_0 s80_p_0 0 adc_mim_bank COUNT=1
Vs80_p_1 s80_p_1 0 DC 0 AC 1
Xs80_p_1 s80_p_1 0 adc_mim_bank COUNT=2
Vs80_p_2 s80_p_2 0 DC 0 AC 1
Xs80_p_2 s80_p_2 0 adc_mim_bank COUNT=4
Vs80_p_3 s80_p_3 0 DC 0 AC 1
Xs80_p_3 s80_p_3 0 adc_mim_bank COUNT=8
Vs80_p_4 s80_p_4 0 DC 0 AC 1
Xs80_p_4 s80_p_4 0 adc_mim_bank COUNT=16
Vs80_p_5 s80_p_5 0 DC 0 AC 1
Xs80_p_5 s80_p_5 0 adc_mim_bank COUNT=32
Vs80_p_6 s80_p_6 0 DC 0 AC 1
Xs80_p_6 s80_p_6 0 adc_mim_bank COUNT=64
Vs80_p_7 s80_p_7 0 DC 0 AC 1
Xs80_p_7 s80_p_7 0 adc_mim_bank COUNT=128
Vs80_p_8 s80_p_8 0 DC 0 AC 1
Xs80_p_8 s80_p_8 0 adc_mim_bank COUNT=256
Vs80_p_9 s80_p_9 0 DC 0 AC 1
Xs80_p_9 s80_p_9 0 adc_mim_bank COUNT=512
Vs80_p_10 s80_p_10 0 DC 0 AC 1
Xs80_p_10 s80_p_10 0 adc_mim_bank COUNT=1024
Vs80_p_11 s80_p_11 0 DC 0 AC 1
Xs80_p_11 s80_p_11 0 adc_mim_bank COUNT=2048
Vs80_p_12 s80_p_12 0 DC 0 AC 1
Xs80_p_12 s80_p_12 0 adc_mim_bank COUNT=1
Vs80_n_0 s80_n_0 0 DC 0 AC 1
Xs80_n_0 s80_n_0 0 adc_mim_bank COUNT=1
Vs80_n_1 s80_n_1 0 DC 0 AC 1
Xs80_n_1 s80_n_1 0 adc_mim_bank COUNT=2
Vs80_n_2 s80_n_2 0 DC 0 AC 1
Xs80_n_2 s80_n_2 0 adc_mim_bank COUNT=4
Vs80_n_3 s80_n_3 0 DC 0 AC 1
Xs80_n_3 s80_n_3 0 adc_mim_bank COUNT=8
Vs80_n_4 s80_n_4 0 DC 0 AC 1
Xs80_n_4 s80_n_4 0 adc_mim_bank COUNT=16
Vs80_n_5 s80_n_5 0 DC 0 AC 1
Xs80_n_5 s80_n_5 0 adc_mim_bank COUNT=32
Vs80_n_6 s80_n_6 0 DC 0 AC 1
Xs80_n_6 s80_n_6 0 adc_mim_bank COUNT=64
Vs80_n_7 s80_n_7 0 DC 0 AC 1
Xs80_n_7 s80_n_7 0 adc_mim_bank COUNT=128
Vs80_n_8 s80_n_8 0 DC 0 AC 1
Xs80_n_8 s80_n_8 0 adc_mim_bank COUNT=256
Vs80_n_9 s80_n_9 0 DC 0 AC 1
Xs80_n_9 s80_n_9 0 adc_mim_bank COUNT=512
Vs80_n_10 s80_n_10 0 DC 0 AC 1
Xs80_n_10 s80_n_10 0 adc_mim_bank COUNT=1024
Vs80_n_11 s80_n_11 0 DC 0 AC 1
Xs80_n_11 s80_n_11 0 adc_mim_bank COUNT=2048
Vs80_n_12 s80_n_12 0 DC 0 AC 1
Xs80_n_12 s80_n_12 0 adc_mim_bank COUNT=1
Vs81_p_0 s81_p_0 0 DC 0 AC 1
Xs81_p_0 s81_p_0 0 adc_mim_bank COUNT=1
Vs81_p_1 s81_p_1 0 DC 0 AC 1
Xs81_p_1 s81_p_1 0 adc_mim_bank COUNT=2
Vs81_p_2 s81_p_2 0 DC 0 AC 1
Xs81_p_2 s81_p_2 0 adc_mim_bank COUNT=4
Vs81_p_3 s81_p_3 0 DC 0 AC 1
Xs81_p_3 s81_p_3 0 adc_mim_bank COUNT=8
Vs81_p_4 s81_p_4 0 DC 0 AC 1
Xs81_p_4 s81_p_4 0 adc_mim_bank COUNT=16
Vs81_p_5 s81_p_5 0 DC 0 AC 1
Xs81_p_5 s81_p_5 0 adc_mim_bank COUNT=32
Vs81_p_6 s81_p_6 0 DC 0 AC 1
Xs81_p_6 s81_p_6 0 adc_mim_bank COUNT=64
Vs81_p_7 s81_p_7 0 DC 0 AC 1
Xs81_p_7 s81_p_7 0 adc_mim_bank COUNT=128
Vs81_p_8 s81_p_8 0 DC 0 AC 1
Xs81_p_8 s81_p_8 0 adc_mim_bank COUNT=256
Vs81_p_9 s81_p_9 0 DC 0 AC 1
Xs81_p_9 s81_p_9 0 adc_mim_bank COUNT=512
Vs81_p_10 s81_p_10 0 DC 0 AC 1
Xs81_p_10 s81_p_10 0 adc_mim_bank COUNT=1024
Vs81_p_11 s81_p_11 0 DC 0 AC 1
Xs81_p_11 s81_p_11 0 adc_mim_bank COUNT=2048
Vs81_p_12 s81_p_12 0 DC 0 AC 1
Xs81_p_12 s81_p_12 0 adc_mim_bank COUNT=1
Vs81_n_0 s81_n_0 0 DC 0 AC 1
Xs81_n_0 s81_n_0 0 adc_mim_bank COUNT=1
Vs81_n_1 s81_n_1 0 DC 0 AC 1
Xs81_n_1 s81_n_1 0 adc_mim_bank COUNT=2
Vs81_n_2 s81_n_2 0 DC 0 AC 1
Xs81_n_2 s81_n_2 0 adc_mim_bank COUNT=4
Vs81_n_3 s81_n_3 0 DC 0 AC 1
Xs81_n_3 s81_n_3 0 adc_mim_bank COUNT=8
Vs81_n_4 s81_n_4 0 DC 0 AC 1
Xs81_n_4 s81_n_4 0 adc_mim_bank COUNT=16
Vs81_n_5 s81_n_5 0 DC 0 AC 1
Xs81_n_5 s81_n_5 0 adc_mim_bank COUNT=32
Vs81_n_6 s81_n_6 0 DC 0 AC 1
Xs81_n_6 s81_n_6 0 adc_mim_bank COUNT=64
Vs81_n_7 s81_n_7 0 DC 0 AC 1
Xs81_n_7 s81_n_7 0 adc_mim_bank COUNT=128
Vs81_n_8 s81_n_8 0 DC 0 AC 1
Xs81_n_8 s81_n_8 0 adc_mim_bank COUNT=256
Vs81_n_9 s81_n_9 0 DC 0 AC 1
Xs81_n_9 s81_n_9 0 adc_mim_bank COUNT=512
Vs81_n_10 s81_n_10 0 DC 0 AC 1
Xs81_n_10 s81_n_10 0 adc_mim_bank COUNT=1024
Vs81_n_11 s81_n_11 0 DC 0 AC 1
Xs81_n_11 s81_n_11 0 adc_mim_bank COUNT=2048
Vs81_n_12 s81_n_12 0 DC 0 AC 1
Xs81_n_12 s81_n_12 0 adc_mim_bank COUNT=1
Vs82_p_0 s82_p_0 0 DC 0 AC 1
Xs82_p_0 s82_p_0 0 adc_mim_bank COUNT=1
Vs82_p_1 s82_p_1 0 DC 0 AC 1
Xs82_p_1 s82_p_1 0 adc_mim_bank COUNT=2
Vs82_p_2 s82_p_2 0 DC 0 AC 1
Xs82_p_2 s82_p_2 0 adc_mim_bank COUNT=4
Vs82_p_3 s82_p_3 0 DC 0 AC 1
Xs82_p_3 s82_p_3 0 adc_mim_bank COUNT=8
Vs82_p_4 s82_p_4 0 DC 0 AC 1
Xs82_p_4 s82_p_4 0 adc_mim_bank COUNT=16
Vs82_p_5 s82_p_5 0 DC 0 AC 1
Xs82_p_5 s82_p_5 0 adc_mim_bank COUNT=32
Vs82_p_6 s82_p_6 0 DC 0 AC 1
Xs82_p_6 s82_p_6 0 adc_mim_bank COUNT=64
Vs82_p_7 s82_p_7 0 DC 0 AC 1
Xs82_p_7 s82_p_7 0 adc_mim_bank COUNT=128
Vs82_p_8 s82_p_8 0 DC 0 AC 1
Xs82_p_8 s82_p_8 0 adc_mim_bank COUNT=256
Vs82_p_9 s82_p_9 0 DC 0 AC 1
Xs82_p_9 s82_p_9 0 adc_mim_bank COUNT=512
Vs82_p_10 s82_p_10 0 DC 0 AC 1
Xs82_p_10 s82_p_10 0 adc_mim_bank COUNT=1024
Vs82_p_11 s82_p_11 0 DC 0 AC 1
Xs82_p_11 s82_p_11 0 adc_mim_bank COUNT=2048
Vs82_p_12 s82_p_12 0 DC 0 AC 1
Xs82_p_12 s82_p_12 0 adc_mim_bank COUNT=1
Vs82_n_0 s82_n_0 0 DC 0 AC 1
Xs82_n_0 s82_n_0 0 adc_mim_bank COUNT=1
Vs82_n_1 s82_n_1 0 DC 0 AC 1
Xs82_n_1 s82_n_1 0 adc_mim_bank COUNT=2
Vs82_n_2 s82_n_2 0 DC 0 AC 1
Xs82_n_2 s82_n_2 0 adc_mim_bank COUNT=4
Vs82_n_3 s82_n_3 0 DC 0 AC 1
Xs82_n_3 s82_n_3 0 adc_mim_bank COUNT=8
Vs82_n_4 s82_n_4 0 DC 0 AC 1
Xs82_n_4 s82_n_4 0 adc_mim_bank COUNT=16
Vs82_n_5 s82_n_5 0 DC 0 AC 1
Xs82_n_5 s82_n_5 0 adc_mim_bank COUNT=32
Vs82_n_6 s82_n_6 0 DC 0 AC 1
Xs82_n_6 s82_n_6 0 adc_mim_bank COUNT=64
Vs82_n_7 s82_n_7 0 DC 0 AC 1
Xs82_n_7 s82_n_7 0 adc_mim_bank COUNT=128
Vs82_n_8 s82_n_8 0 DC 0 AC 1
Xs82_n_8 s82_n_8 0 adc_mim_bank COUNT=256
Vs82_n_9 s82_n_9 0 DC 0 AC 1
Xs82_n_9 s82_n_9 0 adc_mim_bank COUNT=512
Vs82_n_10 s82_n_10 0 DC 0 AC 1
Xs82_n_10 s82_n_10 0 adc_mim_bank COUNT=1024
Vs82_n_11 s82_n_11 0 DC 0 AC 1
Xs82_n_11 s82_n_11 0 adc_mim_bank COUNT=2048
Vs82_n_12 s82_n_12 0 DC 0 AC 1
Xs82_n_12 s82_n_12 0 adc_mim_bank COUNT=1
Vs83_p_0 s83_p_0 0 DC 0 AC 1
Xs83_p_0 s83_p_0 0 adc_mim_bank COUNT=1
Vs83_p_1 s83_p_1 0 DC 0 AC 1
Xs83_p_1 s83_p_1 0 adc_mim_bank COUNT=2
Vs83_p_2 s83_p_2 0 DC 0 AC 1
Xs83_p_2 s83_p_2 0 adc_mim_bank COUNT=4
Vs83_p_3 s83_p_3 0 DC 0 AC 1
Xs83_p_3 s83_p_3 0 adc_mim_bank COUNT=8
Vs83_p_4 s83_p_4 0 DC 0 AC 1
Xs83_p_4 s83_p_4 0 adc_mim_bank COUNT=16
Vs83_p_5 s83_p_5 0 DC 0 AC 1
Xs83_p_5 s83_p_5 0 adc_mim_bank COUNT=32
Vs83_p_6 s83_p_6 0 DC 0 AC 1
Xs83_p_6 s83_p_6 0 adc_mim_bank COUNT=64
Vs83_p_7 s83_p_7 0 DC 0 AC 1
Xs83_p_7 s83_p_7 0 adc_mim_bank COUNT=128
Vs83_p_8 s83_p_8 0 DC 0 AC 1
Xs83_p_8 s83_p_8 0 adc_mim_bank COUNT=256
Vs83_p_9 s83_p_9 0 DC 0 AC 1
Xs83_p_9 s83_p_9 0 adc_mim_bank COUNT=512
Vs83_p_10 s83_p_10 0 DC 0 AC 1
Xs83_p_10 s83_p_10 0 adc_mim_bank COUNT=1024
Vs83_p_11 s83_p_11 0 DC 0 AC 1
Xs83_p_11 s83_p_11 0 adc_mim_bank COUNT=2048
Vs83_p_12 s83_p_12 0 DC 0 AC 1
Xs83_p_12 s83_p_12 0 adc_mim_bank COUNT=1
Vs83_n_0 s83_n_0 0 DC 0 AC 1
Xs83_n_0 s83_n_0 0 adc_mim_bank COUNT=1
Vs83_n_1 s83_n_1 0 DC 0 AC 1
Xs83_n_1 s83_n_1 0 adc_mim_bank COUNT=2
Vs83_n_2 s83_n_2 0 DC 0 AC 1
Xs83_n_2 s83_n_2 0 adc_mim_bank COUNT=4
Vs83_n_3 s83_n_3 0 DC 0 AC 1
Xs83_n_3 s83_n_3 0 adc_mim_bank COUNT=8
Vs83_n_4 s83_n_4 0 DC 0 AC 1
Xs83_n_4 s83_n_4 0 adc_mim_bank COUNT=16
Vs83_n_5 s83_n_5 0 DC 0 AC 1
Xs83_n_5 s83_n_5 0 adc_mim_bank COUNT=32
Vs83_n_6 s83_n_6 0 DC 0 AC 1
Xs83_n_6 s83_n_6 0 adc_mim_bank COUNT=64
Vs83_n_7 s83_n_7 0 DC 0 AC 1
Xs83_n_7 s83_n_7 0 adc_mim_bank COUNT=128
Vs83_n_8 s83_n_8 0 DC 0 AC 1
Xs83_n_8 s83_n_8 0 adc_mim_bank COUNT=256
Vs83_n_9 s83_n_9 0 DC 0 AC 1
Xs83_n_9 s83_n_9 0 adc_mim_bank COUNT=512
Vs83_n_10 s83_n_10 0 DC 0 AC 1
Xs83_n_10 s83_n_10 0 adc_mim_bank COUNT=1024
Vs83_n_11 s83_n_11 0 DC 0 AC 1
Xs83_n_11 s83_n_11 0 adc_mim_bank COUNT=2048
Vs83_n_12 s83_n_12 0 DC 0 AC 1
Xs83_n_12 s83_n_12 0 adc_mim_bank COUNT=1
Vs84_p_0 s84_p_0 0 DC 0 AC 1
Xs84_p_0 s84_p_0 0 adc_mim_bank COUNT=1
Vs84_p_1 s84_p_1 0 DC 0 AC 1
Xs84_p_1 s84_p_1 0 adc_mim_bank COUNT=2
Vs84_p_2 s84_p_2 0 DC 0 AC 1
Xs84_p_2 s84_p_2 0 adc_mim_bank COUNT=4
Vs84_p_3 s84_p_3 0 DC 0 AC 1
Xs84_p_3 s84_p_3 0 adc_mim_bank COUNT=8
Vs84_p_4 s84_p_4 0 DC 0 AC 1
Xs84_p_4 s84_p_4 0 adc_mim_bank COUNT=16
Vs84_p_5 s84_p_5 0 DC 0 AC 1
Xs84_p_5 s84_p_5 0 adc_mim_bank COUNT=32
Vs84_p_6 s84_p_6 0 DC 0 AC 1
Xs84_p_6 s84_p_6 0 adc_mim_bank COUNT=64
Vs84_p_7 s84_p_7 0 DC 0 AC 1
Xs84_p_7 s84_p_7 0 adc_mim_bank COUNT=128
Vs84_p_8 s84_p_8 0 DC 0 AC 1
Xs84_p_8 s84_p_8 0 adc_mim_bank COUNT=256
Vs84_p_9 s84_p_9 0 DC 0 AC 1
Xs84_p_9 s84_p_9 0 adc_mim_bank COUNT=512
Vs84_p_10 s84_p_10 0 DC 0 AC 1
Xs84_p_10 s84_p_10 0 adc_mim_bank COUNT=1024
Vs84_p_11 s84_p_11 0 DC 0 AC 1
Xs84_p_11 s84_p_11 0 adc_mim_bank COUNT=2048
Vs84_p_12 s84_p_12 0 DC 0 AC 1
Xs84_p_12 s84_p_12 0 adc_mim_bank COUNT=1
Vs84_n_0 s84_n_0 0 DC 0 AC 1
Xs84_n_0 s84_n_0 0 adc_mim_bank COUNT=1
Vs84_n_1 s84_n_1 0 DC 0 AC 1
Xs84_n_1 s84_n_1 0 adc_mim_bank COUNT=2
Vs84_n_2 s84_n_2 0 DC 0 AC 1
Xs84_n_2 s84_n_2 0 adc_mim_bank COUNT=4
Vs84_n_3 s84_n_3 0 DC 0 AC 1
Xs84_n_3 s84_n_3 0 adc_mim_bank COUNT=8
Vs84_n_4 s84_n_4 0 DC 0 AC 1
Xs84_n_4 s84_n_4 0 adc_mim_bank COUNT=16
Vs84_n_5 s84_n_5 0 DC 0 AC 1
Xs84_n_5 s84_n_5 0 adc_mim_bank COUNT=32
Vs84_n_6 s84_n_6 0 DC 0 AC 1
Xs84_n_6 s84_n_6 0 adc_mim_bank COUNT=64
Vs84_n_7 s84_n_7 0 DC 0 AC 1
Xs84_n_7 s84_n_7 0 adc_mim_bank COUNT=128
Vs84_n_8 s84_n_8 0 DC 0 AC 1
Xs84_n_8 s84_n_8 0 adc_mim_bank COUNT=256
Vs84_n_9 s84_n_9 0 DC 0 AC 1
Xs84_n_9 s84_n_9 0 adc_mim_bank COUNT=512
Vs84_n_10 s84_n_10 0 DC 0 AC 1
Xs84_n_10 s84_n_10 0 adc_mim_bank COUNT=1024
Vs84_n_11 s84_n_11 0 DC 0 AC 1
Xs84_n_11 s84_n_11 0 adc_mim_bank COUNT=2048
Vs84_n_12 s84_n_12 0 DC 0 AC 1
Xs84_n_12 s84_n_12 0 adc_mim_bank COUNT=1
Vs85_p_0 s85_p_0 0 DC 0 AC 1
Xs85_p_0 s85_p_0 0 adc_mim_bank COUNT=1
Vs85_p_1 s85_p_1 0 DC 0 AC 1
Xs85_p_1 s85_p_1 0 adc_mim_bank COUNT=2
Vs85_p_2 s85_p_2 0 DC 0 AC 1
Xs85_p_2 s85_p_2 0 adc_mim_bank COUNT=4
Vs85_p_3 s85_p_3 0 DC 0 AC 1
Xs85_p_3 s85_p_3 0 adc_mim_bank COUNT=8
Vs85_p_4 s85_p_4 0 DC 0 AC 1
Xs85_p_4 s85_p_4 0 adc_mim_bank COUNT=16
Vs85_p_5 s85_p_5 0 DC 0 AC 1
Xs85_p_5 s85_p_5 0 adc_mim_bank COUNT=32
Vs85_p_6 s85_p_6 0 DC 0 AC 1
Xs85_p_6 s85_p_6 0 adc_mim_bank COUNT=64
Vs85_p_7 s85_p_7 0 DC 0 AC 1
Xs85_p_7 s85_p_7 0 adc_mim_bank COUNT=128
Vs85_p_8 s85_p_8 0 DC 0 AC 1
Xs85_p_8 s85_p_8 0 adc_mim_bank COUNT=256
Vs85_p_9 s85_p_9 0 DC 0 AC 1
Xs85_p_9 s85_p_9 0 adc_mim_bank COUNT=512
Vs85_p_10 s85_p_10 0 DC 0 AC 1
Xs85_p_10 s85_p_10 0 adc_mim_bank COUNT=1024
Vs85_p_11 s85_p_11 0 DC 0 AC 1
Xs85_p_11 s85_p_11 0 adc_mim_bank COUNT=2048
Vs85_p_12 s85_p_12 0 DC 0 AC 1
Xs85_p_12 s85_p_12 0 adc_mim_bank COUNT=1
Vs85_n_0 s85_n_0 0 DC 0 AC 1
Xs85_n_0 s85_n_0 0 adc_mim_bank COUNT=1
Vs85_n_1 s85_n_1 0 DC 0 AC 1
Xs85_n_1 s85_n_1 0 adc_mim_bank COUNT=2
Vs85_n_2 s85_n_2 0 DC 0 AC 1
Xs85_n_2 s85_n_2 0 adc_mim_bank COUNT=4
Vs85_n_3 s85_n_3 0 DC 0 AC 1
Xs85_n_3 s85_n_3 0 adc_mim_bank COUNT=8
Vs85_n_4 s85_n_4 0 DC 0 AC 1
Xs85_n_4 s85_n_4 0 adc_mim_bank COUNT=16
Vs85_n_5 s85_n_5 0 DC 0 AC 1
Xs85_n_5 s85_n_5 0 adc_mim_bank COUNT=32
Vs85_n_6 s85_n_6 0 DC 0 AC 1
Xs85_n_6 s85_n_6 0 adc_mim_bank COUNT=64
Vs85_n_7 s85_n_7 0 DC 0 AC 1
Xs85_n_7 s85_n_7 0 adc_mim_bank COUNT=128
Vs85_n_8 s85_n_8 0 DC 0 AC 1
Xs85_n_8 s85_n_8 0 adc_mim_bank COUNT=256
Vs85_n_9 s85_n_9 0 DC 0 AC 1
Xs85_n_9 s85_n_9 0 adc_mim_bank COUNT=512
Vs85_n_10 s85_n_10 0 DC 0 AC 1
Xs85_n_10 s85_n_10 0 adc_mim_bank COUNT=1024
Vs85_n_11 s85_n_11 0 DC 0 AC 1
Xs85_n_11 s85_n_11 0 adc_mim_bank COUNT=2048
Vs85_n_12 s85_n_12 0 DC 0 AC 1
Xs85_n_12 s85_n_12 0 adc_mim_bank COUNT=1
Vs86_p_0 s86_p_0 0 DC 0 AC 1
Xs86_p_0 s86_p_0 0 adc_mim_bank COUNT=1
Vs86_p_1 s86_p_1 0 DC 0 AC 1
Xs86_p_1 s86_p_1 0 adc_mim_bank COUNT=2
Vs86_p_2 s86_p_2 0 DC 0 AC 1
Xs86_p_2 s86_p_2 0 adc_mim_bank COUNT=4
Vs86_p_3 s86_p_3 0 DC 0 AC 1
Xs86_p_3 s86_p_3 0 adc_mim_bank COUNT=8
Vs86_p_4 s86_p_4 0 DC 0 AC 1
Xs86_p_4 s86_p_4 0 adc_mim_bank COUNT=16
Vs86_p_5 s86_p_5 0 DC 0 AC 1
Xs86_p_5 s86_p_5 0 adc_mim_bank COUNT=32
Vs86_p_6 s86_p_6 0 DC 0 AC 1
Xs86_p_6 s86_p_6 0 adc_mim_bank COUNT=64
Vs86_p_7 s86_p_7 0 DC 0 AC 1
Xs86_p_7 s86_p_7 0 adc_mim_bank COUNT=128
Vs86_p_8 s86_p_8 0 DC 0 AC 1
Xs86_p_8 s86_p_8 0 adc_mim_bank COUNT=256
Vs86_p_9 s86_p_9 0 DC 0 AC 1
Xs86_p_9 s86_p_9 0 adc_mim_bank COUNT=512
Vs86_p_10 s86_p_10 0 DC 0 AC 1
Xs86_p_10 s86_p_10 0 adc_mim_bank COUNT=1024
Vs86_p_11 s86_p_11 0 DC 0 AC 1
Xs86_p_11 s86_p_11 0 adc_mim_bank COUNT=2048
Vs86_p_12 s86_p_12 0 DC 0 AC 1
Xs86_p_12 s86_p_12 0 adc_mim_bank COUNT=1
Vs86_n_0 s86_n_0 0 DC 0 AC 1
Xs86_n_0 s86_n_0 0 adc_mim_bank COUNT=1
Vs86_n_1 s86_n_1 0 DC 0 AC 1
Xs86_n_1 s86_n_1 0 adc_mim_bank COUNT=2
Vs86_n_2 s86_n_2 0 DC 0 AC 1
Xs86_n_2 s86_n_2 0 adc_mim_bank COUNT=4
Vs86_n_3 s86_n_3 0 DC 0 AC 1
Xs86_n_3 s86_n_3 0 adc_mim_bank COUNT=8
Vs86_n_4 s86_n_4 0 DC 0 AC 1
Xs86_n_4 s86_n_4 0 adc_mim_bank COUNT=16
Vs86_n_5 s86_n_5 0 DC 0 AC 1
Xs86_n_5 s86_n_5 0 adc_mim_bank COUNT=32
Vs86_n_6 s86_n_6 0 DC 0 AC 1
Xs86_n_6 s86_n_6 0 adc_mim_bank COUNT=64
Vs86_n_7 s86_n_7 0 DC 0 AC 1
Xs86_n_7 s86_n_7 0 adc_mim_bank COUNT=128
Vs86_n_8 s86_n_8 0 DC 0 AC 1
Xs86_n_8 s86_n_8 0 adc_mim_bank COUNT=256
Vs86_n_9 s86_n_9 0 DC 0 AC 1
Xs86_n_9 s86_n_9 0 adc_mim_bank COUNT=512
Vs86_n_10 s86_n_10 0 DC 0 AC 1
Xs86_n_10 s86_n_10 0 adc_mim_bank COUNT=1024
Vs86_n_11 s86_n_11 0 DC 0 AC 1
Xs86_n_11 s86_n_11 0 adc_mim_bank COUNT=2048
Vs86_n_12 s86_n_12 0 DC 0 AC 1
Xs86_n_12 s86_n_12 0 adc_mim_bank COUNT=1
Vs87_p_0 s87_p_0 0 DC 0 AC 1
Xs87_p_0 s87_p_0 0 adc_mim_bank COUNT=1
Vs87_p_1 s87_p_1 0 DC 0 AC 1
Xs87_p_1 s87_p_1 0 adc_mim_bank COUNT=2
Vs87_p_2 s87_p_2 0 DC 0 AC 1
Xs87_p_2 s87_p_2 0 adc_mim_bank COUNT=4
Vs87_p_3 s87_p_3 0 DC 0 AC 1
Xs87_p_3 s87_p_3 0 adc_mim_bank COUNT=8
Vs87_p_4 s87_p_4 0 DC 0 AC 1
Xs87_p_4 s87_p_4 0 adc_mim_bank COUNT=16
Vs87_p_5 s87_p_5 0 DC 0 AC 1
Xs87_p_5 s87_p_5 0 adc_mim_bank COUNT=32
Vs87_p_6 s87_p_6 0 DC 0 AC 1
Xs87_p_6 s87_p_6 0 adc_mim_bank COUNT=64
Vs87_p_7 s87_p_7 0 DC 0 AC 1
Xs87_p_7 s87_p_7 0 adc_mim_bank COUNT=128
Vs87_p_8 s87_p_8 0 DC 0 AC 1
Xs87_p_8 s87_p_8 0 adc_mim_bank COUNT=256
Vs87_p_9 s87_p_9 0 DC 0 AC 1
Xs87_p_9 s87_p_9 0 adc_mim_bank COUNT=512
Vs87_p_10 s87_p_10 0 DC 0 AC 1
Xs87_p_10 s87_p_10 0 adc_mim_bank COUNT=1024
Vs87_p_11 s87_p_11 0 DC 0 AC 1
Xs87_p_11 s87_p_11 0 adc_mim_bank COUNT=2048
Vs87_p_12 s87_p_12 0 DC 0 AC 1
Xs87_p_12 s87_p_12 0 adc_mim_bank COUNT=1
Vs87_n_0 s87_n_0 0 DC 0 AC 1
Xs87_n_0 s87_n_0 0 adc_mim_bank COUNT=1
Vs87_n_1 s87_n_1 0 DC 0 AC 1
Xs87_n_1 s87_n_1 0 adc_mim_bank COUNT=2
Vs87_n_2 s87_n_2 0 DC 0 AC 1
Xs87_n_2 s87_n_2 0 adc_mim_bank COUNT=4
Vs87_n_3 s87_n_3 0 DC 0 AC 1
Xs87_n_3 s87_n_3 0 adc_mim_bank COUNT=8
Vs87_n_4 s87_n_4 0 DC 0 AC 1
Xs87_n_4 s87_n_4 0 adc_mim_bank COUNT=16
Vs87_n_5 s87_n_5 0 DC 0 AC 1
Xs87_n_5 s87_n_5 0 adc_mim_bank COUNT=32
Vs87_n_6 s87_n_6 0 DC 0 AC 1
Xs87_n_6 s87_n_6 0 adc_mim_bank COUNT=64
Vs87_n_7 s87_n_7 0 DC 0 AC 1
Xs87_n_7 s87_n_7 0 adc_mim_bank COUNT=128
Vs87_n_8 s87_n_8 0 DC 0 AC 1
Xs87_n_8 s87_n_8 0 adc_mim_bank COUNT=256
Vs87_n_9 s87_n_9 0 DC 0 AC 1
Xs87_n_9 s87_n_9 0 adc_mim_bank COUNT=512
Vs87_n_10 s87_n_10 0 DC 0 AC 1
Xs87_n_10 s87_n_10 0 adc_mim_bank COUNT=1024
Vs87_n_11 s87_n_11 0 DC 0 AC 1
Xs87_n_11 s87_n_11 0 adc_mim_bank COUNT=2048
Vs87_n_12 s87_n_12 0 DC 0 AC 1
Xs87_n_12 s87_n_12 0 adc_mim_bank COUNT=1
Vs88_p_0 s88_p_0 0 DC 0 AC 1
Xs88_p_0 s88_p_0 0 adc_mim_bank COUNT=1
Vs88_p_1 s88_p_1 0 DC 0 AC 1
Xs88_p_1 s88_p_1 0 adc_mim_bank COUNT=2
Vs88_p_2 s88_p_2 0 DC 0 AC 1
Xs88_p_2 s88_p_2 0 adc_mim_bank COUNT=4
Vs88_p_3 s88_p_3 0 DC 0 AC 1
Xs88_p_3 s88_p_3 0 adc_mim_bank COUNT=8
Vs88_p_4 s88_p_4 0 DC 0 AC 1
Xs88_p_4 s88_p_4 0 adc_mim_bank COUNT=16
Vs88_p_5 s88_p_5 0 DC 0 AC 1
Xs88_p_5 s88_p_5 0 adc_mim_bank COUNT=32
Vs88_p_6 s88_p_6 0 DC 0 AC 1
Xs88_p_6 s88_p_6 0 adc_mim_bank COUNT=64
Vs88_p_7 s88_p_7 0 DC 0 AC 1
Xs88_p_7 s88_p_7 0 adc_mim_bank COUNT=128
Vs88_p_8 s88_p_8 0 DC 0 AC 1
Xs88_p_8 s88_p_8 0 adc_mim_bank COUNT=256
Vs88_p_9 s88_p_9 0 DC 0 AC 1
Xs88_p_9 s88_p_9 0 adc_mim_bank COUNT=512
Vs88_p_10 s88_p_10 0 DC 0 AC 1
Xs88_p_10 s88_p_10 0 adc_mim_bank COUNT=1024
Vs88_p_11 s88_p_11 0 DC 0 AC 1
Xs88_p_11 s88_p_11 0 adc_mim_bank COUNT=2048
Vs88_p_12 s88_p_12 0 DC 0 AC 1
Xs88_p_12 s88_p_12 0 adc_mim_bank COUNT=1
Vs88_n_0 s88_n_0 0 DC 0 AC 1
Xs88_n_0 s88_n_0 0 adc_mim_bank COUNT=1
Vs88_n_1 s88_n_1 0 DC 0 AC 1
Xs88_n_1 s88_n_1 0 adc_mim_bank COUNT=2
Vs88_n_2 s88_n_2 0 DC 0 AC 1
Xs88_n_2 s88_n_2 0 adc_mim_bank COUNT=4
Vs88_n_3 s88_n_3 0 DC 0 AC 1
Xs88_n_3 s88_n_3 0 adc_mim_bank COUNT=8
Vs88_n_4 s88_n_4 0 DC 0 AC 1
Xs88_n_4 s88_n_4 0 adc_mim_bank COUNT=16
Vs88_n_5 s88_n_5 0 DC 0 AC 1
Xs88_n_5 s88_n_5 0 adc_mim_bank COUNT=32
Vs88_n_6 s88_n_6 0 DC 0 AC 1
Xs88_n_6 s88_n_6 0 adc_mim_bank COUNT=64
Vs88_n_7 s88_n_7 0 DC 0 AC 1
Xs88_n_7 s88_n_7 0 adc_mim_bank COUNT=128
Vs88_n_8 s88_n_8 0 DC 0 AC 1
Xs88_n_8 s88_n_8 0 adc_mim_bank COUNT=256
Vs88_n_9 s88_n_9 0 DC 0 AC 1
Xs88_n_9 s88_n_9 0 adc_mim_bank COUNT=512
Vs88_n_10 s88_n_10 0 DC 0 AC 1
Xs88_n_10 s88_n_10 0 adc_mim_bank COUNT=1024
Vs88_n_11 s88_n_11 0 DC 0 AC 1
Xs88_n_11 s88_n_11 0 adc_mim_bank COUNT=2048
Vs88_n_12 s88_n_12 0 DC 0 AC 1
Xs88_n_12 s88_n_12 0 adc_mim_bank COUNT=1
Vs89_p_0 s89_p_0 0 DC 0 AC 1
Xs89_p_0 s89_p_0 0 adc_mim_bank COUNT=1
Vs89_p_1 s89_p_1 0 DC 0 AC 1
Xs89_p_1 s89_p_1 0 adc_mim_bank COUNT=2
Vs89_p_2 s89_p_2 0 DC 0 AC 1
Xs89_p_2 s89_p_2 0 adc_mim_bank COUNT=4
Vs89_p_3 s89_p_3 0 DC 0 AC 1
Xs89_p_3 s89_p_3 0 adc_mim_bank COUNT=8
Vs89_p_4 s89_p_4 0 DC 0 AC 1
Xs89_p_4 s89_p_4 0 adc_mim_bank COUNT=16
Vs89_p_5 s89_p_5 0 DC 0 AC 1
Xs89_p_5 s89_p_5 0 adc_mim_bank COUNT=32
Vs89_p_6 s89_p_6 0 DC 0 AC 1
Xs89_p_6 s89_p_6 0 adc_mim_bank COUNT=64
Vs89_p_7 s89_p_7 0 DC 0 AC 1
Xs89_p_7 s89_p_7 0 adc_mim_bank COUNT=128
Vs89_p_8 s89_p_8 0 DC 0 AC 1
Xs89_p_8 s89_p_8 0 adc_mim_bank COUNT=256
Vs89_p_9 s89_p_9 0 DC 0 AC 1
Xs89_p_9 s89_p_9 0 adc_mim_bank COUNT=512
Vs89_p_10 s89_p_10 0 DC 0 AC 1
Xs89_p_10 s89_p_10 0 adc_mim_bank COUNT=1024
Vs89_p_11 s89_p_11 0 DC 0 AC 1
Xs89_p_11 s89_p_11 0 adc_mim_bank COUNT=2048
Vs89_p_12 s89_p_12 0 DC 0 AC 1
Xs89_p_12 s89_p_12 0 adc_mim_bank COUNT=1
Vs89_n_0 s89_n_0 0 DC 0 AC 1
Xs89_n_0 s89_n_0 0 adc_mim_bank COUNT=1
Vs89_n_1 s89_n_1 0 DC 0 AC 1
Xs89_n_1 s89_n_1 0 adc_mim_bank COUNT=2
Vs89_n_2 s89_n_2 0 DC 0 AC 1
Xs89_n_2 s89_n_2 0 adc_mim_bank COUNT=4
Vs89_n_3 s89_n_3 0 DC 0 AC 1
Xs89_n_3 s89_n_3 0 adc_mim_bank COUNT=8
Vs89_n_4 s89_n_4 0 DC 0 AC 1
Xs89_n_4 s89_n_4 0 adc_mim_bank COUNT=16
Vs89_n_5 s89_n_5 0 DC 0 AC 1
Xs89_n_5 s89_n_5 0 adc_mim_bank COUNT=32
Vs89_n_6 s89_n_6 0 DC 0 AC 1
Xs89_n_6 s89_n_6 0 adc_mim_bank COUNT=64
Vs89_n_7 s89_n_7 0 DC 0 AC 1
Xs89_n_7 s89_n_7 0 adc_mim_bank COUNT=128
Vs89_n_8 s89_n_8 0 DC 0 AC 1
Xs89_n_8 s89_n_8 0 adc_mim_bank COUNT=256
Vs89_n_9 s89_n_9 0 DC 0 AC 1
Xs89_n_9 s89_n_9 0 adc_mim_bank COUNT=512
Vs89_n_10 s89_n_10 0 DC 0 AC 1
Xs89_n_10 s89_n_10 0 adc_mim_bank COUNT=1024
Vs89_n_11 s89_n_11 0 DC 0 AC 1
Xs89_n_11 s89_n_11 0 adc_mim_bank COUNT=2048
Vs89_n_12 s89_n_12 0 DC 0 AC 1
Xs89_n_12 s89_n_12 0 adc_mim_bank COUNT=1
Vs90_p_0 s90_p_0 0 DC 0 AC 1
Xs90_p_0 s90_p_0 0 adc_mim_bank COUNT=1
Vs90_p_1 s90_p_1 0 DC 0 AC 1
Xs90_p_1 s90_p_1 0 adc_mim_bank COUNT=2
Vs90_p_2 s90_p_2 0 DC 0 AC 1
Xs90_p_2 s90_p_2 0 adc_mim_bank COUNT=4
Vs90_p_3 s90_p_3 0 DC 0 AC 1
Xs90_p_3 s90_p_3 0 adc_mim_bank COUNT=8
Vs90_p_4 s90_p_4 0 DC 0 AC 1
Xs90_p_4 s90_p_4 0 adc_mim_bank COUNT=16
Vs90_p_5 s90_p_5 0 DC 0 AC 1
Xs90_p_5 s90_p_5 0 adc_mim_bank COUNT=32
Vs90_p_6 s90_p_6 0 DC 0 AC 1
Xs90_p_6 s90_p_6 0 adc_mim_bank COUNT=64
Vs90_p_7 s90_p_7 0 DC 0 AC 1
Xs90_p_7 s90_p_7 0 adc_mim_bank COUNT=128
Vs90_p_8 s90_p_8 0 DC 0 AC 1
Xs90_p_8 s90_p_8 0 adc_mim_bank COUNT=256
Vs90_p_9 s90_p_9 0 DC 0 AC 1
Xs90_p_9 s90_p_9 0 adc_mim_bank COUNT=512
Vs90_p_10 s90_p_10 0 DC 0 AC 1
Xs90_p_10 s90_p_10 0 adc_mim_bank COUNT=1024
Vs90_p_11 s90_p_11 0 DC 0 AC 1
Xs90_p_11 s90_p_11 0 adc_mim_bank COUNT=2048
Vs90_p_12 s90_p_12 0 DC 0 AC 1
Xs90_p_12 s90_p_12 0 adc_mim_bank COUNT=1
Vs90_n_0 s90_n_0 0 DC 0 AC 1
Xs90_n_0 s90_n_0 0 adc_mim_bank COUNT=1
Vs90_n_1 s90_n_1 0 DC 0 AC 1
Xs90_n_1 s90_n_1 0 adc_mim_bank COUNT=2
Vs90_n_2 s90_n_2 0 DC 0 AC 1
Xs90_n_2 s90_n_2 0 adc_mim_bank COUNT=4
Vs90_n_3 s90_n_3 0 DC 0 AC 1
Xs90_n_3 s90_n_3 0 adc_mim_bank COUNT=8
Vs90_n_4 s90_n_4 0 DC 0 AC 1
Xs90_n_4 s90_n_4 0 adc_mim_bank COUNT=16
Vs90_n_5 s90_n_5 0 DC 0 AC 1
Xs90_n_5 s90_n_5 0 adc_mim_bank COUNT=32
Vs90_n_6 s90_n_6 0 DC 0 AC 1
Xs90_n_6 s90_n_6 0 adc_mim_bank COUNT=64
Vs90_n_7 s90_n_7 0 DC 0 AC 1
Xs90_n_7 s90_n_7 0 adc_mim_bank COUNT=128
Vs90_n_8 s90_n_8 0 DC 0 AC 1
Xs90_n_8 s90_n_8 0 adc_mim_bank COUNT=256
Vs90_n_9 s90_n_9 0 DC 0 AC 1
Xs90_n_9 s90_n_9 0 adc_mim_bank COUNT=512
Vs90_n_10 s90_n_10 0 DC 0 AC 1
Xs90_n_10 s90_n_10 0 adc_mim_bank COUNT=1024
Vs90_n_11 s90_n_11 0 DC 0 AC 1
Xs90_n_11 s90_n_11 0 adc_mim_bank COUNT=2048
Vs90_n_12 s90_n_12 0 DC 0 AC 1
Xs90_n_12 s90_n_12 0 adc_mim_bank COUNT=1
Vs91_p_0 s91_p_0 0 DC 0 AC 1
Xs91_p_0 s91_p_0 0 adc_mim_bank COUNT=1
Vs91_p_1 s91_p_1 0 DC 0 AC 1
Xs91_p_1 s91_p_1 0 adc_mim_bank COUNT=2
Vs91_p_2 s91_p_2 0 DC 0 AC 1
Xs91_p_2 s91_p_2 0 adc_mim_bank COUNT=4
Vs91_p_3 s91_p_3 0 DC 0 AC 1
Xs91_p_3 s91_p_3 0 adc_mim_bank COUNT=8
Vs91_p_4 s91_p_4 0 DC 0 AC 1
Xs91_p_4 s91_p_4 0 adc_mim_bank COUNT=16
Vs91_p_5 s91_p_5 0 DC 0 AC 1
Xs91_p_5 s91_p_5 0 adc_mim_bank COUNT=32
Vs91_p_6 s91_p_6 0 DC 0 AC 1
Xs91_p_6 s91_p_6 0 adc_mim_bank COUNT=64
Vs91_p_7 s91_p_7 0 DC 0 AC 1
Xs91_p_7 s91_p_7 0 adc_mim_bank COUNT=128
Vs91_p_8 s91_p_8 0 DC 0 AC 1
Xs91_p_8 s91_p_8 0 adc_mim_bank COUNT=256
Vs91_p_9 s91_p_9 0 DC 0 AC 1
Xs91_p_9 s91_p_9 0 adc_mim_bank COUNT=512
Vs91_p_10 s91_p_10 0 DC 0 AC 1
Xs91_p_10 s91_p_10 0 adc_mim_bank COUNT=1024
Vs91_p_11 s91_p_11 0 DC 0 AC 1
Xs91_p_11 s91_p_11 0 adc_mim_bank COUNT=2048
Vs91_p_12 s91_p_12 0 DC 0 AC 1
Xs91_p_12 s91_p_12 0 adc_mim_bank COUNT=1
Vs91_n_0 s91_n_0 0 DC 0 AC 1
Xs91_n_0 s91_n_0 0 adc_mim_bank COUNT=1
Vs91_n_1 s91_n_1 0 DC 0 AC 1
Xs91_n_1 s91_n_1 0 adc_mim_bank COUNT=2
Vs91_n_2 s91_n_2 0 DC 0 AC 1
Xs91_n_2 s91_n_2 0 adc_mim_bank COUNT=4
Vs91_n_3 s91_n_3 0 DC 0 AC 1
Xs91_n_3 s91_n_3 0 adc_mim_bank COUNT=8
Vs91_n_4 s91_n_4 0 DC 0 AC 1
Xs91_n_4 s91_n_4 0 adc_mim_bank COUNT=16
Vs91_n_5 s91_n_5 0 DC 0 AC 1
Xs91_n_5 s91_n_5 0 adc_mim_bank COUNT=32
Vs91_n_6 s91_n_6 0 DC 0 AC 1
Xs91_n_6 s91_n_6 0 adc_mim_bank COUNT=64
Vs91_n_7 s91_n_7 0 DC 0 AC 1
Xs91_n_7 s91_n_7 0 adc_mim_bank COUNT=128
Vs91_n_8 s91_n_8 0 DC 0 AC 1
Xs91_n_8 s91_n_8 0 adc_mim_bank COUNT=256
Vs91_n_9 s91_n_9 0 DC 0 AC 1
Xs91_n_9 s91_n_9 0 adc_mim_bank COUNT=512
Vs91_n_10 s91_n_10 0 DC 0 AC 1
Xs91_n_10 s91_n_10 0 adc_mim_bank COUNT=1024
Vs91_n_11 s91_n_11 0 DC 0 AC 1
Xs91_n_11 s91_n_11 0 adc_mim_bank COUNT=2048
Vs91_n_12 s91_n_12 0 DC 0 AC 1
Xs91_n_12 s91_n_12 0 adc_mim_bank COUNT=1
Vs92_p_0 s92_p_0 0 DC 0 AC 1
Xs92_p_0 s92_p_0 0 adc_mim_bank COUNT=1
Vs92_p_1 s92_p_1 0 DC 0 AC 1
Xs92_p_1 s92_p_1 0 adc_mim_bank COUNT=2
Vs92_p_2 s92_p_2 0 DC 0 AC 1
Xs92_p_2 s92_p_2 0 adc_mim_bank COUNT=4
Vs92_p_3 s92_p_3 0 DC 0 AC 1
Xs92_p_3 s92_p_3 0 adc_mim_bank COUNT=8
Vs92_p_4 s92_p_4 0 DC 0 AC 1
Xs92_p_4 s92_p_4 0 adc_mim_bank COUNT=16
Vs92_p_5 s92_p_5 0 DC 0 AC 1
Xs92_p_5 s92_p_5 0 adc_mim_bank COUNT=32
Vs92_p_6 s92_p_6 0 DC 0 AC 1
Xs92_p_6 s92_p_6 0 adc_mim_bank COUNT=64
Vs92_p_7 s92_p_7 0 DC 0 AC 1
Xs92_p_7 s92_p_7 0 adc_mim_bank COUNT=128
Vs92_p_8 s92_p_8 0 DC 0 AC 1
Xs92_p_8 s92_p_8 0 adc_mim_bank COUNT=256
Vs92_p_9 s92_p_9 0 DC 0 AC 1
Xs92_p_9 s92_p_9 0 adc_mim_bank COUNT=512
Vs92_p_10 s92_p_10 0 DC 0 AC 1
Xs92_p_10 s92_p_10 0 adc_mim_bank COUNT=1024
Vs92_p_11 s92_p_11 0 DC 0 AC 1
Xs92_p_11 s92_p_11 0 adc_mim_bank COUNT=2048
Vs92_p_12 s92_p_12 0 DC 0 AC 1
Xs92_p_12 s92_p_12 0 adc_mim_bank COUNT=1
Vs92_n_0 s92_n_0 0 DC 0 AC 1
Xs92_n_0 s92_n_0 0 adc_mim_bank COUNT=1
Vs92_n_1 s92_n_1 0 DC 0 AC 1
Xs92_n_1 s92_n_1 0 adc_mim_bank COUNT=2
Vs92_n_2 s92_n_2 0 DC 0 AC 1
Xs92_n_2 s92_n_2 0 adc_mim_bank COUNT=4
Vs92_n_3 s92_n_3 0 DC 0 AC 1
Xs92_n_3 s92_n_3 0 adc_mim_bank COUNT=8
Vs92_n_4 s92_n_4 0 DC 0 AC 1
Xs92_n_4 s92_n_4 0 adc_mim_bank COUNT=16
Vs92_n_5 s92_n_5 0 DC 0 AC 1
Xs92_n_5 s92_n_5 0 adc_mim_bank COUNT=32
Vs92_n_6 s92_n_6 0 DC 0 AC 1
Xs92_n_6 s92_n_6 0 adc_mim_bank COUNT=64
Vs92_n_7 s92_n_7 0 DC 0 AC 1
Xs92_n_7 s92_n_7 0 adc_mim_bank COUNT=128
Vs92_n_8 s92_n_8 0 DC 0 AC 1
Xs92_n_8 s92_n_8 0 adc_mim_bank COUNT=256
Vs92_n_9 s92_n_9 0 DC 0 AC 1
Xs92_n_9 s92_n_9 0 adc_mim_bank COUNT=512
Vs92_n_10 s92_n_10 0 DC 0 AC 1
Xs92_n_10 s92_n_10 0 adc_mim_bank COUNT=1024
Vs92_n_11 s92_n_11 0 DC 0 AC 1
Xs92_n_11 s92_n_11 0 adc_mim_bank COUNT=2048
Vs92_n_12 s92_n_12 0 DC 0 AC 1
Xs92_n_12 s92_n_12 0 adc_mim_bank COUNT=1
Vs93_p_0 s93_p_0 0 DC 0 AC 1
Xs93_p_0 s93_p_0 0 adc_mim_bank COUNT=1
Vs93_p_1 s93_p_1 0 DC 0 AC 1
Xs93_p_1 s93_p_1 0 adc_mim_bank COUNT=2
Vs93_p_2 s93_p_2 0 DC 0 AC 1
Xs93_p_2 s93_p_2 0 adc_mim_bank COUNT=4
Vs93_p_3 s93_p_3 0 DC 0 AC 1
Xs93_p_3 s93_p_3 0 adc_mim_bank COUNT=8
Vs93_p_4 s93_p_4 0 DC 0 AC 1
Xs93_p_4 s93_p_4 0 adc_mim_bank COUNT=16
Vs93_p_5 s93_p_5 0 DC 0 AC 1
Xs93_p_5 s93_p_5 0 adc_mim_bank COUNT=32
Vs93_p_6 s93_p_6 0 DC 0 AC 1
Xs93_p_6 s93_p_6 0 adc_mim_bank COUNT=64
Vs93_p_7 s93_p_7 0 DC 0 AC 1
Xs93_p_7 s93_p_7 0 adc_mim_bank COUNT=128
Vs93_p_8 s93_p_8 0 DC 0 AC 1
Xs93_p_8 s93_p_8 0 adc_mim_bank COUNT=256
Vs93_p_9 s93_p_9 0 DC 0 AC 1
Xs93_p_9 s93_p_9 0 adc_mim_bank COUNT=512
Vs93_p_10 s93_p_10 0 DC 0 AC 1
Xs93_p_10 s93_p_10 0 adc_mim_bank COUNT=1024
Vs93_p_11 s93_p_11 0 DC 0 AC 1
Xs93_p_11 s93_p_11 0 adc_mim_bank COUNT=2048
Vs93_p_12 s93_p_12 0 DC 0 AC 1
Xs93_p_12 s93_p_12 0 adc_mim_bank COUNT=1
Vs93_n_0 s93_n_0 0 DC 0 AC 1
Xs93_n_0 s93_n_0 0 adc_mim_bank COUNT=1
Vs93_n_1 s93_n_1 0 DC 0 AC 1
Xs93_n_1 s93_n_1 0 adc_mim_bank COUNT=2
Vs93_n_2 s93_n_2 0 DC 0 AC 1
Xs93_n_2 s93_n_2 0 adc_mim_bank COUNT=4
Vs93_n_3 s93_n_3 0 DC 0 AC 1
Xs93_n_3 s93_n_3 0 adc_mim_bank COUNT=8
Vs93_n_4 s93_n_4 0 DC 0 AC 1
Xs93_n_4 s93_n_4 0 adc_mim_bank COUNT=16
Vs93_n_5 s93_n_5 0 DC 0 AC 1
Xs93_n_5 s93_n_5 0 adc_mim_bank COUNT=32
Vs93_n_6 s93_n_6 0 DC 0 AC 1
Xs93_n_6 s93_n_6 0 adc_mim_bank COUNT=64
Vs93_n_7 s93_n_7 0 DC 0 AC 1
Xs93_n_7 s93_n_7 0 adc_mim_bank COUNT=128
Vs93_n_8 s93_n_8 0 DC 0 AC 1
Xs93_n_8 s93_n_8 0 adc_mim_bank COUNT=256
Vs93_n_9 s93_n_9 0 DC 0 AC 1
Xs93_n_9 s93_n_9 0 adc_mim_bank COUNT=512
Vs93_n_10 s93_n_10 0 DC 0 AC 1
Xs93_n_10 s93_n_10 0 adc_mim_bank COUNT=1024
Vs93_n_11 s93_n_11 0 DC 0 AC 1
Xs93_n_11 s93_n_11 0 adc_mim_bank COUNT=2048
Vs93_n_12 s93_n_12 0 DC 0 AC 1
Xs93_n_12 s93_n_12 0 adc_mim_bank COUNT=1
Vs94_p_0 s94_p_0 0 DC 0 AC 1
Xs94_p_0 s94_p_0 0 adc_mim_bank COUNT=1
Vs94_p_1 s94_p_1 0 DC 0 AC 1
Xs94_p_1 s94_p_1 0 adc_mim_bank COUNT=2
Vs94_p_2 s94_p_2 0 DC 0 AC 1
Xs94_p_2 s94_p_2 0 adc_mim_bank COUNT=4
Vs94_p_3 s94_p_3 0 DC 0 AC 1
Xs94_p_3 s94_p_3 0 adc_mim_bank COUNT=8
Vs94_p_4 s94_p_4 0 DC 0 AC 1
Xs94_p_4 s94_p_4 0 adc_mim_bank COUNT=16
Vs94_p_5 s94_p_5 0 DC 0 AC 1
Xs94_p_5 s94_p_5 0 adc_mim_bank COUNT=32
Vs94_p_6 s94_p_6 0 DC 0 AC 1
Xs94_p_6 s94_p_6 0 adc_mim_bank COUNT=64
Vs94_p_7 s94_p_7 0 DC 0 AC 1
Xs94_p_7 s94_p_7 0 adc_mim_bank COUNT=128
Vs94_p_8 s94_p_8 0 DC 0 AC 1
Xs94_p_8 s94_p_8 0 adc_mim_bank COUNT=256
Vs94_p_9 s94_p_9 0 DC 0 AC 1
Xs94_p_9 s94_p_9 0 adc_mim_bank COUNT=512
Vs94_p_10 s94_p_10 0 DC 0 AC 1
Xs94_p_10 s94_p_10 0 adc_mim_bank COUNT=1024
Vs94_p_11 s94_p_11 0 DC 0 AC 1
Xs94_p_11 s94_p_11 0 adc_mim_bank COUNT=2048
Vs94_p_12 s94_p_12 0 DC 0 AC 1
Xs94_p_12 s94_p_12 0 adc_mim_bank COUNT=1
Vs94_n_0 s94_n_0 0 DC 0 AC 1
Xs94_n_0 s94_n_0 0 adc_mim_bank COUNT=1
Vs94_n_1 s94_n_1 0 DC 0 AC 1
Xs94_n_1 s94_n_1 0 adc_mim_bank COUNT=2
Vs94_n_2 s94_n_2 0 DC 0 AC 1
Xs94_n_2 s94_n_2 0 adc_mim_bank COUNT=4
Vs94_n_3 s94_n_3 0 DC 0 AC 1
Xs94_n_3 s94_n_3 0 adc_mim_bank COUNT=8
Vs94_n_4 s94_n_4 0 DC 0 AC 1
Xs94_n_4 s94_n_4 0 adc_mim_bank COUNT=16
Vs94_n_5 s94_n_5 0 DC 0 AC 1
Xs94_n_5 s94_n_5 0 adc_mim_bank COUNT=32
Vs94_n_6 s94_n_6 0 DC 0 AC 1
Xs94_n_6 s94_n_6 0 adc_mim_bank COUNT=64
Vs94_n_7 s94_n_7 0 DC 0 AC 1
Xs94_n_7 s94_n_7 0 adc_mim_bank COUNT=128
Vs94_n_8 s94_n_8 0 DC 0 AC 1
Xs94_n_8 s94_n_8 0 adc_mim_bank COUNT=256
Vs94_n_9 s94_n_9 0 DC 0 AC 1
Xs94_n_9 s94_n_9 0 adc_mim_bank COUNT=512
Vs94_n_10 s94_n_10 0 DC 0 AC 1
Xs94_n_10 s94_n_10 0 adc_mim_bank COUNT=1024
Vs94_n_11 s94_n_11 0 DC 0 AC 1
Xs94_n_11 s94_n_11 0 adc_mim_bank COUNT=2048
Vs94_n_12 s94_n_12 0 DC 0 AC 1
Xs94_n_12 s94_n_12 0 adc_mim_bank COUNT=1
Vs95_p_0 s95_p_0 0 DC 0 AC 1
Xs95_p_0 s95_p_0 0 adc_mim_bank COUNT=1
Vs95_p_1 s95_p_1 0 DC 0 AC 1
Xs95_p_1 s95_p_1 0 adc_mim_bank COUNT=2
Vs95_p_2 s95_p_2 0 DC 0 AC 1
Xs95_p_2 s95_p_2 0 adc_mim_bank COUNT=4
Vs95_p_3 s95_p_3 0 DC 0 AC 1
Xs95_p_3 s95_p_3 0 adc_mim_bank COUNT=8
Vs95_p_4 s95_p_4 0 DC 0 AC 1
Xs95_p_4 s95_p_4 0 adc_mim_bank COUNT=16
Vs95_p_5 s95_p_5 0 DC 0 AC 1
Xs95_p_5 s95_p_5 0 adc_mim_bank COUNT=32
Vs95_p_6 s95_p_6 0 DC 0 AC 1
Xs95_p_6 s95_p_6 0 adc_mim_bank COUNT=64
Vs95_p_7 s95_p_7 0 DC 0 AC 1
Xs95_p_7 s95_p_7 0 adc_mim_bank COUNT=128
Vs95_p_8 s95_p_8 0 DC 0 AC 1
Xs95_p_8 s95_p_8 0 adc_mim_bank COUNT=256
Vs95_p_9 s95_p_9 0 DC 0 AC 1
Xs95_p_9 s95_p_9 0 adc_mim_bank COUNT=512
Vs95_p_10 s95_p_10 0 DC 0 AC 1
Xs95_p_10 s95_p_10 0 adc_mim_bank COUNT=1024
Vs95_p_11 s95_p_11 0 DC 0 AC 1
Xs95_p_11 s95_p_11 0 adc_mim_bank COUNT=2048
Vs95_p_12 s95_p_12 0 DC 0 AC 1
Xs95_p_12 s95_p_12 0 adc_mim_bank COUNT=1
Vs95_n_0 s95_n_0 0 DC 0 AC 1
Xs95_n_0 s95_n_0 0 adc_mim_bank COUNT=1
Vs95_n_1 s95_n_1 0 DC 0 AC 1
Xs95_n_1 s95_n_1 0 adc_mim_bank COUNT=2
Vs95_n_2 s95_n_2 0 DC 0 AC 1
Xs95_n_2 s95_n_2 0 adc_mim_bank COUNT=4
Vs95_n_3 s95_n_3 0 DC 0 AC 1
Xs95_n_3 s95_n_3 0 adc_mim_bank COUNT=8
Vs95_n_4 s95_n_4 0 DC 0 AC 1
Xs95_n_4 s95_n_4 0 adc_mim_bank COUNT=16
Vs95_n_5 s95_n_5 0 DC 0 AC 1
Xs95_n_5 s95_n_5 0 adc_mim_bank COUNT=32
Vs95_n_6 s95_n_6 0 DC 0 AC 1
Xs95_n_6 s95_n_6 0 adc_mim_bank COUNT=64
Vs95_n_7 s95_n_7 0 DC 0 AC 1
Xs95_n_7 s95_n_7 0 adc_mim_bank COUNT=128
Vs95_n_8 s95_n_8 0 DC 0 AC 1
Xs95_n_8 s95_n_8 0 adc_mim_bank COUNT=256
Vs95_n_9 s95_n_9 0 DC 0 AC 1
Xs95_n_9 s95_n_9 0 adc_mim_bank COUNT=512
Vs95_n_10 s95_n_10 0 DC 0 AC 1
Xs95_n_10 s95_n_10 0 adc_mim_bank COUNT=1024
Vs95_n_11 s95_n_11 0 DC 0 AC 1
Xs95_n_11 s95_n_11 0 adc_mim_bank COUNT=2048
Vs95_n_12 s95_n_12 0 DC 0 AC 1
Xs95_n_12 s95_n_12 0 adc_mim_bank COUNT=1
Vs96_p_0 s96_p_0 0 DC 0 AC 1
Xs96_p_0 s96_p_0 0 adc_mim_bank COUNT=1
Vs96_p_1 s96_p_1 0 DC 0 AC 1
Xs96_p_1 s96_p_1 0 adc_mim_bank COUNT=2
Vs96_p_2 s96_p_2 0 DC 0 AC 1
Xs96_p_2 s96_p_2 0 adc_mim_bank COUNT=4
Vs96_p_3 s96_p_3 0 DC 0 AC 1
Xs96_p_3 s96_p_3 0 adc_mim_bank COUNT=8
Vs96_p_4 s96_p_4 0 DC 0 AC 1
Xs96_p_4 s96_p_4 0 adc_mim_bank COUNT=16
Vs96_p_5 s96_p_5 0 DC 0 AC 1
Xs96_p_5 s96_p_5 0 adc_mim_bank COUNT=32
Vs96_p_6 s96_p_6 0 DC 0 AC 1
Xs96_p_6 s96_p_6 0 adc_mim_bank COUNT=64
Vs96_p_7 s96_p_7 0 DC 0 AC 1
Xs96_p_7 s96_p_7 0 adc_mim_bank COUNT=128
Vs96_p_8 s96_p_8 0 DC 0 AC 1
Xs96_p_8 s96_p_8 0 adc_mim_bank COUNT=256
Vs96_p_9 s96_p_9 0 DC 0 AC 1
Xs96_p_9 s96_p_9 0 adc_mim_bank COUNT=512
Vs96_p_10 s96_p_10 0 DC 0 AC 1
Xs96_p_10 s96_p_10 0 adc_mim_bank COUNT=1024
Vs96_p_11 s96_p_11 0 DC 0 AC 1
Xs96_p_11 s96_p_11 0 adc_mim_bank COUNT=2048
Vs96_p_12 s96_p_12 0 DC 0 AC 1
Xs96_p_12 s96_p_12 0 adc_mim_bank COUNT=1
Vs96_n_0 s96_n_0 0 DC 0 AC 1
Xs96_n_0 s96_n_0 0 adc_mim_bank COUNT=1
Vs96_n_1 s96_n_1 0 DC 0 AC 1
Xs96_n_1 s96_n_1 0 adc_mim_bank COUNT=2
Vs96_n_2 s96_n_2 0 DC 0 AC 1
Xs96_n_2 s96_n_2 0 adc_mim_bank COUNT=4
Vs96_n_3 s96_n_3 0 DC 0 AC 1
Xs96_n_3 s96_n_3 0 adc_mim_bank COUNT=8
Vs96_n_4 s96_n_4 0 DC 0 AC 1
Xs96_n_4 s96_n_4 0 adc_mim_bank COUNT=16
Vs96_n_5 s96_n_5 0 DC 0 AC 1
Xs96_n_5 s96_n_5 0 adc_mim_bank COUNT=32
Vs96_n_6 s96_n_6 0 DC 0 AC 1
Xs96_n_6 s96_n_6 0 adc_mim_bank COUNT=64
Vs96_n_7 s96_n_7 0 DC 0 AC 1
Xs96_n_7 s96_n_7 0 adc_mim_bank COUNT=128
Vs96_n_8 s96_n_8 0 DC 0 AC 1
Xs96_n_8 s96_n_8 0 adc_mim_bank COUNT=256
Vs96_n_9 s96_n_9 0 DC 0 AC 1
Xs96_n_9 s96_n_9 0 adc_mim_bank COUNT=512
Vs96_n_10 s96_n_10 0 DC 0 AC 1
Xs96_n_10 s96_n_10 0 adc_mim_bank COUNT=1024
Vs96_n_11 s96_n_11 0 DC 0 AC 1
Xs96_n_11 s96_n_11 0 adc_mim_bank COUNT=2048
Vs96_n_12 s96_n_12 0 DC 0 AC 1
Xs96_n_12 s96_n_12 0 adc_mim_bank COUNT=1
Vs97_p_0 s97_p_0 0 DC 0 AC 1
Xs97_p_0 s97_p_0 0 adc_mim_bank COUNT=1
Vs97_p_1 s97_p_1 0 DC 0 AC 1
Xs97_p_1 s97_p_1 0 adc_mim_bank COUNT=2
Vs97_p_2 s97_p_2 0 DC 0 AC 1
Xs97_p_2 s97_p_2 0 adc_mim_bank COUNT=4
Vs97_p_3 s97_p_3 0 DC 0 AC 1
Xs97_p_3 s97_p_3 0 adc_mim_bank COUNT=8
Vs97_p_4 s97_p_4 0 DC 0 AC 1
Xs97_p_4 s97_p_4 0 adc_mim_bank COUNT=16
Vs97_p_5 s97_p_5 0 DC 0 AC 1
Xs97_p_5 s97_p_5 0 adc_mim_bank COUNT=32
Vs97_p_6 s97_p_6 0 DC 0 AC 1
Xs97_p_6 s97_p_6 0 adc_mim_bank COUNT=64
Vs97_p_7 s97_p_7 0 DC 0 AC 1
Xs97_p_7 s97_p_7 0 adc_mim_bank COUNT=128
Vs97_p_8 s97_p_8 0 DC 0 AC 1
Xs97_p_8 s97_p_8 0 adc_mim_bank COUNT=256
Vs97_p_9 s97_p_9 0 DC 0 AC 1
Xs97_p_9 s97_p_9 0 adc_mim_bank COUNT=512
Vs97_p_10 s97_p_10 0 DC 0 AC 1
Xs97_p_10 s97_p_10 0 adc_mim_bank COUNT=1024
Vs97_p_11 s97_p_11 0 DC 0 AC 1
Xs97_p_11 s97_p_11 0 adc_mim_bank COUNT=2048
Vs97_p_12 s97_p_12 0 DC 0 AC 1
Xs97_p_12 s97_p_12 0 adc_mim_bank COUNT=1
Vs97_n_0 s97_n_0 0 DC 0 AC 1
Xs97_n_0 s97_n_0 0 adc_mim_bank COUNT=1
Vs97_n_1 s97_n_1 0 DC 0 AC 1
Xs97_n_1 s97_n_1 0 adc_mim_bank COUNT=2
Vs97_n_2 s97_n_2 0 DC 0 AC 1
Xs97_n_2 s97_n_2 0 adc_mim_bank COUNT=4
Vs97_n_3 s97_n_3 0 DC 0 AC 1
Xs97_n_3 s97_n_3 0 adc_mim_bank COUNT=8
Vs97_n_4 s97_n_4 0 DC 0 AC 1
Xs97_n_4 s97_n_4 0 adc_mim_bank COUNT=16
Vs97_n_5 s97_n_5 0 DC 0 AC 1
Xs97_n_5 s97_n_5 0 adc_mim_bank COUNT=32
Vs97_n_6 s97_n_6 0 DC 0 AC 1
Xs97_n_6 s97_n_6 0 adc_mim_bank COUNT=64
Vs97_n_7 s97_n_7 0 DC 0 AC 1
Xs97_n_7 s97_n_7 0 adc_mim_bank COUNT=128
Vs97_n_8 s97_n_8 0 DC 0 AC 1
Xs97_n_8 s97_n_8 0 adc_mim_bank COUNT=256
Vs97_n_9 s97_n_9 0 DC 0 AC 1
Xs97_n_9 s97_n_9 0 adc_mim_bank COUNT=512
Vs97_n_10 s97_n_10 0 DC 0 AC 1
Xs97_n_10 s97_n_10 0 adc_mim_bank COUNT=1024
Vs97_n_11 s97_n_11 0 DC 0 AC 1
Xs97_n_11 s97_n_11 0 adc_mim_bank COUNT=2048
Vs97_n_12 s97_n_12 0 DC 0 AC 1
Xs97_n_12 s97_n_12 0 adc_mim_bank COUNT=1
Vs98_p_0 s98_p_0 0 DC 0 AC 1
Xs98_p_0 s98_p_0 0 adc_mim_bank COUNT=1
Vs98_p_1 s98_p_1 0 DC 0 AC 1
Xs98_p_1 s98_p_1 0 adc_mim_bank COUNT=2
Vs98_p_2 s98_p_2 0 DC 0 AC 1
Xs98_p_2 s98_p_2 0 adc_mim_bank COUNT=4
Vs98_p_3 s98_p_3 0 DC 0 AC 1
Xs98_p_3 s98_p_3 0 adc_mim_bank COUNT=8
Vs98_p_4 s98_p_4 0 DC 0 AC 1
Xs98_p_4 s98_p_4 0 adc_mim_bank COUNT=16
Vs98_p_5 s98_p_5 0 DC 0 AC 1
Xs98_p_5 s98_p_5 0 adc_mim_bank COUNT=32
Vs98_p_6 s98_p_6 0 DC 0 AC 1
Xs98_p_6 s98_p_6 0 adc_mim_bank COUNT=64
Vs98_p_7 s98_p_7 0 DC 0 AC 1
Xs98_p_7 s98_p_7 0 adc_mim_bank COUNT=128
Vs98_p_8 s98_p_8 0 DC 0 AC 1
Xs98_p_8 s98_p_8 0 adc_mim_bank COUNT=256
Vs98_p_9 s98_p_9 0 DC 0 AC 1
Xs98_p_9 s98_p_9 0 adc_mim_bank COUNT=512
Vs98_p_10 s98_p_10 0 DC 0 AC 1
Xs98_p_10 s98_p_10 0 adc_mim_bank COUNT=1024
Vs98_p_11 s98_p_11 0 DC 0 AC 1
Xs98_p_11 s98_p_11 0 adc_mim_bank COUNT=2048
Vs98_p_12 s98_p_12 0 DC 0 AC 1
Xs98_p_12 s98_p_12 0 adc_mim_bank COUNT=1
Vs98_n_0 s98_n_0 0 DC 0 AC 1
Xs98_n_0 s98_n_0 0 adc_mim_bank COUNT=1
Vs98_n_1 s98_n_1 0 DC 0 AC 1
Xs98_n_1 s98_n_1 0 adc_mim_bank COUNT=2
Vs98_n_2 s98_n_2 0 DC 0 AC 1
Xs98_n_2 s98_n_2 0 adc_mim_bank COUNT=4
Vs98_n_3 s98_n_3 0 DC 0 AC 1
Xs98_n_3 s98_n_3 0 adc_mim_bank COUNT=8
Vs98_n_4 s98_n_4 0 DC 0 AC 1
Xs98_n_4 s98_n_4 0 adc_mim_bank COUNT=16
Vs98_n_5 s98_n_5 0 DC 0 AC 1
Xs98_n_5 s98_n_5 0 adc_mim_bank COUNT=32
Vs98_n_6 s98_n_6 0 DC 0 AC 1
Xs98_n_6 s98_n_6 0 adc_mim_bank COUNT=64
Vs98_n_7 s98_n_7 0 DC 0 AC 1
Xs98_n_7 s98_n_7 0 adc_mim_bank COUNT=128
Vs98_n_8 s98_n_8 0 DC 0 AC 1
Xs98_n_8 s98_n_8 0 adc_mim_bank COUNT=256
Vs98_n_9 s98_n_9 0 DC 0 AC 1
Xs98_n_9 s98_n_9 0 adc_mim_bank COUNT=512
Vs98_n_10 s98_n_10 0 DC 0 AC 1
Xs98_n_10 s98_n_10 0 adc_mim_bank COUNT=1024
Vs98_n_11 s98_n_11 0 DC 0 AC 1
Xs98_n_11 s98_n_11 0 adc_mim_bank COUNT=2048
Vs98_n_12 s98_n_12 0 DC 0 AC 1
Xs98_n_12 s98_n_12 0 adc_mim_bank COUNT=1
Vs99_p_0 s99_p_0 0 DC 0 AC 1
Xs99_p_0 s99_p_0 0 adc_mim_bank COUNT=1
Vs99_p_1 s99_p_1 0 DC 0 AC 1
Xs99_p_1 s99_p_1 0 adc_mim_bank COUNT=2
Vs99_p_2 s99_p_2 0 DC 0 AC 1
Xs99_p_2 s99_p_2 0 adc_mim_bank COUNT=4
Vs99_p_3 s99_p_3 0 DC 0 AC 1
Xs99_p_3 s99_p_3 0 adc_mim_bank COUNT=8
Vs99_p_4 s99_p_4 0 DC 0 AC 1
Xs99_p_4 s99_p_4 0 adc_mim_bank COUNT=16
Vs99_p_5 s99_p_5 0 DC 0 AC 1
Xs99_p_5 s99_p_5 0 adc_mim_bank COUNT=32
Vs99_p_6 s99_p_6 0 DC 0 AC 1
Xs99_p_6 s99_p_6 0 adc_mim_bank COUNT=64
Vs99_p_7 s99_p_7 0 DC 0 AC 1
Xs99_p_7 s99_p_7 0 adc_mim_bank COUNT=128
Vs99_p_8 s99_p_8 0 DC 0 AC 1
Xs99_p_8 s99_p_8 0 adc_mim_bank COUNT=256
Vs99_p_9 s99_p_9 0 DC 0 AC 1
Xs99_p_9 s99_p_9 0 adc_mim_bank COUNT=512
Vs99_p_10 s99_p_10 0 DC 0 AC 1
Xs99_p_10 s99_p_10 0 adc_mim_bank COUNT=1024
Vs99_p_11 s99_p_11 0 DC 0 AC 1
Xs99_p_11 s99_p_11 0 adc_mim_bank COUNT=2048
Vs99_p_12 s99_p_12 0 DC 0 AC 1
Xs99_p_12 s99_p_12 0 adc_mim_bank COUNT=1
Vs99_n_0 s99_n_0 0 DC 0 AC 1
Xs99_n_0 s99_n_0 0 adc_mim_bank COUNT=1
Vs99_n_1 s99_n_1 0 DC 0 AC 1
Xs99_n_1 s99_n_1 0 adc_mim_bank COUNT=2
Vs99_n_2 s99_n_2 0 DC 0 AC 1
Xs99_n_2 s99_n_2 0 adc_mim_bank COUNT=4
Vs99_n_3 s99_n_3 0 DC 0 AC 1
Xs99_n_3 s99_n_3 0 adc_mim_bank COUNT=8
Vs99_n_4 s99_n_4 0 DC 0 AC 1
Xs99_n_4 s99_n_4 0 adc_mim_bank COUNT=16
Vs99_n_5 s99_n_5 0 DC 0 AC 1
Xs99_n_5 s99_n_5 0 adc_mim_bank COUNT=32
Vs99_n_6 s99_n_6 0 DC 0 AC 1
Xs99_n_6 s99_n_6 0 adc_mim_bank COUNT=64
Vs99_n_7 s99_n_7 0 DC 0 AC 1
Xs99_n_7 s99_n_7 0 adc_mim_bank COUNT=128
Vs99_n_8 s99_n_8 0 DC 0 AC 1
Xs99_n_8 s99_n_8 0 adc_mim_bank COUNT=256
Vs99_n_9 s99_n_9 0 DC 0 AC 1
Xs99_n_9 s99_n_9 0 adc_mim_bank COUNT=512
Vs99_n_10 s99_n_10 0 DC 0 AC 1
Xs99_n_10 s99_n_10 0 adc_mim_bank COUNT=1024
Vs99_n_11 s99_n_11 0 DC 0 AC 1
Xs99_n_11 s99_n_11 0 adc_mim_bank COUNT=2048
Vs99_n_12 s99_n_12 0 DC 0 AC 1
Xs99_n_12 s99_n_12 0 adc_mim_bank COUNT=1
Vs100_p_0 s100_p_0 0 DC 0 AC 1
Xs100_p_0 s100_p_0 0 adc_mim_bank COUNT=1
Vs100_p_1 s100_p_1 0 DC 0 AC 1
Xs100_p_1 s100_p_1 0 adc_mim_bank COUNT=2
Vs100_p_2 s100_p_2 0 DC 0 AC 1
Xs100_p_2 s100_p_2 0 adc_mim_bank COUNT=4
Vs100_p_3 s100_p_3 0 DC 0 AC 1
Xs100_p_3 s100_p_3 0 adc_mim_bank COUNT=8
Vs100_p_4 s100_p_4 0 DC 0 AC 1
Xs100_p_4 s100_p_4 0 adc_mim_bank COUNT=16
Vs100_p_5 s100_p_5 0 DC 0 AC 1
Xs100_p_5 s100_p_5 0 adc_mim_bank COUNT=32
Vs100_p_6 s100_p_6 0 DC 0 AC 1
Xs100_p_6 s100_p_6 0 adc_mim_bank COUNT=64
Vs100_p_7 s100_p_7 0 DC 0 AC 1
Xs100_p_7 s100_p_7 0 adc_mim_bank COUNT=128
Vs100_p_8 s100_p_8 0 DC 0 AC 1
Xs100_p_8 s100_p_8 0 adc_mim_bank COUNT=256
Vs100_p_9 s100_p_9 0 DC 0 AC 1
Xs100_p_9 s100_p_9 0 adc_mim_bank COUNT=512
Vs100_p_10 s100_p_10 0 DC 0 AC 1
Xs100_p_10 s100_p_10 0 adc_mim_bank COUNT=1024
Vs100_p_11 s100_p_11 0 DC 0 AC 1
Xs100_p_11 s100_p_11 0 adc_mim_bank COUNT=2048
Vs100_p_12 s100_p_12 0 DC 0 AC 1
Xs100_p_12 s100_p_12 0 adc_mim_bank COUNT=1
Vs100_n_0 s100_n_0 0 DC 0 AC 1
Xs100_n_0 s100_n_0 0 adc_mim_bank COUNT=1
Vs100_n_1 s100_n_1 0 DC 0 AC 1
Xs100_n_1 s100_n_1 0 adc_mim_bank COUNT=2
Vs100_n_2 s100_n_2 0 DC 0 AC 1
Xs100_n_2 s100_n_2 0 adc_mim_bank COUNT=4
Vs100_n_3 s100_n_3 0 DC 0 AC 1
Xs100_n_3 s100_n_3 0 adc_mim_bank COUNT=8
Vs100_n_4 s100_n_4 0 DC 0 AC 1
Xs100_n_4 s100_n_4 0 adc_mim_bank COUNT=16
Vs100_n_5 s100_n_5 0 DC 0 AC 1
Xs100_n_5 s100_n_5 0 adc_mim_bank COUNT=32
Vs100_n_6 s100_n_6 0 DC 0 AC 1
Xs100_n_6 s100_n_6 0 adc_mim_bank COUNT=64
Vs100_n_7 s100_n_7 0 DC 0 AC 1
Xs100_n_7 s100_n_7 0 adc_mim_bank COUNT=128
Vs100_n_8 s100_n_8 0 DC 0 AC 1
Xs100_n_8 s100_n_8 0 adc_mim_bank COUNT=256
Vs100_n_9 s100_n_9 0 DC 0 AC 1
Xs100_n_9 s100_n_9 0 adc_mim_bank COUNT=512
Vs100_n_10 s100_n_10 0 DC 0 AC 1
Xs100_n_10 s100_n_10 0 adc_mim_bank COUNT=1024
Vs100_n_11 s100_n_11 0 DC 0 AC 1
Xs100_n_11 s100_n_11 0 adc_mim_bank COUNT=2048
Vs100_n_12 s100_n_12 0 DC 0 AC 1
Xs100_n_12 s100_n_12 0 adc_mim_bank COUNT=1
Vs101_p_0 s101_p_0 0 DC 0 AC 1
Xs101_p_0 s101_p_0 0 adc_mim_bank COUNT=1
Vs101_p_1 s101_p_1 0 DC 0 AC 1
Xs101_p_1 s101_p_1 0 adc_mim_bank COUNT=2
Vs101_p_2 s101_p_2 0 DC 0 AC 1
Xs101_p_2 s101_p_2 0 adc_mim_bank COUNT=4
Vs101_p_3 s101_p_3 0 DC 0 AC 1
Xs101_p_3 s101_p_3 0 adc_mim_bank COUNT=8
Vs101_p_4 s101_p_4 0 DC 0 AC 1
Xs101_p_4 s101_p_4 0 adc_mim_bank COUNT=16
Vs101_p_5 s101_p_5 0 DC 0 AC 1
Xs101_p_5 s101_p_5 0 adc_mim_bank COUNT=32
Vs101_p_6 s101_p_6 0 DC 0 AC 1
Xs101_p_6 s101_p_6 0 adc_mim_bank COUNT=64
Vs101_p_7 s101_p_7 0 DC 0 AC 1
Xs101_p_7 s101_p_7 0 adc_mim_bank COUNT=128
Vs101_p_8 s101_p_8 0 DC 0 AC 1
Xs101_p_8 s101_p_8 0 adc_mim_bank COUNT=256
Vs101_p_9 s101_p_9 0 DC 0 AC 1
Xs101_p_9 s101_p_9 0 adc_mim_bank COUNT=512
Vs101_p_10 s101_p_10 0 DC 0 AC 1
Xs101_p_10 s101_p_10 0 adc_mim_bank COUNT=1024
Vs101_p_11 s101_p_11 0 DC 0 AC 1
Xs101_p_11 s101_p_11 0 adc_mim_bank COUNT=2048
Vs101_p_12 s101_p_12 0 DC 0 AC 1
Xs101_p_12 s101_p_12 0 adc_mim_bank COUNT=1
Vs101_n_0 s101_n_0 0 DC 0 AC 1
Xs101_n_0 s101_n_0 0 adc_mim_bank COUNT=1
Vs101_n_1 s101_n_1 0 DC 0 AC 1
Xs101_n_1 s101_n_1 0 adc_mim_bank COUNT=2
Vs101_n_2 s101_n_2 0 DC 0 AC 1
Xs101_n_2 s101_n_2 0 adc_mim_bank COUNT=4
Vs101_n_3 s101_n_3 0 DC 0 AC 1
Xs101_n_3 s101_n_3 0 adc_mim_bank COUNT=8
Vs101_n_4 s101_n_4 0 DC 0 AC 1
Xs101_n_4 s101_n_4 0 adc_mim_bank COUNT=16
Vs101_n_5 s101_n_5 0 DC 0 AC 1
Xs101_n_5 s101_n_5 0 adc_mim_bank COUNT=32
Vs101_n_6 s101_n_6 0 DC 0 AC 1
Xs101_n_6 s101_n_6 0 adc_mim_bank COUNT=64
Vs101_n_7 s101_n_7 0 DC 0 AC 1
Xs101_n_7 s101_n_7 0 adc_mim_bank COUNT=128
Vs101_n_8 s101_n_8 0 DC 0 AC 1
Xs101_n_8 s101_n_8 0 adc_mim_bank COUNT=256
Vs101_n_9 s101_n_9 0 DC 0 AC 1
Xs101_n_9 s101_n_9 0 adc_mim_bank COUNT=512
Vs101_n_10 s101_n_10 0 DC 0 AC 1
Xs101_n_10 s101_n_10 0 adc_mim_bank COUNT=1024
Vs101_n_11 s101_n_11 0 DC 0 AC 1
Xs101_n_11 s101_n_11 0 adc_mim_bank COUNT=2048
Vs101_n_12 s101_n_12 0 DC 0 AC 1
Xs101_n_12 s101_n_12 0 adc_mim_bank COUNT=1
Vs102_p_0 s102_p_0 0 DC 0 AC 1
Xs102_p_0 s102_p_0 0 adc_mim_bank COUNT=1
Vs102_p_1 s102_p_1 0 DC 0 AC 1
Xs102_p_1 s102_p_1 0 adc_mim_bank COUNT=2
Vs102_p_2 s102_p_2 0 DC 0 AC 1
Xs102_p_2 s102_p_2 0 adc_mim_bank COUNT=4
Vs102_p_3 s102_p_3 0 DC 0 AC 1
Xs102_p_3 s102_p_3 0 adc_mim_bank COUNT=8
Vs102_p_4 s102_p_4 0 DC 0 AC 1
Xs102_p_4 s102_p_4 0 adc_mim_bank COUNT=16
Vs102_p_5 s102_p_5 0 DC 0 AC 1
Xs102_p_5 s102_p_5 0 adc_mim_bank COUNT=32
Vs102_p_6 s102_p_6 0 DC 0 AC 1
Xs102_p_6 s102_p_6 0 adc_mim_bank COUNT=64
Vs102_p_7 s102_p_7 0 DC 0 AC 1
Xs102_p_7 s102_p_7 0 adc_mim_bank COUNT=128
Vs102_p_8 s102_p_8 0 DC 0 AC 1
Xs102_p_8 s102_p_8 0 adc_mim_bank COUNT=256
Vs102_p_9 s102_p_9 0 DC 0 AC 1
Xs102_p_9 s102_p_9 0 adc_mim_bank COUNT=512
Vs102_p_10 s102_p_10 0 DC 0 AC 1
Xs102_p_10 s102_p_10 0 adc_mim_bank COUNT=1024
Vs102_p_11 s102_p_11 0 DC 0 AC 1
Xs102_p_11 s102_p_11 0 adc_mim_bank COUNT=2048
Vs102_p_12 s102_p_12 0 DC 0 AC 1
Xs102_p_12 s102_p_12 0 adc_mim_bank COUNT=1
Vs102_n_0 s102_n_0 0 DC 0 AC 1
Xs102_n_0 s102_n_0 0 adc_mim_bank COUNT=1
Vs102_n_1 s102_n_1 0 DC 0 AC 1
Xs102_n_1 s102_n_1 0 adc_mim_bank COUNT=2
Vs102_n_2 s102_n_2 0 DC 0 AC 1
Xs102_n_2 s102_n_2 0 adc_mim_bank COUNT=4
Vs102_n_3 s102_n_3 0 DC 0 AC 1
Xs102_n_3 s102_n_3 0 adc_mim_bank COUNT=8
Vs102_n_4 s102_n_4 0 DC 0 AC 1
Xs102_n_4 s102_n_4 0 adc_mim_bank COUNT=16
Vs102_n_5 s102_n_5 0 DC 0 AC 1
Xs102_n_5 s102_n_5 0 adc_mim_bank COUNT=32
Vs102_n_6 s102_n_6 0 DC 0 AC 1
Xs102_n_6 s102_n_6 0 adc_mim_bank COUNT=64
Vs102_n_7 s102_n_7 0 DC 0 AC 1
Xs102_n_7 s102_n_7 0 adc_mim_bank COUNT=128
Vs102_n_8 s102_n_8 0 DC 0 AC 1
Xs102_n_8 s102_n_8 0 adc_mim_bank COUNT=256
Vs102_n_9 s102_n_9 0 DC 0 AC 1
Xs102_n_9 s102_n_9 0 adc_mim_bank COUNT=512
Vs102_n_10 s102_n_10 0 DC 0 AC 1
Xs102_n_10 s102_n_10 0 adc_mim_bank COUNT=1024
Vs102_n_11 s102_n_11 0 DC 0 AC 1
Xs102_n_11 s102_n_11 0 adc_mim_bank COUNT=2048
Vs102_n_12 s102_n_12 0 DC 0 AC 1
Xs102_n_12 s102_n_12 0 adc_mim_bank COUNT=1
Vs103_p_0 s103_p_0 0 DC 0 AC 1
Xs103_p_0 s103_p_0 0 adc_mim_bank COUNT=1
Vs103_p_1 s103_p_1 0 DC 0 AC 1
Xs103_p_1 s103_p_1 0 adc_mim_bank COUNT=2
Vs103_p_2 s103_p_2 0 DC 0 AC 1
Xs103_p_2 s103_p_2 0 adc_mim_bank COUNT=4
Vs103_p_3 s103_p_3 0 DC 0 AC 1
Xs103_p_3 s103_p_3 0 adc_mim_bank COUNT=8
Vs103_p_4 s103_p_4 0 DC 0 AC 1
Xs103_p_4 s103_p_4 0 adc_mim_bank COUNT=16
Vs103_p_5 s103_p_5 0 DC 0 AC 1
Xs103_p_5 s103_p_5 0 adc_mim_bank COUNT=32
Vs103_p_6 s103_p_6 0 DC 0 AC 1
Xs103_p_6 s103_p_6 0 adc_mim_bank COUNT=64
Vs103_p_7 s103_p_7 0 DC 0 AC 1
Xs103_p_7 s103_p_7 0 adc_mim_bank COUNT=128
Vs103_p_8 s103_p_8 0 DC 0 AC 1
Xs103_p_8 s103_p_8 0 adc_mim_bank COUNT=256
Vs103_p_9 s103_p_9 0 DC 0 AC 1
Xs103_p_9 s103_p_9 0 adc_mim_bank COUNT=512
Vs103_p_10 s103_p_10 0 DC 0 AC 1
Xs103_p_10 s103_p_10 0 adc_mim_bank COUNT=1024
Vs103_p_11 s103_p_11 0 DC 0 AC 1
Xs103_p_11 s103_p_11 0 adc_mim_bank COUNT=2048
Vs103_p_12 s103_p_12 0 DC 0 AC 1
Xs103_p_12 s103_p_12 0 adc_mim_bank COUNT=1
Vs103_n_0 s103_n_0 0 DC 0 AC 1
Xs103_n_0 s103_n_0 0 adc_mim_bank COUNT=1
Vs103_n_1 s103_n_1 0 DC 0 AC 1
Xs103_n_1 s103_n_1 0 adc_mim_bank COUNT=2
Vs103_n_2 s103_n_2 0 DC 0 AC 1
Xs103_n_2 s103_n_2 0 adc_mim_bank COUNT=4
Vs103_n_3 s103_n_3 0 DC 0 AC 1
Xs103_n_3 s103_n_3 0 adc_mim_bank COUNT=8
Vs103_n_4 s103_n_4 0 DC 0 AC 1
Xs103_n_4 s103_n_4 0 adc_mim_bank COUNT=16
Vs103_n_5 s103_n_5 0 DC 0 AC 1
Xs103_n_5 s103_n_5 0 adc_mim_bank COUNT=32
Vs103_n_6 s103_n_6 0 DC 0 AC 1
Xs103_n_6 s103_n_6 0 adc_mim_bank COUNT=64
Vs103_n_7 s103_n_7 0 DC 0 AC 1
Xs103_n_7 s103_n_7 0 adc_mim_bank COUNT=128
Vs103_n_8 s103_n_8 0 DC 0 AC 1
Xs103_n_8 s103_n_8 0 adc_mim_bank COUNT=256
Vs103_n_9 s103_n_9 0 DC 0 AC 1
Xs103_n_9 s103_n_9 0 adc_mim_bank COUNT=512
Vs103_n_10 s103_n_10 0 DC 0 AC 1
Xs103_n_10 s103_n_10 0 adc_mim_bank COUNT=1024
Vs103_n_11 s103_n_11 0 DC 0 AC 1
Xs103_n_11 s103_n_11 0 adc_mim_bank COUNT=2048
Vs103_n_12 s103_n_12 0 DC 0 AC 1
Xs103_n_12 s103_n_12 0 adc_mim_bank COUNT=1
Vs104_p_0 s104_p_0 0 DC 0 AC 1
Xs104_p_0 s104_p_0 0 adc_mim_bank COUNT=1
Vs104_p_1 s104_p_1 0 DC 0 AC 1
Xs104_p_1 s104_p_1 0 adc_mim_bank COUNT=2
Vs104_p_2 s104_p_2 0 DC 0 AC 1
Xs104_p_2 s104_p_2 0 adc_mim_bank COUNT=4
Vs104_p_3 s104_p_3 0 DC 0 AC 1
Xs104_p_3 s104_p_3 0 adc_mim_bank COUNT=8
Vs104_p_4 s104_p_4 0 DC 0 AC 1
Xs104_p_4 s104_p_4 0 adc_mim_bank COUNT=16
Vs104_p_5 s104_p_5 0 DC 0 AC 1
Xs104_p_5 s104_p_5 0 adc_mim_bank COUNT=32
Vs104_p_6 s104_p_6 0 DC 0 AC 1
Xs104_p_6 s104_p_6 0 adc_mim_bank COUNT=64
Vs104_p_7 s104_p_7 0 DC 0 AC 1
Xs104_p_7 s104_p_7 0 adc_mim_bank COUNT=128
Vs104_p_8 s104_p_8 0 DC 0 AC 1
Xs104_p_8 s104_p_8 0 adc_mim_bank COUNT=256
Vs104_p_9 s104_p_9 0 DC 0 AC 1
Xs104_p_9 s104_p_9 0 adc_mim_bank COUNT=512
Vs104_p_10 s104_p_10 0 DC 0 AC 1
Xs104_p_10 s104_p_10 0 adc_mim_bank COUNT=1024
Vs104_p_11 s104_p_11 0 DC 0 AC 1
Xs104_p_11 s104_p_11 0 adc_mim_bank COUNT=2048
Vs104_p_12 s104_p_12 0 DC 0 AC 1
Xs104_p_12 s104_p_12 0 adc_mim_bank COUNT=1
Vs104_n_0 s104_n_0 0 DC 0 AC 1
Xs104_n_0 s104_n_0 0 adc_mim_bank COUNT=1
Vs104_n_1 s104_n_1 0 DC 0 AC 1
Xs104_n_1 s104_n_1 0 adc_mim_bank COUNT=2
Vs104_n_2 s104_n_2 0 DC 0 AC 1
Xs104_n_2 s104_n_2 0 adc_mim_bank COUNT=4
Vs104_n_3 s104_n_3 0 DC 0 AC 1
Xs104_n_3 s104_n_3 0 adc_mim_bank COUNT=8
Vs104_n_4 s104_n_4 0 DC 0 AC 1
Xs104_n_4 s104_n_4 0 adc_mim_bank COUNT=16
Vs104_n_5 s104_n_5 0 DC 0 AC 1
Xs104_n_5 s104_n_5 0 adc_mim_bank COUNT=32
Vs104_n_6 s104_n_6 0 DC 0 AC 1
Xs104_n_6 s104_n_6 0 adc_mim_bank COUNT=64
Vs104_n_7 s104_n_7 0 DC 0 AC 1
Xs104_n_7 s104_n_7 0 adc_mim_bank COUNT=128
Vs104_n_8 s104_n_8 0 DC 0 AC 1
Xs104_n_8 s104_n_8 0 adc_mim_bank COUNT=256
Vs104_n_9 s104_n_9 0 DC 0 AC 1
Xs104_n_9 s104_n_9 0 adc_mim_bank COUNT=512
Vs104_n_10 s104_n_10 0 DC 0 AC 1
Xs104_n_10 s104_n_10 0 adc_mim_bank COUNT=1024
Vs104_n_11 s104_n_11 0 DC 0 AC 1
Xs104_n_11 s104_n_11 0 adc_mim_bank COUNT=2048
Vs104_n_12 s104_n_12 0 DC 0 AC 1
Xs104_n_12 s104_n_12 0 adc_mim_bank COUNT=1
Vs105_p_0 s105_p_0 0 DC 0 AC 1
Xs105_p_0 s105_p_0 0 adc_mim_bank COUNT=1
Vs105_p_1 s105_p_1 0 DC 0 AC 1
Xs105_p_1 s105_p_1 0 adc_mim_bank COUNT=2
Vs105_p_2 s105_p_2 0 DC 0 AC 1
Xs105_p_2 s105_p_2 0 adc_mim_bank COUNT=4
Vs105_p_3 s105_p_3 0 DC 0 AC 1
Xs105_p_3 s105_p_3 0 adc_mim_bank COUNT=8
Vs105_p_4 s105_p_4 0 DC 0 AC 1
Xs105_p_4 s105_p_4 0 adc_mim_bank COUNT=16
Vs105_p_5 s105_p_5 0 DC 0 AC 1
Xs105_p_5 s105_p_5 0 adc_mim_bank COUNT=32
Vs105_p_6 s105_p_6 0 DC 0 AC 1
Xs105_p_6 s105_p_6 0 adc_mim_bank COUNT=64
Vs105_p_7 s105_p_7 0 DC 0 AC 1
Xs105_p_7 s105_p_7 0 adc_mim_bank COUNT=128
Vs105_p_8 s105_p_8 0 DC 0 AC 1
Xs105_p_8 s105_p_8 0 adc_mim_bank COUNT=256
Vs105_p_9 s105_p_9 0 DC 0 AC 1
Xs105_p_9 s105_p_9 0 adc_mim_bank COUNT=512
Vs105_p_10 s105_p_10 0 DC 0 AC 1
Xs105_p_10 s105_p_10 0 adc_mim_bank COUNT=1024
Vs105_p_11 s105_p_11 0 DC 0 AC 1
Xs105_p_11 s105_p_11 0 adc_mim_bank COUNT=2048
Vs105_p_12 s105_p_12 0 DC 0 AC 1
Xs105_p_12 s105_p_12 0 adc_mim_bank COUNT=1
Vs105_n_0 s105_n_0 0 DC 0 AC 1
Xs105_n_0 s105_n_0 0 adc_mim_bank COUNT=1
Vs105_n_1 s105_n_1 0 DC 0 AC 1
Xs105_n_1 s105_n_1 0 adc_mim_bank COUNT=2
Vs105_n_2 s105_n_2 0 DC 0 AC 1
Xs105_n_2 s105_n_2 0 adc_mim_bank COUNT=4
Vs105_n_3 s105_n_3 0 DC 0 AC 1
Xs105_n_3 s105_n_3 0 adc_mim_bank COUNT=8
Vs105_n_4 s105_n_4 0 DC 0 AC 1
Xs105_n_4 s105_n_4 0 adc_mim_bank COUNT=16
Vs105_n_5 s105_n_5 0 DC 0 AC 1
Xs105_n_5 s105_n_5 0 adc_mim_bank COUNT=32
Vs105_n_6 s105_n_6 0 DC 0 AC 1
Xs105_n_6 s105_n_6 0 adc_mim_bank COUNT=64
Vs105_n_7 s105_n_7 0 DC 0 AC 1
Xs105_n_7 s105_n_7 0 adc_mim_bank COUNT=128
Vs105_n_8 s105_n_8 0 DC 0 AC 1
Xs105_n_8 s105_n_8 0 adc_mim_bank COUNT=256
Vs105_n_9 s105_n_9 0 DC 0 AC 1
Xs105_n_9 s105_n_9 0 adc_mim_bank COUNT=512
Vs105_n_10 s105_n_10 0 DC 0 AC 1
Xs105_n_10 s105_n_10 0 adc_mim_bank COUNT=1024
Vs105_n_11 s105_n_11 0 DC 0 AC 1
Xs105_n_11 s105_n_11 0 adc_mim_bank COUNT=2048
Vs105_n_12 s105_n_12 0 DC 0 AC 1
Xs105_n_12 s105_n_12 0 adc_mim_bank COUNT=1
Vs106_p_0 s106_p_0 0 DC 0 AC 1
Xs106_p_0 s106_p_0 0 adc_mim_bank COUNT=1
Vs106_p_1 s106_p_1 0 DC 0 AC 1
Xs106_p_1 s106_p_1 0 adc_mim_bank COUNT=2
Vs106_p_2 s106_p_2 0 DC 0 AC 1
Xs106_p_2 s106_p_2 0 adc_mim_bank COUNT=4
Vs106_p_3 s106_p_3 0 DC 0 AC 1
Xs106_p_3 s106_p_3 0 adc_mim_bank COUNT=8
Vs106_p_4 s106_p_4 0 DC 0 AC 1
Xs106_p_4 s106_p_4 0 adc_mim_bank COUNT=16
Vs106_p_5 s106_p_5 0 DC 0 AC 1
Xs106_p_5 s106_p_5 0 adc_mim_bank COUNT=32
Vs106_p_6 s106_p_6 0 DC 0 AC 1
Xs106_p_6 s106_p_6 0 adc_mim_bank COUNT=64
Vs106_p_7 s106_p_7 0 DC 0 AC 1
Xs106_p_7 s106_p_7 0 adc_mim_bank COUNT=128
Vs106_p_8 s106_p_8 0 DC 0 AC 1
Xs106_p_8 s106_p_8 0 adc_mim_bank COUNT=256
Vs106_p_9 s106_p_9 0 DC 0 AC 1
Xs106_p_9 s106_p_9 0 adc_mim_bank COUNT=512
Vs106_p_10 s106_p_10 0 DC 0 AC 1
Xs106_p_10 s106_p_10 0 adc_mim_bank COUNT=1024
Vs106_p_11 s106_p_11 0 DC 0 AC 1
Xs106_p_11 s106_p_11 0 adc_mim_bank COUNT=2048
Vs106_p_12 s106_p_12 0 DC 0 AC 1
Xs106_p_12 s106_p_12 0 adc_mim_bank COUNT=1
Vs106_n_0 s106_n_0 0 DC 0 AC 1
Xs106_n_0 s106_n_0 0 adc_mim_bank COUNT=1
Vs106_n_1 s106_n_1 0 DC 0 AC 1
Xs106_n_1 s106_n_1 0 adc_mim_bank COUNT=2
Vs106_n_2 s106_n_2 0 DC 0 AC 1
Xs106_n_2 s106_n_2 0 adc_mim_bank COUNT=4
Vs106_n_3 s106_n_3 0 DC 0 AC 1
Xs106_n_3 s106_n_3 0 adc_mim_bank COUNT=8
Vs106_n_4 s106_n_4 0 DC 0 AC 1
Xs106_n_4 s106_n_4 0 adc_mim_bank COUNT=16
Vs106_n_5 s106_n_5 0 DC 0 AC 1
Xs106_n_5 s106_n_5 0 adc_mim_bank COUNT=32
Vs106_n_6 s106_n_6 0 DC 0 AC 1
Xs106_n_6 s106_n_6 0 adc_mim_bank COUNT=64
Vs106_n_7 s106_n_7 0 DC 0 AC 1
Xs106_n_7 s106_n_7 0 adc_mim_bank COUNT=128
Vs106_n_8 s106_n_8 0 DC 0 AC 1
Xs106_n_8 s106_n_8 0 adc_mim_bank COUNT=256
Vs106_n_9 s106_n_9 0 DC 0 AC 1
Xs106_n_9 s106_n_9 0 adc_mim_bank COUNT=512
Vs106_n_10 s106_n_10 0 DC 0 AC 1
Xs106_n_10 s106_n_10 0 adc_mim_bank COUNT=1024
Vs106_n_11 s106_n_11 0 DC 0 AC 1
Xs106_n_11 s106_n_11 0 adc_mim_bank COUNT=2048
Vs106_n_12 s106_n_12 0 DC 0 AC 1
Xs106_n_12 s106_n_12 0 adc_mim_bank COUNT=1
Vs107_p_0 s107_p_0 0 DC 0 AC 1
Xs107_p_0 s107_p_0 0 adc_mim_bank COUNT=1
Vs107_p_1 s107_p_1 0 DC 0 AC 1
Xs107_p_1 s107_p_1 0 adc_mim_bank COUNT=2
Vs107_p_2 s107_p_2 0 DC 0 AC 1
Xs107_p_2 s107_p_2 0 adc_mim_bank COUNT=4
Vs107_p_3 s107_p_3 0 DC 0 AC 1
Xs107_p_3 s107_p_3 0 adc_mim_bank COUNT=8
Vs107_p_4 s107_p_4 0 DC 0 AC 1
Xs107_p_4 s107_p_4 0 adc_mim_bank COUNT=16
Vs107_p_5 s107_p_5 0 DC 0 AC 1
Xs107_p_5 s107_p_5 0 adc_mim_bank COUNT=32
Vs107_p_6 s107_p_6 0 DC 0 AC 1
Xs107_p_6 s107_p_6 0 adc_mim_bank COUNT=64
Vs107_p_7 s107_p_7 0 DC 0 AC 1
Xs107_p_7 s107_p_7 0 adc_mim_bank COUNT=128
Vs107_p_8 s107_p_8 0 DC 0 AC 1
Xs107_p_8 s107_p_8 0 adc_mim_bank COUNT=256
Vs107_p_9 s107_p_9 0 DC 0 AC 1
Xs107_p_9 s107_p_9 0 adc_mim_bank COUNT=512
Vs107_p_10 s107_p_10 0 DC 0 AC 1
Xs107_p_10 s107_p_10 0 adc_mim_bank COUNT=1024
Vs107_p_11 s107_p_11 0 DC 0 AC 1
Xs107_p_11 s107_p_11 0 adc_mim_bank COUNT=2048
Vs107_p_12 s107_p_12 0 DC 0 AC 1
Xs107_p_12 s107_p_12 0 adc_mim_bank COUNT=1
Vs107_n_0 s107_n_0 0 DC 0 AC 1
Xs107_n_0 s107_n_0 0 adc_mim_bank COUNT=1
Vs107_n_1 s107_n_1 0 DC 0 AC 1
Xs107_n_1 s107_n_1 0 adc_mim_bank COUNT=2
Vs107_n_2 s107_n_2 0 DC 0 AC 1
Xs107_n_2 s107_n_2 0 adc_mim_bank COUNT=4
Vs107_n_3 s107_n_3 0 DC 0 AC 1
Xs107_n_3 s107_n_3 0 adc_mim_bank COUNT=8
Vs107_n_4 s107_n_4 0 DC 0 AC 1
Xs107_n_4 s107_n_4 0 adc_mim_bank COUNT=16
Vs107_n_5 s107_n_5 0 DC 0 AC 1
Xs107_n_5 s107_n_5 0 adc_mim_bank COUNT=32
Vs107_n_6 s107_n_6 0 DC 0 AC 1
Xs107_n_6 s107_n_6 0 adc_mim_bank COUNT=64
Vs107_n_7 s107_n_7 0 DC 0 AC 1
Xs107_n_7 s107_n_7 0 adc_mim_bank COUNT=128
Vs107_n_8 s107_n_8 0 DC 0 AC 1
Xs107_n_8 s107_n_8 0 adc_mim_bank COUNT=256
Vs107_n_9 s107_n_9 0 DC 0 AC 1
Xs107_n_9 s107_n_9 0 adc_mim_bank COUNT=512
Vs107_n_10 s107_n_10 0 DC 0 AC 1
Xs107_n_10 s107_n_10 0 adc_mim_bank COUNT=1024
Vs107_n_11 s107_n_11 0 DC 0 AC 1
Xs107_n_11 s107_n_11 0 adc_mim_bank COUNT=2048
Vs107_n_12 s107_n_12 0 DC 0 AC 1
Xs107_n_12 s107_n_12 0 adc_mim_bank COUNT=1
Vs108_p_0 s108_p_0 0 DC 0 AC 1
Xs108_p_0 s108_p_0 0 adc_mim_bank COUNT=1
Vs108_p_1 s108_p_1 0 DC 0 AC 1
Xs108_p_1 s108_p_1 0 adc_mim_bank COUNT=2
Vs108_p_2 s108_p_2 0 DC 0 AC 1
Xs108_p_2 s108_p_2 0 adc_mim_bank COUNT=4
Vs108_p_3 s108_p_3 0 DC 0 AC 1
Xs108_p_3 s108_p_3 0 adc_mim_bank COUNT=8
Vs108_p_4 s108_p_4 0 DC 0 AC 1
Xs108_p_4 s108_p_4 0 adc_mim_bank COUNT=16
Vs108_p_5 s108_p_5 0 DC 0 AC 1
Xs108_p_5 s108_p_5 0 adc_mim_bank COUNT=32
Vs108_p_6 s108_p_6 0 DC 0 AC 1
Xs108_p_6 s108_p_6 0 adc_mim_bank COUNT=64
Vs108_p_7 s108_p_7 0 DC 0 AC 1
Xs108_p_7 s108_p_7 0 adc_mim_bank COUNT=128
Vs108_p_8 s108_p_8 0 DC 0 AC 1
Xs108_p_8 s108_p_8 0 adc_mim_bank COUNT=256
Vs108_p_9 s108_p_9 0 DC 0 AC 1
Xs108_p_9 s108_p_9 0 adc_mim_bank COUNT=512
Vs108_p_10 s108_p_10 0 DC 0 AC 1
Xs108_p_10 s108_p_10 0 adc_mim_bank COUNT=1024
Vs108_p_11 s108_p_11 0 DC 0 AC 1
Xs108_p_11 s108_p_11 0 adc_mim_bank COUNT=2048
Vs108_p_12 s108_p_12 0 DC 0 AC 1
Xs108_p_12 s108_p_12 0 adc_mim_bank COUNT=1
Vs108_n_0 s108_n_0 0 DC 0 AC 1
Xs108_n_0 s108_n_0 0 adc_mim_bank COUNT=1
Vs108_n_1 s108_n_1 0 DC 0 AC 1
Xs108_n_1 s108_n_1 0 adc_mim_bank COUNT=2
Vs108_n_2 s108_n_2 0 DC 0 AC 1
Xs108_n_2 s108_n_2 0 adc_mim_bank COUNT=4
Vs108_n_3 s108_n_3 0 DC 0 AC 1
Xs108_n_3 s108_n_3 0 adc_mim_bank COUNT=8
Vs108_n_4 s108_n_4 0 DC 0 AC 1
Xs108_n_4 s108_n_4 0 adc_mim_bank COUNT=16
Vs108_n_5 s108_n_5 0 DC 0 AC 1
Xs108_n_5 s108_n_5 0 adc_mim_bank COUNT=32
Vs108_n_6 s108_n_6 0 DC 0 AC 1
Xs108_n_6 s108_n_6 0 adc_mim_bank COUNT=64
Vs108_n_7 s108_n_7 0 DC 0 AC 1
Xs108_n_7 s108_n_7 0 adc_mim_bank COUNT=128
Vs108_n_8 s108_n_8 0 DC 0 AC 1
Xs108_n_8 s108_n_8 0 adc_mim_bank COUNT=256
Vs108_n_9 s108_n_9 0 DC 0 AC 1
Xs108_n_9 s108_n_9 0 adc_mim_bank COUNT=512
Vs108_n_10 s108_n_10 0 DC 0 AC 1
Xs108_n_10 s108_n_10 0 adc_mim_bank COUNT=1024
Vs108_n_11 s108_n_11 0 DC 0 AC 1
Xs108_n_11 s108_n_11 0 adc_mim_bank COUNT=2048
Vs108_n_12 s108_n_12 0 DC 0 AC 1
Xs108_n_12 s108_n_12 0 adc_mim_bank COUNT=1
Vs109_p_0 s109_p_0 0 DC 0 AC 1
Xs109_p_0 s109_p_0 0 adc_mim_bank COUNT=1
Vs109_p_1 s109_p_1 0 DC 0 AC 1
Xs109_p_1 s109_p_1 0 adc_mim_bank COUNT=2
Vs109_p_2 s109_p_2 0 DC 0 AC 1
Xs109_p_2 s109_p_2 0 adc_mim_bank COUNT=4
Vs109_p_3 s109_p_3 0 DC 0 AC 1
Xs109_p_3 s109_p_3 0 adc_mim_bank COUNT=8
Vs109_p_4 s109_p_4 0 DC 0 AC 1
Xs109_p_4 s109_p_4 0 adc_mim_bank COUNT=16
Vs109_p_5 s109_p_5 0 DC 0 AC 1
Xs109_p_5 s109_p_5 0 adc_mim_bank COUNT=32
Vs109_p_6 s109_p_6 0 DC 0 AC 1
Xs109_p_6 s109_p_6 0 adc_mim_bank COUNT=64
Vs109_p_7 s109_p_7 0 DC 0 AC 1
Xs109_p_7 s109_p_7 0 adc_mim_bank COUNT=128
Vs109_p_8 s109_p_8 0 DC 0 AC 1
Xs109_p_8 s109_p_8 0 adc_mim_bank COUNT=256
Vs109_p_9 s109_p_9 0 DC 0 AC 1
Xs109_p_9 s109_p_9 0 adc_mim_bank COUNT=512
Vs109_p_10 s109_p_10 0 DC 0 AC 1
Xs109_p_10 s109_p_10 0 adc_mim_bank COUNT=1024
Vs109_p_11 s109_p_11 0 DC 0 AC 1
Xs109_p_11 s109_p_11 0 adc_mim_bank COUNT=2048
Vs109_p_12 s109_p_12 0 DC 0 AC 1
Xs109_p_12 s109_p_12 0 adc_mim_bank COUNT=1
Vs109_n_0 s109_n_0 0 DC 0 AC 1
Xs109_n_0 s109_n_0 0 adc_mim_bank COUNT=1
Vs109_n_1 s109_n_1 0 DC 0 AC 1
Xs109_n_1 s109_n_1 0 adc_mim_bank COUNT=2
Vs109_n_2 s109_n_2 0 DC 0 AC 1
Xs109_n_2 s109_n_2 0 adc_mim_bank COUNT=4
Vs109_n_3 s109_n_3 0 DC 0 AC 1
Xs109_n_3 s109_n_3 0 adc_mim_bank COUNT=8
Vs109_n_4 s109_n_4 0 DC 0 AC 1
Xs109_n_4 s109_n_4 0 adc_mim_bank COUNT=16
Vs109_n_5 s109_n_5 0 DC 0 AC 1
Xs109_n_5 s109_n_5 0 adc_mim_bank COUNT=32
Vs109_n_6 s109_n_6 0 DC 0 AC 1
Xs109_n_6 s109_n_6 0 adc_mim_bank COUNT=64
Vs109_n_7 s109_n_7 0 DC 0 AC 1
Xs109_n_7 s109_n_7 0 adc_mim_bank COUNT=128
Vs109_n_8 s109_n_8 0 DC 0 AC 1
Xs109_n_8 s109_n_8 0 adc_mim_bank COUNT=256
Vs109_n_9 s109_n_9 0 DC 0 AC 1
Xs109_n_9 s109_n_9 0 adc_mim_bank COUNT=512
Vs109_n_10 s109_n_10 0 DC 0 AC 1
Xs109_n_10 s109_n_10 0 adc_mim_bank COUNT=1024
Vs109_n_11 s109_n_11 0 DC 0 AC 1
Xs109_n_11 s109_n_11 0 adc_mim_bank COUNT=2048
Vs109_n_12 s109_n_12 0 DC 0 AC 1
Xs109_n_12 s109_n_12 0 adc_mim_bank COUNT=1
Vs110_p_0 s110_p_0 0 DC 0 AC 1
Xs110_p_0 s110_p_0 0 adc_mim_bank COUNT=1
Vs110_p_1 s110_p_1 0 DC 0 AC 1
Xs110_p_1 s110_p_1 0 adc_mim_bank COUNT=2
Vs110_p_2 s110_p_2 0 DC 0 AC 1
Xs110_p_2 s110_p_2 0 adc_mim_bank COUNT=4
Vs110_p_3 s110_p_3 0 DC 0 AC 1
Xs110_p_3 s110_p_3 0 adc_mim_bank COUNT=8
Vs110_p_4 s110_p_4 0 DC 0 AC 1
Xs110_p_4 s110_p_4 0 adc_mim_bank COUNT=16
Vs110_p_5 s110_p_5 0 DC 0 AC 1
Xs110_p_5 s110_p_5 0 adc_mim_bank COUNT=32
Vs110_p_6 s110_p_6 0 DC 0 AC 1
Xs110_p_6 s110_p_6 0 adc_mim_bank COUNT=64
Vs110_p_7 s110_p_7 0 DC 0 AC 1
Xs110_p_7 s110_p_7 0 adc_mim_bank COUNT=128
Vs110_p_8 s110_p_8 0 DC 0 AC 1
Xs110_p_8 s110_p_8 0 adc_mim_bank COUNT=256
Vs110_p_9 s110_p_9 0 DC 0 AC 1
Xs110_p_9 s110_p_9 0 adc_mim_bank COUNT=512
Vs110_p_10 s110_p_10 0 DC 0 AC 1
Xs110_p_10 s110_p_10 0 adc_mim_bank COUNT=1024
Vs110_p_11 s110_p_11 0 DC 0 AC 1
Xs110_p_11 s110_p_11 0 adc_mim_bank COUNT=2048
Vs110_p_12 s110_p_12 0 DC 0 AC 1
Xs110_p_12 s110_p_12 0 adc_mim_bank COUNT=1
Vs110_n_0 s110_n_0 0 DC 0 AC 1
Xs110_n_0 s110_n_0 0 adc_mim_bank COUNT=1
Vs110_n_1 s110_n_1 0 DC 0 AC 1
Xs110_n_1 s110_n_1 0 adc_mim_bank COUNT=2
Vs110_n_2 s110_n_2 0 DC 0 AC 1
Xs110_n_2 s110_n_2 0 adc_mim_bank COUNT=4
Vs110_n_3 s110_n_3 0 DC 0 AC 1
Xs110_n_3 s110_n_3 0 adc_mim_bank COUNT=8
Vs110_n_4 s110_n_4 0 DC 0 AC 1
Xs110_n_4 s110_n_4 0 adc_mim_bank COUNT=16
Vs110_n_5 s110_n_5 0 DC 0 AC 1
Xs110_n_5 s110_n_5 0 adc_mim_bank COUNT=32
Vs110_n_6 s110_n_6 0 DC 0 AC 1
Xs110_n_6 s110_n_6 0 adc_mim_bank COUNT=64
Vs110_n_7 s110_n_7 0 DC 0 AC 1
Xs110_n_7 s110_n_7 0 adc_mim_bank COUNT=128
Vs110_n_8 s110_n_8 0 DC 0 AC 1
Xs110_n_8 s110_n_8 0 adc_mim_bank COUNT=256
Vs110_n_9 s110_n_9 0 DC 0 AC 1
Xs110_n_9 s110_n_9 0 adc_mim_bank COUNT=512
Vs110_n_10 s110_n_10 0 DC 0 AC 1
Xs110_n_10 s110_n_10 0 adc_mim_bank COUNT=1024
Vs110_n_11 s110_n_11 0 DC 0 AC 1
Xs110_n_11 s110_n_11 0 adc_mim_bank COUNT=2048
Vs110_n_12 s110_n_12 0 DC 0 AC 1
Xs110_n_12 s110_n_12 0 adc_mim_bank COUNT=1
Vs111_p_0 s111_p_0 0 DC 0 AC 1
Xs111_p_0 s111_p_0 0 adc_mim_bank COUNT=1
Vs111_p_1 s111_p_1 0 DC 0 AC 1
Xs111_p_1 s111_p_1 0 adc_mim_bank COUNT=2
Vs111_p_2 s111_p_2 0 DC 0 AC 1
Xs111_p_2 s111_p_2 0 adc_mim_bank COUNT=4
Vs111_p_3 s111_p_3 0 DC 0 AC 1
Xs111_p_3 s111_p_3 0 adc_mim_bank COUNT=8
Vs111_p_4 s111_p_4 0 DC 0 AC 1
Xs111_p_4 s111_p_4 0 adc_mim_bank COUNT=16
Vs111_p_5 s111_p_5 0 DC 0 AC 1
Xs111_p_5 s111_p_5 0 adc_mim_bank COUNT=32
Vs111_p_6 s111_p_6 0 DC 0 AC 1
Xs111_p_6 s111_p_6 0 adc_mim_bank COUNT=64
Vs111_p_7 s111_p_7 0 DC 0 AC 1
Xs111_p_7 s111_p_7 0 adc_mim_bank COUNT=128
Vs111_p_8 s111_p_8 0 DC 0 AC 1
Xs111_p_8 s111_p_8 0 adc_mim_bank COUNT=256
Vs111_p_9 s111_p_9 0 DC 0 AC 1
Xs111_p_9 s111_p_9 0 adc_mim_bank COUNT=512
Vs111_p_10 s111_p_10 0 DC 0 AC 1
Xs111_p_10 s111_p_10 0 adc_mim_bank COUNT=1024
Vs111_p_11 s111_p_11 0 DC 0 AC 1
Xs111_p_11 s111_p_11 0 adc_mim_bank COUNT=2048
Vs111_p_12 s111_p_12 0 DC 0 AC 1
Xs111_p_12 s111_p_12 0 adc_mim_bank COUNT=1
Vs111_n_0 s111_n_0 0 DC 0 AC 1
Xs111_n_0 s111_n_0 0 adc_mim_bank COUNT=1
Vs111_n_1 s111_n_1 0 DC 0 AC 1
Xs111_n_1 s111_n_1 0 adc_mim_bank COUNT=2
Vs111_n_2 s111_n_2 0 DC 0 AC 1
Xs111_n_2 s111_n_2 0 adc_mim_bank COUNT=4
Vs111_n_3 s111_n_3 0 DC 0 AC 1
Xs111_n_3 s111_n_3 0 adc_mim_bank COUNT=8
Vs111_n_4 s111_n_4 0 DC 0 AC 1
Xs111_n_4 s111_n_4 0 adc_mim_bank COUNT=16
Vs111_n_5 s111_n_5 0 DC 0 AC 1
Xs111_n_5 s111_n_5 0 adc_mim_bank COUNT=32
Vs111_n_6 s111_n_6 0 DC 0 AC 1
Xs111_n_6 s111_n_6 0 adc_mim_bank COUNT=64
Vs111_n_7 s111_n_7 0 DC 0 AC 1
Xs111_n_7 s111_n_7 0 adc_mim_bank COUNT=128
Vs111_n_8 s111_n_8 0 DC 0 AC 1
Xs111_n_8 s111_n_8 0 adc_mim_bank COUNT=256
Vs111_n_9 s111_n_9 0 DC 0 AC 1
Xs111_n_9 s111_n_9 0 adc_mim_bank COUNT=512
Vs111_n_10 s111_n_10 0 DC 0 AC 1
Xs111_n_10 s111_n_10 0 adc_mim_bank COUNT=1024
Vs111_n_11 s111_n_11 0 DC 0 AC 1
Xs111_n_11 s111_n_11 0 adc_mim_bank COUNT=2048
Vs111_n_12 s111_n_12 0 DC 0 AC 1
Xs111_n_12 s111_n_12 0 adc_mim_bank COUNT=1
Vs112_p_0 s112_p_0 0 DC 0 AC 1
Xs112_p_0 s112_p_0 0 adc_mim_bank COUNT=1
Vs112_p_1 s112_p_1 0 DC 0 AC 1
Xs112_p_1 s112_p_1 0 adc_mim_bank COUNT=2
Vs112_p_2 s112_p_2 0 DC 0 AC 1
Xs112_p_2 s112_p_2 0 adc_mim_bank COUNT=4
Vs112_p_3 s112_p_3 0 DC 0 AC 1
Xs112_p_3 s112_p_3 0 adc_mim_bank COUNT=8
Vs112_p_4 s112_p_4 0 DC 0 AC 1
Xs112_p_4 s112_p_4 0 adc_mim_bank COUNT=16
Vs112_p_5 s112_p_5 0 DC 0 AC 1
Xs112_p_5 s112_p_5 0 adc_mim_bank COUNT=32
Vs112_p_6 s112_p_6 0 DC 0 AC 1
Xs112_p_6 s112_p_6 0 adc_mim_bank COUNT=64
Vs112_p_7 s112_p_7 0 DC 0 AC 1
Xs112_p_7 s112_p_7 0 adc_mim_bank COUNT=128
Vs112_p_8 s112_p_8 0 DC 0 AC 1
Xs112_p_8 s112_p_8 0 adc_mim_bank COUNT=256
Vs112_p_9 s112_p_9 0 DC 0 AC 1
Xs112_p_9 s112_p_9 0 adc_mim_bank COUNT=512
Vs112_p_10 s112_p_10 0 DC 0 AC 1
Xs112_p_10 s112_p_10 0 adc_mim_bank COUNT=1024
Vs112_p_11 s112_p_11 0 DC 0 AC 1
Xs112_p_11 s112_p_11 0 adc_mim_bank COUNT=2048
Vs112_p_12 s112_p_12 0 DC 0 AC 1
Xs112_p_12 s112_p_12 0 adc_mim_bank COUNT=1
Vs112_n_0 s112_n_0 0 DC 0 AC 1
Xs112_n_0 s112_n_0 0 adc_mim_bank COUNT=1
Vs112_n_1 s112_n_1 0 DC 0 AC 1
Xs112_n_1 s112_n_1 0 adc_mim_bank COUNT=2
Vs112_n_2 s112_n_2 0 DC 0 AC 1
Xs112_n_2 s112_n_2 0 adc_mim_bank COUNT=4
Vs112_n_3 s112_n_3 0 DC 0 AC 1
Xs112_n_3 s112_n_3 0 adc_mim_bank COUNT=8
Vs112_n_4 s112_n_4 0 DC 0 AC 1
Xs112_n_4 s112_n_4 0 adc_mim_bank COUNT=16
Vs112_n_5 s112_n_5 0 DC 0 AC 1
Xs112_n_5 s112_n_5 0 adc_mim_bank COUNT=32
Vs112_n_6 s112_n_6 0 DC 0 AC 1
Xs112_n_6 s112_n_6 0 adc_mim_bank COUNT=64
Vs112_n_7 s112_n_7 0 DC 0 AC 1
Xs112_n_7 s112_n_7 0 adc_mim_bank COUNT=128
Vs112_n_8 s112_n_8 0 DC 0 AC 1
Xs112_n_8 s112_n_8 0 adc_mim_bank COUNT=256
Vs112_n_9 s112_n_9 0 DC 0 AC 1
Xs112_n_9 s112_n_9 0 adc_mim_bank COUNT=512
Vs112_n_10 s112_n_10 0 DC 0 AC 1
Xs112_n_10 s112_n_10 0 adc_mim_bank COUNT=1024
Vs112_n_11 s112_n_11 0 DC 0 AC 1
Xs112_n_11 s112_n_11 0 adc_mim_bank COUNT=2048
Vs112_n_12 s112_n_12 0 DC 0 AC 1
Xs112_n_12 s112_n_12 0 adc_mim_bank COUNT=1
Vs113_p_0 s113_p_0 0 DC 0 AC 1
Xs113_p_0 s113_p_0 0 adc_mim_bank COUNT=1
Vs113_p_1 s113_p_1 0 DC 0 AC 1
Xs113_p_1 s113_p_1 0 adc_mim_bank COUNT=2
Vs113_p_2 s113_p_2 0 DC 0 AC 1
Xs113_p_2 s113_p_2 0 adc_mim_bank COUNT=4
Vs113_p_3 s113_p_3 0 DC 0 AC 1
Xs113_p_3 s113_p_3 0 adc_mim_bank COUNT=8
Vs113_p_4 s113_p_4 0 DC 0 AC 1
Xs113_p_4 s113_p_4 0 adc_mim_bank COUNT=16
Vs113_p_5 s113_p_5 0 DC 0 AC 1
Xs113_p_5 s113_p_5 0 adc_mim_bank COUNT=32
Vs113_p_6 s113_p_6 0 DC 0 AC 1
Xs113_p_6 s113_p_6 0 adc_mim_bank COUNT=64
Vs113_p_7 s113_p_7 0 DC 0 AC 1
Xs113_p_7 s113_p_7 0 adc_mim_bank COUNT=128
Vs113_p_8 s113_p_8 0 DC 0 AC 1
Xs113_p_8 s113_p_8 0 adc_mim_bank COUNT=256
Vs113_p_9 s113_p_9 0 DC 0 AC 1
Xs113_p_9 s113_p_9 0 adc_mim_bank COUNT=512
Vs113_p_10 s113_p_10 0 DC 0 AC 1
Xs113_p_10 s113_p_10 0 adc_mim_bank COUNT=1024
Vs113_p_11 s113_p_11 0 DC 0 AC 1
Xs113_p_11 s113_p_11 0 adc_mim_bank COUNT=2048
Vs113_p_12 s113_p_12 0 DC 0 AC 1
Xs113_p_12 s113_p_12 0 adc_mim_bank COUNT=1
Vs113_n_0 s113_n_0 0 DC 0 AC 1
Xs113_n_0 s113_n_0 0 adc_mim_bank COUNT=1
Vs113_n_1 s113_n_1 0 DC 0 AC 1
Xs113_n_1 s113_n_1 0 adc_mim_bank COUNT=2
Vs113_n_2 s113_n_2 0 DC 0 AC 1
Xs113_n_2 s113_n_2 0 adc_mim_bank COUNT=4
Vs113_n_3 s113_n_3 0 DC 0 AC 1
Xs113_n_3 s113_n_3 0 adc_mim_bank COUNT=8
Vs113_n_4 s113_n_4 0 DC 0 AC 1
Xs113_n_4 s113_n_4 0 adc_mim_bank COUNT=16
Vs113_n_5 s113_n_5 0 DC 0 AC 1
Xs113_n_5 s113_n_5 0 adc_mim_bank COUNT=32
Vs113_n_6 s113_n_6 0 DC 0 AC 1
Xs113_n_6 s113_n_6 0 adc_mim_bank COUNT=64
Vs113_n_7 s113_n_7 0 DC 0 AC 1
Xs113_n_7 s113_n_7 0 adc_mim_bank COUNT=128
Vs113_n_8 s113_n_8 0 DC 0 AC 1
Xs113_n_8 s113_n_8 0 adc_mim_bank COUNT=256
Vs113_n_9 s113_n_9 0 DC 0 AC 1
Xs113_n_9 s113_n_9 0 adc_mim_bank COUNT=512
Vs113_n_10 s113_n_10 0 DC 0 AC 1
Xs113_n_10 s113_n_10 0 adc_mim_bank COUNT=1024
Vs113_n_11 s113_n_11 0 DC 0 AC 1
Xs113_n_11 s113_n_11 0 adc_mim_bank COUNT=2048
Vs113_n_12 s113_n_12 0 DC 0 AC 1
Xs113_n_12 s113_n_12 0 adc_mim_bank COUNT=1
Vs114_p_0 s114_p_0 0 DC 0 AC 1
Xs114_p_0 s114_p_0 0 adc_mim_bank COUNT=1
Vs114_p_1 s114_p_1 0 DC 0 AC 1
Xs114_p_1 s114_p_1 0 adc_mim_bank COUNT=2
Vs114_p_2 s114_p_2 0 DC 0 AC 1
Xs114_p_2 s114_p_2 0 adc_mim_bank COUNT=4
Vs114_p_3 s114_p_3 0 DC 0 AC 1
Xs114_p_3 s114_p_3 0 adc_mim_bank COUNT=8
Vs114_p_4 s114_p_4 0 DC 0 AC 1
Xs114_p_4 s114_p_4 0 adc_mim_bank COUNT=16
Vs114_p_5 s114_p_5 0 DC 0 AC 1
Xs114_p_5 s114_p_5 0 adc_mim_bank COUNT=32
Vs114_p_6 s114_p_6 0 DC 0 AC 1
Xs114_p_6 s114_p_6 0 adc_mim_bank COUNT=64
Vs114_p_7 s114_p_7 0 DC 0 AC 1
Xs114_p_7 s114_p_7 0 adc_mim_bank COUNT=128
Vs114_p_8 s114_p_8 0 DC 0 AC 1
Xs114_p_8 s114_p_8 0 adc_mim_bank COUNT=256
Vs114_p_9 s114_p_9 0 DC 0 AC 1
Xs114_p_9 s114_p_9 0 adc_mim_bank COUNT=512
Vs114_p_10 s114_p_10 0 DC 0 AC 1
Xs114_p_10 s114_p_10 0 adc_mim_bank COUNT=1024
Vs114_p_11 s114_p_11 0 DC 0 AC 1
Xs114_p_11 s114_p_11 0 adc_mim_bank COUNT=2048
Vs114_p_12 s114_p_12 0 DC 0 AC 1
Xs114_p_12 s114_p_12 0 adc_mim_bank COUNT=1
Vs114_n_0 s114_n_0 0 DC 0 AC 1
Xs114_n_0 s114_n_0 0 adc_mim_bank COUNT=1
Vs114_n_1 s114_n_1 0 DC 0 AC 1
Xs114_n_1 s114_n_1 0 adc_mim_bank COUNT=2
Vs114_n_2 s114_n_2 0 DC 0 AC 1
Xs114_n_2 s114_n_2 0 adc_mim_bank COUNT=4
Vs114_n_3 s114_n_3 0 DC 0 AC 1
Xs114_n_3 s114_n_3 0 adc_mim_bank COUNT=8
Vs114_n_4 s114_n_4 0 DC 0 AC 1
Xs114_n_4 s114_n_4 0 adc_mim_bank COUNT=16
Vs114_n_5 s114_n_5 0 DC 0 AC 1
Xs114_n_5 s114_n_5 0 adc_mim_bank COUNT=32
Vs114_n_6 s114_n_6 0 DC 0 AC 1
Xs114_n_6 s114_n_6 0 adc_mim_bank COUNT=64
Vs114_n_7 s114_n_7 0 DC 0 AC 1
Xs114_n_7 s114_n_7 0 adc_mim_bank COUNT=128
Vs114_n_8 s114_n_8 0 DC 0 AC 1
Xs114_n_8 s114_n_8 0 adc_mim_bank COUNT=256
Vs114_n_9 s114_n_9 0 DC 0 AC 1
Xs114_n_9 s114_n_9 0 adc_mim_bank COUNT=512
Vs114_n_10 s114_n_10 0 DC 0 AC 1
Xs114_n_10 s114_n_10 0 adc_mim_bank COUNT=1024
Vs114_n_11 s114_n_11 0 DC 0 AC 1
Xs114_n_11 s114_n_11 0 adc_mim_bank COUNT=2048
Vs114_n_12 s114_n_12 0 DC 0 AC 1
Xs114_n_12 s114_n_12 0 adc_mim_bank COUNT=1
Vs115_p_0 s115_p_0 0 DC 0 AC 1
Xs115_p_0 s115_p_0 0 adc_mim_bank COUNT=1
Vs115_p_1 s115_p_1 0 DC 0 AC 1
Xs115_p_1 s115_p_1 0 adc_mim_bank COUNT=2
Vs115_p_2 s115_p_2 0 DC 0 AC 1
Xs115_p_2 s115_p_2 0 adc_mim_bank COUNT=4
Vs115_p_3 s115_p_3 0 DC 0 AC 1
Xs115_p_3 s115_p_3 0 adc_mim_bank COUNT=8
Vs115_p_4 s115_p_4 0 DC 0 AC 1
Xs115_p_4 s115_p_4 0 adc_mim_bank COUNT=16
Vs115_p_5 s115_p_5 0 DC 0 AC 1
Xs115_p_5 s115_p_5 0 adc_mim_bank COUNT=32
Vs115_p_6 s115_p_6 0 DC 0 AC 1
Xs115_p_6 s115_p_6 0 adc_mim_bank COUNT=64
Vs115_p_7 s115_p_7 0 DC 0 AC 1
Xs115_p_7 s115_p_7 0 adc_mim_bank COUNT=128
Vs115_p_8 s115_p_8 0 DC 0 AC 1
Xs115_p_8 s115_p_8 0 adc_mim_bank COUNT=256
Vs115_p_9 s115_p_9 0 DC 0 AC 1
Xs115_p_9 s115_p_9 0 adc_mim_bank COUNT=512
Vs115_p_10 s115_p_10 0 DC 0 AC 1
Xs115_p_10 s115_p_10 0 adc_mim_bank COUNT=1024
Vs115_p_11 s115_p_11 0 DC 0 AC 1
Xs115_p_11 s115_p_11 0 adc_mim_bank COUNT=2048
Vs115_p_12 s115_p_12 0 DC 0 AC 1
Xs115_p_12 s115_p_12 0 adc_mim_bank COUNT=1
Vs115_n_0 s115_n_0 0 DC 0 AC 1
Xs115_n_0 s115_n_0 0 adc_mim_bank COUNT=1
Vs115_n_1 s115_n_1 0 DC 0 AC 1
Xs115_n_1 s115_n_1 0 adc_mim_bank COUNT=2
Vs115_n_2 s115_n_2 0 DC 0 AC 1
Xs115_n_2 s115_n_2 0 adc_mim_bank COUNT=4
Vs115_n_3 s115_n_3 0 DC 0 AC 1
Xs115_n_3 s115_n_3 0 adc_mim_bank COUNT=8
Vs115_n_4 s115_n_4 0 DC 0 AC 1
Xs115_n_4 s115_n_4 0 adc_mim_bank COUNT=16
Vs115_n_5 s115_n_5 0 DC 0 AC 1
Xs115_n_5 s115_n_5 0 adc_mim_bank COUNT=32
Vs115_n_6 s115_n_6 0 DC 0 AC 1
Xs115_n_6 s115_n_6 0 adc_mim_bank COUNT=64
Vs115_n_7 s115_n_7 0 DC 0 AC 1
Xs115_n_7 s115_n_7 0 adc_mim_bank COUNT=128
Vs115_n_8 s115_n_8 0 DC 0 AC 1
Xs115_n_8 s115_n_8 0 adc_mim_bank COUNT=256
Vs115_n_9 s115_n_9 0 DC 0 AC 1
Xs115_n_9 s115_n_9 0 adc_mim_bank COUNT=512
Vs115_n_10 s115_n_10 0 DC 0 AC 1
Xs115_n_10 s115_n_10 0 adc_mim_bank COUNT=1024
Vs115_n_11 s115_n_11 0 DC 0 AC 1
Xs115_n_11 s115_n_11 0 adc_mim_bank COUNT=2048
Vs115_n_12 s115_n_12 0 DC 0 AC 1
Xs115_n_12 s115_n_12 0 adc_mim_bank COUNT=1
Vs116_p_0 s116_p_0 0 DC 0 AC 1
Xs116_p_0 s116_p_0 0 adc_mim_bank COUNT=1
Vs116_p_1 s116_p_1 0 DC 0 AC 1
Xs116_p_1 s116_p_1 0 adc_mim_bank COUNT=2
Vs116_p_2 s116_p_2 0 DC 0 AC 1
Xs116_p_2 s116_p_2 0 adc_mim_bank COUNT=4
Vs116_p_3 s116_p_3 0 DC 0 AC 1
Xs116_p_3 s116_p_3 0 adc_mim_bank COUNT=8
Vs116_p_4 s116_p_4 0 DC 0 AC 1
Xs116_p_4 s116_p_4 0 adc_mim_bank COUNT=16
Vs116_p_5 s116_p_5 0 DC 0 AC 1
Xs116_p_5 s116_p_5 0 adc_mim_bank COUNT=32
Vs116_p_6 s116_p_6 0 DC 0 AC 1
Xs116_p_6 s116_p_6 0 adc_mim_bank COUNT=64
Vs116_p_7 s116_p_7 0 DC 0 AC 1
Xs116_p_7 s116_p_7 0 adc_mim_bank COUNT=128
Vs116_p_8 s116_p_8 0 DC 0 AC 1
Xs116_p_8 s116_p_8 0 adc_mim_bank COUNT=256
Vs116_p_9 s116_p_9 0 DC 0 AC 1
Xs116_p_9 s116_p_9 0 adc_mim_bank COUNT=512
Vs116_p_10 s116_p_10 0 DC 0 AC 1
Xs116_p_10 s116_p_10 0 adc_mim_bank COUNT=1024
Vs116_p_11 s116_p_11 0 DC 0 AC 1
Xs116_p_11 s116_p_11 0 adc_mim_bank COUNT=2048
Vs116_p_12 s116_p_12 0 DC 0 AC 1
Xs116_p_12 s116_p_12 0 adc_mim_bank COUNT=1
Vs116_n_0 s116_n_0 0 DC 0 AC 1
Xs116_n_0 s116_n_0 0 adc_mim_bank COUNT=1
Vs116_n_1 s116_n_1 0 DC 0 AC 1
Xs116_n_1 s116_n_1 0 adc_mim_bank COUNT=2
Vs116_n_2 s116_n_2 0 DC 0 AC 1
Xs116_n_2 s116_n_2 0 adc_mim_bank COUNT=4
Vs116_n_3 s116_n_3 0 DC 0 AC 1
Xs116_n_3 s116_n_3 0 adc_mim_bank COUNT=8
Vs116_n_4 s116_n_4 0 DC 0 AC 1
Xs116_n_4 s116_n_4 0 adc_mim_bank COUNT=16
Vs116_n_5 s116_n_5 0 DC 0 AC 1
Xs116_n_5 s116_n_5 0 adc_mim_bank COUNT=32
Vs116_n_6 s116_n_6 0 DC 0 AC 1
Xs116_n_6 s116_n_6 0 adc_mim_bank COUNT=64
Vs116_n_7 s116_n_7 0 DC 0 AC 1
Xs116_n_7 s116_n_7 0 adc_mim_bank COUNT=128
Vs116_n_8 s116_n_8 0 DC 0 AC 1
Xs116_n_8 s116_n_8 0 adc_mim_bank COUNT=256
Vs116_n_9 s116_n_9 0 DC 0 AC 1
Xs116_n_9 s116_n_9 0 adc_mim_bank COUNT=512
Vs116_n_10 s116_n_10 0 DC 0 AC 1
Xs116_n_10 s116_n_10 0 adc_mim_bank COUNT=1024
Vs116_n_11 s116_n_11 0 DC 0 AC 1
Xs116_n_11 s116_n_11 0 adc_mim_bank COUNT=2048
Vs116_n_12 s116_n_12 0 DC 0 AC 1
Xs116_n_12 s116_n_12 0 adc_mim_bank COUNT=1
Vs117_p_0 s117_p_0 0 DC 0 AC 1
Xs117_p_0 s117_p_0 0 adc_mim_bank COUNT=1
Vs117_p_1 s117_p_1 0 DC 0 AC 1
Xs117_p_1 s117_p_1 0 adc_mim_bank COUNT=2
Vs117_p_2 s117_p_2 0 DC 0 AC 1
Xs117_p_2 s117_p_2 0 adc_mim_bank COUNT=4
Vs117_p_3 s117_p_3 0 DC 0 AC 1
Xs117_p_3 s117_p_3 0 adc_mim_bank COUNT=8
Vs117_p_4 s117_p_4 0 DC 0 AC 1
Xs117_p_4 s117_p_4 0 adc_mim_bank COUNT=16
Vs117_p_5 s117_p_5 0 DC 0 AC 1
Xs117_p_5 s117_p_5 0 adc_mim_bank COUNT=32
Vs117_p_6 s117_p_6 0 DC 0 AC 1
Xs117_p_6 s117_p_6 0 adc_mim_bank COUNT=64
Vs117_p_7 s117_p_7 0 DC 0 AC 1
Xs117_p_7 s117_p_7 0 adc_mim_bank COUNT=128
Vs117_p_8 s117_p_8 0 DC 0 AC 1
Xs117_p_8 s117_p_8 0 adc_mim_bank COUNT=256
Vs117_p_9 s117_p_9 0 DC 0 AC 1
Xs117_p_9 s117_p_9 0 adc_mim_bank COUNT=512
Vs117_p_10 s117_p_10 0 DC 0 AC 1
Xs117_p_10 s117_p_10 0 adc_mim_bank COUNT=1024
Vs117_p_11 s117_p_11 0 DC 0 AC 1
Xs117_p_11 s117_p_11 0 adc_mim_bank COUNT=2048
Vs117_p_12 s117_p_12 0 DC 0 AC 1
Xs117_p_12 s117_p_12 0 adc_mim_bank COUNT=1
Vs117_n_0 s117_n_0 0 DC 0 AC 1
Xs117_n_0 s117_n_0 0 adc_mim_bank COUNT=1
Vs117_n_1 s117_n_1 0 DC 0 AC 1
Xs117_n_1 s117_n_1 0 adc_mim_bank COUNT=2
Vs117_n_2 s117_n_2 0 DC 0 AC 1
Xs117_n_2 s117_n_2 0 adc_mim_bank COUNT=4
Vs117_n_3 s117_n_3 0 DC 0 AC 1
Xs117_n_3 s117_n_3 0 adc_mim_bank COUNT=8
Vs117_n_4 s117_n_4 0 DC 0 AC 1
Xs117_n_4 s117_n_4 0 adc_mim_bank COUNT=16
Vs117_n_5 s117_n_5 0 DC 0 AC 1
Xs117_n_5 s117_n_5 0 adc_mim_bank COUNT=32
Vs117_n_6 s117_n_6 0 DC 0 AC 1
Xs117_n_6 s117_n_6 0 adc_mim_bank COUNT=64
Vs117_n_7 s117_n_7 0 DC 0 AC 1
Xs117_n_7 s117_n_7 0 adc_mim_bank COUNT=128
Vs117_n_8 s117_n_8 0 DC 0 AC 1
Xs117_n_8 s117_n_8 0 adc_mim_bank COUNT=256
Vs117_n_9 s117_n_9 0 DC 0 AC 1
Xs117_n_9 s117_n_9 0 adc_mim_bank COUNT=512
Vs117_n_10 s117_n_10 0 DC 0 AC 1
Xs117_n_10 s117_n_10 0 adc_mim_bank COUNT=1024
Vs117_n_11 s117_n_11 0 DC 0 AC 1
Xs117_n_11 s117_n_11 0 adc_mim_bank COUNT=2048
Vs117_n_12 s117_n_12 0 DC 0 AC 1
Xs117_n_12 s117_n_12 0 adc_mim_bank COUNT=1
Vs118_p_0 s118_p_0 0 DC 0 AC 1
Xs118_p_0 s118_p_0 0 adc_mim_bank COUNT=1
Vs118_p_1 s118_p_1 0 DC 0 AC 1
Xs118_p_1 s118_p_1 0 adc_mim_bank COUNT=2
Vs118_p_2 s118_p_2 0 DC 0 AC 1
Xs118_p_2 s118_p_2 0 adc_mim_bank COUNT=4
Vs118_p_3 s118_p_3 0 DC 0 AC 1
Xs118_p_3 s118_p_3 0 adc_mim_bank COUNT=8
Vs118_p_4 s118_p_4 0 DC 0 AC 1
Xs118_p_4 s118_p_4 0 adc_mim_bank COUNT=16
Vs118_p_5 s118_p_5 0 DC 0 AC 1
Xs118_p_5 s118_p_5 0 adc_mim_bank COUNT=32
Vs118_p_6 s118_p_6 0 DC 0 AC 1
Xs118_p_6 s118_p_6 0 adc_mim_bank COUNT=64
Vs118_p_7 s118_p_7 0 DC 0 AC 1
Xs118_p_7 s118_p_7 0 adc_mim_bank COUNT=128
Vs118_p_8 s118_p_8 0 DC 0 AC 1
Xs118_p_8 s118_p_8 0 adc_mim_bank COUNT=256
Vs118_p_9 s118_p_9 0 DC 0 AC 1
Xs118_p_9 s118_p_9 0 adc_mim_bank COUNT=512
Vs118_p_10 s118_p_10 0 DC 0 AC 1
Xs118_p_10 s118_p_10 0 adc_mim_bank COUNT=1024
Vs118_p_11 s118_p_11 0 DC 0 AC 1
Xs118_p_11 s118_p_11 0 adc_mim_bank COUNT=2048
Vs118_p_12 s118_p_12 0 DC 0 AC 1
Xs118_p_12 s118_p_12 0 adc_mim_bank COUNT=1
Vs118_n_0 s118_n_0 0 DC 0 AC 1
Xs118_n_0 s118_n_0 0 adc_mim_bank COUNT=1
Vs118_n_1 s118_n_1 0 DC 0 AC 1
Xs118_n_1 s118_n_1 0 adc_mim_bank COUNT=2
Vs118_n_2 s118_n_2 0 DC 0 AC 1
Xs118_n_2 s118_n_2 0 adc_mim_bank COUNT=4
Vs118_n_3 s118_n_3 0 DC 0 AC 1
Xs118_n_3 s118_n_3 0 adc_mim_bank COUNT=8
Vs118_n_4 s118_n_4 0 DC 0 AC 1
Xs118_n_4 s118_n_4 0 adc_mim_bank COUNT=16
Vs118_n_5 s118_n_5 0 DC 0 AC 1
Xs118_n_5 s118_n_5 0 adc_mim_bank COUNT=32
Vs118_n_6 s118_n_6 0 DC 0 AC 1
Xs118_n_6 s118_n_6 0 adc_mim_bank COUNT=64
Vs118_n_7 s118_n_7 0 DC 0 AC 1
Xs118_n_7 s118_n_7 0 adc_mim_bank COUNT=128
Vs118_n_8 s118_n_8 0 DC 0 AC 1
Xs118_n_8 s118_n_8 0 adc_mim_bank COUNT=256
Vs118_n_9 s118_n_9 0 DC 0 AC 1
Xs118_n_9 s118_n_9 0 adc_mim_bank COUNT=512
Vs118_n_10 s118_n_10 0 DC 0 AC 1
Xs118_n_10 s118_n_10 0 adc_mim_bank COUNT=1024
Vs118_n_11 s118_n_11 0 DC 0 AC 1
Xs118_n_11 s118_n_11 0 adc_mim_bank COUNT=2048
Vs118_n_12 s118_n_12 0 DC 0 AC 1
Xs118_n_12 s118_n_12 0 adc_mim_bank COUNT=1
Vs119_p_0 s119_p_0 0 DC 0 AC 1
Xs119_p_0 s119_p_0 0 adc_mim_bank COUNT=1
Vs119_p_1 s119_p_1 0 DC 0 AC 1
Xs119_p_1 s119_p_1 0 adc_mim_bank COUNT=2
Vs119_p_2 s119_p_2 0 DC 0 AC 1
Xs119_p_2 s119_p_2 0 adc_mim_bank COUNT=4
Vs119_p_3 s119_p_3 0 DC 0 AC 1
Xs119_p_3 s119_p_3 0 adc_mim_bank COUNT=8
Vs119_p_4 s119_p_4 0 DC 0 AC 1
Xs119_p_4 s119_p_4 0 adc_mim_bank COUNT=16
Vs119_p_5 s119_p_5 0 DC 0 AC 1
Xs119_p_5 s119_p_5 0 adc_mim_bank COUNT=32
Vs119_p_6 s119_p_6 0 DC 0 AC 1
Xs119_p_6 s119_p_6 0 adc_mim_bank COUNT=64
Vs119_p_7 s119_p_7 0 DC 0 AC 1
Xs119_p_7 s119_p_7 0 adc_mim_bank COUNT=128
Vs119_p_8 s119_p_8 0 DC 0 AC 1
Xs119_p_8 s119_p_8 0 adc_mim_bank COUNT=256
Vs119_p_9 s119_p_9 0 DC 0 AC 1
Xs119_p_9 s119_p_9 0 adc_mim_bank COUNT=512
Vs119_p_10 s119_p_10 0 DC 0 AC 1
Xs119_p_10 s119_p_10 0 adc_mim_bank COUNT=1024
Vs119_p_11 s119_p_11 0 DC 0 AC 1
Xs119_p_11 s119_p_11 0 adc_mim_bank COUNT=2048
Vs119_p_12 s119_p_12 0 DC 0 AC 1
Xs119_p_12 s119_p_12 0 adc_mim_bank COUNT=1
Vs119_n_0 s119_n_0 0 DC 0 AC 1
Xs119_n_0 s119_n_0 0 adc_mim_bank COUNT=1
Vs119_n_1 s119_n_1 0 DC 0 AC 1
Xs119_n_1 s119_n_1 0 adc_mim_bank COUNT=2
Vs119_n_2 s119_n_2 0 DC 0 AC 1
Xs119_n_2 s119_n_2 0 adc_mim_bank COUNT=4
Vs119_n_3 s119_n_3 0 DC 0 AC 1
Xs119_n_3 s119_n_3 0 adc_mim_bank COUNT=8
Vs119_n_4 s119_n_4 0 DC 0 AC 1
Xs119_n_4 s119_n_4 0 adc_mim_bank COUNT=16
Vs119_n_5 s119_n_5 0 DC 0 AC 1
Xs119_n_5 s119_n_5 0 adc_mim_bank COUNT=32
Vs119_n_6 s119_n_6 0 DC 0 AC 1
Xs119_n_6 s119_n_6 0 adc_mim_bank COUNT=64
Vs119_n_7 s119_n_7 0 DC 0 AC 1
Xs119_n_7 s119_n_7 0 adc_mim_bank COUNT=128
Vs119_n_8 s119_n_8 0 DC 0 AC 1
Xs119_n_8 s119_n_8 0 adc_mim_bank COUNT=256
Vs119_n_9 s119_n_9 0 DC 0 AC 1
Xs119_n_9 s119_n_9 0 adc_mim_bank COUNT=512
Vs119_n_10 s119_n_10 0 DC 0 AC 1
Xs119_n_10 s119_n_10 0 adc_mim_bank COUNT=1024
Vs119_n_11 s119_n_11 0 DC 0 AC 1
Xs119_n_11 s119_n_11 0 adc_mim_bank COUNT=2048
Vs119_n_12 s119_n_12 0 DC 0 AC 1
Xs119_n_12 s119_n_12 0 adc_mim_bank COUNT=1
Vs120_p_0 s120_p_0 0 DC 0 AC 1
Xs120_p_0 s120_p_0 0 adc_mim_bank COUNT=1
Vs120_p_1 s120_p_1 0 DC 0 AC 1
Xs120_p_1 s120_p_1 0 adc_mim_bank COUNT=2
Vs120_p_2 s120_p_2 0 DC 0 AC 1
Xs120_p_2 s120_p_2 0 adc_mim_bank COUNT=4
Vs120_p_3 s120_p_3 0 DC 0 AC 1
Xs120_p_3 s120_p_3 0 adc_mim_bank COUNT=8
Vs120_p_4 s120_p_4 0 DC 0 AC 1
Xs120_p_4 s120_p_4 0 adc_mim_bank COUNT=16
Vs120_p_5 s120_p_5 0 DC 0 AC 1
Xs120_p_5 s120_p_5 0 adc_mim_bank COUNT=32
Vs120_p_6 s120_p_6 0 DC 0 AC 1
Xs120_p_6 s120_p_6 0 adc_mim_bank COUNT=64
Vs120_p_7 s120_p_7 0 DC 0 AC 1
Xs120_p_7 s120_p_7 0 adc_mim_bank COUNT=128
Vs120_p_8 s120_p_8 0 DC 0 AC 1
Xs120_p_8 s120_p_8 0 adc_mim_bank COUNT=256
Vs120_p_9 s120_p_9 0 DC 0 AC 1
Xs120_p_9 s120_p_9 0 adc_mim_bank COUNT=512
Vs120_p_10 s120_p_10 0 DC 0 AC 1
Xs120_p_10 s120_p_10 0 adc_mim_bank COUNT=1024
Vs120_p_11 s120_p_11 0 DC 0 AC 1
Xs120_p_11 s120_p_11 0 adc_mim_bank COUNT=2048
Vs120_p_12 s120_p_12 0 DC 0 AC 1
Xs120_p_12 s120_p_12 0 adc_mim_bank COUNT=1
Vs120_n_0 s120_n_0 0 DC 0 AC 1
Xs120_n_0 s120_n_0 0 adc_mim_bank COUNT=1
Vs120_n_1 s120_n_1 0 DC 0 AC 1
Xs120_n_1 s120_n_1 0 adc_mim_bank COUNT=2
Vs120_n_2 s120_n_2 0 DC 0 AC 1
Xs120_n_2 s120_n_2 0 adc_mim_bank COUNT=4
Vs120_n_3 s120_n_3 0 DC 0 AC 1
Xs120_n_3 s120_n_3 0 adc_mim_bank COUNT=8
Vs120_n_4 s120_n_4 0 DC 0 AC 1
Xs120_n_4 s120_n_4 0 adc_mim_bank COUNT=16
Vs120_n_5 s120_n_5 0 DC 0 AC 1
Xs120_n_5 s120_n_5 0 adc_mim_bank COUNT=32
Vs120_n_6 s120_n_6 0 DC 0 AC 1
Xs120_n_6 s120_n_6 0 adc_mim_bank COUNT=64
Vs120_n_7 s120_n_7 0 DC 0 AC 1
Xs120_n_7 s120_n_7 0 adc_mim_bank COUNT=128
Vs120_n_8 s120_n_8 0 DC 0 AC 1
Xs120_n_8 s120_n_8 0 adc_mim_bank COUNT=256
Vs120_n_9 s120_n_9 0 DC 0 AC 1
Xs120_n_9 s120_n_9 0 adc_mim_bank COUNT=512
Vs120_n_10 s120_n_10 0 DC 0 AC 1
Xs120_n_10 s120_n_10 0 adc_mim_bank COUNT=1024
Vs120_n_11 s120_n_11 0 DC 0 AC 1
Xs120_n_11 s120_n_11 0 adc_mim_bank COUNT=2048
Vs120_n_12 s120_n_12 0 DC 0 AC 1
Xs120_n_12 s120_n_12 0 adc_mim_bank COUNT=1
Vs121_p_0 s121_p_0 0 DC 0 AC 1
Xs121_p_0 s121_p_0 0 adc_mim_bank COUNT=1
Vs121_p_1 s121_p_1 0 DC 0 AC 1
Xs121_p_1 s121_p_1 0 adc_mim_bank COUNT=2
Vs121_p_2 s121_p_2 0 DC 0 AC 1
Xs121_p_2 s121_p_2 0 adc_mim_bank COUNT=4
Vs121_p_3 s121_p_3 0 DC 0 AC 1
Xs121_p_3 s121_p_3 0 adc_mim_bank COUNT=8
Vs121_p_4 s121_p_4 0 DC 0 AC 1
Xs121_p_4 s121_p_4 0 adc_mim_bank COUNT=16
Vs121_p_5 s121_p_5 0 DC 0 AC 1
Xs121_p_5 s121_p_5 0 adc_mim_bank COUNT=32
Vs121_p_6 s121_p_6 0 DC 0 AC 1
Xs121_p_6 s121_p_6 0 adc_mim_bank COUNT=64
Vs121_p_7 s121_p_7 0 DC 0 AC 1
Xs121_p_7 s121_p_7 0 adc_mim_bank COUNT=128
Vs121_p_8 s121_p_8 0 DC 0 AC 1
Xs121_p_8 s121_p_8 0 adc_mim_bank COUNT=256
Vs121_p_9 s121_p_9 0 DC 0 AC 1
Xs121_p_9 s121_p_9 0 adc_mim_bank COUNT=512
Vs121_p_10 s121_p_10 0 DC 0 AC 1
Xs121_p_10 s121_p_10 0 adc_mim_bank COUNT=1024
Vs121_p_11 s121_p_11 0 DC 0 AC 1
Xs121_p_11 s121_p_11 0 adc_mim_bank COUNT=2048
Vs121_p_12 s121_p_12 0 DC 0 AC 1
Xs121_p_12 s121_p_12 0 adc_mim_bank COUNT=1
Vs121_n_0 s121_n_0 0 DC 0 AC 1
Xs121_n_0 s121_n_0 0 adc_mim_bank COUNT=1
Vs121_n_1 s121_n_1 0 DC 0 AC 1
Xs121_n_1 s121_n_1 0 adc_mim_bank COUNT=2
Vs121_n_2 s121_n_2 0 DC 0 AC 1
Xs121_n_2 s121_n_2 0 adc_mim_bank COUNT=4
Vs121_n_3 s121_n_3 0 DC 0 AC 1
Xs121_n_3 s121_n_3 0 adc_mim_bank COUNT=8
Vs121_n_4 s121_n_4 0 DC 0 AC 1
Xs121_n_4 s121_n_4 0 adc_mim_bank COUNT=16
Vs121_n_5 s121_n_5 0 DC 0 AC 1
Xs121_n_5 s121_n_5 0 adc_mim_bank COUNT=32
Vs121_n_6 s121_n_6 0 DC 0 AC 1
Xs121_n_6 s121_n_6 0 adc_mim_bank COUNT=64
Vs121_n_7 s121_n_7 0 DC 0 AC 1
Xs121_n_7 s121_n_7 0 adc_mim_bank COUNT=128
Vs121_n_8 s121_n_8 0 DC 0 AC 1
Xs121_n_8 s121_n_8 0 adc_mim_bank COUNT=256
Vs121_n_9 s121_n_9 0 DC 0 AC 1
Xs121_n_9 s121_n_9 0 adc_mim_bank COUNT=512
Vs121_n_10 s121_n_10 0 DC 0 AC 1
Xs121_n_10 s121_n_10 0 adc_mim_bank COUNT=1024
Vs121_n_11 s121_n_11 0 DC 0 AC 1
Xs121_n_11 s121_n_11 0 adc_mim_bank COUNT=2048
Vs121_n_12 s121_n_12 0 DC 0 AC 1
Xs121_n_12 s121_n_12 0 adc_mim_bank COUNT=1
Vs122_p_0 s122_p_0 0 DC 0 AC 1
Xs122_p_0 s122_p_0 0 adc_mim_bank COUNT=1
Vs122_p_1 s122_p_1 0 DC 0 AC 1
Xs122_p_1 s122_p_1 0 adc_mim_bank COUNT=2
Vs122_p_2 s122_p_2 0 DC 0 AC 1
Xs122_p_2 s122_p_2 0 adc_mim_bank COUNT=4
Vs122_p_3 s122_p_3 0 DC 0 AC 1
Xs122_p_3 s122_p_3 0 adc_mim_bank COUNT=8
Vs122_p_4 s122_p_4 0 DC 0 AC 1
Xs122_p_4 s122_p_4 0 adc_mim_bank COUNT=16
Vs122_p_5 s122_p_5 0 DC 0 AC 1
Xs122_p_5 s122_p_5 0 adc_mim_bank COUNT=32
Vs122_p_6 s122_p_6 0 DC 0 AC 1
Xs122_p_6 s122_p_6 0 adc_mim_bank COUNT=64
Vs122_p_7 s122_p_7 0 DC 0 AC 1
Xs122_p_7 s122_p_7 0 adc_mim_bank COUNT=128
Vs122_p_8 s122_p_8 0 DC 0 AC 1
Xs122_p_8 s122_p_8 0 adc_mim_bank COUNT=256
Vs122_p_9 s122_p_9 0 DC 0 AC 1
Xs122_p_9 s122_p_9 0 adc_mim_bank COUNT=512
Vs122_p_10 s122_p_10 0 DC 0 AC 1
Xs122_p_10 s122_p_10 0 adc_mim_bank COUNT=1024
Vs122_p_11 s122_p_11 0 DC 0 AC 1
Xs122_p_11 s122_p_11 0 adc_mim_bank COUNT=2048
Vs122_p_12 s122_p_12 0 DC 0 AC 1
Xs122_p_12 s122_p_12 0 adc_mim_bank COUNT=1
Vs122_n_0 s122_n_0 0 DC 0 AC 1
Xs122_n_0 s122_n_0 0 adc_mim_bank COUNT=1
Vs122_n_1 s122_n_1 0 DC 0 AC 1
Xs122_n_1 s122_n_1 0 adc_mim_bank COUNT=2
Vs122_n_2 s122_n_2 0 DC 0 AC 1
Xs122_n_2 s122_n_2 0 adc_mim_bank COUNT=4
Vs122_n_3 s122_n_3 0 DC 0 AC 1
Xs122_n_3 s122_n_3 0 adc_mim_bank COUNT=8
Vs122_n_4 s122_n_4 0 DC 0 AC 1
Xs122_n_4 s122_n_4 0 adc_mim_bank COUNT=16
Vs122_n_5 s122_n_5 0 DC 0 AC 1
Xs122_n_5 s122_n_5 0 adc_mim_bank COUNT=32
Vs122_n_6 s122_n_6 0 DC 0 AC 1
Xs122_n_6 s122_n_6 0 adc_mim_bank COUNT=64
Vs122_n_7 s122_n_7 0 DC 0 AC 1
Xs122_n_7 s122_n_7 0 adc_mim_bank COUNT=128
Vs122_n_8 s122_n_8 0 DC 0 AC 1
Xs122_n_8 s122_n_8 0 adc_mim_bank COUNT=256
Vs122_n_9 s122_n_9 0 DC 0 AC 1
Xs122_n_9 s122_n_9 0 adc_mim_bank COUNT=512
Vs122_n_10 s122_n_10 0 DC 0 AC 1
Xs122_n_10 s122_n_10 0 adc_mim_bank COUNT=1024
Vs122_n_11 s122_n_11 0 DC 0 AC 1
Xs122_n_11 s122_n_11 0 adc_mim_bank COUNT=2048
Vs122_n_12 s122_n_12 0 DC 0 AC 1
Xs122_n_12 s122_n_12 0 adc_mim_bank COUNT=1
Vs123_p_0 s123_p_0 0 DC 0 AC 1
Xs123_p_0 s123_p_0 0 adc_mim_bank COUNT=1
Vs123_p_1 s123_p_1 0 DC 0 AC 1
Xs123_p_1 s123_p_1 0 adc_mim_bank COUNT=2
Vs123_p_2 s123_p_2 0 DC 0 AC 1
Xs123_p_2 s123_p_2 0 adc_mim_bank COUNT=4
Vs123_p_3 s123_p_3 0 DC 0 AC 1
Xs123_p_3 s123_p_3 0 adc_mim_bank COUNT=8
Vs123_p_4 s123_p_4 0 DC 0 AC 1
Xs123_p_4 s123_p_4 0 adc_mim_bank COUNT=16
Vs123_p_5 s123_p_5 0 DC 0 AC 1
Xs123_p_5 s123_p_5 0 adc_mim_bank COUNT=32
Vs123_p_6 s123_p_6 0 DC 0 AC 1
Xs123_p_6 s123_p_6 0 adc_mim_bank COUNT=64
Vs123_p_7 s123_p_7 0 DC 0 AC 1
Xs123_p_7 s123_p_7 0 adc_mim_bank COUNT=128
Vs123_p_8 s123_p_8 0 DC 0 AC 1
Xs123_p_8 s123_p_8 0 adc_mim_bank COUNT=256
Vs123_p_9 s123_p_9 0 DC 0 AC 1
Xs123_p_9 s123_p_9 0 adc_mim_bank COUNT=512
Vs123_p_10 s123_p_10 0 DC 0 AC 1
Xs123_p_10 s123_p_10 0 adc_mim_bank COUNT=1024
Vs123_p_11 s123_p_11 0 DC 0 AC 1
Xs123_p_11 s123_p_11 0 adc_mim_bank COUNT=2048
Vs123_p_12 s123_p_12 0 DC 0 AC 1
Xs123_p_12 s123_p_12 0 adc_mim_bank COUNT=1
Vs123_n_0 s123_n_0 0 DC 0 AC 1
Xs123_n_0 s123_n_0 0 adc_mim_bank COUNT=1
Vs123_n_1 s123_n_1 0 DC 0 AC 1
Xs123_n_1 s123_n_1 0 adc_mim_bank COUNT=2
Vs123_n_2 s123_n_2 0 DC 0 AC 1
Xs123_n_2 s123_n_2 0 adc_mim_bank COUNT=4
Vs123_n_3 s123_n_3 0 DC 0 AC 1
Xs123_n_3 s123_n_3 0 adc_mim_bank COUNT=8
Vs123_n_4 s123_n_4 0 DC 0 AC 1
Xs123_n_4 s123_n_4 0 adc_mim_bank COUNT=16
Vs123_n_5 s123_n_5 0 DC 0 AC 1
Xs123_n_5 s123_n_5 0 adc_mim_bank COUNT=32
Vs123_n_6 s123_n_6 0 DC 0 AC 1
Xs123_n_6 s123_n_6 0 adc_mim_bank COUNT=64
Vs123_n_7 s123_n_7 0 DC 0 AC 1
Xs123_n_7 s123_n_7 0 adc_mim_bank COUNT=128
Vs123_n_8 s123_n_8 0 DC 0 AC 1
Xs123_n_8 s123_n_8 0 adc_mim_bank COUNT=256
Vs123_n_9 s123_n_9 0 DC 0 AC 1
Xs123_n_9 s123_n_9 0 adc_mim_bank COUNT=512
Vs123_n_10 s123_n_10 0 DC 0 AC 1
Xs123_n_10 s123_n_10 0 adc_mim_bank COUNT=1024
Vs123_n_11 s123_n_11 0 DC 0 AC 1
Xs123_n_11 s123_n_11 0 adc_mim_bank COUNT=2048
Vs123_n_12 s123_n_12 0 DC 0 AC 1
Xs123_n_12 s123_n_12 0 adc_mim_bank COUNT=1
Vs124_p_0 s124_p_0 0 DC 0 AC 1
Xs124_p_0 s124_p_0 0 adc_mim_bank COUNT=1
Vs124_p_1 s124_p_1 0 DC 0 AC 1
Xs124_p_1 s124_p_1 0 adc_mim_bank COUNT=2
Vs124_p_2 s124_p_2 0 DC 0 AC 1
Xs124_p_2 s124_p_2 0 adc_mim_bank COUNT=4
Vs124_p_3 s124_p_3 0 DC 0 AC 1
Xs124_p_3 s124_p_3 0 adc_mim_bank COUNT=8
Vs124_p_4 s124_p_4 0 DC 0 AC 1
Xs124_p_4 s124_p_4 0 adc_mim_bank COUNT=16
Vs124_p_5 s124_p_5 0 DC 0 AC 1
Xs124_p_5 s124_p_5 0 adc_mim_bank COUNT=32
Vs124_p_6 s124_p_6 0 DC 0 AC 1
Xs124_p_6 s124_p_6 0 adc_mim_bank COUNT=64
Vs124_p_7 s124_p_7 0 DC 0 AC 1
Xs124_p_7 s124_p_7 0 adc_mim_bank COUNT=128
Vs124_p_8 s124_p_8 0 DC 0 AC 1
Xs124_p_8 s124_p_8 0 adc_mim_bank COUNT=256
Vs124_p_9 s124_p_9 0 DC 0 AC 1
Xs124_p_9 s124_p_9 0 adc_mim_bank COUNT=512
Vs124_p_10 s124_p_10 0 DC 0 AC 1
Xs124_p_10 s124_p_10 0 adc_mim_bank COUNT=1024
Vs124_p_11 s124_p_11 0 DC 0 AC 1
Xs124_p_11 s124_p_11 0 adc_mim_bank COUNT=2048
Vs124_p_12 s124_p_12 0 DC 0 AC 1
Xs124_p_12 s124_p_12 0 adc_mim_bank COUNT=1
Vs124_n_0 s124_n_0 0 DC 0 AC 1
Xs124_n_0 s124_n_0 0 adc_mim_bank COUNT=1
Vs124_n_1 s124_n_1 0 DC 0 AC 1
Xs124_n_1 s124_n_1 0 adc_mim_bank COUNT=2
Vs124_n_2 s124_n_2 0 DC 0 AC 1
Xs124_n_2 s124_n_2 0 adc_mim_bank COUNT=4
Vs124_n_3 s124_n_3 0 DC 0 AC 1
Xs124_n_3 s124_n_3 0 adc_mim_bank COUNT=8
Vs124_n_4 s124_n_4 0 DC 0 AC 1
Xs124_n_4 s124_n_4 0 adc_mim_bank COUNT=16
Vs124_n_5 s124_n_5 0 DC 0 AC 1
Xs124_n_5 s124_n_5 0 adc_mim_bank COUNT=32
Vs124_n_6 s124_n_6 0 DC 0 AC 1
Xs124_n_6 s124_n_6 0 adc_mim_bank COUNT=64
Vs124_n_7 s124_n_7 0 DC 0 AC 1
Xs124_n_7 s124_n_7 0 adc_mim_bank COUNT=128
Vs124_n_8 s124_n_8 0 DC 0 AC 1
Xs124_n_8 s124_n_8 0 adc_mim_bank COUNT=256
Vs124_n_9 s124_n_9 0 DC 0 AC 1
Xs124_n_9 s124_n_9 0 adc_mim_bank COUNT=512
Vs124_n_10 s124_n_10 0 DC 0 AC 1
Xs124_n_10 s124_n_10 0 adc_mim_bank COUNT=1024
Vs124_n_11 s124_n_11 0 DC 0 AC 1
Xs124_n_11 s124_n_11 0 adc_mim_bank COUNT=2048
Vs124_n_12 s124_n_12 0 DC 0 AC 1
Xs124_n_12 s124_n_12 0 adc_mim_bank COUNT=1
Vs125_p_0 s125_p_0 0 DC 0 AC 1
Xs125_p_0 s125_p_0 0 adc_mim_bank COUNT=1
Vs125_p_1 s125_p_1 0 DC 0 AC 1
Xs125_p_1 s125_p_1 0 adc_mim_bank COUNT=2
Vs125_p_2 s125_p_2 0 DC 0 AC 1
Xs125_p_2 s125_p_2 0 adc_mim_bank COUNT=4
Vs125_p_3 s125_p_3 0 DC 0 AC 1
Xs125_p_3 s125_p_3 0 adc_mim_bank COUNT=8
Vs125_p_4 s125_p_4 0 DC 0 AC 1
Xs125_p_4 s125_p_4 0 adc_mim_bank COUNT=16
Vs125_p_5 s125_p_5 0 DC 0 AC 1
Xs125_p_5 s125_p_5 0 adc_mim_bank COUNT=32
Vs125_p_6 s125_p_6 0 DC 0 AC 1
Xs125_p_6 s125_p_6 0 adc_mim_bank COUNT=64
Vs125_p_7 s125_p_7 0 DC 0 AC 1
Xs125_p_7 s125_p_7 0 adc_mim_bank COUNT=128
Vs125_p_8 s125_p_8 0 DC 0 AC 1
Xs125_p_8 s125_p_8 0 adc_mim_bank COUNT=256
Vs125_p_9 s125_p_9 0 DC 0 AC 1
Xs125_p_9 s125_p_9 0 adc_mim_bank COUNT=512
Vs125_p_10 s125_p_10 0 DC 0 AC 1
Xs125_p_10 s125_p_10 0 adc_mim_bank COUNT=1024
Vs125_p_11 s125_p_11 0 DC 0 AC 1
Xs125_p_11 s125_p_11 0 adc_mim_bank COUNT=2048
Vs125_p_12 s125_p_12 0 DC 0 AC 1
Xs125_p_12 s125_p_12 0 adc_mim_bank COUNT=1
Vs125_n_0 s125_n_0 0 DC 0 AC 1
Xs125_n_0 s125_n_0 0 adc_mim_bank COUNT=1
Vs125_n_1 s125_n_1 0 DC 0 AC 1
Xs125_n_1 s125_n_1 0 adc_mim_bank COUNT=2
Vs125_n_2 s125_n_2 0 DC 0 AC 1
Xs125_n_2 s125_n_2 0 adc_mim_bank COUNT=4
Vs125_n_3 s125_n_3 0 DC 0 AC 1
Xs125_n_3 s125_n_3 0 adc_mim_bank COUNT=8
Vs125_n_4 s125_n_4 0 DC 0 AC 1
Xs125_n_4 s125_n_4 0 adc_mim_bank COUNT=16
Vs125_n_5 s125_n_5 0 DC 0 AC 1
Xs125_n_5 s125_n_5 0 adc_mim_bank COUNT=32
Vs125_n_6 s125_n_6 0 DC 0 AC 1
Xs125_n_6 s125_n_6 0 adc_mim_bank COUNT=64
Vs125_n_7 s125_n_7 0 DC 0 AC 1
Xs125_n_7 s125_n_7 0 adc_mim_bank COUNT=128
Vs125_n_8 s125_n_8 0 DC 0 AC 1
Xs125_n_8 s125_n_8 0 adc_mim_bank COUNT=256
Vs125_n_9 s125_n_9 0 DC 0 AC 1
Xs125_n_9 s125_n_9 0 adc_mim_bank COUNT=512
Vs125_n_10 s125_n_10 0 DC 0 AC 1
Xs125_n_10 s125_n_10 0 adc_mim_bank COUNT=1024
Vs125_n_11 s125_n_11 0 DC 0 AC 1
Xs125_n_11 s125_n_11 0 adc_mim_bank COUNT=2048
Vs125_n_12 s125_n_12 0 DC 0 AC 1
Xs125_n_12 s125_n_12 0 adc_mim_bank COUNT=1
Vs126_p_0 s126_p_0 0 DC 0 AC 1
Xs126_p_0 s126_p_0 0 adc_mim_bank COUNT=1
Vs126_p_1 s126_p_1 0 DC 0 AC 1
Xs126_p_1 s126_p_1 0 adc_mim_bank COUNT=2
Vs126_p_2 s126_p_2 0 DC 0 AC 1
Xs126_p_2 s126_p_2 0 adc_mim_bank COUNT=4
Vs126_p_3 s126_p_3 0 DC 0 AC 1
Xs126_p_3 s126_p_3 0 adc_mim_bank COUNT=8
Vs126_p_4 s126_p_4 0 DC 0 AC 1
Xs126_p_4 s126_p_4 0 adc_mim_bank COUNT=16
Vs126_p_5 s126_p_5 0 DC 0 AC 1
Xs126_p_5 s126_p_5 0 adc_mim_bank COUNT=32
Vs126_p_6 s126_p_6 0 DC 0 AC 1
Xs126_p_6 s126_p_6 0 adc_mim_bank COUNT=64
Vs126_p_7 s126_p_7 0 DC 0 AC 1
Xs126_p_7 s126_p_7 0 adc_mim_bank COUNT=128
Vs126_p_8 s126_p_8 0 DC 0 AC 1
Xs126_p_8 s126_p_8 0 adc_mim_bank COUNT=256
Vs126_p_9 s126_p_9 0 DC 0 AC 1
Xs126_p_9 s126_p_9 0 adc_mim_bank COUNT=512
Vs126_p_10 s126_p_10 0 DC 0 AC 1
Xs126_p_10 s126_p_10 0 adc_mim_bank COUNT=1024
Vs126_p_11 s126_p_11 0 DC 0 AC 1
Xs126_p_11 s126_p_11 0 adc_mim_bank COUNT=2048
Vs126_p_12 s126_p_12 0 DC 0 AC 1
Xs126_p_12 s126_p_12 0 adc_mim_bank COUNT=1
Vs126_n_0 s126_n_0 0 DC 0 AC 1
Xs126_n_0 s126_n_0 0 adc_mim_bank COUNT=1
Vs126_n_1 s126_n_1 0 DC 0 AC 1
Xs126_n_1 s126_n_1 0 adc_mim_bank COUNT=2
Vs126_n_2 s126_n_2 0 DC 0 AC 1
Xs126_n_2 s126_n_2 0 adc_mim_bank COUNT=4
Vs126_n_3 s126_n_3 0 DC 0 AC 1
Xs126_n_3 s126_n_3 0 adc_mim_bank COUNT=8
Vs126_n_4 s126_n_4 0 DC 0 AC 1
Xs126_n_4 s126_n_4 0 adc_mim_bank COUNT=16
Vs126_n_5 s126_n_5 0 DC 0 AC 1
Xs126_n_5 s126_n_5 0 adc_mim_bank COUNT=32
Vs126_n_6 s126_n_6 0 DC 0 AC 1
Xs126_n_6 s126_n_6 0 adc_mim_bank COUNT=64
Vs126_n_7 s126_n_7 0 DC 0 AC 1
Xs126_n_7 s126_n_7 0 adc_mim_bank COUNT=128
Vs126_n_8 s126_n_8 0 DC 0 AC 1
Xs126_n_8 s126_n_8 0 adc_mim_bank COUNT=256
Vs126_n_9 s126_n_9 0 DC 0 AC 1
Xs126_n_9 s126_n_9 0 adc_mim_bank COUNT=512
Vs126_n_10 s126_n_10 0 DC 0 AC 1
Xs126_n_10 s126_n_10 0 adc_mim_bank COUNT=1024
Vs126_n_11 s126_n_11 0 DC 0 AC 1
Xs126_n_11 s126_n_11 0 adc_mim_bank COUNT=2048
Vs126_n_12 s126_n_12 0 DC 0 AC 1
Xs126_n_12 s126_n_12 0 adc_mim_bank COUNT=1
Vs127_p_0 s127_p_0 0 DC 0 AC 1
Xs127_p_0 s127_p_0 0 adc_mim_bank COUNT=1
Vs127_p_1 s127_p_1 0 DC 0 AC 1
Xs127_p_1 s127_p_1 0 adc_mim_bank COUNT=2
Vs127_p_2 s127_p_2 0 DC 0 AC 1
Xs127_p_2 s127_p_2 0 adc_mim_bank COUNT=4
Vs127_p_3 s127_p_3 0 DC 0 AC 1
Xs127_p_3 s127_p_3 0 adc_mim_bank COUNT=8
Vs127_p_4 s127_p_4 0 DC 0 AC 1
Xs127_p_4 s127_p_4 0 adc_mim_bank COUNT=16
Vs127_p_5 s127_p_5 0 DC 0 AC 1
Xs127_p_5 s127_p_5 0 adc_mim_bank COUNT=32
Vs127_p_6 s127_p_6 0 DC 0 AC 1
Xs127_p_6 s127_p_6 0 adc_mim_bank COUNT=64
Vs127_p_7 s127_p_7 0 DC 0 AC 1
Xs127_p_7 s127_p_7 0 adc_mim_bank COUNT=128
Vs127_p_8 s127_p_8 0 DC 0 AC 1
Xs127_p_8 s127_p_8 0 adc_mim_bank COUNT=256
Vs127_p_9 s127_p_9 0 DC 0 AC 1
Xs127_p_9 s127_p_9 0 adc_mim_bank COUNT=512
Vs127_p_10 s127_p_10 0 DC 0 AC 1
Xs127_p_10 s127_p_10 0 adc_mim_bank COUNT=1024
Vs127_p_11 s127_p_11 0 DC 0 AC 1
Xs127_p_11 s127_p_11 0 adc_mim_bank COUNT=2048
Vs127_p_12 s127_p_12 0 DC 0 AC 1
Xs127_p_12 s127_p_12 0 adc_mim_bank COUNT=1
Vs127_n_0 s127_n_0 0 DC 0 AC 1
Xs127_n_0 s127_n_0 0 adc_mim_bank COUNT=1
Vs127_n_1 s127_n_1 0 DC 0 AC 1
Xs127_n_1 s127_n_1 0 adc_mim_bank COUNT=2
Vs127_n_2 s127_n_2 0 DC 0 AC 1
Xs127_n_2 s127_n_2 0 adc_mim_bank COUNT=4
Vs127_n_3 s127_n_3 0 DC 0 AC 1
Xs127_n_3 s127_n_3 0 adc_mim_bank COUNT=8
Vs127_n_4 s127_n_4 0 DC 0 AC 1
Xs127_n_4 s127_n_4 0 adc_mim_bank COUNT=16
Vs127_n_5 s127_n_5 0 DC 0 AC 1
Xs127_n_5 s127_n_5 0 adc_mim_bank COUNT=32
Vs127_n_6 s127_n_6 0 DC 0 AC 1
Xs127_n_6 s127_n_6 0 adc_mim_bank COUNT=64
Vs127_n_7 s127_n_7 0 DC 0 AC 1
Xs127_n_7 s127_n_7 0 adc_mim_bank COUNT=128
Vs127_n_8 s127_n_8 0 DC 0 AC 1
Xs127_n_8 s127_n_8 0 adc_mim_bank COUNT=256
Vs127_n_9 s127_n_9 0 DC 0 AC 1
Xs127_n_9 s127_n_9 0 adc_mim_bank COUNT=512
Vs127_n_10 s127_n_10 0 DC 0 AC 1
Xs127_n_10 s127_n_10 0 adc_mim_bank COUNT=1024
Vs127_n_11 s127_n_11 0 DC 0 AC 1
Xs127_n_11 s127_n_11 0 adc_mim_bank COUNT=2048
Vs127_n_12 s127_n_12 0 DC 0 AC 1
Xs127_n_12 s127_n_12 0 adc_mim_bank COUNT=1
Vs128_p_0 s128_p_0 0 DC 0 AC 1
Xs128_p_0 s128_p_0 0 adc_mim_bank COUNT=1
Vs128_p_1 s128_p_1 0 DC 0 AC 1
Xs128_p_1 s128_p_1 0 adc_mim_bank COUNT=2
Vs128_p_2 s128_p_2 0 DC 0 AC 1
Xs128_p_2 s128_p_2 0 adc_mim_bank COUNT=4
Vs128_p_3 s128_p_3 0 DC 0 AC 1
Xs128_p_3 s128_p_3 0 adc_mim_bank COUNT=8
Vs128_p_4 s128_p_4 0 DC 0 AC 1
Xs128_p_4 s128_p_4 0 adc_mim_bank COUNT=16
Vs128_p_5 s128_p_5 0 DC 0 AC 1
Xs128_p_5 s128_p_5 0 adc_mim_bank COUNT=32
Vs128_p_6 s128_p_6 0 DC 0 AC 1
Xs128_p_6 s128_p_6 0 adc_mim_bank COUNT=64
Vs128_p_7 s128_p_7 0 DC 0 AC 1
Xs128_p_7 s128_p_7 0 adc_mim_bank COUNT=128
Vs128_p_8 s128_p_8 0 DC 0 AC 1
Xs128_p_8 s128_p_8 0 adc_mim_bank COUNT=256
Vs128_p_9 s128_p_9 0 DC 0 AC 1
Xs128_p_9 s128_p_9 0 adc_mim_bank COUNT=512
Vs128_p_10 s128_p_10 0 DC 0 AC 1
Xs128_p_10 s128_p_10 0 adc_mim_bank COUNT=1024
Vs128_p_11 s128_p_11 0 DC 0 AC 1
Xs128_p_11 s128_p_11 0 adc_mim_bank COUNT=2048
Vs128_p_12 s128_p_12 0 DC 0 AC 1
Xs128_p_12 s128_p_12 0 adc_mim_bank COUNT=1
Vs128_n_0 s128_n_0 0 DC 0 AC 1
Xs128_n_0 s128_n_0 0 adc_mim_bank COUNT=1
Vs128_n_1 s128_n_1 0 DC 0 AC 1
Xs128_n_1 s128_n_1 0 adc_mim_bank COUNT=2
Vs128_n_2 s128_n_2 0 DC 0 AC 1
Xs128_n_2 s128_n_2 0 adc_mim_bank COUNT=4
Vs128_n_3 s128_n_3 0 DC 0 AC 1
Xs128_n_3 s128_n_3 0 adc_mim_bank COUNT=8
Vs128_n_4 s128_n_4 0 DC 0 AC 1
Xs128_n_4 s128_n_4 0 adc_mim_bank COUNT=16
Vs128_n_5 s128_n_5 0 DC 0 AC 1
Xs128_n_5 s128_n_5 0 adc_mim_bank COUNT=32
Vs128_n_6 s128_n_6 0 DC 0 AC 1
Xs128_n_6 s128_n_6 0 adc_mim_bank COUNT=64
Vs128_n_7 s128_n_7 0 DC 0 AC 1
Xs128_n_7 s128_n_7 0 adc_mim_bank COUNT=128
Vs128_n_8 s128_n_8 0 DC 0 AC 1
Xs128_n_8 s128_n_8 0 adc_mim_bank COUNT=256
Vs128_n_9 s128_n_9 0 DC 0 AC 1
Xs128_n_9 s128_n_9 0 adc_mim_bank COUNT=512
Vs128_n_10 s128_n_10 0 DC 0 AC 1
Xs128_n_10 s128_n_10 0 adc_mim_bank COUNT=1024
Vs128_n_11 s128_n_11 0 DC 0 AC 1
Xs128_n_11 s128_n_11 0 adc_mim_bank COUNT=2048
Vs128_n_12 s128_n_12 0 DC 0 AC 1
Xs128_n_12 s128_n_12 0 adc_mim_bank COUNT=1
Vs129_p_0 s129_p_0 0 DC 0 AC 1
Xs129_p_0 s129_p_0 0 adc_mim_bank COUNT=1
Vs129_p_1 s129_p_1 0 DC 0 AC 1
Xs129_p_1 s129_p_1 0 adc_mim_bank COUNT=2
Vs129_p_2 s129_p_2 0 DC 0 AC 1
Xs129_p_2 s129_p_2 0 adc_mim_bank COUNT=4
Vs129_p_3 s129_p_3 0 DC 0 AC 1
Xs129_p_3 s129_p_3 0 adc_mim_bank COUNT=8
Vs129_p_4 s129_p_4 0 DC 0 AC 1
Xs129_p_4 s129_p_4 0 adc_mim_bank COUNT=16
Vs129_p_5 s129_p_5 0 DC 0 AC 1
Xs129_p_5 s129_p_5 0 adc_mim_bank COUNT=32
Vs129_p_6 s129_p_6 0 DC 0 AC 1
Xs129_p_6 s129_p_6 0 adc_mim_bank COUNT=64
Vs129_p_7 s129_p_7 0 DC 0 AC 1
Xs129_p_7 s129_p_7 0 adc_mim_bank COUNT=128
Vs129_p_8 s129_p_8 0 DC 0 AC 1
Xs129_p_8 s129_p_8 0 adc_mim_bank COUNT=256
Vs129_p_9 s129_p_9 0 DC 0 AC 1
Xs129_p_9 s129_p_9 0 adc_mim_bank COUNT=512
Vs129_p_10 s129_p_10 0 DC 0 AC 1
Xs129_p_10 s129_p_10 0 adc_mim_bank COUNT=1024
Vs129_p_11 s129_p_11 0 DC 0 AC 1
Xs129_p_11 s129_p_11 0 adc_mim_bank COUNT=2048
Vs129_p_12 s129_p_12 0 DC 0 AC 1
Xs129_p_12 s129_p_12 0 adc_mim_bank COUNT=1
Vs129_n_0 s129_n_0 0 DC 0 AC 1
Xs129_n_0 s129_n_0 0 adc_mim_bank COUNT=1
Vs129_n_1 s129_n_1 0 DC 0 AC 1
Xs129_n_1 s129_n_1 0 adc_mim_bank COUNT=2
Vs129_n_2 s129_n_2 0 DC 0 AC 1
Xs129_n_2 s129_n_2 0 adc_mim_bank COUNT=4
Vs129_n_3 s129_n_3 0 DC 0 AC 1
Xs129_n_3 s129_n_3 0 adc_mim_bank COUNT=8
Vs129_n_4 s129_n_4 0 DC 0 AC 1
Xs129_n_4 s129_n_4 0 adc_mim_bank COUNT=16
Vs129_n_5 s129_n_5 0 DC 0 AC 1
Xs129_n_5 s129_n_5 0 adc_mim_bank COUNT=32
Vs129_n_6 s129_n_6 0 DC 0 AC 1
Xs129_n_6 s129_n_6 0 adc_mim_bank COUNT=64
Vs129_n_7 s129_n_7 0 DC 0 AC 1
Xs129_n_7 s129_n_7 0 adc_mim_bank COUNT=128
Vs129_n_8 s129_n_8 0 DC 0 AC 1
Xs129_n_8 s129_n_8 0 adc_mim_bank COUNT=256
Vs129_n_9 s129_n_9 0 DC 0 AC 1
Xs129_n_9 s129_n_9 0 adc_mim_bank COUNT=512
Vs129_n_10 s129_n_10 0 DC 0 AC 1
Xs129_n_10 s129_n_10 0 adc_mim_bank COUNT=1024
Vs129_n_11 s129_n_11 0 DC 0 AC 1
Xs129_n_11 s129_n_11 0 adc_mim_bank COUNT=2048
Vs129_n_12 s129_n_12 0 DC 0 AC 1
Xs129_n_12 s129_n_12 0 adc_mim_bank COUNT=1
Vs130_p_0 s130_p_0 0 DC 0 AC 1
Xs130_p_0 s130_p_0 0 adc_mim_bank COUNT=1
Vs130_p_1 s130_p_1 0 DC 0 AC 1
Xs130_p_1 s130_p_1 0 adc_mim_bank COUNT=2
Vs130_p_2 s130_p_2 0 DC 0 AC 1
Xs130_p_2 s130_p_2 0 adc_mim_bank COUNT=4
Vs130_p_3 s130_p_3 0 DC 0 AC 1
Xs130_p_3 s130_p_3 0 adc_mim_bank COUNT=8
Vs130_p_4 s130_p_4 0 DC 0 AC 1
Xs130_p_4 s130_p_4 0 adc_mim_bank COUNT=16
Vs130_p_5 s130_p_5 0 DC 0 AC 1
Xs130_p_5 s130_p_5 0 adc_mim_bank COUNT=32
Vs130_p_6 s130_p_6 0 DC 0 AC 1
Xs130_p_6 s130_p_6 0 adc_mim_bank COUNT=64
Vs130_p_7 s130_p_7 0 DC 0 AC 1
Xs130_p_7 s130_p_7 0 adc_mim_bank COUNT=128
Vs130_p_8 s130_p_8 0 DC 0 AC 1
Xs130_p_8 s130_p_8 0 adc_mim_bank COUNT=256
Vs130_p_9 s130_p_9 0 DC 0 AC 1
Xs130_p_9 s130_p_9 0 adc_mim_bank COUNT=512
Vs130_p_10 s130_p_10 0 DC 0 AC 1
Xs130_p_10 s130_p_10 0 adc_mim_bank COUNT=1024
Vs130_p_11 s130_p_11 0 DC 0 AC 1
Xs130_p_11 s130_p_11 0 adc_mim_bank COUNT=2048
Vs130_p_12 s130_p_12 0 DC 0 AC 1
Xs130_p_12 s130_p_12 0 adc_mim_bank COUNT=1
Vs130_n_0 s130_n_0 0 DC 0 AC 1
Xs130_n_0 s130_n_0 0 adc_mim_bank COUNT=1
Vs130_n_1 s130_n_1 0 DC 0 AC 1
Xs130_n_1 s130_n_1 0 adc_mim_bank COUNT=2
Vs130_n_2 s130_n_2 0 DC 0 AC 1
Xs130_n_2 s130_n_2 0 adc_mim_bank COUNT=4
Vs130_n_3 s130_n_3 0 DC 0 AC 1
Xs130_n_3 s130_n_3 0 adc_mim_bank COUNT=8
Vs130_n_4 s130_n_4 0 DC 0 AC 1
Xs130_n_4 s130_n_4 0 adc_mim_bank COUNT=16
Vs130_n_5 s130_n_5 0 DC 0 AC 1
Xs130_n_5 s130_n_5 0 adc_mim_bank COUNT=32
Vs130_n_6 s130_n_6 0 DC 0 AC 1
Xs130_n_6 s130_n_6 0 adc_mim_bank COUNT=64
Vs130_n_7 s130_n_7 0 DC 0 AC 1
Xs130_n_7 s130_n_7 0 adc_mim_bank COUNT=128
Vs130_n_8 s130_n_8 0 DC 0 AC 1
Xs130_n_8 s130_n_8 0 adc_mim_bank COUNT=256
Vs130_n_9 s130_n_9 0 DC 0 AC 1
Xs130_n_9 s130_n_9 0 adc_mim_bank COUNT=512
Vs130_n_10 s130_n_10 0 DC 0 AC 1
Xs130_n_10 s130_n_10 0 adc_mim_bank COUNT=1024
Vs130_n_11 s130_n_11 0 DC 0 AC 1
Xs130_n_11 s130_n_11 0 adc_mim_bank COUNT=2048
Vs130_n_12 s130_n_12 0 DC 0 AC 1
Xs130_n_12 s130_n_12 0 adc_mim_bank COUNT=1
Vs131_p_0 s131_p_0 0 DC 0 AC 1
Xs131_p_0 s131_p_0 0 adc_mim_bank COUNT=1
Vs131_p_1 s131_p_1 0 DC 0 AC 1
Xs131_p_1 s131_p_1 0 adc_mim_bank COUNT=2
Vs131_p_2 s131_p_2 0 DC 0 AC 1
Xs131_p_2 s131_p_2 0 adc_mim_bank COUNT=4
Vs131_p_3 s131_p_3 0 DC 0 AC 1
Xs131_p_3 s131_p_3 0 adc_mim_bank COUNT=8
Vs131_p_4 s131_p_4 0 DC 0 AC 1
Xs131_p_4 s131_p_4 0 adc_mim_bank COUNT=16
Vs131_p_5 s131_p_5 0 DC 0 AC 1
Xs131_p_5 s131_p_5 0 adc_mim_bank COUNT=32
Vs131_p_6 s131_p_6 0 DC 0 AC 1
Xs131_p_6 s131_p_6 0 adc_mim_bank COUNT=64
Vs131_p_7 s131_p_7 0 DC 0 AC 1
Xs131_p_7 s131_p_7 0 adc_mim_bank COUNT=128
Vs131_p_8 s131_p_8 0 DC 0 AC 1
Xs131_p_8 s131_p_8 0 adc_mim_bank COUNT=256
Vs131_p_9 s131_p_9 0 DC 0 AC 1
Xs131_p_9 s131_p_9 0 adc_mim_bank COUNT=512
Vs131_p_10 s131_p_10 0 DC 0 AC 1
Xs131_p_10 s131_p_10 0 adc_mim_bank COUNT=1024
Vs131_p_11 s131_p_11 0 DC 0 AC 1
Xs131_p_11 s131_p_11 0 adc_mim_bank COUNT=2048
Vs131_p_12 s131_p_12 0 DC 0 AC 1
Xs131_p_12 s131_p_12 0 adc_mim_bank COUNT=1
Vs131_n_0 s131_n_0 0 DC 0 AC 1
Xs131_n_0 s131_n_0 0 adc_mim_bank COUNT=1
Vs131_n_1 s131_n_1 0 DC 0 AC 1
Xs131_n_1 s131_n_1 0 adc_mim_bank COUNT=2
Vs131_n_2 s131_n_2 0 DC 0 AC 1
Xs131_n_2 s131_n_2 0 adc_mim_bank COUNT=4
Vs131_n_3 s131_n_3 0 DC 0 AC 1
Xs131_n_3 s131_n_3 0 adc_mim_bank COUNT=8
Vs131_n_4 s131_n_4 0 DC 0 AC 1
Xs131_n_4 s131_n_4 0 adc_mim_bank COUNT=16
Vs131_n_5 s131_n_5 0 DC 0 AC 1
Xs131_n_5 s131_n_5 0 adc_mim_bank COUNT=32
Vs131_n_6 s131_n_6 0 DC 0 AC 1
Xs131_n_6 s131_n_6 0 adc_mim_bank COUNT=64
Vs131_n_7 s131_n_7 0 DC 0 AC 1
Xs131_n_7 s131_n_7 0 adc_mim_bank COUNT=128
Vs131_n_8 s131_n_8 0 DC 0 AC 1
Xs131_n_8 s131_n_8 0 adc_mim_bank COUNT=256
Vs131_n_9 s131_n_9 0 DC 0 AC 1
Xs131_n_9 s131_n_9 0 adc_mim_bank COUNT=512
Vs131_n_10 s131_n_10 0 DC 0 AC 1
Xs131_n_10 s131_n_10 0 adc_mim_bank COUNT=1024
Vs131_n_11 s131_n_11 0 DC 0 AC 1
Xs131_n_11 s131_n_11 0 adc_mim_bank COUNT=2048
Vs131_n_12 s131_n_12 0 DC 0 AC 1
Xs131_n_12 s131_n_12 0 adc_mim_bank COUNT=1
Vs132_p_0 s132_p_0 0 DC 0 AC 1
Xs132_p_0 s132_p_0 0 adc_mim_bank COUNT=1
Vs132_p_1 s132_p_1 0 DC 0 AC 1
Xs132_p_1 s132_p_1 0 adc_mim_bank COUNT=2
Vs132_p_2 s132_p_2 0 DC 0 AC 1
Xs132_p_2 s132_p_2 0 adc_mim_bank COUNT=4
Vs132_p_3 s132_p_3 0 DC 0 AC 1
Xs132_p_3 s132_p_3 0 adc_mim_bank COUNT=8
Vs132_p_4 s132_p_4 0 DC 0 AC 1
Xs132_p_4 s132_p_4 0 adc_mim_bank COUNT=16
Vs132_p_5 s132_p_5 0 DC 0 AC 1
Xs132_p_5 s132_p_5 0 adc_mim_bank COUNT=32
Vs132_p_6 s132_p_6 0 DC 0 AC 1
Xs132_p_6 s132_p_6 0 adc_mim_bank COUNT=64
Vs132_p_7 s132_p_7 0 DC 0 AC 1
Xs132_p_7 s132_p_7 0 adc_mim_bank COUNT=128
Vs132_p_8 s132_p_8 0 DC 0 AC 1
Xs132_p_8 s132_p_8 0 adc_mim_bank COUNT=256
Vs132_p_9 s132_p_9 0 DC 0 AC 1
Xs132_p_9 s132_p_9 0 adc_mim_bank COUNT=512
Vs132_p_10 s132_p_10 0 DC 0 AC 1
Xs132_p_10 s132_p_10 0 adc_mim_bank COUNT=1024
Vs132_p_11 s132_p_11 0 DC 0 AC 1
Xs132_p_11 s132_p_11 0 adc_mim_bank COUNT=2048
Vs132_p_12 s132_p_12 0 DC 0 AC 1
Xs132_p_12 s132_p_12 0 adc_mim_bank COUNT=1
Vs132_n_0 s132_n_0 0 DC 0 AC 1
Xs132_n_0 s132_n_0 0 adc_mim_bank COUNT=1
Vs132_n_1 s132_n_1 0 DC 0 AC 1
Xs132_n_1 s132_n_1 0 adc_mim_bank COUNT=2
Vs132_n_2 s132_n_2 0 DC 0 AC 1
Xs132_n_2 s132_n_2 0 adc_mim_bank COUNT=4
Vs132_n_3 s132_n_3 0 DC 0 AC 1
Xs132_n_3 s132_n_3 0 adc_mim_bank COUNT=8
Vs132_n_4 s132_n_4 0 DC 0 AC 1
Xs132_n_4 s132_n_4 0 adc_mim_bank COUNT=16
Vs132_n_5 s132_n_5 0 DC 0 AC 1
Xs132_n_5 s132_n_5 0 adc_mim_bank COUNT=32
Vs132_n_6 s132_n_6 0 DC 0 AC 1
Xs132_n_6 s132_n_6 0 adc_mim_bank COUNT=64
Vs132_n_7 s132_n_7 0 DC 0 AC 1
Xs132_n_7 s132_n_7 0 adc_mim_bank COUNT=128
Vs132_n_8 s132_n_8 0 DC 0 AC 1
Xs132_n_8 s132_n_8 0 adc_mim_bank COUNT=256
Vs132_n_9 s132_n_9 0 DC 0 AC 1
Xs132_n_9 s132_n_9 0 adc_mim_bank COUNT=512
Vs132_n_10 s132_n_10 0 DC 0 AC 1
Xs132_n_10 s132_n_10 0 adc_mim_bank COUNT=1024
Vs132_n_11 s132_n_11 0 DC 0 AC 1
Xs132_n_11 s132_n_11 0 adc_mim_bank COUNT=2048
Vs132_n_12 s132_n_12 0 DC 0 AC 1
Xs132_n_12 s132_n_12 0 adc_mim_bank COUNT=1
Vs133_p_0 s133_p_0 0 DC 0 AC 1
Xs133_p_0 s133_p_0 0 adc_mim_bank COUNT=1
Vs133_p_1 s133_p_1 0 DC 0 AC 1
Xs133_p_1 s133_p_1 0 adc_mim_bank COUNT=2
Vs133_p_2 s133_p_2 0 DC 0 AC 1
Xs133_p_2 s133_p_2 0 adc_mim_bank COUNT=4
Vs133_p_3 s133_p_3 0 DC 0 AC 1
Xs133_p_3 s133_p_3 0 adc_mim_bank COUNT=8
Vs133_p_4 s133_p_4 0 DC 0 AC 1
Xs133_p_4 s133_p_4 0 adc_mim_bank COUNT=16
Vs133_p_5 s133_p_5 0 DC 0 AC 1
Xs133_p_5 s133_p_5 0 adc_mim_bank COUNT=32
Vs133_p_6 s133_p_6 0 DC 0 AC 1
Xs133_p_6 s133_p_6 0 adc_mim_bank COUNT=64
Vs133_p_7 s133_p_7 0 DC 0 AC 1
Xs133_p_7 s133_p_7 0 adc_mim_bank COUNT=128
Vs133_p_8 s133_p_8 0 DC 0 AC 1
Xs133_p_8 s133_p_8 0 adc_mim_bank COUNT=256
Vs133_p_9 s133_p_9 0 DC 0 AC 1
Xs133_p_9 s133_p_9 0 adc_mim_bank COUNT=512
Vs133_p_10 s133_p_10 0 DC 0 AC 1
Xs133_p_10 s133_p_10 0 adc_mim_bank COUNT=1024
Vs133_p_11 s133_p_11 0 DC 0 AC 1
Xs133_p_11 s133_p_11 0 adc_mim_bank COUNT=2048
Vs133_p_12 s133_p_12 0 DC 0 AC 1
Xs133_p_12 s133_p_12 0 adc_mim_bank COUNT=1
Vs133_n_0 s133_n_0 0 DC 0 AC 1
Xs133_n_0 s133_n_0 0 adc_mim_bank COUNT=1
Vs133_n_1 s133_n_1 0 DC 0 AC 1
Xs133_n_1 s133_n_1 0 adc_mim_bank COUNT=2
Vs133_n_2 s133_n_2 0 DC 0 AC 1
Xs133_n_2 s133_n_2 0 adc_mim_bank COUNT=4
Vs133_n_3 s133_n_3 0 DC 0 AC 1
Xs133_n_3 s133_n_3 0 adc_mim_bank COUNT=8
Vs133_n_4 s133_n_4 0 DC 0 AC 1
Xs133_n_4 s133_n_4 0 adc_mim_bank COUNT=16
Vs133_n_5 s133_n_5 0 DC 0 AC 1
Xs133_n_5 s133_n_5 0 adc_mim_bank COUNT=32
Vs133_n_6 s133_n_6 0 DC 0 AC 1
Xs133_n_6 s133_n_6 0 adc_mim_bank COUNT=64
Vs133_n_7 s133_n_7 0 DC 0 AC 1
Xs133_n_7 s133_n_7 0 adc_mim_bank COUNT=128
Vs133_n_8 s133_n_8 0 DC 0 AC 1
Xs133_n_8 s133_n_8 0 adc_mim_bank COUNT=256
Vs133_n_9 s133_n_9 0 DC 0 AC 1
Xs133_n_9 s133_n_9 0 adc_mim_bank COUNT=512
Vs133_n_10 s133_n_10 0 DC 0 AC 1
Xs133_n_10 s133_n_10 0 adc_mim_bank COUNT=1024
Vs133_n_11 s133_n_11 0 DC 0 AC 1
Xs133_n_11 s133_n_11 0 adc_mim_bank COUNT=2048
Vs133_n_12 s133_n_12 0 DC 0 AC 1
Xs133_n_12 s133_n_12 0 adc_mim_bank COUNT=1
Vs134_p_0 s134_p_0 0 DC 0 AC 1
Xs134_p_0 s134_p_0 0 adc_mim_bank COUNT=1
Vs134_p_1 s134_p_1 0 DC 0 AC 1
Xs134_p_1 s134_p_1 0 adc_mim_bank COUNT=2
Vs134_p_2 s134_p_2 0 DC 0 AC 1
Xs134_p_2 s134_p_2 0 adc_mim_bank COUNT=4
Vs134_p_3 s134_p_3 0 DC 0 AC 1
Xs134_p_3 s134_p_3 0 adc_mim_bank COUNT=8
Vs134_p_4 s134_p_4 0 DC 0 AC 1
Xs134_p_4 s134_p_4 0 adc_mim_bank COUNT=16
Vs134_p_5 s134_p_5 0 DC 0 AC 1
Xs134_p_5 s134_p_5 0 adc_mim_bank COUNT=32
Vs134_p_6 s134_p_6 0 DC 0 AC 1
Xs134_p_6 s134_p_6 0 adc_mim_bank COUNT=64
Vs134_p_7 s134_p_7 0 DC 0 AC 1
Xs134_p_7 s134_p_7 0 adc_mim_bank COUNT=128
Vs134_p_8 s134_p_8 0 DC 0 AC 1
Xs134_p_8 s134_p_8 0 adc_mim_bank COUNT=256
Vs134_p_9 s134_p_9 0 DC 0 AC 1
Xs134_p_9 s134_p_9 0 adc_mim_bank COUNT=512
Vs134_p_10 s134_p_10 0 DC 0 AC 1
Xs134_p_10 s134_p_10 0 adc_mim_bank COUNT=1024
Vs134_p_11 s134_p_11 0 DC 0 AC 1
Xs134_p_11 s134_p_11 0 adc_mim_bank COUNT=2048
Vs134_p_12 s134_p_12 0 DC 0 AC 1
Xs134_p_12 s134_p_12 0 adc_mim_bank COUNT=1
Vs134_n_0 s134_n_0 0 DC 0 AC 1
Xs134_n_0 s134_n_0 0 adc_mim_bank COUNT=1
Vs134_n_1 s134_n_1 0 DC 0 AC 1
Xs134_n_1 s134_n_1 0 adc_mim_bank COUNT=2
Vs134_n_2 s134_n_2 0 DC 0 AC 1
Xs134_n_2 s134_n_2 0 adc_mim_bank COUNT=4
Vs134_n_3 s134_n_3 0 DC 0 AC 1
Xs134_n_3 s134_n_3 0 adc_mim_bank COUNT=8
Vs134_n_4 s134_n_4 0 DC 0 AC 1
Xs134_n_4 s134_n_4 0 adc_mim_bank COUNT=16
Vs134_n_5 s134_n_5 0 DC 0 AC 1
Xs134_n_5 s134_n_5 0 adc_mim_bank COUNT=32
Vs134_n_6 s134_n_6 0 DC 0 AC 1
Xs134_n_6 s134_n_6 0 adc_mim_bank COUNT=64
Vs134_n_7 s134_n_7 0 DC 0 AC 1
Xs134_n_7 s134_n_7 0 adc_mim_bank COUNT=128
Vs134_n_8 s134_n_8 0 DC 0 AC 1
Xs134_n_8 s134_n_8 0 adc_mim_bank COUNT=256
Vs134_n_9 s134_n_9 0 DC 0 AC 1
Xs134_n_9 s134_n_9 0 adc_mim_bank COUNT=512
Vs134_n_10 s134_n_10 0 DC 0 AC 1
Xs134_n_10 s134_n_10 0 adc_mim_bank COUNT=1024
Vs134_n_11 s134_n_11 0 DC 0 AC 1
Xs134_n_11 s134_n_11 0 adc_mim_bank COUNT=2048
Vs134_n_12 s134_n_12 0 DC 0 AC 1
Xs134_n_12 s134_n_12 0 adc_mim_bank COUNT=1
Vs135_p_0 s135_p_0 0 DC 0 AC 1
Xs135_p_0 s135_p_0 0 adc_mim_bank COUNT=1
Vs135_p_1 s135_p_1 0 DC 0 AC 1
Xs135_p_1 s135_p_1 0 adc_mim_bank COUNT=2
Vs135_p_2 s135_p_2 0 DC 0 AC 1
Xs135_p_2 s135_p_2 0 adc_mim_bank COUNT=4
Vs135_p_3 s135_p_3 0 DC 0 AC 1
Xs135_p_3 s135_p_3 0 adc_mim_bank COUNT=8
Vs135_p_4 s135_p_4 0 DC 0 AC 1
Xs135_p_4 s135_p_4 0 adc_mim_bank COUNT=16
Vs135_p_5 s135_p_5 0 DC 0 AC 1
Xs135_p_5 s135_p_5 0 adc_mim_bank COUNT=32
Vs135_p_6 s135_p_6 0 DC 0 AC 1
Xs135_p_6 s135_p_6 0 adc_mim_bank COUNT=64
Vs135_p_7 s135_p_7 0 DC 0 AC 1
Xs135_p_7 s135_p_7 0 adc_mim_bank COUNT=128
Vs135_p_8 s135_p_8 0 DC 0 AC 1
Xs135_p_8 s135_p_8 0 adc_mim_bank COUNT=256
Vs135_p_9 s135_p_9 0 DC 0 AC 1
Xs135_p_9 s135_p_9 0 adc_mim_bank COUNT=512
Vs135_p_10 s135_p_10 0 DC 0 AC 1
Xs135_p_10 s135_p_10 0 adc_mim_bank COUNT=1024
Vs135_p_11 s135_p_11 0 DC 0 AC 1
Xs135_p_11 s135_p_11 0 adc_mim_bank COUNT=2048
Vs135_p_12 s135_p_12 0 DC 0 AC 1
Xs135_p_12 s135_p_12 0 adc_mim_bank COUNT=1
Vs135_n_0 s135_n_0 0 DC 0 AC 1
Xs135_n_0 s135_n_0 0 adc_mim_bank COUNT=1
Vs135_n_1 s135_n_1 0 DC 0 AC 1
Xs135_n_1 s135_n_1 0 adc_mim_bank COUNT=2
Vs135_n_2 s135_n_2 0 DC 0 AC 1
Xs135_n_2 s135_n_2 0 adc_mim_bank COUNT=4
Vs135_n_3 s135_n_3 0 DC 0 AC 1
Xs135_n_3 s135_n_3 0 adc_mim_bank COUNT=8
Vs135_n_4 s135_n_4 0 DC 0 AC 1
Xs135_n_4 s135_n_4 0 adc_mim_bank COUNT=16
Vs135_n_5 s135_n_5 0 DC 0 AC 1
Xs135_n_5 s135_n_5 0 adc_mim_bank COUNT=32
Vs135_n_6 s135_n_6 0 DC 0 AC 1
Xs135_n_6 s135_n_6 0 adc_mim_bank COUNT=64
Vs135_n_7 s135_n_7 0 DC 0 AC 1
Xs135_n_7 s135_n_7 0 adc_mim_bank COUNT=128
Vs135_n_8 s135_n_8 0 DC 0 AC 1
Xs135_n_8 s135_n_8 0 adc_mim_bank COUNT=256
Vs135_n_9 s135_n_9 0 DC 0 AC 1
Xs135_n_9 s135_n_9 0 adc_mim_bank COUNT=512
Vs135_n_10 s135_n_10 0 DC 0 AC 1
Xs135_n_10 s135_n_10 0 adc_mim_bank COUNT=1024
Vs135_n_11 s135_n_11 0 DC 0 AC 1
Xs135_n_11 s135_n_11 0 adc_mim_bank COUNT=2048
Vs135_n_12 s135_n_12 0 DC 0 AC 1
Xs135_n_12 s135_n_12 0 adc_mim_bank COUNT=1
Vs136_p_0 s136_p_0 0 DC 0 AC 1
Xs136_p_0 s136_p_0 0 adc_mim_bank COUNT=1
Vs136_p_1 s136_p_1 0 DC 0 AC 1
Xs136_p_1 s136_p_1 0 adc_mim_bank COUNT=2
Vs136_p_2 s136_p_2 0 DC 0 AC 1
Xs136_p_2 s136_p_2 0 adc_mim_bank COUNT=4
Vs136_p_3 s136_p_3 0 DC 0 AC 1
Xs136_p_3 s136_p_3 0 adc_mim_bank COUNT=8
Vs136_p_4 s136_p_4 0 DC 0 AC 1
Xs136_p_4 s136_p_4 0 adc_mim_bank COUNT=16
Vs136_p_5 s136_p_5 0 DC 0 AC 1
Xs136_p_5 s136_p_5 0 adc_mim_bank COUNT=32
Vs136_p_6 s136_p_6 0 DC 0 AC 1
Xs136_p_6 s136_p_6 0 adc_mim_bank COUNT=64
Vs136_p_7 s136_p_7 0 DC 0 AC 1
Xs136_p_7 s136_p_7 0 adc_mim_bank COUNT=128
Vs136_p_8 s136_p_8 0 DC 0 AC 1
Xs136_p_8 s136_p_8 0 adc_mim_bank COUNT=256
Vs136_p_9 s136_p_9 0 DC 0 AC 1
Xs136_p_9 s136_p_9 0 adc_mim_bank COUNT=512
Vs136_p_10 s136_p_10 0 DC 0 AC 1
Xs136_p_10 s136_p_10 0 adc_mim_bank COUNT=1024
Vs136_p_11 s136_p_11 0 DC 0 AC 1
Xs136_p_11 s136_p_11 0 adc_mim_bank COUNT=2048
Vs136_p_12 s136_p_12 0 DC 0 AC 1
Xs136_p_12 s136_p_12 0 adc_mim_bank COUNT=1
Vs136_n_0 s136_n_0 0 DC 0 AC 1
Xs136_n_0 s136_n_0 0 adc_mim_bank COUNT=1
Vs136_n_1 s136_n_1 0 DC 0 AC 1
Xs136_n_1 s136_n_1 0 adc_mim_bank COUNT=2
Vs136_n_2 s136_n_2 0 DC 0 AC 1
Xs136_n_2 s136_n_2 0 adc_mim_bank COUNT=4
Vs136_n_3 s136_n_3 0 DC 0 AC 1
Xs136_n_3 s136_n_3 0 adc_mim_bank COUNT=8
Vs136_n_4 s136_n_4 0 DC 0 AC 1
Xs136_n_4 s136_n_4 0 adc_mim_bank COUNT=16
Vs136_n_5 s136_n_5 0 DC 0 AC 1
Xs136_n_5 s136_n_5 0 adc_mim_bank COUNT=32
Vs136_n_6 s136_n_6 0 DC 0 AC 1
Xs136_n_6 s136_n_6 0 adc_mim_bank COUNT=64
Vs136_n_7 s136_n_7 0 DC 0 AC 1
Xs136_n_7 s136_n_7 0 adc_mim_bank COUNT=128
Vs136_n_8 s136_n_8 0 DC 0 AC 1
Xs136_n_8 s136_n_8 0 adc_mim_bank COUNT=256
Vs136_n_9 s136_n_9 0 DC 0 AC 1
Xs136_n_9 s136_n_9 0 adc_mim_bank COUNT=512
Vs136_n_10 s136_n_10 0 DC 0 AC 1
Xs136_n_10 s136_n_10 0 adc_mim_bank COUNT=1024
Vs136_n_11 s136_n_11 0 DC 0 AC 1
Xs136_n_11 s136_n_11 0 adc_mim_bank COUNT=2048
Vs136_n_12 s136_n_12 0 DC 0 AC 1
Xs136_n_12 s136_n_12 0 adc_mim_bank COUNT=1
Vs137_p_0 s137_p_0 0 DC 0 AC 1
Xs137_p_0 s137_p_0 0 adc_mim_bank COUNT=1
Vs137_p_1 s137_p_1 0 DC 0 AC 1
Xs137_p_1 s137_p_1 0 adc_mim_bank COUNT=2
Vs137_p_2 s137_p_2 0 DC 0 AC 1
Xs137_p_2 s137_p_2 0 adc_mim_bank COUNT=4
Vs137_p_3 s137_p_3 0 DC 0 AC 1
Xs137_p_3 s137_p_3 0 adc_mim_bank COUNT=8
Vs137_p_4 s137_p_4 0 DC 0 AC 1
Xs137_p_4 s137_p_4 0 adc_mim_bank COUNT=16
Vs137_p_5 s137_p_5 0 DC 0 AC 1
Xs137_p_5 s137_p_5 0 adc_mim_bank COUNT=32
Vs137_p_6 s137_p_6 0 DC 0 AC 1
Xs137_p_6 s137_p_6 0 adc_mim_bank COUNT=64
Vs137_p_7 s137_p_7 0 DC 0 AC 1
Xs137_p_7 s137_p_7 0 adc_mim_bank COUNT=128
Vs137_p_8 s137_p_8 0 DC 0 AC 1
Xs137_p_8 s137_p_8 0 adc_mim_bank COUNT=256
Vs137_p_9 s137_p_9 0 DC 0 AC 1
Xs137_p_9 s137_p_9 0 adc_mim_bank COUNT=512
Vs137_p_10 s137_p_10 0 DC 0 AC 1
Xs137_p_10 s137_p_10 0 adc_mim_bank COUNT=1024
Vs137_p_11 s137_p_11 0 DC 0 AC 1
Xs137_p_11 s137_p_11 0 adc_mim_bank COUNT=2048
Vs137_p_12 s137_p_12 0 DC 0 AC 1
Xs137_p_12 s137_p_12 0 adc_mim_bank COUNT=1
Vs137_n_0 s137_n_0 0 DC 0 AC 1
Xs137_n_0 s137_n_0 0 adc_mim_bank COUNT=1
Vs137_n_1 s137_n_1 0 DC 0 AC 1
Xs137_n_1 s137_n_1 0 adc_mim_bank COUNT=2
Vs137_n_2 s137_n_2 0 DC 0 AC 1
Xs137_n_2 s137_n_2 0 adc_mim_bank COUNT=4
Vs137_n_3 s137_n_3 0 DC 0 AC 1
Xs137_n_3 s137_n_3 0 adc_mim_bank COUNT=8
Vs137_n_4 s137_n_4 0 DC 0 AC 1
Xs137_n_4 s137_n_4 0 adc_mim_bank COUNT=16
Vs137_n_5 s137_n_5 0 DC 0 AC 1
Xs137_n_5 s137_n_5 0 adc_mim_bank COUNT=32
Vs137_n_6 s137_n_6 0 DC 0 AC 1
Xs137_n_6 s137_n_6 0 adc_mim_bank COUNT=64
Vs137_n_7 s137_n_7 0 DC 0 AC 1
Xs137_n_7 s137_n_7 0 adc_mim_bank COUNT=128
Vs137_n_8 s137_n_8 0 DC 0 AC 1
Xs137_n_8 s137_n_8 0 adc_mim_bank COUNT=256
Vs137_n_9 s137_n_9 0 DC 0 AC 1
Xs137_n_9 s137_n_9 0 adc_mim_bank COUNT=512
Vs137_n_10 s137_n_10 0 DC 0 AC 1
Xs137_n_10 s137_n_10 0 adc_mim_bank COUNT=1024
Vs137_n_11 s137_n_11 0 DC 0 AC 1
Xs137_n_11 s137_n_11 0 adc_mim_bank COUNT=2048
Vs137_n_12 s137_n_12 0 DC 0 AC 1
Xs137_n_12 s137_n_12 0 adc_mim_bank COUNT=1
Vs138_p_0 s138_p_0 0 DC 0 AC 1
Xs138_p_0 s138_p_0 0 adc_mim_bank COUNT=1
Vs138_p_1 s138_p_1 0 DC 0 AC 1
Xs138_p_1 s138_p_1 0 adc_mim_bank COUNT=2
Vs138_p_2 s138_p_2 0 DC 0 AC 1
Xs138_p_2 s138_p_2 0 adc_mim_bank COUNT=4
Vs138_p_3 s138_p_3 0 DC 0 AC 1
Xs138_p_3 s138_p_3 0 adc_mim_bank COUNT=8
Vs138_p_4 s138_p_4 0 DC 0 AC 1
Xs138_p_4 s138_p_4 0 adc_mim_bank COUNT=16
Vs138_p_5 s138_p_5 0 DC 0 AC 1
Xs138_p_5 s138_p_5 0 adc_mim_bank COUNT=32
Vs138_p_6 s138_p_6 0 DC 0 AC 1
Xs138_p_6 s138_p_6 0 adc_mim_bank COUNT=64
Vs138_p_7 s138_p_7 0 DC 0 AC 1
Xs138_p_7 s138_p_7 0 adc_mim_bank COUNT=128
Vs138_p_8 s138_p_8 0 DC 0 AC 1
Xs138_p_8 s138_p_8 0 adc_mim_bank COUNT=256
Vs138_p_9 s138_p_9 0 DC 0 AC 1
Xs138_p_9 s138_p_9 0 adc_mim_bank COUNT=512
Vs138_p_10 s138_p_10 0 DC 0 AC 1
Xs138_p_10 s138_p_10 0 adc_mim_bank COUNT=1024
Vs138_p_11 s138_p_11 0 DC 0 AC 1
Xs138_p_11 s138_p_11 0 adc_mim_bank COUNT=2048
Vs138_p_12 s138_p_12 0 DC 0 AC 1
Xs138_p_12 s138_p_12 0 adc_mim_bank COUNT=1
Vs138_n_0 s138_n_0 0 DC 0 AC 1
Xs138_n_0 s138_n_0 0 adc_mim_bank COUNT=1
Vs138_n_1 s138_n_1 0 DC 0 AC 1
Xs138_n_1 s138_n_1 0 adc_mim_bank COUNT=2
Vs138_n_2 s138_n_2 0 DC 0 AC 1
Xs138_n_2 s138_n_2 0 adc_mim_bank COUNT=4
Vs138_n_3 s138_n_3 0 DC 0 AC 1
Xs138_n_3 s138_n_3 0 adc_mim_bank COUNT=8
Vs138_n_4 s138_n_4 0 DC 0 AC 1
Xs138_n_4 s138_n_4 0 adc_mim_bank COUNT=16
Vs138_n_5 s138_n_5 0 DC 0 AC 1
Xs138_n_5 s138_n_5 0 adc_mim_bank COUNT=32
Vs138_n_6 s138_n_6 0 DC 0 AC 1
Xs138_n_6 s138_n_6 0 adc_mim_bank COUNT=64
Vs138_n_7 s138_n_7 0 DC 0 AC 1
Xs138_n_7 s138_n_7 0 adc_mim_bank COUNT=128
Vs138_n_8 s138_n_8 0 DC 0 AC 1
Xs138_n_8 s138_n_8 0 adc_mim_bank COUNT=256
Vs138_n_9 s138_n_9 0 DC 0 AC 1
Xs138_n_9 s138_n_9 0 adc_mim_bank COUNT=512
Vs138_n_10 s138_n_10 0 DC 0 AC 1
Xs138_n_10 s138_n_10 0 adc_mim_bank COUNT=1024
Vs138_n_11 s138_n_11 0 DC 0 AC 1
Xs138_n_11 s138_n_11 0 adc_mim_bank COUNT=2048
Vs138_n_12 s138_n_12 0 DC 0 AC 1
Xs138_n_12 s138_n_12 0 adc_mim_bank COUNT=1
Vs139_p_0 s139_p_0 0 DC 0 AC 1
Xs139_p_0 s139_p_0 0 adc_mim_bank COUNT=1
Vs139_p_1 s139_p_1 0 DC 0 AC 1
Xs139_p_1 s139_p_1 0 adc_mim_bank COUNT=2
Vs139_p_2 s139_p_2 0 DC 0 AC 1
Xs139_p_2 s139_p_2 0 adc_mim_bank COUNT=4
Vs139_p_3 s139_p_3 0 DC 0 AC 1
Xs139_p_3 s139_p_3 0 adc_mim_bank COUNT=8
Vs139_p_4 s139_p_4 0 DC 0 AC 1
Xs139_p_4 s139_p_4 0 adc_mim_bank COUNT=16
Vs139_p_5 s139_p_5 0 DC 0 AC 1
Xs139_p_5 s139_p_5 0 adc_mim_bank COUNT=32
Vs139_p_6 s139_p_6 0 DC 0 AC 1
Xs139_p_6 s139_p_6 0 adc_mim_bank COUNT=64
Vs139_p_7 s139_p_7 0 DC 0 AC 1
Xs139_p_7 s139_p_7 0 adc_mim_bank COUNT=128
Vs139_p_8 s139_p_8 0 DC 0 AC 1
Xs139_p_8 s139_p_8 0 adc_mim_bank COUNT=256
Vs139_p_9 s139_p_9 0 DC 0 AC 1
Xs139_p_9 s139_p_9 0 adc_mim_bank COUNT=512
Vs139_p_10 s139_p_10 0 DC 0 AC 1
Xs139_p_10 s139_p_10 0 adc_mim_bank COUNT=1024
Vs139_p_11 s139_p_11 0 DC 0 AC 1
Xs139_p_11 s139_p_11 0 adc_mim_bank COUNT=2048
Vs139_p_12 s139_p_12 0 DC 0 AC 1
Xs139_p_12 s139_p_12 0 adc_mim_bank COUNT=1
Vs139_n_0 s139_n_0 0 DC 0 AC 1
Xs139_n_0 s139_n_0 0 adc_mim_bank COUNT=1
Vs139_n_1 s139_n_1 0 DC 0 AC 1
Xs139_n_1 s139_n_1 0 adc_mim_bank COUNT=2
Vs139_n_2 s139_n_2 0 DC 0 AC 1
Xs139_n_2 s139_n_2 0 adc_mim_bank COUNT=4
Vs139_n_3 s139_n_3 0 DC 0 AC 1
Xs139_n_3 s139_n_3 0 adc_mim_bank COUNT=8
Vs139_n_4 s139_n_4 0 DC 0 AC 1
Xs139_n_4 s139_n_4 0 adc_mim_bank COUNT=16
Vs139_n_5 s139_n_5 0 DC 0 AC 1
Xs139_n_5 s139_n_5 0 adc_mim_bank COUNT=32
Vs139_n_6 s139_n_6 0 DC 0 AC 1
Xs139_n_6 s139_n_6 0 adc_mim_bank COUNT=64
Vs139_n_7 s139_n_7 0 DC 0 AC 1
Xs139_n_7 s139_n_7 0 adc_mim_bank COUNT=128
Vs139_n_8 s139_n_8 0 DC 0 AC 1
Xs139_n_8 s139_n_8 0 adc_mim_bank COUNT=256
Vs139_n_9 s139_n_9 0 DC 0 AC 1
Xs139_n_9 s139_n_9 0 adc_mim_bank COUNT=512
Vs139_n_10 s139_n_10 0 DC 0 AC 1
Xs139_n_10 s139_n_10 0 adc_mim_bank COUNT=1024
Vs139_n_11 s139_n_11 0 DC 0 AC 1
Xs139_n_11 s139_n_11 0 adc_mim_bank COUNT=2048
Vs139_n_12 s139_n_12 0 DC 0 AC 1
Xs139_n_12 s139_n_12 0 adc_mim_bank COUNT=1
Vs140_p_0 s140_p_0 0 DC 0 AC 1
Xs140_p_0 s140_p_0 0 adc_mim_bank COUNT=1
Vs140_p_1 s140_p_1 0 DC 0 AC 1
Xs140_p_1 s140_p_1 0 adc_mim_bank COUNT=2
Vs140_p_2 s140_p_2 0 DC 0 AC 1
Xs140_p_2 s140_p_2 0 adc_mim_bank COUNT=4
Vs140_p_3 s140_p_3 0 DC 0 AC 1
Xs140_p_3 s140_p_3 0 adc_mim_bank COUNT=8
Vs140_p_4 s140_p_4 0 DC 0 AC 1
Xs140_p_4 s140_p_4 0 adc_mim_bank COUNT=16
Vs140_p_5 s140_p_5 0 DC 0 AC 1
Xs140_p_5 s140_p_5 0 adc_mim_bank COUNT=32
Vs140_p_6 s140_p_6 0 DC 0 AC 1
Xs140_p_6 s140_p_6 0 adc_mim_bank COUNT=64
Vs140_p_7 s140_p_7 0 DC 0 AC 1
Xs140_p_7 s140_p_7 0 adc_mim_bank COUNT=128
Vs140_p_8 s140_p_8 0 DC 0 AC 1
Xs140_p_8 s140_p_8 0 adc_mim_bank COUNT=256
Vs140_p_9 s140_p_9 0 DC 0 AC 1
Xs140_p_9 s140_p_9 0 adc_mim_bank COUNT=512
Vs140_p_10 s140_p_10 0 DC 0 AC 1
Xs140_p_10 s140_p_10 0 adc_mim_bank COUNT=1024
Vs140_p_11 s140_p_11 0 DC 0 AC 1
Xs140_p_11 s140_p_11 0 adc_mim_bank COUNT=2048
Vs140_p_12 s140_p_12 0 DC 0 AC 1
Xs140_p_12 s140_p_12 0 adc_mim_bank COUNT=1
Vs140_n_0 s140_n_0 0 DC 0 AC 1
Xs140_n_0 s140_n_0 0 adc_mim_bank COUNT=1
Vs140_n_1 s140_n_1 0 DC 0 AC 1
Xs140_n_1 s140_n_1 0 adc_mim_bank COUNT=2
Vs140_n_2 s140_n_2 0 DC 0 AC 1
Xs140_n_2 s140_n_2 0 adc_mim_bank COUNT=4
Vs140_n_3 s140_n_3 0 DC 0 AC 1
Xs140_n_3 s140_n_3 0 adc_mim_bank COUNT=8
Vs140_n_4 s140_n_4 0 DC 0 AC 1
Xs140_n_4 s140_n_4 0 adc_mim_bank COUNT=16
Vs140_n_5 s140_n_5 0 DC 0 AC 1
Xs140_n_5 s140_n_5 0 adc_mim_bank COUNT=32
Vs140_n_6 s140_n_6 0 DC 0 AC 1
Xs140_n_6 s140_n_6 0 adc_mim_bank COUNT=64
Vs140_n_7 s140_n_7 0 DC 0 AC 1
Xs140_n_7 s140_n_7 0 adc_mim_bank COUNT=128
Vs140_n_8 s140_n_8 0 DC 0 AC 1
Xs140_n_8 s140_n_8 0 adc_mim_bank COUNT=256
Vs140_n_9 s140_n_9 0 DC 0 AC 1
Xs140_n_9 s140_n_9 0 adc_mim_bank COUNT=512
Vs140_n_10 s140_n_10 0 DC 0 AC 1
Xs140_n_10 s140_n_10 0 adc_mim_bank COUNT=1024
Vs140_n_11 s140_n_11 0 DC 0 AC 1
Xs140_n_11 s140_n_11 0 adc_mim_bank COUNT=2048
Vs140_n_12 s140_n_12 0 DC 0 AC 1
Xs140_n_12 s140_n_12 0 adc_mim_bank COUNT=1
Vs141_p_0 s141_p_0 0 DC 0 AC 1
Xs141_p_0 s141_p_0 0 adc_mim_bank COUNT=1
Vs141_p_1 s141_p_1 0 DC 0 AC 1
Xs141_p_1 s141_p_1 0 adc_mim_bank COUNT=2
Vs141_p_2 s141_p_2 0 DC 0 AC 1
Xs141_p_2 s141_p_2 0 adc_mim_bank COUNT=4
Vs141_p_3 s141_p_3 0 DC 0 AC 1
Xs141_p_3 s141_p_3 0 adc_mim_bank COUNT=8
Vs141_p_4 s141_p_4 0 DC 0 AC 1
Xs141_p_4 s141_p_4 0 adc_mim_bank COUNT=16
Vs141_p_5 s141_p_5 0 DC 0 AC 1
Xs141_p_5 s141_p_5 0 adc_mim_bank COUNT=32
Vs141_p_6 s141_p_6 0 DC 0 AC 1
Xs141_p_6 s141_p_6 0 adc_mim_bank COUNT=64
Vs141_p_7 s141_p_7 0 DC 0 AC 1
Xs141_p_7 s141_p_7 0 adc_mim_bank COUNT=128
Vs141_p_8 s141_p_8 0 DC 0 AC 1
Xs141_p_8 s141_p_8 0 adc_mim_bank COUNT=256
Vs141_p_9 s141_p_9 0 DC 0 AC 1
Xs141_p_9 s141_p_9 0 adc_mim_bank COUNT=512
Vs141_p_10 s141_p_10 0 DC 0 AC 1
Xs141_p_10 s141_p_10 0 adc_mim_bank COUNT=1024
Vs141_p_11 s141_p_11 0 DC 0 AC 1
Xs141_p_11 s141_p_11 0 adc_mim_bank COUNT=2048
Vs141_p_12 s141_p_12 0 DC 0 AC 1
Xs141_p_12 s141_p_12 0 adc_mim_bank COUNT=1
Vs141_n_0 s141_n_0 0 DC 0 AC 1
Xs141_n_0 s141_n_0 0 adc_mim_bank COUNT=1
Vs141_n_1 s141_n_1 0 DC 0 AC 1
Xs141_n_1 s141_n_1 0 adc_mim_bank COUNT=2
Vs141_n_2 s141_n_2 0 DC 0 AC 1
Xs141_n_2 s141_n_2 0 adc_mim_bank COUNT=4
Vs141_n_3 s141_n_3 0 DC 0 AC 1
Xs141_n_3 s141_n_3 0 adc_mim_bank COUNT=8
Vs141_n_4 s141_n_4 0 DC 0 AC 1
Xs141_n_4 s141_n_4 0 adc_mim_bank COUNT=16
Vs141_n_5 s141_n_5 0 DC 0 AC 1
Xs141_n_5 s141_n_5 0 adc_mim_bank COUNT=32
Vs141_n_6 s141_n_6 0 DC 0 AC 1
Xs141_n_6 s141_n_6 0 adc_mim_bank COUNT=64
Vs141_n_7 s141_n_7 0 DC 0 AC 1
Xs141_n_7 s141_n_7 0 adc_mim_bank COUNT=128
Vs141_n_8 s141_n_8 0 DC 0 AC 1
Xs141_n_8 s141_n_8 0 adc_mim_bank COUNT=256
Vs141_n_9 s141_n_9 0 DC 0 AC 1
Xs141_n_9 s141_n_9 0 adc_mim_bank COUNT=512
Vs141_n_10 s141_n_10 0 DC 0 AC 1
Xs141_n_10 s141_n_10 0 adc_mim_bank COUNT=1024
Vs141_n_11 s141_n_11 0 DC 0 AC 1
Xs141_n_11 s141_n_11 0 adc_mim_bank COUNT=2048
Vs141_n_12 s141_n_12 0 DC 0 AC 1
Xs141_n_12 s141_n_12 0 adc_mim_bank COUNT=1
Vs142_p_0 s142_p_0 0 DC 0 AC 1
Xs142_p_0 s142_p_0 0 adc_mim_bank COUNT=1
Vs142_p_1 s142_p_1 0 DC 0 AC 1
Xs142_p_1 s142_p_1 0 adc_mim_bank COUNT=2
Vs142_p_2 s142_p_2 0 DC 0 AC 1
Xs142_p_2 s142_p_2 0 adc_mim_bank COUNT=4
Vs142_p_3 s142_p_3 0 DC 0 AC 1
Xs142_p_3 s142_p_3 0 adc_mim_bank COUNT=8
Vs142_p_4 s142_p_4 0 DC 0 AC 1
Xs142_p_4 s142_p_4 0 adc_mim_bank COUNT=16
Vs142_p_5 s142_p_5 0 DC 0 AC 1
Xs142_p_5 s142_p_5 0 adc_mim_bank COUNT=32
Vs142_p_6 s142_p_6 0 DC 0 AC 1
Xs142_p_6 s142_p_6 0 adc_mim_bank COUNT=64
Vs142_p_7 s142_p_7 0 DC 0 AC 1
Xs142_p_7 s142_p_7 0 adc_mim_bank COUNT=128
Vs142_p_8 s142_p_8 0 DC 0 AC 1
Xs142_p_8 s142_p_8 0 adc_mim_bank COUNT=256
Vs142_p_9 s142_p_9 0 DC 0 AC 1
Xs142_p_9 s142_p_9 0 adc_mim_bank COUNT=512
Vs142_p_10 s142_p_10 0 DC 0 AC 1
Xs142_p_10 s142_p_10 0 adc_mim_bank COUNT=1024
Vs142_p_11 s142_p_11 0 DC 0 AC 1
Xs142_p_11 s142_p_11 0 adc_mim_bank COUNT=2048
Vs142_p_12 s142_p_12 0 DC 0 AC 1
Xs142_p_12 s142_p_12 0 adc_mim_bank COUNT=1
Vs142_n_0 s142_n_0 0 DC 0 AC 1
Xs142_n_0 s142_n_0 0 adc_mim_bank COUNT=1
Vs142_n_1 s142_n_1 0 DC 0 AC 1
Xs142_n_1 s142_n_1 0 adc_mim_bank COUNT=2
Vs142_n_2 s142_n_2 0 DC 0 AC 1
Xs142_n_2 s142_n_2 0 adc_mim_bank COUNT=4
Vs142_n_3 s142_n_3 0 DC 0 AC 1
Xs142_n_3 s142_n_3 0 adc_mim_bank COUNT=8
Vs142_n_4 s142_n_4 0 DC 0 AC 1
Xs142_n_4 s142_n_4 0 adc_mim_bank COUNT=16
Vs142_n_5 s142_n_5 0 DC 0 AC 1
Xs142_n_5 s142_n_5 0 adc_mim_bank COUNT=32
Vs142_n_6 s142_n_6 0 DC 0 AC 1
Xs142_n_6 s142_n_6 0 adc_mim_bank COUNT=64
Vs142_n_7 s142_n_7 0 DC 0 AC 1
Xs142_n_7 s142_n_7 0 adc_mim_bank COUNT=128
Vs142_n_8 s142_n_8 0 DC 0 AC 1
Xs142_n_8 s142_n_8 0 adc_mim_bank COUNT=256
Vs142_n_9 s142_n_9 0 DC 0 AC 1
Xs142_n_9 s142_n_9 0 adc_mim_bank COUNT=512
Vs142_n_10 s142_n_10 0 DC 0 AC 1
Xs142_n_10 s142_n_10 0 adc_mim_bank COUNT=1024
Vs142_n_11 s142_n_11 0 DC 0 AC 1
Xs142_n_11 s142_n_11 0 adc_mim_bank COUNT=2048
Vs142_n_12 s142_n_12 0 DC 0 AC 1
Xs142_n_12 s142_n_12 0 adc_mim_bank COUNT=1
Vs143_p_0 s143_p_0 0 DC 0 AC 1
Xs143_p_0 s143_p_0 0 adc_mim_bank COUNT=1
Vs143_p_1 s143_p_1 0 DC 0 AC 1
Xs143_p_1 s143_p_1 0 adc_mim_bank COUNT=2
Vs143_p_2 s143_p_2 0 DC 0 AC 1
Xs143_p_2 s143_p_2 0 adc_mim_bank COUNT=4
Vs143_p_3 s143_p_3 0 DC 0 AC 1
Xs143_p_3 s143_p_3 0 adc_mim_bank COUNT=8
Vs143_p_4 s143_p_4 0 DC 0 AC 1
Xs143_p_4 s143_p_4 0 adc_mim_bank COUNT=16
Vs143_p_5 s143_p_5 0 DC 0 AC 1
Xs143_p_5 s143_p_5 0 adc_mim_bank COUNT=32
Vs143_p_6 s143_p_6 0 DC 0 AC 1
Xs143_p_6 s143_p_6 0 adc_mim_bank COUNT=64
Vs143_p_7 s143_p_7 0 DC 0 AC 1
Xs143_p_7 s143_p_7 0 adc_mim_bank COUNT=128
Vs143_p_8 s143_p_8 0 DC 0 AC 1
Xs143_p_8 s143_p_8 0 adc_mim_bank COUNT=256
Vs143_p_9 s143_p_9 0 DC 0 AC 1
Xs143_p_9 s143_p_9 0 adc_mim_bank COUNT=512
Vs143_p_10 s143_p_10 0 DC 0 AC 1
Xs143_p_10 s143_p_10 0 adc_mim_bank COUNT=1024
Vs143_p_11 s143_p_11 0 DC 0 AC 1
Xs143_p_11 s143_p_11 0 adc_mim_bank COUNT=2048
Vs143_p_12 s143_p_12 0 DC 0 AC 1
Xs143_p_12 s143_p_12 0 adc_mim_bank COUNT=1
Vs143_n_0 s143_n_0 0 DC 0 AC 1
Xs143_n_0 s143_n_0 0 adc_mim_bank COUNT=1
Vs143_n_1 s143_n_1 0 DC 0 AC 1
Xs143_n_1 s143_n_1 0 adc_mim_bank COUNT=2
Vs143_n_2 s143_n_2 0 DC 0 AC 1
Xs143_n_2 s143_n_2 0 adc_mim_bank COUNT=4
Vs143_n_3 s143_n_3 0 DC 0 AC 1
Xs143_n_3 s143_n_3 0 adc_mim_bank COUNT=8
Vs143_n_4 s143_n_4 0 DC 0 AC 1
Xs143_n_4 s143_n_4 0 adc_mim_bank COUNT=16
Vs143_n_5 s143_n_5 0 DC 0 AC 1
Xs143_n_5 s143_n_5 0 adc_mim_bank COUNT=32
Vs143_n_6 s143_n_6 0 DC 0 AC 1
Xs143_n_6 s143_n_6 0 adc_mim_bank COUNT=64
Vs143_n_7 s143_n_7 0 DC 0 AC 1
Xs143_n_7 s143_n_7 0 adc_mim_bank COUNT=128
Vs143_n_8 s143_n_8 0 DC 0 AC 1
Xs143_n_8 s143_n_8 0 adc_mim_bank COUNT=256
Vs143_n_9 s143_n_9 0 DC 0 AC 1
Xs143_n_9 s143_n_9 0 adc_mim_bank COUNT=512
Vs143_n_10 s143_n_10 0 DC 0 AC 1
Xs143_n_10 s143_n_10 0 adc_mim_bank COUNT=1024
Vs143_n_11 s143_n_11 0 DC 0 AC 1
Xs143_n_11 s143_n_11 0 adc_mim_bank COUNT=2048
Vs143_n_12 s143_n_12 0 DC 0 AC 1
Xs143_n_12 s143_n_12 0 adc_mim_bank COUNT=1
Vs144_p_0 s144_p_0 0 DC 0 AC 1
Xs144_p_0 s144_p_0 0 adc_mim_bank COUNT=1
Vs144_p_1 s144_p_1 0 DC 0 AC 1
Xs144_p_1 s144_p_1 0 adc_mim_bank COUNT=2
Vs144_p_2 s144_p_2 0 DC 0 AC 1
Xs144_p_2 s144_p_2 0 adc_mim_bank COUNT=4
Vs144_p_3 s144_p_3 0 DC 0 AC 1
Xs144_p_3 s144_p_3 0 adc_mim_bank COUNT=8
Vs144_p_4 s144_p_4 0 DC 0 AC 1
Xs144_p_4 s144_p_4 0 adc_mim_bank COUNT=16
Vs144_p_5 s144_p_5 0 DC 0 AC 1
Xs144_p_5 s144_p_5 0 adc_mim_bank COUNT=32
Vs144_p_6 s144_p_6 0 DC 0 AC 1
Xs144_p_6 s144_p_6 0 adc_mim_bank COUNT=64
Vs144_p_7 s144_p_7 0 DC 0 AC 1
Xs144_p_7 s144_p_7 0 adc_mim_bank COUNT=128
Vs144_p_8 s144_p_8 0 DC 0 AC 1
Xs144_p_8 s144_p_8 0 adc_mim_bank COUNT=256
Vs144_p_9 s144_p_9 0 DC 0 AC 1
Xs144_p_9 s144_p_9 0 adc_mim_bank COUNT=512
Vs144_p_10 s144_p_10 0 DC 0 AC 1
Xs144_p_10 s144_p_10 0 adc_mim_bank COUNT=1024
Vs144_p_11 s144_p_11 0 DC 0 AC 1
Xs144_p_11 s144_p_11 0 adc_mim_bank COUNT=2048
Vs144_p_12 s144_p_12 0 DC 0 AC 1
Xs144_p_12 s144_p_12 0 adc_mim_bank COUNT=1
Vs144_n_0 s144_n_0 0 DC 0 AC 1
Xs144_n_0 s144_n_0 0 adc_mim_bank COUNT=1
Vs144_n_1 s144_n_1 0 DC 0 AC 1
Xs144_n_1 s144_n_1 0 adc_mim_bank COUNT=2
Vs144_n_2 s144_n_2 0 DC 0 AC 1
Xs144_n_2 s144_n_2 0 adc_mim_bank COUNT=4
Vs144_n_3 s144_n_3 0 DC 0 AC 1
Xs144_n_3 s144_n_3 0 adc_mim_bank COUNT=8
Vs144_n_4 s144_n_4 0 DC 0 AC 1
Xs144_n_4 s144_n_4 0 adc_mim_bank COUNT=16
Vs144_n_5 s144_n_5 0 DC 0 AC 1
Xs144_n_5 s144_n_5 0 adc_mim_bank COUNT=32
Vs144_n_6 s144_n_6 0 DC 0 AC 1
Xs144_n_6 s144_n_6 0 adc_mim_bank COUNT=64
Vs144_n_7 s144_n_7 0 DC 0 AC 1
Xs144_n_7 s144_n_7 0 adc_mim_bank COUNT=128
Vs144_n_8 s144_n_8 0 DC 0 AC 1
Xs144_n_8 s144_n_8 0 adc_mim_bank COUNT=256
Vs144_n_9 s144_n_9 0 DC 0 AC 1
Xs144_n_9 s144_n_9 0 adc_mim_bank COUNT=512
Vs144_n_10 s144_n_10 0 DC 0 AC 1
Xs144_n_10 s144_n_10 0 adc_mim_bank COUNT=1024
Vs144_n_11 s144_n_11 0 DC 0 AC 1
Xs144_n_11 s144_n_11 0 adc_mim_bank COUNT=2048
Vs144_n_12 s144_n_12 0 DC 0 AC 1
Xs144_n_12 s144_n_12 0 adc_mim_bank COUNT=1
Vs145_p_0 s145_p_0 0 DC 0 AC 1
Xs145_p_0 s145_p_0 0 adc_mim_bank COUNT=1
Vs145_p_1 s145_p_1 0 DC 0 AC 1
Xs145_p_1 s145_p_1 0 adc_mim_bank COUNT=2
Vs145_p_2 s145_p_2 0 DC 0 AC 1
Xs145_p_2 s145_p_2 0 adc_mim_bank COUNT=4
Vs145_p_3 s145_p_3 0 DC 0 AC 1
Xs145_p_3 s145_p_3 0 adc_mim_bank COUNT=8
Vs145_p_4 s145_p_4 0 DC 0 AC 1
Xs145_p_4 s145_p_4 0 adc_mim_bank COUNT=16
Vs145_p_5 s145_p_5 0 DC 0 AC 1
Xs145_p_5 s145_p_5 0 adc_mim_bank COUNT=32
Vs145_p_6 s145_p_6 0 DC 0 AC 1
Xs145_p_6 s145_p_6 0 adc_mim_bank COUNT=64
Vs145_p_7 s145_p_7 0 DC 0 AC 1
Xs145_p_7 s145_p_7 0 adc_mim_bank COUNT=128
Vs145_p_8 s145_p_8 0 DC 0 AC 1
Xs145_p_8 s145_p_8 0 adc_mim_bank COUNT=256
Vs145_p_9 s145_p_9 0 DC 0 AC 1
Xs145_p_9 s145_p_9 0 adc_mim_bank COUNT=512
Vs145_p_10 s145_p_10 0 DC 0 AC 1
Xs145_p_10 s145_p_10 0 adc_mim_bank COUNT=1024
Vs145_p_11 s145_p_11 0 DC 0 AC 1
Xs145_p_11 s145_p_11 0 adc_mim_bank COUNT=2048
Vs145_p_12 s145_p_12 0 DC 0 AC 1
Xs145_p_12 s145_p_12 0 adc_mim_bank COUNT=1
Vs145_n_0 s145_n_0 0 DC 0 AC 1
Xs145_n_0 s145_n_0 0 adc_mim_bank COUNT=1
Vs145_n_1 s145_n_1 0 DC 0 AC 1
Xs145_n_1 s145_n_1 0 adc_mim_bank COUNT=2
Vs145_n_2 s145_n_2 0 DC 0 AC 1
Xs145_n_2 s145_n_2 0 adc_mim_bank COUNT=4
Vs145_n_3 s145_n_3 0 DC 0 AC 1
Xs145_n_3 s145_n_3 0 adc_mim_bank COUNT=8
Vs145_n_4 s145_n_4 0 DC 0 AC 1
Xs145_n_4 s145_n_4 0 adc_mim_bank COUNT=16
Vs145_n_5 s145_n_5 0 DC 0 AC 1
Xs145_n_5 s145_n_5 0 adc_mim_bank COUNT=32
Vs145_n_6 s145_n_6 0 DC 0 AC 1
Xs145_n_6 s145_n_6 0 adc_mim_bank COUNT=64
Vs145_n_7 s145_n_7 0 DC 0 AC 1
Xs145_n_7 s145_n_7 0 adc_mim_bank COUNT=128
Vs145_n_8 s145_n_8 0 DC 0 AC 1
Xs145_n_8 s145_n_8 0 adc_mim_bank COUNT=256
Vs145_n_9 s145_n_9 0 DC 0 AC 1
Xs145_n_9 s145_n_9 0 adc_mim_bank COUNT=512
Vs145_n_10 s145_n_10 0 DC 0 AC 1
Xs145_n_10 s145_n_10 0 adc_mim_bank COUNT=1024
Vs145_n_11 s145_n_11 0 DC 0 AC 1
Xs145_n_11 s145_n_11 0 adc_mim_bank COUNT=2048
Vs145_n_12 s145_n_12 0 DC 0 AC 1
Xs145_n_12 s145_n_12 0 adc_mim_bank COUNT=1
Vs146_p_0 s146_p_0 0 DC 0 AC 1
Xs146_p_0 s146_p_0 0 adc_mim_bank COUNT=1
Vs146_p_1 s146_p_1 0 DC 0 AC 1
Xs146_p_1 s146_p_1 0 adc_mim_bank COUNT=2
Vs146_p_2 s146_p_2 0 DC 0 AC 1
Xs146_p_2 s146_p_2 0 adc_mim_bank COUNT=4
Vs146_p_3 s146_p_3 0 DC 0 AC 1
Xs146_p_3 s146_p_3 0 adc_mim_bank COUNT=8
Vs146_p_4 s146_p_4 0 DC 0 AC 1
Xs146_p_4 s146_p_4 0 adc_mim_bank COUNT=16
Vs146_p_5 s146_p_5 0 DC 0 AC 1
Xs146_p_5 s146_p_5 0 adc_mim_bank COUNT=32
Vs146_p_6 s146_p_6 0 DC 0 AC 1
Xs146_p_6 s146_p_6 0 adc_mim_bank COUNT=64
Vs146_p_7 s146_p_7 0 DC 0 AC 1
Xs146_p_7 s146_p_7 0 adc_mim_bank COUNT=128
Vs146_p_8 s146_p_8 0 DC 0 AC 1
Xs146_p_8 s146_p_8 0 adc_mim_bank COUNT=256
Vs146_p_9 s146_p_9 0 DC 0 AC 1
Xs146_p_9 s146_p_9 0 adc_mim_bank COUNT=512
Vs146_p_10 s146_p_10 0 DC 0 AC 1
Xs146_p_10 s146_p_10 0 adc_mim_bank COUNT=1024
Vs146_p_11 s146_p_11 0 DC 0 AC 1
Xs146_p_11 s146_p_11 0 adc_mim_bank COUNT=2048
Vs146_p_12 s146_p_12 0 DC 0 AC 1
Xs146_p_12 s146_p_12 0 adc_mim_bank COUNT=1
Vs146_n_0 s146_n_0 0 DC 0 AC 1
Xs146_n_0 s146_n_0 0 adc_mim_bank COUNT=1
Vs146_n_1 s146_n_1 0 DC 0 AC 1
Xs146_n_1 s146_n_1 0 adc_mim_bank COUNT=2
Vs146_n_2 s146_n_2 0 DC 0 AC 1
Xs146_n_2 s146_n_2 0 adc_mim_bank COUNT=4
Vs146_n_3 s146_n_3 0 DC 0 AC 1
Xs146_n_3 s146_n_3 0 adc_mim_bank COUNT=8
Vs146_n_4 s146_n_4 0 DC 0 AC 1
Xs146_n_4 s146_n_4 0 adc_mim_bank COUNT=16
Vs146_n_5 s146_n_5 0 DC 0 AC 1
Xs146_n_5 s146_n_5 0 adc_mim_bank COUNT=32
Vs146_n_6 s146_n_6 0 DC 0 AC 1
Xs146_n_6 s146_n_6 0 adc_mim_bank COUNT=64
Vs146_n_7 s146_n_7 0 DC 0 AC 1
Xs146_n_7 s146_n_7 0 adc_mim_bank COUNT=128
Vs146_n_8 s146_n_8 0 DC 0 AC 1
Xs146_n_8 s146_n_8 0 adc_mim_bank COUNT=256
Vs146_n_9 s146_n_9 0 DC 0 AC 1
Xs146_n_9 s146_n_9 0 adc_mim_bank COUNT=512
Vs146_n_10 s146_n_10 0 DC 0 AC 1
Xs146_n_10 s146_n_10 0 adc_mim_bank COUNT=1024
Vs146_n_11 s146_n_11 0 DC 0 AC 1
Xs146_n_11 s146_n_11 0 adc_mim_bank COUNT=2048
Vs146_n_12 s146_n_12 0 DC 0 AC 1
Xs146_n_12 s146_n_12 0 adc_mim_bank COUNT=1
Vs147_p_0 s147_p_0 0 DC 0 AC 1
Xs147_p_0 s147_p_0 0 adc_mim_bank COUNT=1
Vs147_p_1 s147_p_1 0 DC 0 AC 1
Xs147_p_1 s147_p_1 0 adc_mim_bank COUNT=2
Vs147_p_2 s147_p_2 0 DC 0 AC 1
Xs147_p_2 s147_p_2 0 adc_mim_bank COUNT=4
Vs147_p_3 s147_p_3 0 DC 0 AC 1
Xs147_p_3 s147_p_3 0 adc_mim_bank COUNT=8
Vs147_p_4 s147_p_4 0 DC 0 AC 1
Xs147_p_4 s147_p_4 0 adc_mim_bank COUNT=16
Vs147_p_5 s147_p_5 0 DC 0 AC 1
Xs147_p_5 s147_p_5 0 adc_mim_bank COUNT=32
Vs147_p_6 s147_p_6 0 DC 0 AC 1
Xs147_p_6 s147_p_6 0 adc_mim_bank COUNT=64
Vs147_p_7 s147_p_7 0 DC 0 AC 1
Xs147_p_7 s147_p_7 0 adc_mim_bank COUNT=128
Vs147_p_8 s147_p_8 0 DC 0 AC 1
Xs147_p_8 s147_p_8 0 adc_mim_bank COUNT=256
Vs147_p_9 s147_p_9 0 DC 0 AC 1
Xs147_p_9 s147_p_9 0 adc_mim_bank COUNT=512
Vs147_p_10 s147_p_10 0 DC 0 AC 1
Xs147_p_10 s147_p_10 0 adc_mim_bank COUNT=1024
Vs147_p_11 s147_p_11 0 DC 0 AC 1
Xs147_p_11 s147_p_11 0 adc_mim_bank COUNT=2048
Vs147_p_12 s147_p_12 0 DC 0 AC 1
Xs147_p_12 s147_p_12 0 adc_mim_bank COUNT=1
Vs147_n_0 s147_n_0 0 DC 0 AC 1
Xs147_n_0 s147_n_0 0 adc_mim_bank COUNT=1
Vs147_n_1 s147_n_1 0 DC 0 AC 1
Xs147_n_1 s147_n_1 0 adc_mim_bank COUNT=2
Vs147_n_2 s147_n_2 0 DC 0 AC 1
Xs147_n_2 s147_n_2 0 adc_mim_bank COUNT=4
Vs147_n_3 s147_n_3 0 DC 0 AC 1
Xs147_n_3 s147_n_3 0 adc_mim_bank COUNT=8
Vs147_n_4 s147_n_4 0 DC 0 AC 1
Xs147_n_4 s147_n_4 0 adc_mim_bank COUNT=16
Vs147_n_5 s147_n_5 0 DC 0 AC 1
Xs147_n_5 s147_n_5 0 adc_mim_bank COUNT=32
Vs147_n_6 s147_n_6 0 DC 0 AC 1
Xs147_n_6 s147_n_6 0 adc_mim_bank COUNT=64
Vs147_n_7 s147_n_7 0 DC 0 AC 1
Xs147_n_7 s147_n_7 0 adc_mim_bank COUNT=128
Vs147_n_8 s147_n_8 0 DC 0 AC 1
Xs147_n_8 s147_n_8 0 adc_mim_bank COUNT=256
Vs147_n_9 s147_n_9 0 DC 0 AC 1
Xs147_n_9 s147_n_9 0 adc_mim_bank COUNT=512
Vs147_n_10 s147_n_10 0 DC 0 AC 1
Xs147_n_10 s147_n_10 0 adc_mim_bank COUNT=1024
Vs147_n_11 s147_n_11 0 DC 0 AC 1
Xs147_n_11 s147_n_11 0 adc_mim_bank COUNT=2048
Vs147_n_12 s147_n_12 0 DC 0 AC 1
Xs147_n_12 s147_n_12 0 adc_mim_bank COUNT=1
Vs148_p_0 s148_p_0 0 DC 0 AC 1
Xs148_p_0 s148_p_0 0 adc_mim_bank COUNT=1
Vs148_p_1 s148_p_1 0 DC 0 AC 1
Xs148_p_1 s148_p_1 0 adc_mim_bank COUNT=2
Vs148_p_2 s148_p_2 0 DC 0 AC 1
Xs148_p_2 s148_p_2 0 adc_mim_bank COUNT=4
Vs148_p_3 s148_p_3 0 DC 0 AC 1
Xs148_p_3 s148_p_3 0 adc_mim_bank COUNT=8
Vs148_p_4 s148_p_4 0 DC 0 AC 1
Xs148_p_4 s148_p_4 0 adc_mim_bank COUNT=16
Vs148_p_5 s148_p_5 0 DC 0 AC 1
Xs148_p_5 s148_p_5 0 adc_mim_bank COUNT=32
Vs148_p_6 s148_p_6 0 DC 0 AC 1
Xs148_p_6 s148_p_6 0 adc_mim_bank COUNT=64
Vs148_p_7 s148_p_7 0 DC 0 AC 1
Xs148_p_7 s148_p_7 0 adc_mim_bank COUNT=128
Vs148_p_8 s148_p_8 0 DC 0 AC 1
Xs148_p_8 s148_p_8 0 adc_mim_bank COUNT=256
Vs148_p_9 s148_p_9 0 DC 0 AC 1
Xs148_p_9 s148_p_9 0 adc_mim_bank COUNT=512
Vs148_p_10 s148_p_10 0 DC 0 AC 1
Xs148_p_10 s148_p_10 0 adc_mim_bank COUNT=1024
Vs148_p_11 s148_p_11 0 DC 0 AC 1
Xs148_p_11 s148_p_11 0 adc_mim_bank COUNT=2048
Vs148_p_12 s148_p_12 0 DC 0 AC 1
Xs148_p_12 s148_p_12 0 adc_mim_bank COUNT=1
Vs148_n_0 s148_n_0 0 DC 0 AC 1
Xs148_n_0 s148_n_0 0 adc_mim_bank COUNT=1
Vs148_n_1 s148_n_1 0 DC 0 AC 1
Xs148_n_1 s148_n_1 0 adc_mim_bank COUNT=2
Vs148_n_2 s148_n_2 0 DC 0 AC 1
Xs148_n_2 s148_n_2 0 adc_mim_bank COUNT=4
Vs148_n_3 s148_n_3 0 DC 0 AC 1
Xs148_n_3 s148_n_3 0 adc_mim_bank COUNT=8
Vs148_n_4 s148_n_4 0 DC 0 AC 1
Xs148_n_4 s148_n_4 0 adc_mim_bank COUNT=16
Vs148_n_5 s148_n_5 0 DC 0 AC 1
Xs148_n_5 s148_n_5 0 adc_mim_bank COUNT=32
Vs148_n_6 s148_n_6 0 DC 0 AC 1
Xs148_n_6 s148_n_6 0 adc_mim_bank COUNT=64
Vs148_n_7 s148_n_7 0 DC 0 AC 1
Xs148_n_7 s148_n_7 0 adc_mim_bank COUNT=128
Vs148_n_8 s148_n_8 0 DC 0 AC 1
Xs148_n_8 s148_n_8 0 adc_mim_bank COUNT=256
Vs148_n_9 s148_n_9 0 DC 0 AC 1
Xs148_n_9 s148_n_9 0 adc_mim_bank COUNT=512
Vs148_n_10 s148_n_10 0 DC 0 AC 1
Xs148_n_10 s148_n_10 0 adc_mim_bank COUNT=1024
Vs148_n_11 s148_n_11 0 DC 0 AC 1
Xs148_n_11 s148_n_11 0 adc_mim_bank COUNT=2048
Vs148_n_12 s148_n_12 0 DC 0 AC 1
Xs148_n_12 s148_n_12 0 adc_mim_bank COUNT=1
Vs149_p_0 s149_p_0 0 DC 0 AC 1
Xs149_p_0 s149_p_0 0 adc_mim_bank COUNT=1
Vs149_p_1 s149_p_1 0 DC 0 AC 1
Xs149_p_1 s149_p_1 0 adc_mim_bank COUNT=2
Vs149_p_2 s149_p_2 0 DC 0 AC 1
Xs149_p_2 s149_p_2 0 adc_mim_bank COUNT=4
Vs149_p_3 s149_p_3 0 DC 0 AC 1
Xs149_p_3 s149_p_3 0 adc_mim_bank COUNT=8
Vs149_p_4 s149_p_4 0 DC 0 AC 1
Xs149_p_4 s149_p_4 0 adc_mim_bank COUNT=16
Vs149_p_5 s149_p_5 0 DC 0 AC 1
Xs149_p_5 s149_p_5 0 adc_mim_bank COUNT=32
Vs149_p_6 s149_p_6 0 DC 0 AC 1
Xs149_p_6 s149_p_6 0 adc_mim_bank COUNT=64
Vs149_p_7 s149_p_7 0 DC 0 AC 1
Xs149_p_7 s149_p_7 0 adc_mim_bank COUNT=128
Vs149_p_8 s149_p_8 0 DC 0 AC 1
Xs149_p_8 s149_p_8 0 adc_mim_bank COUNT=256
Vs149_p_9 s149_p_9 0 DC 0 AC 1
Xs149_p_9 s149_p_9 0 adc_mim_bank COUNT=512
Vs149_p_10 s149_p_10 0 DC 0 AC 1
Xs149_p_10 s149_p_10 0 adc_mim_bank COUNT=1024
Vs149_p_11 s149_p_11 0 DC 0 AC 1
Xs149_p_11 s149_p_11 0 adc_mim_bank COUNT=2048
Vs149_p_12 s149_p_12 0 DC 0 AC 1
Xs149_p_12 s149_p_12 0 adc_mim_bank COUNT=1
Vs149_n_0 s149_n_0 0 DC 0 AC 1
Xs149_n_0 s149_n_0 0 adc_mim_bank COUNT=1
Vs149_n_1 s149_n_1 0 DC 0 AC 1
Xs149_n_1 s149_n_1 0 adc_mim_bank COUNT=2
Vs149_n_2 s149_n_2 0 DC 0 AC 1
Xs149_n_2 s149_n_2 0 adc_mim_bank COUNT=4
Vs149_n_3 s149_n_3 0 DC 0 AC 1
Xs149_n_3 s149_n_3 0 adc_mim_bank COUNT=8
Vs149_n_4 s149_n_4 0 DC 0 AC 1
Xs149_n_4 s149_n_4 0 adc_mim_bank COUNT=16
Vs149_n_5 s149_n_5 0 DC 0 AC 1
Xs149_n_5 s149_n_5 0 adc_mim_bank COUNT=32
Vs149_n_6 s149_n_6 0 DC 0 AC 1
Xs149_n_6 s149_n_6 0 adc_mim_bank COUNT=64
Vs149_n_7 s149_n_7 0 DC 0 AC 1
Xs149_n_7 s149_n_7 0 adc_mim_bank COUNT=128
Vs149_n_8 s149_n_8 0 DC 0 AC 1
Xs149_n_8 s149_n_8 0 adc_mim_bank COUNT=256
Vs149_n_9 s149_n_9 0 DC 0 AC 1
Xs149_n_9 s149_n_9 0 adc_mim_bank COUNT=512
Vs149_n_10 s149_n_10 0 DC 0 AC 1
Xs149_n_10 s149_n_10 0 adc_mim_bank COUNT=1024
Vs149_n_11 s149_n_11 0 DC 0 AC 1
Xs149_n_11 s149_n_11 0 adc_mim_bank COUNT=2048
Vs149_n_12 s149_n_12 0 DC 0 AC 1
Xs149_n_12 s149_n_12 0 adc_mim_bank COUNT=1
Vs150_p_0 s150_p_0 0 DC 0 AC 1
Xs150_p_0 s150_p_0 0 adc_mim_bank COUNT=1
Vs150_p_1 s150_p_1 0 DC 0 AC 1
Xs150_p_1 s150_p_1 0 adc_mim_bank COUNT=2
Vs150_p_2 s150_p_2 0 DC 0 AC 1
Xs150_p_2 s150_p_2 0 adc_mim_bank COUNT=4
Vs150_p_3 s150_p_3 0 DC 0 AC 1
Xs150_p_3 s150_p_3 0 adc_mim_bank COUNT=8
Vs150_p_4 s150_p_4 0 DC 0 AC 1
Xs150_p_4 s150_p_4 0 adc_mim_bank COUNT=16
Vs150_p_5 s150_p_5 0 DC 0 AC 1
Xs150_p_5 s150_p_5 0 adc_mim_bank COUNT=32
Vs150_p_6 s150_p_6 0 DC 0 AC 1
Xs150_p_6 s150_p_6 0 adc_mim_bank COUNT=64
Vs150_p_7 s150_p_7 0 DC 0 AC 1
Xs150_p_7 s150_p_7 0 adc_mim_bank COUNT=128
Vs150_p_8 s150_p_8 0 DC 0 AC 1
Xs150_p_8 s150_p_8 0 adc_mim_bank COUNT=256
Vs150_p_9 s150_p_9 0 DC 0 AC 1
Xs150_p_9 s150_p_9 0 adc_mim_bank COUNT=512
Vs150_p_10 s150_p_10 0 DC 0 AC 1
Xs150_p_10 s150_p_10 0 adc_mim_bank COUNT=1024
Vs150_p_11 s150_p_11 0 DC 0 AC 1
Xs150_p_11 s150_p_11 0 adc_mim_bank COUNT=2048
Vs150_p_12 s150_p_12 0 DC 0 AC 1
Xs150_p_12 s150_p_12 0 adc_mim_bank COUNT=1
Vs150_n_0 s150_n_0 0 DC 0 AC 1
Xs150_n_0 s150_n_0 0 adc_mim_bank COUNT=1
Vs150_n_1 s150_n_1 0 DC 0 AC 1
Xs150_n_1 s150_n_1 0 adc_mim_bank COUNT=2
Vs150_n_2 s150_n_2 0 DC 0 AC 1
Xs150_n_2 s150_n_2 0 adc_mim_bank COUNT=4
Vs150_n_3 s150_n_3 0 DC 0 AC 1
Xs150_n_3 s150_n_3 0 adc_mim_bank COUNT=8
Vs150_n_4 s150_n_4 0 DC 0 AC 1
Xs150_n_4 s150_n_4 0 adc_mim_bank COUNT=16
Vs150_n_5 s150_n_5 0 DC 0 AC 1
Xs150_n_5 s150_n_5 0 adc_mim_bank COUNT=32
Vs150_n_6 s150_n_6 0 DC 0 AC 1
Xs150_n_6 s150_n_6 0 adc_mim_bank COUNT=64
Vs150_n_7 s150_n_7 0 DC 0 AC 1
Xs150_n_7 s150_n_7 0 adc_mim_bank COUNT=128
Vs150_n_8 s150_n_8 0 DC 0 AC 1
Xs150_n_8 s150_n_8 0 adc_mim_bank COUNT=256
Vs150_n_9 s150_n_9 0 DC 0 AC 1
Xs150_n_9 s150_n_9 0 adc_mim_bank COUNT=512
Vs150_n_10 s150_n_10 0 DC 0 AC 1
Xs150_n_10 s150_n_10 0 adc_mim_bank COUNT=1024
Vs150_n_11 s150_n_11 0 DC 0 AC 1
Xs150_n_11 s150_n_11 0 adc_mim_bank COUNT=2048
Vs150_n_12 s150_n_12 0 DC 0 AC 1
Xs150_n_12 s150_n_12 0 adc_mim_bank COUNT=1
Vs151_p_0 s151_p_0 0 DC 0 AC 1
Xs151_p_0 s151_p_0 0 adc_mim_bank COUNT=1
Vs151_p_1 s151_p_1 0 DC 0 AC 1
Xs151_p_1 s151_p_1 0 adc_mim_bank COUNT=2
Vs151_p_2 s151_p_2 0 DC 0 AC 1
Xs151_p_2 s151_p_2 0 adc_mim_bank COUNT=4
Vs151_p_3 s151_p_3 0 DC 0 AC 1
Xs151_p_3 s151_p_3 0 adc_mim_bank COUNT=8
Vs151_p_4 s151_p_4 0 DC 0 AC 1
Xs151_p_4 s151_p_4 0 adc_mim_bank COUNT=16
Vs151_p_5 s151_p_5 0 DC 0 AC 1
Xs151_p_5 s151_p_5 0 adc_mim_bank COUNT=32
Vs151_p_6 s151_p_6 0 DC 0 AC 1
Xs151_p_6 s151_p_6 0 adc_mim_bank COUNT=64
Vs151_p_7 s151_p_7 0 DC 0 AC 1
Xs151_p_7 s151_p_7 0 adc_mim_bank COUNT=128
Vs151_p_8 s151_p_8 0 DC 0 AC 1
Xs151_p_8 s151_p_8 0 adc_mim_bank COUNT=256
Vs151_p_9 s151_p_9 0 DC 0 AC 1
Xs151_p_9 s151_p_9 0 adc_mim_bank COUNT=512
Vs151_p_10 s151_p_10 0 DC 0 AC 1
Xs151_p_10 s151_p_10 0 adc_mim_bank COUNT=1024
Vs151_p_11 s151_p_11 0 DC 0 AC 1
Xs151_p_11 s151_p_11 0 adc_mim_bank COUNT=2048
Vs151_p_12 s151_p_12 0 DC 0 AC 1
Xs151_p_12 s151_p_12 0 adc_mim_bank COUNT=1
Vs151_n_0 s151_n_0 0 DC 0 AC 1
Xs151_n_0 s151_n_0 0 adc_mim_bank COUNT=1
Vs151_n_1 s151_n_1 0 DC 0 AC 1
Xs151_n_1 s151_n_1 0 adc_mim_bank COUNT=2
Vs151_n_2 s151_n_2 0 DC 0 AC 1
Xs151_n_2 s151_n_2 0 adc_mim_bank COUNT=4
Vs151_n_3 s151_n_3 0 DC 0 AC 1
Xs151_n_3 s151_n_3 0 adc_mim_bank COUNT=8
Vs151_n_4 s151_n_4 0 DC 0 AC 1
Xs151_n_4 s151_n_4 0 adc_mim_bank COUNT=16
Vs151_n_5 s151_n_5 0 DC 0 AC 1
Xs151_n_5 s151_n_5 0 adc_mim_bank COUNT=32
Vs151_n_6 s151_n_6 0 DC 0 AC 1
Xs151_n_6 s151_n_6 0 adc_mim_bank COUNT=64
Vs151_n_7 s151_n_7 0 DC 0 AC 1
Xs151_n_7 s151_n_7 0 adc_mim_bank COUNT=128
Vs151_n_8 s151_n_8 0 DC 0 AC 1
Xs151_n_8 s151_n_8 0 adc_mim_bank COUNT=256
Vs151_n_9 s151_n_9 0 DC 0 AC 1
Xs151_n_9 s151_n_9 0 adc_mim_bank COUNT=512
Vs151_n_10 s151_n_10 0 DC 0 AC 1
Xs151_n_10 s151_n_10 0 adc_mim_bank COUNT=1024
Vs151_n_11 s151_n_11 0 DC 0 AC 1
Xs151_n_11 s151_n_11 0 adc_mim_bank COUNT=2048
Vs151_n_12 s151_n_12 0 DC 0 AC 1
Xs151_n_12 s151_n_12 0 adc_mim_bank COUNT=1
Vs152_p_0 s152_p_0 0 DC 0 AC 1
Xs152_p_0 s152_p_0 0 adc_mim_bank COUNT=1
Vs152_p_1 s152_p_1 0 DC 0 AC 1
Xs152_p_1 s152_p_1 0 adc_mim_bank COUNT=2
Vs152_p_2 s152_p_2 0 DC 0 AC 1
Xs152_p_2 s152_p_2 0 adc_mim_bank COUNT=4
Vs152_p_3 s152_p_3 0 DC 0 AC 1
Xs152_p_3 s152_p_3 0 adc_mim_bank COUNT=8
Vs152_p_4 s152_p_4 0 DC 0 AC 1
Xs152_p_4 s152_p_4 0 adc_mim_bank COUNT=16
Vs152_p_5 s152_p_5 0 DC 0 AC 1
Xs152_p_5 s152_p_5 0 adc_mim_bank COUNT=32
Vs152_p_6 s152_p_6 0 DC 0 AC 1
Xs152_p_6 s152_p_6 0 adc_mim_bank COUNT=64
Vs152_p_7 s152_p_7 0 DC 0 AC 1
Xs152_p_7 s152_p_7 0 adc_mim_bank COUNT=128
Vs152_p_8 s152_p_8 0 DC 0 AC 1
Xs152_p_8 s152_p_8 0 adc_mim_bank COUNT=256
Vs152_p_9 s152_p_9 0 DC 0 AC 1
Xs152_p_9 s152_p_9 0 adc_mim_bank COUNT=512
Vs152_p_10 s152_p_10 0 DC 0 AC 1
Xs152_p_10 s152_p_10 0 adc_mim_bank COUNT=1024
Vs152_p_11 s152_p_11 0 DC 0 AC 1
Xs152_p_11 s152_p_11 0 adc_mim_bank COUNT=2048
Vs152_p_12 s152_p_12 0 DC 0 AC 1
Xs152_p_12 s152_p_12 0 adc_mim_bank COUNT=1
Vs152_n_0 s152_n_0 0 DC 0 AC 1
Xs152_n_0 s152_n_0 0 adc_mim_bank COUNT=1
Vs152_n_1 s152_n_1 0 DC 0 AC 1
Xs152_n_1 s152_n_1 0 adc_mim_bank COUNT=2
Vs152_n_2 s152_n_2 0 DC 0 AC 1
Xs152_n_2 s152_n_2 0 adc_mim_bank COUNT=4
Vs152_n_3 s152_n_3 0 DC 0 AC 1
Xs152_n_3 s152_n_3 0 adc_mim_bank COUNT=8
Vs152_n_4 s152_n_4 0 DC 0 AC 1
Xs152_n_4 s152_n_4 0 adc_mim_bank COUNT=16
Vs152_n_5 s152_n_5 0 DC 0 AC 1
Xs152_n_5 s152_n_5 0 adc_mim_bank COUNT=32
Vs152_n_6 s152_n_6 0 DC 0 AC 1
Xs152_n_6 s152_n_6 0 adc_mim_bank COUNT=64
Vs152_n_7 s152_n_7 0 DC 0 AC 1
Xs152_n_7 s152_n_7 0 adc_mim_bank COUNT=128
Vs152_n_8 s152_n_8 0 DC 0 AC 1
Xs152_n_8 s152_n_8 0 adc_mim_bank COUNT=256
Vs152_n_9 s152_n_9 0 DC 0 AC 1
Xs152_n_9 s152_n_9 0 adc_mim_bank COUNT=512
Vs152_n_10 s152_n_10 0 DC 0 AC 1
Xs152_n_10 s152_n_10 0 adc_mim_bank COUNT=1024
Vs152_n_11 s152_n_11 0 DC 0 AC 1
Xs152_n_11 s152_n_11 0 adc_mim_bank COUNT=2048
Vs152_n_12 s152_n_12 0 DC 0 AC 1
Xs152_n_12 s152_n_12 0 adc_mim_bank COUNT=1
Vs153_p_0 s153_p_0 0 DC 0 AC 1
Xs153_p_0 s153_p_0 0 adc_mim_bank COUNT=1
Vs153_p_1 s153_p_1 0 DC 0 AC 1
Xs153_p_1 s153_p_1 0 adc_mim_bank COUNT=2
Vs153_p_2 s153_p_2 0 DC 0 AC 1
Xs153_p_2 s153_p_2 0 adc_mim_bank COUNT=4
Vs153_p_3 s153_p_3 0 DC 0 AC 1
Xs153_p_3 s153_p_3 0 adc_mim_bank COUNT=8
Vs153_p_4 s153_p_4 0 DC 0 AC 1
Xs153_p_4 s153_p_4 0 adc_mim_bank COUNT=16
Vs153_p_5 s153_p_5 0 DC 0 AC 1
Xs153_p_5 s153_p_5 0 adc_mim_bank COUNT=32
Vs153_p_6 s153_p_6 0 DC 0 AC 1
Xs153_p_6 s153_p_6 0 adc_mim_bank COUNT=64
Vs153_p_7 s153_p_7 0 DC 0 AC 1
Xs153_p_7 s153_p_7 0 adc_mim_bank COUNT=128
Vs153_p_8 s153_p_8 0 DC 0 AC 1
Xs153_p_8 s153_p_8 0 adc_mim_bank COUNT=256
Vs153_p_9 s153_p_9 0 DC 0 AC 1
Xs153_p_9 s153_p_9 0 adc_mim_bank COUNT=512
Vs153_p_10 s153_p_10 0 DC 0 AC 1
Xs153_p_10 s153_p_10 0 adc_mim_bank COUNT=1024
Vs153_p_11 s153_p_11 0 DC 0 AC 1
Xs153_p_11 s153_p_11 0 adc_mim_bank COUNT=2048
Vs153_p_12 s153_p_12 0 DC 0 AC 1
Xs153_p_12 s153_p_12 0 adc_mim_bank COUNT=1
Vs153_n_0 s153_n_0 0 DC 0 AC 1
Xs153_n_0 s153_n_0 0 adc_mim_bank COUNT=1
Vs153_n_1 s153_n_1 0 DC 0 AC 1
Xs153_n_1 s153_n_1 0 adc_mim_bank COUNT=2
Vs153_n_2 s153_n_2 0 DC 0 AC 1
Xs153_n_2 s153_n_2 0 adc_mim_bank COUNT=4
Vs153_n_3 s153_n_3 0 DC 0 AC 1
Xs153_n_3 s153_n_3 0 adc_mim_bank COUNT=8
Vs153_n_4 s153_n_4 0 DC 0 AC 1
Xs153_n_4 s153_n_4 0 adc_mim_bank COUNT=16
Vs153_n_5 s153_n_5 0 DC 0 AC 1
Xs153_n_5 s153_n_5 0 adc_mim_bank COUNT=32
Vs153_n_6 s153_n_6 0 DC 0 AC 1
Xs153_n_6 s153_n_6 0 adc_mim_bank COUNT=64
Vs153_n_7 s153_n_7 0 DC 0 AC 1
Xs153_n_7 s153_n_7 0 adc_mim_bank COUNT=128
Vs153_n_8 s153_n_8 0 DC 0 AC 1
Xs153_n_8 s153_n_8 0 adc_mim_bank COUNT=256
Vs153_n_9 s153_n_9 0 DC 0 AC 1
Xs153_n_9 s153_n_9 0 adc_mim_bank COUNT=512
Vs153_n_10 s153_n_10 0 DC 0 AC 1
Xs153_n_10 s153_n_10 0 adc_mim_bank COUNT=1024
Vs153_n_11 s153_n_11 0 DC 0 AC 1
Xs153_n_11 s153_n_11 0 adc_mim_bank COUNT=2048
Vs153_n_12 s153_n_12 0 DC 0 AC 1
Xs153_n_12 s153_n_12 0 adc_mim_bank COUNT=1
Vs154_p_0 s154_p_0 0 DC 0 AC 1
Xs154_p_0 s154_p_0 0 adc_mim_bank COUNT=1
Vs154_p_1 s154_p_1 0 DC 0 AC 1
Xs154_p_1 s154_p_1 0 adc_mim_bank COUNT=2
Vs154_p_2 s154_p_2 0 DC 0 AC 1
Xs154_p_2 s154_p_2 0 adc_mim_bank COUNT=4
Vs154_p_3 s154_p_3 0 DC 0 AC 1
Xs154_p_3 s154_p_3 0 adc_mim_bank COUNT=8
Vs154_p_4 s154_p_4 0 DC 0 AC 1
Xs154_p_4 s154_p_4 0 adc_mim_bank COUNT=16
Vs154_p_5 s154_p_5 0 DC 0 AC 1
Xs154_p_5 s154_p_5 0 adc_mim_bank COUNT=32
Vs154_p_6 s154_p_6 0 DC 0 AC 1
Xs154_p_6 s154_p_6 0 adc_mim_bank COUNT=64
Vs154_p_7 s154_p_7 0 DC 0 AC 1
Xs154_p_7 s154_p_7 0 adc_mim_bank COUNT=128
Vs154_p_8 s154_p_8 0 DC 0 AC 1
Xs154_p_8 s154_p_8 0 adc_mim_bank COUNT=256
Vs154_p_9 s154_p_9 0 DC 0 AC 1
Xs154_p_9 s154_p_9 0 adc_mim_bank COUNT=512
Vs154_p_10 s154_p_10 0 DC 0 AC 1
Xs154_p_10 s154_p_10 0 adc_mim_bank COUNT=1024
Vs154_p_11 s154_p_11 0 DC 0 AC 1
Xs154_p_11 s154_p_11 0 adc_mim_bank COUNT=2048
Vs154_p_12 s154_p_12 0 DC 0 AC 1
Xs154_p_12 s154_p_12 0 adc_mim_bank COUNT=1
Vs154_n_0 s154_n_0 0 DC 0 AC 1
Xs154_n_0 s154_n_0 0 adc_mim_bank COUNT=1
Vs154_n_1 s154_n_1 0 DC 0 AC 1
Xs154_n_1 s154_n_1 0 adc_mim_bank COUNT=2
Vs154_n_2 s154_n_2 0 DC 0 AC 1
Xs154_n_2 s154_n_2 0 adc_mim_bank COUNT=4
Vs154_n_3 s154_n_3 0 DC 0 AC 1
Xs154_n_3 s154_n_3 0 adc_mim_bank COUNT=8
Vs154_n_4 s154_n_4 0 DC 0 AC 1
Xs154_n_4 s154_n_4 0 adc_mim_bank COUNT=16
Vs154_n_5 s154_n_5 0 DC 0 AC 1
Xs154_n_5 s154_n_5 0 adc_mim_bank COUNT=32
Vs154_n_6 s154_n_6 0 DC 0 AC 1
Xs154_n_6 s154_n_6 0 adc_mim_bank COUNT=64
Vs154_n_7 s154_n_7 0 DC 0 AC 1
Xs154_n_7 s154_n_7 0 adc_mim_bank COUNT=128
Vs154_n_8 s154_n_8 0 DC 0 AC 1
Xs154_n_8 s154_n_8 0 adc_mim_bank COUNT=256
Vs154_n_9 s154_n_9 0 DC 0 AC 1
Xs154_n_9 s154_n_9 0 adc_mim_bank COUNT=512
Vs154_n_10 s154_n_10 0 DC 0 AC 1
Xs154_n_10 s154_n_10 0 adc_mim_bank COUNT=1024
Vs154_n_11 s154_n_11 0 DC 0 AC 1
Xs154_n_11 s154_n_11 0 adc_mim_bank COUNT=2048
Vs154_n_12 s154_n_12 0 DC 0 AC 1
Xs154_n_12 s154_n_12 0 adc_mim_bank COUNT=1
Vs155_p_0 s155_p_0 0 DC 0 AC 1
Xs155_p_0 s155_p_0 0 adc_mim_bank COUNT=1
Vs155_p_1 s155_p_1 0 DC 0 AC 1
Xs155_p_1 s155_p_1 0 adc_mim_bank COUNT=2
Vs155_p_2 s155_p_2 0 DC 0 AC 1
Xs155_p_2 s155_p_2 0 adc_mim_bank COUNT=4
Vs155_p_3 s155_p_3 0 DC 0 AC 1
Xs155_p_3 s155_p_3 0 adc_mim_bank COUNT=8
Vs155_p_4 s155_p_4 0 DC 0 AC 1
Xs155_p_4 s155_p_4 0 adc_mim_bank COUNT=16
Vs155_p_5 s155_p_5 0 DC 0 AC 1
Xs155_p_5 s155_p_5 0 adc_mim_bank COUNT=32
Vs155_p_6 s155_p_6 0 DC 0 AC 1
Xs155_p_6 s155_p_6 0 adc_mim_bank COUNT=64
Vs155_p_7 s155_p_7 0 DC 0 AC 1
Xs155_p_7 s155_p_7 0 adc_mim_bank COUNT=128
Vs155_p_8 s155_p_8 0 DC 0 AC 1
Xs155_p_8 s155_p_8 0 adc_mim_bank COUNT=256
Vs155_p_9 s155_p_9 0 DC 0 AC 1
Xs155_p_9 s155_p_9 0 adc_mim_bank COUNT=512
Vs155_p_10 s155_p_10 0 DC 0 AC 1
Xs155_p_10 s155_p_10 0 adc_mim_bank COUNT=1024
Vs155_p_11 s155_p_11 0 DC 0 AC 1
Xs155_p_11 s155_p_11 0 adc_mim_bank COUNT=2048
Vs155_p_12 s155_p_12 0 DC 0 AC 1
Xs155_p_12 s155_p_12 0 adc_mim_bank COUNT=1
Vs155_n_0 s155_n_0 0 DC 0 AC 1
Xs155_n_0 s155_n_0 0 adc_mim_bank COUNT=1
Vs155_n_1 s155_n_1 0 DC 0 AC 1
Xs155_n_1 s155_n_1 0 adc_mim_bank COUNT=2
Vs155_n_2 s155_n_2 0 DC 0 AC 1
Xs155_n_2 s155_n_2 0 adc_mim_bank COUNT=4
Vs155_n_3 s155_n_3 0 DC 0 AC 1
Xs155_n_3 s155_n_3 0 adc_mim_bank COUNT=8
Vs155_n_4 s155_n_4 0 DC 0 AC 1
Xs155_n_4 s155_n_4 0 adc_mim_bank COUNT=16
Vs155_n_5 s155_n_5 0 DC 0 AC 1
Xs155_n_5 s155_n_5 0 adc_mim_bank COUNT=32
Vs155_n_6 s155_n_6 0 DC 0 AC 1
Xs155_n_6 s155_n_6 0 adc_mim_bank COUNT=64
Vs155_n_7 s155_n_7 0 DC 0 AC 1
Xs155_n_7 s155_n_7 0 adc_mim_bank COUNT=128
Vs155_n_8 s155_n_8 0 DC 0 AC 1
Xs155_n_8 s155_n_8 0 adc_mim_bank COUNT=256
Vs155_n_9 s155_n_9 0 DC 0 AC 1
Xs155_n_9 s155_n_9 0 adc_mim_bank COUNT=512
Vs155_n_10 s155_n_10 0 DC 0 AC 1
Xs155_n_10 s155_n_10 0 adc_mim_bank COUNT=1024
Vs155_n_11 s155_n_11 0 DC 0 AC 1
Xs155_n_11 s155_n_11 0 adc_mim_bank COUNT=2048
Vs155_n_12 s155_n_12 0 DC 0 AC 1
Xs155_n_12 s155_n_12 0 adc_mim_bank COUNT=1
Vs156_p_0 s156_p_0 0 DC 0 AC 1
Xs156_p_0 s156_p_0 0 adc_mim_bank COUNT=1
Vs156_p_1 s156_p_1 0 DC 0 AC 1
Xs156_p_1 s156_p_1 0 adc_mim_bank COUNT=2
Vs156_p_2 s156_p_2 0 DC 0 AC 1
Xs156_p_2 s156_p_2 0 adc_mim_bank COUNT=4
Vs156_p_3 s156_p_3 0 DC 0 AC 1
Xs156_p_3 s156_p_3 0 adc_mim_bank COUNT=8
Vs156_p_4 s156_p_4 0 DC 0 AC 1
Xs156_p_4 s156_p_4 0 adc_mim_bank COUNT=16
Vs156_p_5 s156_p_5 0 DC 0 AC 1
Xs156_p_5 s156_p_5 0 adc_mim_bank COUNT=32
Vs156_p_6 s156_p_6 0 DC 0 AC 1
Xs156_p_6 s156_p_6 0 adc_mim_bank COUNT=64
Vs156_p_7 s156_p_7 0 DC 0 AC 1
Xs156_p_7 s156_p_7 0 adc_mim_bank COUNT=128
Vs156_p_8 s156_p_8 0 DC 0 AC 1
Xs156_p_8 s156_p_8 0 adc_mim_bank COUNT=256
Vs156_p_9 s156_p_9 0 DC 0 AC 1
Xs156_p_9 s156_p_9 0 adc_mim_bank COUNT=512
Vs156_p_10 s156_p_10 0 DC 0 AC 1
Xs156_p_10 s156_p_10 0 adc_mim_bank COUNT=1024
Vs156_p_11 s156_p_11 0 DC 0 AC 1
Xs156_p_11 s156_p_11 0 adc_mim_bank COUNT=2048
Vs156_p_12 s156_p_12 0 DC 0 AC 1
Xs156_p_12 s156_p_12 0 adc_mim_bank COUNT=1
Vs156_n_0 s156_n_0 0 DC 0 AC 1
Xs156_n_0 s156_n_0 0 adc_mim_bank COUNT=1
Vs156_n_1 s156_n_1 0 DC 0 AC 1
Xs156_n_1 s156_n_1 0 adc_mim_bank COUNT=2
Vs156_n_2 s156_n_2 0 DC 0 AC 1
Xs156_n_2 s156_n_2 0 adc_mim_bank COUNT=4
Vs156_n_3 s156_n_3 0 DC 0 AC 1
Xs156_n_3 s156_n_3 0 adc_mim_bank COUNT=8
Vs156_n_4 s156_n_4 0 DC 0 AC 1
Xs156_n_4 s156_n_4 0 adc_mim_bank COUNT=16
Vs156_n_5 s156_n_5 0 DC 0 AC 1
Xs156_n_5 s156_n_5 0 adc_mim_bank COUNT=32
Vs156_n_6 s156_n_6 0 DC 0 AC 1
Xs156_n_6 s156_n_6 0 adc_mim_bank COUNT=64
Vs156_n_7 s156_n_7 0 DC 0 AC 1
Xs156_n_7 s156_n_7 0 adc_mim_bank COUNT=128
Vs156_n_8 s156_n_8 0 DC 0 AC 1
Xs156_n_8 s156_n_8 0 adc_mim_bank COUNT=256
Vs156_n_9 s156_n_9 0 DC 0 AC 1
Xs156_n_9 s156_n_9 0 adc_mim_bank COUNT=512
Vs156_n_10 s156_n_10 0 DC 0 AC 1
Xs156_n_10 s156_n_10 0 adc_mim_bank COUNT=1024
Vs156_n_11 s156_n_11 0 DC 0 AC 1
Xs156_n_11 s156_n_11 0 adc_mim_bank COUNT=2048
Vs156_n_12 s156_n_12 0 DC 0 AC 1
Xs156_n_12 s156_n_12 0 adc_mim_bank COUNT=1
Vs157_p_0 s157_p_0 0 DC 0 AC 1
Xs157_p_0 s157_p_0 0 adc_mim_bank COUNT=1
Vs157_p_1 s157_p_1 0 DC 0 AC 1
Xs157_p_1 s157_p_1 0 adc_mim_bank COUNT=2
Vs157_p_2 s157_p_2 0 DC 0 AC 1
Xs157_p_2 s157_p_2 0 adc_mim_bank COUNT=4
Vs157_p_3 s157_p_3 0 DC 0 AC 1
Xs157_p_3 s157_p_3 0 adc_mim_bank COUNT=8
Vs157_p_4 s157_p_4 0 DC 0 AC 1
Xs157_p_4 s157_p_4 0 adc_mim_bank COUNT=16
Vs157_p_5 s157_p_5 0 DC 0 AC 1
Xs157_p_5 s157_p_5 0 adc_mim_bank COUNT=32
Vs157_p_6 s157_p_6 0 DC 0 AC 1
Xs157_p_6 s157_p_6 0 adc_mim_bank COUNT=64
Vs157_p_7 s157_p_7 0 DC 0 AC 1
Xs157_p_7 s157_p_7 0 adc_mim_bank COUNT=128
Vs157_p_8 s157_p_8 0 DC 0 AC 1
Xs157_p_8 s157_p_8 0 adc_mim_bank COUNT=256
Vs157_p_9 s157_p_9 0 DC 0 AC 1
Xs157_p_9 s157_p_9 0 adc_mim_bank COUNT=512
Vs157_p_10 s157_p_10 0 DC 0 AC 1
Xs157_p_10 s157_p_10 0 adc_mim_bank COUNT=1024
Vs157_p_11 s157_p_11 0 DC 0 AC 1
Xs157_p_11 s157_p_11 0 adc_mim_bank COUNT=2048
Vs157_p_12 s157_p_12 0 DC 0 AC 1
Xs157_p_12 s157_p_12 0 adc_mim_bank COUNT=1
Vs157_n_0 s157_n_0 0 DC 0 AC 1
Xs157_n_0 s157_n_0 0 adc_mim_bank COUNT=1
Vs157_n_1 s157_n_1 0 DC 0 AC 1
Xs157_n_1 s157_n_1 0 adc_mim_bank COUNT=2
Vs157_n_2 s157_n_2 0 DC 0 AC 1
Xs157_n_2 s157_n_2 0 adc_mim_bank COUNT=4
Vs157_n_3 s157_n_3 0 DC 0 AC 1
Xs157_n_3 s157_n_3 0 adc_mim_bank COUNT=8
Vs157_n_4 s157_n_4 0 DC 0 AC 1
Xs157_n_4 s157_n_4 0 adc_mim_bank COUNT=16
Vs157_n_5 s157_n_5 0 DC 0 AC 1
Xs157_n_5 s157_n_5 0 adc_mim_bank COUNT=32
Vs157_n_6 s157_n_6 0 DC 0 AC 1
Xs157_n_6 s157_n_6 0 adc_mim_bank COUNT=64
Vs157_n_7 s157_n_7 0 DC 0 AC 1
Xs157_n_7 s157_n_7 0 adc_mim_bank COUNT=128
Vs157_n_8 s157_n_8 0 DC 0 AC 1
Xs157_n_8 s157_n_8 0 adc_mim_bank COUNT=256
Vs157_n_9 s157_n_9 0 DC 0 AC 1
Xs157_n_9 s157_n_9 0 adc_mim_bank COUNT=512
Vs157_n_10 s157_n_10 0 DC 0 AC 1
Xs157_n_10 s157_n_10 0 adc_mim_bank COUNT=1024
Vs157_n_11 s157_n_11 0 DC 0 AC 1
Xs157_n_11 s157_n_11 0 adc_mim_bank COUNT=2048
Vs157_n_12 s157_n_12 0 DC 0 AC 1
Xs157_n_12 s157_n_12 0 adc_mim_bank COUNT=1
Vs158_p_0 s158_p_0 0 DC 0 AC 1
Xs158_p_0 s158_p_0 0 adc_mim_bank COUNT=1
Vs158_p_1 s158_p_1 0 DC 0 AC 1
Xs158_p_1 s158_p_1 0 adc_mim_bank COUNT=2
Vs158_p_2 s158_p_2 0 DC 0 AC 1
Xs158_p_2 s158_p_2 0 adc_mim_bank COUNT=4
Vs158_p_3 s158_p_3 0 DC 0 AC 1
Xs158_p_3 s158_p_3 0 adc_mim_bank COUNT=8
Vs158_p_4 s158_p_4 0 DC 0 AC 1
Xs158_p_4 s158_p_4 0 adc_mim_bank COUNT=16
Vs158_p_5 s158_p_5 0 DC 0 AC 1
Xs158_p_5 s158_p_5 0 adc_mim_bank COUNT=32
Vs158_p_6 s158_p_6 0 DC 0 AC 1
Xs158_p_6 s158_p_6 0 adc_mim_bank COUNT=64
Vs158_p_7 s158_p_7 0 DC 0 AC 1
Xs158_p_7 s158_p_7 0 adc_mim_bank COUNT=128
Vs158_p_8 s158_p_8 0 DC 0 AC 1
Xs158_p_8 s158_p_8 0 adc_mim_bank COUNT=256
Vs158_p_9 s158_p_9 0 DC 0 AC 1
Xs158_p_9 s158_p_9 0 adc_mim_bank COUNT=512
Vs158_p_10 s158_p_10 0 DC 0 AC 1
Xs158_p_10 s158_p_10 0 adc_mim_bank COUNT=1024
Vs158_p_11 s158_p_11 0 DC 0 AC 1
Xs158_p_11 s158_p_11 0 adc_mim_bank COUNT=2048
Vs158_p_12 s158_p_12 0 DC 0 AC 1
Xs158_p_12 s158_p_12 0 adc_mim_bank COUNT=1
Vs158_n_0 s158_n_0 0 DC 0 AC 1
Xs158_n_0 s158_n_0 0 adc_mim_bank COUNT=1
Vs158_n_1 s158_n_1 0 DC 0 AC 1
Xs158_n_1 s158_n_1 0 adc_mim_bank COUNT=2
Vs158_n_2 s158_n_2 0 DC 0 AC 1
Xs158_n_2 s158_n_2 0 adc_mim_bank COUNT=4
Vs158_n_3 s158_n_3 0 DC 0 AC 1
Xs158_n_3 s158_n_3 0 adc_mim_bank COUNT=8
Vs158_n_4 s158_n_4 0 DC 0 AC 1
Xs158_n_4 s158_n_4 0 adc_mim_bank COUNT=16
Vs158_n_5 s158_n_5 0 DC 0 AC 1
Xs158_n_5 s158_n_5 0 adc_mim_bank COUNT=32
Vs158_n_6 s158_n_6 0 DC 0 AC 1
Xs158_n_6 s158_n_6 0 adc_mim_bank COUNT=64
Vs158_n_7 s158_n_7 0 DC 0 AC 1
Xs158_n_7 s158_n_7 0 adc_mim_bank COUNT=128
Vs158_n_8 s158_n_8 0 DC 0 AC 1
Xs158_n_8 s158_n_8 0 adc_mim_bank COUNT=256
Vs158_n_9 s158_n_9 0 DC 0 AC 1
Xs158_n_9 s158_n_9 0 adc_mim_bank COUNT=512
Vs158_n_10 s158_n_10 0 DC 0 AC 1
Xs158_n_10 s158_n_10 0 adc_mim_bank COUNT=1024
Vs158_n_11 s158_n_11 0 DC 0 AC 1
Xs158_n_11 s158_n_11 0 adc_mim_bank COUNT=2048
Vs158_n_12 s158_n_12 0 DC 0 AC 1
Xs158_n_12 s158_n_12 0 adc_mim_bank COUNT=1
Vs159_p_0 s159_p_0 0 DC 0 AC 1
Xs159_p_0 s159_p_0 0 adc_mim_bank COUNT=1
Vs159_p_1 s159_p_1 0 DC 0 AC 1
Xs159_p_1 s159_p_1 0 adc_mim_bank COUNT=2
Vs159_p_2 s159_p_2 0 DC 0 AC 1
Xs159_p_2 s159_p_2 0 adc_mim_bank COUNT=4
Vs159_p_3 s159_p_3 0 DC 0 AC 1
Xs159_p_3 s159_p_3 0 adc_mim_bank COUNT=8
Vs159_p_4 s159_p_4 0 DC 0 AC 1
Xs159_p_4 s159_p_4 0 adc_mim_bank COUNT=16
Vs159_p_5 s159_p_5 0 DC 0 AC 1
Xs159_p_5 s159_p_5 0 adc_mim_bank COUNT=32
Vs159_p_6 s159_p_6 0 DC 0 AC 1
Xs159_p_6 s159_p_6 0 adc_mim_bank COUNT=64
Vs159_p_7 s159_p_7 0 DC 0 AC 1
Xs159_p_7 s159_p_7 0 adc_mim_bank COUNT=128
Vs159_p_8 s159_p_8 0 DC 0 AC 1
Xs159_p_8 s159_p_8 0 adc_mim_bank COUNT=256
Vs159_p_9 s159_p_9 0 DC 0 AC 1
Xs159_p_9 s159_p_9 0 adc_mim_bank COUNT=512
Vs159_p_10 s159_p_10 0 DC 0 AC 1
Xs159_p_10 s159_p_10 0 adc_mim_bank COUNT=1024
Vs159_p_11 s159_p_11 0 DC 0 AC 1
Xs159_p_11 s159_p_11 0 adc_mim_bank COUNT=2048
Vs159_p_12 s159_p_12 0 DC 0 AC 1
Xs159_p_12 s159_p_12 0 adc_mim_bank COUNT=1
Vs159_n_0 s159_n_0 0 DC 0 AC 1
Xs159_n_0 s159_n_0 0 adc_mim_bank COUNT=1
Vs159_n_1 s159_n_1 0 DC 0 AC 1
Xs159_n_1 s159_n_1 0 adc_mim_bank COUNT=2
Vs159_n_2 s159_n_2 0 DC 0 AC 1
Xs159_n_2 s159_n_2 0 adc_mim_bank COUNT=4
Vs159_n_3 s159_n_3 0 DC 0 AC 1
Xs159_n_3 s159_n_3 0 adc_mim_bank COUNT=8
Vs159_n_4 s159_n_4 0 DC 0 AC 1
Xs159_n_4 s159_n_4 0 adc_mim_bank COUNT=16
Vs159_n_5 s159_n_5 0 DC 0 AC 1
Xs159_n_5 s159_n_5 0 adc_mim_bank COUNT=32
Vs159_n_6 s159_n_6 0 DC 0 AC 1
Xs159_n_6 s159_n_6 0 adc_mim_bank COUNT=64
Vs159_n_7 s159_n_7 0 DC 0 AC 1
Xs159_n_7 s159_n_7 0 adc_mim_bank COUNT=128
Vs159_n_8 s159_n_8 0 DC 0 AC 1
Xs159_n_8 s159_n_8 0 adc_mim_bank COUNT=256
Vs159_n_9 s159_n_9 0 DC 0 AC 1
Xs159_n_9 s159_n_9 0 adc_mim_bank COUNT=512
Vs159_n_10 s159_n_10 0 DC 0 AC 1
Xs159_n_10 s159_n_10 0 adc_mim_bank COUNT=1024
Vs159_n_11 s159_n_11 0 DC 0 AC 1
Xs159_n_11 s159_n_11 0 adc_mim_bank COUNT=2048
Vs159_n_12 s159_n_12 0 DC 0 AC 1
Xs159_n_12 s159_n_12 0 adc_mim_bank COUNT=1
Vs160_p_0 s160_p_0 0 DC 0 AC 1
Xs160_p_0 s160_p_0 0 adc_mim_bank COUNT=1
Vs160_p_1 s160_p_1 0 DC 0 AC 1
Xs160_p_1 s160_p_1 0 adc_mim_bank COUNT=2
Vs160_p_2 s160_p_2 0 DC 0 AC 1
Xs160_p_2 s160_p_2 0 adc_mim_bank COUNT=4
Vs160_p_3 s160_p_3 0 DC 0 AC 1
Xs160_p_3 s160_p_3 0 adc_mim_bank COUNT=8
Vs160_p_4 s160_p_4 0 DC 0 AC 1
Xs160_p_4 s160_p_4 0 adc_mim_bank COUNT=16
Vs160_p_5 s160_p_5 0 DC 0 AC 1
Xs160_p_5 s160_p_5 0 adc_mim_bank COUNT=32
Vs160_p_6 s160_p_6 0 DC 0 AC 1
Xs160_p_6 s160_p_6 0 adc_mim_bank COUNT=64
Vs160_p_7 s160_p_7 0 DC 0 AC 1
Xs160_p_7 s160_p_7 0 adc_mim_bank COUNT=128
Vs160_p_8 s160_p_8 0 DC 0 AC 1
Xs160_p_8 s160_p_8 0 adc_mim_bank COUNT=256
Vs160_p_9 s160_p_9 0 DC 0 AC 1
Xs160_p_9 s160_p_9 0 adc_mim_bank COUNT=512
Vs160_p_10 s160_p_10 0 DC 0 AC 1
Xs160_p_10 s160_p_10 0 adc_mim_bank COUNT=1024
Vs160_p_11 s160_p_11 0 DC 0 AC 1
Xs160_p_11 s160_p_11 0 adc_mim_bank COUNT=2048
Vs160_p_12 s160_p_12 0 DC 0 AC 1
Xs160_p_12 s160_p_12 0 adc_mim_bank COUNT=1
Vs160_n_0 s160_n_0 0 DC 0 AC 1
Xs160_n_0 s160_n_0 0 adc_mim_bank COUNT=1
Vs160_n_1 s160_n_1 0 DC 0 AC 1
Xs160_n_1 s160_n_1 0 adc_mim_bank COUNT=2
Vs160_n_2 s160_n_2 0 DC 0 AC 1
Xs160_n_2 s160_n_2 0 adc_mim_bank COUNT=4
Vs160_n_3 s160_n_3 0 DC 0 AC 1
Xs160_n_3 s160_n_3 0 adc_mim_bank COUNT=8
Vs160_n_4 s160_n_4 0 DC 0 AC 1
Xs160_n_4 s160_n_4 0 adc_mim_bank COUNT=16
Vs160_n_5 s160_n_5 0 DC 0 AC 1
Xs160_n_5 s160_n_5 0 adc_mim_bank COUNT=32
Vs160_n_6 s160_n_6 0 DC 0 AC 1
Xs160_n_6 s160_n_6 0 adc_mim_bank COUNT=64
Vs160_n_7 s160_n_7 0 DC 0 AC 1
Xs160_n_7 s160_n_7 0 adc_mim_bank COUNT=128
Vs160_n_8 s160_n_8 0 DC 0 AC 1
Xs160_n_8 s160_n_8 0 adc_mim_bank COUNT=256
Vs160_n_9 s160_n_9 0 DC 0 AC 1
Xs160_n_9 s160_n_9 0 adc_mim_bank COUNT=512
Vs160_n_10 s160_n_10 0 DC 0 AC 1
Xs160_n_10 s160_n_10 0 adc_mim_bank COUNT=1024
Vs160_n_11 s160_n_11 0 DC 0 AC 1
Xs160_n_11 s160_n_11 0 adc_mim_bank COUNT=2048
Vs160_n_12 s160_n_12 0 DC 0 AC 1
Xs160_n_12 s160_n_12 0 adc_mim_bank COUNT=1
Vs161_p_0 s161_p_0 0 DC 0 AC 1
Xs161_p_0 s161_p_0 0 adc_mim_bank COUNT=1
Vs161_p_1 s161_p_1 0 DC 0 AC 1
Xs161_p_1 s161_p_1 0 adc_mim_bank COUNT=2
Vs161_p_2 s161_p_2 0 DC 0 AC 1
Xs161_p_2 s161_p_2 0 adc_mim_bank COUNT=4
Vs161_p_3 s161_p_3 0 DC 0 AC 1
Xs161_p_3 s161_p_3 0 adc_mim_bank COUNT=8
Vs161_p_4 s161_p_4 0 DC 0 AC 1
Xs161_p_4 s161_p_4 0 adc_mim_bank COUNT=16
Vs161_p_5 s161_p_5 0 DC 0 AC 1
Xs161_p_5 s161_p_5 0 adc_mim_bank COUNT=32
Vs161_p_6 s161_p_6 0 DC 0 AC 1
Xs161_p_6 s161_p_6 0 adc_mim_bank COUNT=64
Vs161_p_7 s161_p_7 0 DC 0 AC 1
Xs161_p_7 s161_p_7 0 adc_mim_bank COUNT=128
Vs161_p_8 s161_p_8 0 DC 0 AC 1
Xs161_p_8 s161_p_8 0 adc_mim_bank COUNT=256
Vs161_p_9 s161_p_9 0 DC 0 AC 1
Xs161_p_9 s161_p_9 0 adc_mim_bank COUNT=512
Vs161_p_10 s161_p_10 0 DC 0 AC 1
Xs161_p_10 s161_p_10 0 adc_mim_bank COUNT=1024
Vs161_p_11 s161_p_11 0 DC 0 AC 1
Xs161_p_11 s161_p_11 0 adc_mim_bank COUNT=2048
Vs161_p_12 s161_p_12 0 DC 0 AC 1
Xs161_p_12 s161_p_12 0 adc_mim_bank COUNT=1
Vs161_n_0 s161_n_0 0 DC 0 AC 1
Xs161_n_0 s161_n_0 0 adc_mim_bank COUNT=1
Vs161_n_1 s161_n_1 0 DC 0 AC 1
Xs161_n_1 s161_n_1 0 adc_mim_bank COUNT=2
Vs161_n_2 s161_n_2 0 DC 0 AC 1
Xs161_n_2 s161_n_2 0 adc_mim_bank COUNT=4
Vs161_n_3 s161_n_3 0 DC 0 AC 1
Xs161_n_3 s161_n_3 0 adc_mim_bank COUNT=8
Vs161_n_4 s161_n_4 0 DC 0 AC 1
Xs161_n_4 s161_n_4 0 adc_mim_bank COUNT=16
Vs161_n_5 s161_n_5 0 DC 0 AC 1
Xs161_n_5 s161_n_5 0 adc_mim_bank COUNT=32
Vs161_n_6 s161_n_6 0 DC 0 AC 1
Xs161_n_6 s161_n_6 0 adc_mim_bank COUNT=64
Vs161_n_7 s161_n_7 0 DC 0 AC 1
Xs161_n_7 s161_n_7 0 adc_mim_bank COUNT=128
Vs161_n_8 s161_n_8 0 DC 0 AC 1
Xs161_n_8 s161_n_8 0 adc_mim_bank COUNT=256
Vs161_n_9 s161_n_9 0 DC 0 AC 1
Xs161_n_9 s161_n_9 0 adc_mim_bank COUNT=512
Vs161_n_10 s161_n_10 0 DC 0 AC 1
Xs161_n_10 s161_n_10 0 adc_mim_bank COUNT=1024
Vs161_n_11 s161_n_11 0 DC 0 AC 1
Xs161_n_11 s161_n_11 0 adc_mim_bank COUNT=2048
Vs161_n_12 s161_n_12 0 DC 0 AC 1
Xs161_n_12 s161_n_12 0 adc_mim_bank COUNT=1
Vs162_p_0 s162_p_0 0 DC 0 AC 1
Xs162_p_0 s162_p_0 0 adc_mim_bank COUNT=1
Vs162_p_1 s162_p_1 0 DC 0 AC 1
Xs162_p_1 s162_p_1 0 adc_mim_bank COUNT=2
Vs162_p_2 s162_p_2 0 DC 0 AC 1
Xs162_p_2 s162_p_2 0 adc_mim_bank COUNT=4
Vs162_p_3 s162_p_3 0 DC 0 AC 1
Xs162_p_3 s162_p_3 0 adc_mim_bank COUNT=8
Vs162_p_4 s162_p_4 0 DC 0 AC 1
Xs162_p_4 s162_p_4 0 adc_mim_bank COUNT=16
Vs162_p_5 s162_p_5 0 DC 0 AC 1
Xs162_p_5 s162_p_5 0 adc_mim_bank COUNT=32
Vs162_p_6 s162_p_6 0 DC 0 AC 1
Xs162_p_6 s162_p_6 0 adc_mim_bank COUNT=64
Vs162_p_7 s162_p_7 0 DC 0 AC 1
Xs162_p_7 s162_p_7 0 adc_mim_bank COUNT=128
Vs162_p_8 s162_p_8 0 DC 0 AC 1
Xs162_p_8 s162_p_8 0 adc_mim_bank COUNT=256
Vs162_p_9 s162_p_9 0 DC 0 AC 1
Xs162_p_9 s162_p_9 0 adc_mim_bank COUNT=512
Vs162_p_10 s162_p_10 0 DC 0 AC 1
Xs162_p_10 s162_p_10 0 adc_mim_bank COUNT=1024
Vs162_p_11 s162_p_11 0 DC 0 AC 1
Xs162_p_11 s162_p_11 0 adc_mim_bank COUNT=2048
Vs162_p_12 s162_p_12 0 DC 0 AC 1
Xs162_p_12 s162_p_12 0 adc_mim_bank COUNT=1
Vs162_n_0 s162_n_0 0 DC 0 AC 1
Xs162_n_0 s162_n_0 0 adc_mim_bank COUNT=1
Vs162_n_1 s162_n_1 0 DC 0 AC 1
Xs162_n_1 s162_n_1 0 adc_mim_bank COUNT=2
Vs162_n_2 s162_n_2 0 DC 0 AC 1
Xs162_n_2 s162_n_2 0 adc_mim_bank COUNT=4
Vs162_n_3 s162_n_3 0 DC 0 AC 1
Xs162_n_3 s162_n_3 0 adc_mim_bank COUNT=8
Vs162_n_4 s162_n_4 0 DC 0 AC 1
Xs162_n_4 s162_n_4 0 adc_mim_bank COUNT=16
Vs162_n_5 s162_n_5 0 DC 0 AC 1
Xs162_n_5 s162_n_5 0 adc_mim_bank COUNT=32
Vs162_n_6 s162_n_6 0 DC 0 AC 1
Xs162_n_6 s162_n_6 0 adc_mim_bank COUNT=64
Vs162_n_7 s162_n_7 0 DC 0 AC 1
Xs162_n_7 s162_n_7 0 adc_mim_bank COUNT=128
Vs162_n_8 s162_n_8 0 DC 0 AC 1
Xs162_n_8 s162_n_8 0 adc_mim_bank COUNT=256
Vs162_n_9 s162_n_9 0 DC 0 AC 1
Xs162_n_9 s162_n_9 0 adc_mim_bank COUNT=512
Vs162_n_10 s162_n_10 0 DC 0 AC 1
Xs162_n_10 s162_n_10 0 adc_mim_bank COUNT=1024
Vs162_n_11 s162_n_11 0 DC 0 AC 1
Xs162_n_11 s162_n_11 0 adc_mim_bank COUNT=2048
Vs162_n_12 s162_n_12 0 DC 0 AC 1
Xs162_n_12 s162_n_12 0 adc_mim_bank COUNT=1
Vs163_p_0 s163_p_0 0 DC 0 AC 1
Xs163_p_0 s163_p_0 0 adc_mim_bank COUNT=1
Vs163_p_1 s163_p_1 0 DC 0 AC 1
Xs163_p_1 s163_p_1 0 adc_mim_bank COUNT=2
Vs163_p_2 s163_p_2 0 DC 0 AC 1
Xs163_p_2 s163_p_2 0 adc_mim_bank COUNT=4
Vs163_p_3 s163_p_3 0 DC 0 AC 1
Xs163_p_3 s163_p_3 0 adc_mim_bank COUNT=8
Vs163_p_4 s163_p_4 0 DC 0 AC 1
Xs163_p_4 s163_p_4 0 adc_mim_bank COUNT=16
Vs163_p_5 s163_p_5 0 DC 0 AC 1
Xs163_p_5 s163_p_5 0 adc_mim_bank COUNT=32
Vs163_p_6 s163_p_6 0 DC 0 AC 1
Xs163_p_6 s163_p_6 0 adc_mim_bank COUNT=64
Vs163_p_7 s163_p_7 0 DC 0 AC 1
Xs163_p_7 s163_p_7 0 adc_mim_bank COUNT=128
Vs163_p_8 s163_p_8 0 DC 0 AC 1
Xs163_p_8 s163_p_8 0 adc_mim_bank COUNT=256
Vs163_p_9 s163_p_9 0 DC 0 AC 1
Xs163_p_9 s163_p_9 0 adc_mim_bank COUNT=512
Vs163_p_10 s163_p_10 0 DC 0 AC 1
Xs163_p_10 s163_p_10 0 adc_mim_bank COUNT=1024
Vs163_p_11 s163_p_11 0 DC 0 AC 1
Xs163_p_11 s163_p_11 0 adc_mim_bank COUNT=2048
Vs163_p_12 s163_p_12 0 DC 0 AC 1
Xs163_p_12 s163_p_12 0 adc_mim_bank COUNT=1
Vs163_n_0 s163_n_0 0 DC 0 AC 1
Xs163_n_0 s163_n_0 0 adc_mim_bank COUNT=1
Vs163_n_1 s163_n_1 0 DC 0 AC 1
Xs163_n_1 s163_n_1 0 adc_mim_bank COUNT=2
Vs163_n_2 s163_n_2 0 DC 0 AC 1
Xs163_n_2 s163_n_2 0 adc_mim_bank COUNT=4
Vs163_n_3 s163_n_3 0 DC 0 AC 1
Xs163_n_3 s163_n_3 0 adc_mim_bank COUNT=8
Vs163_n_4 s163_n_4 0 DC 0 AC 1
Xs163_n_4 s163_n_4 0 adc_mim_bank COUNT=16
Vs163_n_5 s163_n_5 0 DC 0 AC 1
Xs163_n_5 s163_n_5 0 adc_mim_bank COUNT=32
Vs163_n_6 s163_n_6 0 DC 0 AC 1
Xs163_n_6 s163_n_6 0 adc_mim_bank COUNT=64
Vs163_n_7 s163_n_7 0 DC 0 AC 1
Xs163_n_7 s163_n_7 0 adc_mim_bank COUNT=128
Vs163_n_8 s163_n_8 0 DC 0 AC 1
Xs163_n_8 s163_n_8 0 adc_mim_bank COUNT=256
Vs163_n_9 s163_n_9 0 DC 0 AC 1
Xs163_n_9 s163_n_9 0 adc_mim_bank COUNT=512
Vs163_n_10 s163_n_10 0 DC 0 AC 1
Xs163_n_10 s163_n_10 0 adc_mim_bank COUNT=1024
Vs163_n_11 s163_n_11 0 DC 0 AC 1
Xs163_n_11 s163_n_11 0 adc_mim_bank COUNT=2048
Vs163_n_12 s163_n_12 0 DC 0 AC 1
Xs163_n_12 s163_n_12 0 adc_mim_bank COUNT=1
Vs164_p_0 s164_p_0 0 DC 0 AC 1
Xs164_p_0 s164_p_0 0 adc_mim_bank COUNT=1
Vs164_p_1 s164_p_1 0 DC 0 AC 1
Xs164_p_1 s164_p_1 0 adc_mim_bank COUNT=2
Vs164_p_2 s164_p_2 0 DC 0 AC 1
Xs164_p_2 s164_p_2 0 adc_mim_bank COUNT=4
Vs164_p_3 s164_p_3 0 DC 0 AC 1
Xs164_p_3 s164_p_3 0 adc_mim_bank COUNT=8
Vs164_p_4 s164_p_4 0 DC 0 AC 1
Xs164_p_4 s164_p_4 0 adc_mim_bank COUNT=16
Vs164_p_5 s164_p_5 0 DC 0 AC 1
Xs164_p_5 s164_p_5 0 adc_mim_bank COUNT=32
Vs164_p_6 s164_p_6 0 DC 0 AC 1
Xs164_p_6 s164_p_6 0 adc_mim_bank COUNT=64
Vs164_p_7 s164_p_7 0 DC 0 AC 1
Xs164_p_7 s164_p_7 0 adc_mim_bank COUNT=128
Vs164_p_8 s164_p_8 0 DC 0 AC 1
Xs164_p_8 s164_p_8 0 adc_mim_bank COUNT=256
Vs164_p_9 s164_p_9 0 DC 0 AC 1
Xs164_p_9 s164_p_9 0 adc_mim_bank COUNT=512
Vs164_p_10 s164_p_10 0 DC 0 AC 1
Xs164_p_10 s164_p_10 0 adc_mim_bank COUNT=1024
Vs164_p_11 s164_p_11 0 DC 0 AC 1
Xs164_p_11 s164_p_11 0 adc_mim_bank COUNT=2048
Vs164_p_12 s164_p_12 0 DC 0 AC 1
Xs164_p_12 s164_p_12 0 adc_mim_bank COUNT=1
Vs164_n_0 s164_n_0 0 DC 0 AC 1
Xs164_n_0 s164_n_0 0 adc_mim_bank COUNT=1
Vs164_n_1 s164_n_1 0 DC 0 AC 1
Xs164_n_1 s164_n_1 0 adc_mim_bank COUNT=2
Vs164_n_2 s164_n_2 0 DC 0 AC 1
Xs164_n_2 s164_n_2 0 adc_mim_bank COUNT=4
Vs164_n_3 s164_n_3 0 DC 0 AC 1
Xs164_n_3 s164_n_3 0 adc_mim_bank COUNT=8
Vs164_n_4 s164_n_4 0 DC 0 AC 1
Xs164_n_4 s164_n_4 0 adc_mim_bank COUNT=16
Vs164_n_5 s164_n_5 0 DC 0 AC 1
Xs164_n_5 s164_n_5 0 adc_mim_bank COUNT=32
Vs164_n_6 s164_n_6 0 DC 0 AC 1
Xs164_n_6 s164_n_6 0 adc_mim_bank COUNT=64
Vs164_n_7 s164_n_7 0 DC 0 AC 1
Xs164_n_7 s164_n_7 0 adc_mim_bank COUNT=128
Vs164_n_8 s164_n_8 0 DC 0 AC 1
Xs164_n_8 s164_n_8 0 adc_mim_bank COUNT=256
Vs164_n_9 s164_n_9 0 DC 0 AC 1
Xs164_n_9 s164_n_9 0 adc_mim_bank COUNT=512
Vs164_n_10 s164_n_10 0 DC 0 AC 1
Xs164_n_10 s164_n_10 0 adc_mim_bank COUNT=1024
Vs164_n_11 s164_n_11 0 DC 0 AC 1
Xs164_n_11 s164_n_11 0 adc_mim_bank COUNT=2048
Vs164_n_12 s164_n_12 0 DC 0 AC 1
Xs164_n_12 s164_n_12 0 adc_mim_bank COUNT=1
Vs165_p_0 s165_p_0 0 DC 0 AC 1
Xs165_p_0 s165_p_0 0 adc_mim_bank COUNT=1
Vs165_p_1 s165_p_1 0 DC 0 AC 1
Xs165_p_1 s165_p_1 0 adc_mim_bank COUNT=2
Vs165_p_2 s165_p_2 0 DC 0 AC 1
Xs165_p_2 s165_p_2 0 adc_mim_bank COUNT=4
Vs165_p_3 s165_p_3 0 DC 0 AC 1
Xs165_p_3 s165_p_3 0 adc_mim_bank COUNT=8
Vs165_p_4 s165_p_4 0 DC 0 AC 1
Xs165_p_4 s165_p_4 0 adc_mim_bank COUNT=16
Vs165_p_5 s165_p_5 0 DC 0 AC 1
Xs165_p_5 s165_p_5 0 adc_mim_bank COUNT=32
Vs165_p_6 s165_p_6 0 DC 0 AC 1
Xs165_p_6 s165_p_6 0 adc_mim_bank COUNT=64
Vs165_p_7 s165_p_7 0 DC 0 AC 1
Xs165_p_7 s165_p_7 0 adc_mim_bank COUNT=128
Vs165_p_8 s165_p_8 0 DC 0 AC 1
Xs165_p_8 s165_p_8 0 adc_mim_bank COUNT=256
Vs165_p_9 s165_p_9 0 DC 0 AC 1
Xs165_p_9 s165_p_9 0 adc_mim_bank COUNT=512
Vs165_p_10 s165_p_10 0 DC 0 AC 1
Xs165_p_10 s165_p_10 0 adc_mim_bank COUNT=1024
Vs165_p_11 s165_p_11 0 DC 0 AC 1
Xs165_p_11 s165_p_11 0 adc_mim_bank COUNT=2048
Vs165_p_12 s165_p_12 0 DC 0 AC 1
Xs165_p_12 s165_p_12 0 adc_mim_bank COUNT=1
Vs165_n_0 s165_n_0 0 DC 0 AC 1
Xs165_n_0 s165_n_0 0 adc_mim_bank COUNT=1
Vs165_n_1 s165_n_1 0 DC 0 AC 1
Xs165_n_1 s165_n_1 0 adc_mim_bank COUNT=2
Vs165_n_2 s165_n_2 0 DC 0 AC 1
Xs165_n_2 s165_n_2 0 adc_mim_bank COUNT=4
Vs165_n_3 s165_n_3 0 DC 0 AC 1
Xs165_n_3 s165_n_3 0 adc_mim_bank COUNT=8
Vs165_n_4 s165_n_4 0 DC 0 AC 1
Xs165_n_4 s165_n_4 0 adc_mim_bank COUNT=16
Vs165_n_5 s165_n_5 0 DC 0 AC 1
Xs165_n_5 s165_n_5 0 adc_mim_bank COUNT=32
Vs165_n_6 s165_n_6 0 DC 0 AC 1
Xs165_n_6 s165_n_6 0 adc_mim_bank COUNT=64
Vs165_n_7 s165_n_7 0 DC 0 AC 1
Xs165_n_7 s165_n_7 0 adc_mim_bank COUNT=128
Vs165_n_8 s165_n_8 0 DC 0 AC 1
Xs165_n_8 s165_n_8 0 adc_mim_bank COUNT=256
Vs165_n_9 s165_n_9 0 DC 0 AC 1
Xs165_n_9 s165_n_9 0 adc_mim_bank COUNT=512
Vs165_n_10 s165_n_10 0 DC 0 AC 1
Xs165_n_10 s165_n_10 0 adc_mim_bank COUNT=1024
Vs165_n_11 s165_n_11 0 DC 0 AC 1
Xs165_n_11 s165_n_11 0 adc_mim_bank COUNT=2048
Vs165_n_12 s165_n_12 0 DC 0 AC 1
Xs165_n_12 s165_n_12 0 adc_mim_bank COUNT=1
Vs166_p_0 s166_p_0 0 DC 0 AC 1
Xs166_p_0 s166_p_0 0 adc_mim_bank COUNT=1
Vs166_p_1 s166_p_1 0 DC 0 AC 1
Xs166_p_1 s166_p_1 0 adc_mim_bank COUNT=2
Vs166_p_2 s166_p_2 0 DC 0 AC 1
Xs166_p_2 s166_p_2 0 adc_mim_bank COUNT=4
Vs166_p_3 s166_p_3 0 DC 0 AC 1
Xs166_p_3 s166_p_3 0 adc_mim_bank COUNT=8
Vs166_p_4 s166_p_4 0 DC 0 AC 1
Xs166_p_4 s166_p_4 0 adc_mim_bank COUNT=16
Vs166_p_5 s166_p_5 0 DC 0 AC 1
Xs166_p_5 s166_p_5 0 adc_mim_bank COUNT=32
Vs166_p_6 s166_p_6 0 DC 0 AC 1
Xs166_p_6 s166_p_6 0 adc_mim_bank COUNT=64
Vs166_p_7 s166_p_7 0 DC 0 AC 1
Xs166_p_7 s166_p_7 0 adc_mim_bank COUNT=128
Vs166_p_8 s166_p_8 0 DC 0 AC 1
Xs166_p_8 s166_p_8 0 adc_mim_bank COUNT=256
Vs166_p_9 s166_p_9 0 DC 0 AC 1
Xs166_p_9 s166_p_9 0 adc_mim_bank COUNT=512
Vs166_p_10 s166_p_10 0 DC 0 AC 1
Xs166_p_10 s166_p_10 0 adc_mim_bank COUNT=1024
Vs166_p_11 s166_p_11 0 DC 0 AC 1
Xs166_p_11 s166_p_11 0 adc_mim_bank COUNT=2048
Vs166_p_12 s166_p_12 0 DC 0 AC 1
Xs166_p_12 s166_p_12 0 adc_mim_bank COUNT=1
Vs166_n_0 s166_n_0 0 DC 0 AC 1
Xs166_n_0 s166_n_0 0 adc_mim_bank COUNT=1
Vs166_n_1 s166_n_1 0 DC 0 AC 1
Xs166_n_1 s166_n_1 0 adc_mim_bank COUNT=2
Vs166_n_2 s166_n_2 0 DC 0 AC 1
Xs166_n_2 s166_n_2 0 adc_mim_bank COUNT=4
Vs166_n_3 s166_n_3 0 DC 0 AC 1
Xs166_n_3 s166_n_3 0 adc_mim_bank COUNT=8
Vs166_n_4 s166_n_4 0 DC 0 AC 1
Xs166_n_4 s166_n_4 0 adc_mim_bank COUNT=16
Vs166_n_5 s166_n_5 0 DC 0 AC 1
Xs166_n_5 s166_n_5 0 adc_mim_bank COUNT=32
Vs166_n_6 s166_n_6 0 DC 0 AC 1
Xs166_n_6 s166_n_6 0 adc_mim_bank COUNT=64
Vs166_n_7 s166_n_7 0 DC 0 AC 1
Xs166_n_7 s166_n_7 0 adc_mim_bank COUNT=128
Vs166_n_8 s166_n_8 0 DC 0 AC 1
Xs166_n_8 s166_n_8 0 adc_mim_bank COUNT=256
Vs166_n_9 s166_n_9 0 DC 0 AC 1
Xs166_n_9 s166_n_9 0 adc_mim_bank COUNT=512
Vs166_n_10 s166_n_10 0 DC 0 AC 1
Xs166_n_10 s166_n_10 0 adc_mim_bank COUNT=1024
Vs166_n_11 s166_n_11 0 DC 0 AC 1
Xs166_n_11 s166_n_11 0 adc_mim_bank COUNT=2048
Vs166_n_12 s166_n_12 0 DC 0 AC 1
Xs166_n_12 s166_n_12 0 adc_mim_bank COUNT=1
Vs167_p_0 s167_p_0 0 DC 0 AC 1
Xs167_p_0 s167_p_0 0 adc_mim_bank COUNT=1
Vs167_p_1 s167_p_1 0 DC 0 AC 1
Xs167_p_1 s167_p_1 0 adc_mim_bank COUNT=2
Vs167_p_2 s167_p_2 0 DC 0 AC 1
Xs167_p_2 s167_p_2 0 adc_mim_bank COUNT=4
Vs167_p_3 s167_p_3 0 DC 0 AC 1
Xs167_p_3 s167_p_3 0 adc_mim_bank COUNT=8
Vs167_p_4 s167_p_4 0 DC 0 AC 1
Xs167_p_4 s167_p_4 0 adc_mim_bank COUNT=16
Vs167_p_5 s167_p_5 0 DC 0 AC 1
Xs167_p_5 s167_p_5 0 adc_mim_bank COUNT=32
Vs167_p_6 s167_p_6 0 DC 0 AC 1
Xs167_p_6 s167_p_6 0 adc_mim_bank COUNT=64
Vs167_p_7 s167_p_7 0 DC 0 AC 1
Xs167_p_7 s167_p_7 0 adc_mim_bank COUNT=128
Vs167_p_8 s167_p_8 0 DC 0 AC 1
Xs167_p_8 s167_p_8 0 adc_mim_bank COUNT=256
Vs167_p_9 s167_p_9 0 DC 0 AC 1
Xs167_p_9 s167_p_9 0 adc_mim_bank COUNT=512
Vs167_p_10 s167_p_10 0 DC 0 AC 1
Xs167_p_10 s167_p_10 0 adc_mim_bank COUNT=1024
Vs167_p_11 s167_p_11 0 DC 0 AC 1
Xs167_p_11 s167_p_11 0 adc_mim_bank COUNT=2048
Vs167_p_12 s167_p_12 0 DC 0 AC 1
Xs167_p_12 s167_p_12 0 adc_mim_bank COUNT=1
Vs167_n_0 s167_n_0 0 DC 0 AC 1
Xs167_n_0 s167_n_0 0 adc_mim_bank COUNT=1
Vs167_n_1 s167_n_1 0 DC 0 AC 1
Xs167_n_1 s167_n_1 0 adc_mim_bank COUNT=2
Vs167_n_2 s167_n_2 0 DC 0 AC 1
Xs167_n_2 s167_n_2 0 adc_mim_bank COUNT=4
Vs167_n_3 s167_n_3 0 DC 0 AC 1
Xs167_n_3 s167_n_3 0 adc_mim_bank COUNT=8
Vs167_n_4 s167_n_4 0 DC 0 AC 1
Xs167_n_4 s167_n_4 0 adc_mim_bank COUNT=16
Vs167_n_5 s167_n_5 0 DC 0 AC 1
Xs167_n_5 s167_n_5 0 adc_mim_bank COUNT=32
Vs167_n_6 s167_n_6 0 DC 0 AC 1
Xs167_n_6 s167_n_6 0 adc_mim_bank COUNT=64
Vs167_n_7 s167_n_7 0 DC 0 AC 1
Xs167_n_7 s167_n_7 0 adc_mim_bank COUNT=128
Vs167_n_8 s167_n_8 0 DC 0 AC 1
Xs167_n_8 s167_n_8 0 adc_mim_bank COUNT=256
Vs167_n_9 s167_n_9 0 DC 0 AC 1
Xs167_n_9 s167_n_9 0 adc_mim_bank COUNT=512
Vs167_n_10 s167_n_10 0 DC 0 AC 1
Xs167_n_10 s167_n_10 0 adc_mim_bank COUNT=1024
Vs167_n_11 s167_n_11 0 DC 0 AC 1
Xs167_n_11 s167_n_11 0 adc_mim_bank COUNT=2048
Vs167_n_12 s167_n_12 0 DC 0 AC 1
Xs167_n_12 s167_n_12 0 adc_mim_bank COUNT=1
Vs168_p_0 s168_p_0 0 DC 0 AC 1
Xs168_p_0 s168_p_0 0 adc_mim_bank COUNT=1
Vs168_p_1 s168_p_1 0 DC 0 AC 1
Xs168_p_1 s168_p_1 0 adc_mim_bank COUNT=2
Vs168_p_2 s168_p_2 0 DC 0 AC 1
Xs168_p_2 s168_p_2 0 adc_mim_bank COUNT=4
Vs168_p_3 s168_p_3 0 DC 0 AC 1
Xs168_p_3 s168_p_3 0 adc_mim_bank COUNT=8
Vs168_p_4 s168_p_4 0 DC 0 AC 1
Xs168_p_4 s168_p_4 0 adc_mim_bank COUNT=16
Vs168_p_5 s168_p_5 0 DC 0 AC 1
Xs168_p_5 s168_p_5 0 adc_mim_bank COUNT=32
Vs168_p_6 s168_p_6 0 DC 0 AC 1
Xs168_p_6 s168_p_6 0 adc_mim_bank COUNT=64
Vs168_p_7 s168_p_7 0 DC 0 AC 1
Xs168_p_7 s168_p_7 0 adc_mim_bank COUNT=128
Vs168_p_8 s168_p_8 0 DC 0 AC 1
Xs168_p_8 s168_p_8 0 adc_mim_bank COUNT=256
Vs168_p_9 s168_p_9 0 DC 0 AC 1
Xs168_p_9 s168_p_9 0 adc_mim_bank COUNT=512
Vs168_p_10 s168_p_10 0 DC 0 AC 1
Xs168_p_10 s168_p_10 0 adc_mim_bank COUNT=1024
Vs168_p_11 s168_p_11 0 DC 0 AC 1
Xs168_p_11 s168_p_11 0 adc_mim_bank COUNT=2048
Vs168_p_12 s168_p_12 0 DC 0 AC 1
Xs168_p_12 s168_p_12 0 adc_mim_bank COUNT=1
Vs168_n_0 s168_n_0 0 DC 0 AC 1
Xs168_n_0 s168_n_0 0 adc_mim_bank COUNT=1
Vs168_n_1 s168_n_1 0 DC 0 AC 1
Xs168_n_1 s168_n_1 0 adc_mim_bank COUNT=2
Vs168_n_2 s168_n_2 0 DC 0 AC 1
Xs168_n_2 s168_n_2 0 adc_mim_bank COUNT=4
Vs168_n_3 s168_n_3 0 DC 0 AC 1
Xs168_n_3 s168_n_3 0 adc_mim_bank COUNT=8
Vs168_n_4 s168_n_4 0 DC 0 AC 1
Xs168_n_4 s168_n_4 0 adc_mim_bank COUNT=16
Vs168_n_5 s168_n_5 0 DC 0 AC 1
Xs168_n_5 s168_n_5 0 adc_mim_bank COUNT=32
Vs168_n_6 s168_n_6 0 DC 0 AC 1
Xs168_n_6 s168_n_6 0 adc_mim_bank COUNT=64
Vs168_n_7 s168_n_7 0 DC 0 AC 1
Xs168_n_7 s168_n_7 0 adc_mim_bank COUNT=128
Vs168_n_8 s168_n_8 0 DC 0 AC 1
Xs168_n_8 s168_n_8 0 adc_mim_bank COUNT=256
Vs168_n_9 s168_n_9 0 DC 0 AC 1
Xs168_n_9 s168_n_9 0 adc_mim_bank COUNT=512
Vs168_n_10 s168_n_10 0 DC 0 AC 1
Xs168_n_10 s168_n_10 0 adc_mim_bank COUNT=1024
Vs168_n_11 s168_n_11 0 DC 0 AC 1
Xs168_n_11 s168_n_11 0 adc_mim_bank COUNT=2048
Vs168_n_12 s168_n_12 0 DC 0 AC 1
Xs168_n_12 s168_n_12 0 adc_mim_bank COUNT=1
Vs169_p_0 s169_p_0 0 DC 0 AC 1
Xs169_p_0 s169_p_0 0 adc_mim_bank COUNT=1
Vs169_p_1 s169_p_1 0 DC 0 AC 1
Xs169_p_1 s169_p_1 0 adc_mim_bank COUNT=2
Vs169_p_2 s169_p_2 0 DC 0 AC 1
Xs169_p_2 s169_p_2 0 adc_mim_bank COUNT=4
Vs169_p_3 s169_p_3 0 DC 0 AC 1
Xs169_p_3 s169_p_3 0 adc_mim_bank COUNT=8
Vs169_p_4 s169_p_4 0 DC 0 AC 1
Xs169_p_4 s169_p_4 0 adc_mim_bank COUNT=16
Vs169_p_5 s169_p_5 0 DC 0 AC 1
Xs169_p_5 s169_p_5 0 adc_mim_bank COUNT=32
Vs169_p_6 s169_p_6 0 DC 0 AC 1
Xs169_p_6 s169_p_6 0 adc_mim_bank COUNT=64
Vs169_p_7 s169_p_7 0 DC 0 AC 1
Xs169_p_7 s169_p_7 0 adc_mim_bank COUNT=128
Vs169_p_8 s169_p_8 0 DC 0 AC 1
Xs169_p_8 s169_p_8 0 adc_mim_bank COUNT=256
Vs169_p_9 s169_p_9 0 DC 0 AC 1
Xs169_p_9 s169_p_9 0 adc_mim_bank COUNT=512
Vs169_p_10 s169_p_10 0 DC 0 AC 1
Xs169_p_10 s169_p_10 0 adc_mim_bank COUNT=1024
Vs169_p_11 s169_p_11 0 DC 0 AC 1
Xs169_p_11 s169_p_11 0 adc_mim_bank COUNT=2048
Vs169_p_12 s169_p_12 0 DC 0 AC 1
Xs169_p_12 s169_p_12 0 adc_mim_bank COUNT=1
Vs169_n_0 s169_n_0 0 DC 0 AC 1
Xs169_n_0 s169_n_0 0 adc_mim_bank COUNT=1
Vs169_n_1 s169_n_1 0 DC 0 AC 1
Xs169_n_1 s169_n_1 0 adc_mim_bank COUNT=2
Vs169_n_2 s169_n_2 0 DC 0 AC 1
Xs169_n_2 s169_n_2 0 adc_mim_bank COUNT=4
Vs169_n_3 s169_n_3 0 DC 0 AC 1
Xs169_n_3 s169_n_3 0 adc_mim_bank COUNT=8
Vs169_n_4 s169_n_4 0 DC 0 AC 1
Xs169_n_4 s169_n_4 0 adc_mim_bank COUNT=16
Vs169_n_5 s169_n_5 0 DC 0 AC 1
Xs169_n_5 s169_n_5 0 adc_mim_bank COUNT=32
Vs169_n_6 s169_n_6 0 DC 0 AC 1
Xs169_n_6 s169_n_6 0 adc_mim_bank COUNT=64
Vs169_n_7 s169_n_7 0 DC 0 AC 1
Xs169_n_7 s169_n_7 0 adc_mim_bank COUNT=128
Vs169_n_8 s169_n_8 0 DC 0 AC 1
Xs169_n_8 s169_n_8 0 adc_mim_bank COUNT=256
Vs169_n_9 s169_n_9 0 DC 0 AC 1
Xs169_n_9 s169_n_9 0 adc_mim_bank COUNT=512
Vs169_n_10 s169_n_10 0 DC 0 AC 1
Xs169_n_10 s169_n_10 0 adc_mim_bank COUNT=1024
Vs169_n_11 s169_n_11 0 DC 0 AC 1
Xs169_n_11 s169_n_11 0 adc_mim_bank COUNT=2048
Vs169_n_12 s169_n_12 0 DC 0 AC 1
Xs169_n_12 s169_n_12 0 adc_mim_bank COUNT=1
Vs170_p_0 s170_p_0 0 DC 0 AC 1
Xs170_p_0 s170_p_0 0 adc_mim_bank COUNT=1
Vs170_p_1 s170_p_1 0 DC 0 AC 1
Xs170_p_1 s170_p_1 0 adc_mim_bank COUNT=2
Vs170_p_2 s170_p_2 0 DC 0 AC 1
Xs170_p_2 s170_p_2 0 adc_mim_bank COUNT=4
Vs170_p_3 s170_p_3 0 DC 0 AC 1
Xs170_p_3 s170_p_3 0 adc_mim_bank COUNT=8
Vs170_p_4 s170_p_4 0 DC 0 AC 1
Xs170_p_4 s170_p_4 0 adc_mim_bank COUNT=16
Vs170_p_5 s170_p_5 0 DC 0 AC 1
Xs170_p_5 s170_p_5 0 adc_mim_bank COUNT=32
Vs170_p_6 s170_p_6 0 DC 0 AC 1
Xs170_p_6 s170_p_6 0 adc_mim_bank COUNT=64
Vs170_p_7 s170_p_7 0 DC 0 AC 1
Xs170_p_7 s170_p_7 0 adc_mim_bank COUNT=128
Vs170_p_8 s170_p_8 0 DC 0 AC 1
Xs170_p_8 s170_p_8 0 adc_mim_bank COUNT=256
Vs170_p_9 s170_p_9 0 DC 0 AC 1
Xs170_p_9 s170_p_9 0 adc_mim_bank COUNT=512
Vs170_p_10 s170_p_10 0 DC 0 AC 1
Xs170_p_10 s170_p_10 0 adc_mim_bank COUNT=1024
Vs170_p_11 s170_p_11 0 DC 0 AC 1
Xs170_p_11 s170_p_11 0 adc_mim_bank COUNT=2048
Vs170_p_12 s170_p_12 0 DC 0 AC 1
Xs170_p_12 s170_p_12 0 adc_mim_bank COUNT=1
Vs170_n_0 s170_n_0 0 DC 0 AC 1
Xs170_n_0 s170_n_0 0 adc_mim_bank COUNT=1
Vs170_n_1 s170_n_1 0 DC 0 AC 1
Xs170_n_1 s170_n_1 0 adc_mim_bank COUNT=2
Vs170_n_2 s170_n_2 0 DC 0 AC 1
Xs170_n_2 s170_n_2 0 adc_mim_bank COUNT=4
Vs170_n_3 s170_n_3 0 DC 0 AC 1
Xs170_n_3 s170_n_3 0 adc_mim_bank COUNT=8
Vs170_n_4 s170_n_4 0 DC 0 AC 1
Xs170_n_4 s170_n_4 0 adc_mim_bank COUNT=16
Vs170_n_5 s170_n_5 0 DC 0 AC 1
Xs170_n_5 s170_n_5 0 adc_mim_bank COUNT=32
Vs170_n_6 s170_n_6 0 DC 0 AC 1
Xs170_n_6 s170_n_6 0 adc_mim_bank COUNT=64
Vs170_n_7 s170_n_7 0 DC 0 AC 1
Xs170_n_7 s170_n_7 0 adc_mim_bank COUNT=128
Vs170_n_8 s170_n_8 0 DC 0 AC 1
Xs170_n_8 s170_n_8 0 adc_mim_bank COUNT=256
Vs170_n_9 s170_n_9 0 DC 0 AC 1
Xs170_n_9 s170_n_9 0 adc_mim_bank COUNT=512
Vs170_n_10 s170_n_10 0 DC 0 AC 1
Xs170_n_10 s170_n_10 0 adc_mim_bank COUNT=1024
Vs170_n_11 s170_n_11 0 DC 0 AC 1
Xs170_n_11 s170_n_11 0 adc_mim_bank COUNT=2048
Vs170_n_12 s170_n_12 0 DC 0 AC 1
Xs170_n_12 s170_n_12 0 adc_mim_bank COUNT=1
Vs171_p_0 s171_p_0 0 DC 0 AC 1
Xs171_p_0 s171_p_0 0 adc_mim_bank COUNT=1
Vs171_p_1 s171_p_1 0 DC 0 AC 1
Xs171_p_1 s171_p_1 0 adc_mim_bank COUNT=2
Vs171_p_2 s171_p_2 0 DC 0 AC 1
Xs171_p_2 s171_p_2 0 adc_mim_bank COUNT=4
Vs171_p_3 s171_p_3 0 DC 0 AC 1
Xs171_p_3 s171_p_3 0 adc_mim_bank COUNT=8
Vs171_p_4 s171_p_4 0 DC 0 AC 1
Xs171_p_4 s171_p_4 0 adc_mim_bank COUNT=16
Vs171_p_5 s171_p_5 0 DC 0 AC 1
Xs171_p_5 s171_p_5 0 adc_mim_bank COUNT=32
Vs171_p_6 s171_p_6 0 DC 0 AC 1
Xs171_p_6 s171_p_6 0 adc_mim_bank COUNT=64
Vs171_p_7 s171_p_7 0 DC 0 AC 1
Xs171_p_7 s171_p_7 0 adc_mim_bank COUNT=128
Vs171_p_8 s171_p_8 0 DC 0 AC 1
Xs171_p_8 s171_p_8 0 adc_mim_bank COUNT=256
Vs171_p_9 s171_p_9 0 DC 0 AC 1
Xs171_p_9 s171_p_9 0 adc_mim_bank COUNT=512
Vs171_p_10 s171_p_10 0 DC 0 AC 1
Xs171_p_10 s171_p_10 0 adc_mim_bank COUNT=1024
Vs171_p_11 s171_p_11 0 DC 0 AC 1
Xs171_p_11 s171_p_11 0 adc_mim_bank COUNT=2048
Vs171_p_12 s171_p_12 0 DC 0 AC 1
Xs171_p_12 s171_p_12 0 adc_mim_bank COUNT=1
Vs171_n_0 s171_n_0 0 DC 0 AC 1
Xs171_n_0 s171_n_0 0 adc_mim_bank COUNT=1
Vs171_n_1 s171_n_1 0 DC 0 AC 1
Xs171_n_1 s171_n_1 0 adc_mim_bank COUNT=2
Vs171_n_2 s171_n_2 0 DC 0 AC 1
Xs171_n_2 s171_n_2 0 adc_mim_bank COUNT=4
Vs171_n_3 s171_n_3 0 DC 0 AC 1
Xs171_n_3 s171_n_3 0 adc_mim_bank COUNT=8
Vs171_n_4 s171_n_4 0 DC 0 AC 1
Xs171_n_4 s171_n_4 0 adc_mim_bank COUNT=16
Vs171_n_5 s171_n_5 0 DC 0 AC 1
Xs171_n_5 s171_n_5 0 adc_mim_bank COUNT=32
Vs171_n_6 s171_n_6 0 DC 0 AC 1
Xs171_n_6 s171_n_6 0 adc_mim_bank COUNT=64
Vs171_n_7 s171_n_7 0 DC 0 AC 1
Xs171_n_7 s171_n_7 0 adc_mim_bank COUNT=128
Vs171_n_8 s171_n_8 0 DC 0 AC 1
Xs171_n_8 s171_n_8 0 adc_mim_bank COUNT=256
Vs171_n_9 s171_n_9 0 DC 0 AC 1
Xs171_n_9 s171_n_9 0 adc_mim_bank COUNT=512
Vs171_n_10 s171_n_10 0 DC 0 AC 1
Xs171_n_10 s171_n_10 0 adc_mim_bank COUNT=1024
Vs171_n_11 s171_n_11 0 DC 0 AC 1
Xs171_n_11 s171_n_11 0 adc_mim_bank COUNT=2048
Vs171_n_12 s171_n_12 0 DC 0 AC 1
Xs171_n_12 s171_n_12 0 adc_mim_bank COUNT=1
Vs172_p_0 s172_p_0 0 DC 0 AC 1
Xs172_p_0 s172_p_0 0 adc_mim_bank COUNT=1
Vs172_p_1 s172_p_1 0 DC 0 AC 1
Xs172_p_1 s172_p_1 0 adc_mim_bank COUNT=2
Vs172_p_2 s172_p_2 0 DC 0 AC 1
Xs172_p_2 s172_p_2 0 adc_mim_bank COUNT=4
Vs172_p_3 s172_p_3 0 DC 0 AC 1
Xs172_p_3 s172_p_3 0 adc_mim_bank COUNT=8
Vs172_p_4 s172_p_4 0 DC 0 AC 1
Xs172_p_4 s172_p_4 0 adc_mim_bank COUNT=16
Vs172_p_5 s172_p_5 0 DC 0 AC 1
Xs172_p_5 s172_p_5 0 adc_mim_bank COUNT=32
Vs172_p_6 s172_p_6 0 DC 0 AC 1
Xs172_p_6 s172_p_6 0 adc_mim_bank COUNT=64
Vs172_p_7 s172_p_7 0 DC 0 AC 1
Xs172_p_7 s172_p_7 0 adc_mim_bank COUNT=128
Vs172_p_8 s172_p_8 0 DC 0 AC 1
Xs172_p_8 s172_p_8 0 adc_mim_bank COUNT=256
Vs172_p_9 s172_p_9 0 DC 0 AC 1
Xs172_p_9 s172_p_9 0 adc_mim_bank COUNT=512
Vs172_p_10 s172_p_10 0 DC 0 AC 1
Xs172_p_10 s172_p_10 0 adc_mim_bank COUNT=1024
Vs172_p_11 s172_p_11 0 DC 0 AC 1
Xs172_p_11 s172_p_11 0 adc_mim_bank COUNT=2048
Vs172_p_12 s172_p_12 0 DC 0 AC 1
Xs172_p_12 s172_p_12 0 adc_mim_bank COUNT=1
Vs172_n_0 s172_n_0 0 DC 0 AC 1
Xs172_n_0 s172_n_0 0 adc_mim_bank COUNT=1
Vs172_n_1 s172_n_1 0 DC 0 AC 1
Xs172_n_1 s172_n_1 0 adc_mim_bank COUNT=2
Vs172_n_2 s172_n_2 0 DC 0 AC 1
Xs172_n_2 s172_n_2 0 adc_mim_bank COUNT=4
Vs172_n_3 s172_n_3 0 DC 0 AC 1
Xs172_n_3 s172_n_3 0 adc_mim_bank COUNT=8
Vs172_n_4 s172_n_4 0 DC 0 AC 1
Xs172_n_4 s172_n_4 0 adc_mim_bank COUNT=16
Vs172_n_5 s172_n_5 0 DC 0 AC 1
Xs172_n_5 s172_n_5 0 adc_mim_bank COUNT=32
Vs172_n_6 s172_n_6 0 DC 0 AC 1
Xs172_n_6 s172_n_6 0 adc_mim_bank COUNT=64
Vs172_n_7 s172_n_7 0 DC 0 AC 1
Xs172_n_7 s172_n_7 0 adc_mim_bank COUNT=128
Vs172_n_8 s172_n_8 0 DC 0 AC 1
Xs172_n_8 s172_n_8 0 adc_mim_bank COUNT=256
Vs172_n_9 s172_n_9 0 DC 0 AC 1
Xs172_n_9 s172_n_9 0 adc_mim_bank COUNT=512
Vs172_n_10 s172_n_10 0 DC 0 AC 1
Xs172_n_10 s172_n_10 0 adc_mim_bank COUNT=1024
Vs172_n_11 s172_n_11 0 DC 0 AC 1
Xs172_n_11 s172_n_11 0 adc_mim_bank COUNT=2048
Vs172_n_12 s172_n_12 0 DC 0 AC 1
Xs172_n_12 s172_n_12 0 adc_mim_bank COUNT=1
Vs173_p_0 s173_p_0 0 DC 0 AC 1
Xs173_p_0 s173_p_0 0 adc_mim_bank COUNT=1
Vs173_p_1 s173_p_1 0 DC 0 AC 1
Xs173_p_1 s173_p_1 0 adc_mim_bank COUNT=2
Vs173_p_2 s173_p_2 0 DC 0 AC 1
Xs173_p_2 s173_p_2 0 adc_mim_bank COUNT=4
Vs173_p_3 s173_p_3 0 DC 0 AC 1
Xs173_p_3 s173_p_3 0 adc_mim_bank COUNT=8
Vs173_p_4 s173_p_4 0 DC 0 AC 1
Xs173_p_4 s173_p_4 0 adc_mim_bank COUNT=16
Vs173_p_5 s173_p_5 0 DC 0 AC 1
Xs173_p_5 s173_p_5 0 adc_mim_bank COUNT=32
Vs173_p_6 s173_p_6 0 DC 0 AC 1
Xs173_p_6 s173_p_6 0 adc_mim_bank COUNT=64
Vs173_p_7 s173_p_7 0 DC 0 AC 1
Xs173_p_7 s173_p_7 0 adc_mim_bank COUNT=128
Vs173_p_8 s173_p_8 0 DC 0 AC 1
Xs173_p_8 s173_p_8 0 adc_mim_bank COUNT=256
Vs173_p_9 s173_p_9 0 DC 0 AC 1
Xs173_p_9 s173_p_9 0 adc_mim_bank COUNT=512
Vs173_p_10 s173_p_10 0 DC 0 AC 1
Xs173_p_10 s173_p_10 0 adc_mim_bank COUNT=1024
Vs173_p_11 s173_p_11 0 DC 0 AC 1
Xs173_p_11 s173_p_11 0 adc_mim_bank COUNT=2048
Vs173_p_12 s173_p_12 0 DC 0 AC 1
Xs173_p_12 s173_p_12 0 adc_mim_bank COUNT=1
Vs173_n_0 s173_n_0 0 DC 0 AC 1
Xs173_n_0 s173_n_0 0 adc_mim_bank COUNT=1
Vs173_n_1 s173_n_1 0 DC 0 AC 1
Xs173_n_1 s173_n_1 0 adc_mim_bank COUNT=2
Vs173_n_2 s173_n_2 0 DC 0 AC 1
Xs173_n_2 s173_n_2 0 adc_mim_bank COUNT=4
Vs173_n_3 s173_n_3 0 DC 0 AC 1
Xs173_n_3 s173_n_3 0 adc_mim_bank COUNT=8
Vs173_n_4 s173_n_4 0 DC 0 AC 1
Xs173_n_4 s173_n_4 0 adc_mim_bank COUNT=16
Vs173_n_5 s173_n_5 0 DC 0 AC 1
Xs173_n_5 s173_n_5 0 adc_mim_bank COUNT=32
Vs173_n_6 s173_n_6 0 DC 0 AC 1
Xs173_n_6 s173_n_6 0 adc_mim_bank COUNT=64
Vs173_n_7 s173_n_7 0 DC 0 AC 1
Xs173_n_7 s173_n_7 0 adc_mim_bank COUNT=128
Vs173_n_8 s173_n_8 0 DC 0 AC 1
Xs173_n_8 s173_n_8 0 adc_mim_bank COUNT=256
Vs173_n_9 s173_n_9 0 DC 0 AC 1
Xs173_n_9 s173_n_9 0 adc_mim_bank COUNT=512
Vs173_n_10 s173_n_10 0 DC 0 AC 1
Xs173_n_10 s173_n_10 0 adc_mim_bank COUNT=1024
Vs173_n_11 s173_n_11 0 DC 0 AC 1
Xs173_n_11 s173_n_11 0 adc_mim_bank COUNT=2048
Vs173_n_12 s173_n_12 0 DC 0 AC 1
Xs173_n_12 s173_n_12 0 adc_mim_bank COUNT=1
Vs174_p_0 s174_p_0 0 DC 0 AC 1
Xs174_p_0 s174_p_0 0 adc_mim_bank COUNT=1
Vs174_p_1 s174_p_1 0 DC 0 AC 1
Xs174_p_1 s174_p_1 0 adc_mim_bank COUNT=2
Vs174_p_2 s174_p_2 0 DC 0 AC 1
Xs174_p_2 s174_p_2 0 adc_mim_bank COUNT=4
Vs174_p_3 s174_p_3 0 DC 0 AC 1
Xs174_p_3 s174_p_3 0 adc_mim_bank COUNT=8
Vs174_p_4 s174_p_4 0 DC 0 AC 1
Xs174_p_4 s174_p_4 0 adc_mim_bank COUNT=16
Vs174_p_5 s174_p_5 0 DC 0 AC 1
Xs174_p_5 s174_p_5 0 adc_mim_bank COUNT=32
Vs174_p_6 s174_p_6 0 DC 0 AC 1
Xs174_p_6 s174_p_6 0 adc_mim_bank COUNT=64
Vs174_p_7 s174_p_7 0 DC 0 AC 1
Xs174_p_7 s174_p_7 0 adc_mim_bank COUNT=128
Vs174_p_8 s174_p_8 0 DC 0 AC 1
Xs174_p_8 s174_p_8 0 adc_mim_bank COUNT=256
Vs174_p_9 s174_p_9 0 DC 0 AC 1
Xs174_p_9 s174_p_9 0 adc_mim_bank COUNT=512
Vs174_p_10 s174_p_10 0 DC 0 AC 1
Xs174_p_10 s174_p_10 0 adc_mim_bank COUNT=1024
Vs174_p_11 s174_p_11 0 DC 0 AC 1
Xs174_p_11 s174_p_11 0 adc_mim_bank COUNT=2048
Vs174_p_12 s174_p_12 0 DC 0 AC 1
Xs174_p_12 s174_p_12 0 adc_mim_bank COUNT=1
Vs174_n_0 s174_n_0 0 DC 0 AC 1
Xs174_n_0 s174_n_0 0 adc_mim_bank COUNT=1
Vs174_n_1 s174_n_1 0 DC 0 AC 1
Xs174_n_1 s174_n_1 0 adc_mim_bank COUNT=2
Vs174_n_2 s174_n_2 0 DC 0 AC 1
Xs174_n_2 s174_n_2 0 adc_mim_bank COUNT=4
Vs174_n_3 s174_n_3 0 DC 0 AC 1
Xs174_n_3 s174_n_3 0 adc_mim_bank COUNT=8
Vs174_n_4 s174_n_4 0 DC 0 AC 1
Xs174_n_4 s174_n_4 0 adc_mim_bank COUNT=16
Vs174_n_5 s174_n_5 0 DC 0 AC 1
Xs174_n_5 s174_n_5 0 adc_mim_bank COUNT=32
Vs174_n_6 s174_n_6 0 DC 0 AC 1
Xs174_n_6 s174_n_6 0 adc_mim_bank COUNT=64
Vs174_n_7 s174_n_7 0 DC 0 AC 1
Xs174_n_7 s174_n_7 0 adc_mim_bank COUNT=128
Vs174_n_8 s174_n_8 0 DC 0 AC 1
Xs174_n_8 s174_n_8 0 adc_mim_bank COUNT=256
Vs174_n_9 s174_n_9 0 DC 0 AC 1
Xs174_n_9 s174_n_9 0 adc_mim_bank COUNT=512
Vs174_n_10 s174_n_10 0 DC 0 AC 1
Xs174_n_10 s174_n_10 0 adc_mim_bank COUNT=1024
Vs174_n_11 s174_n_11 0 DC 0 AC 1
Xs174_n_11 s174_n_11 0 adc_mim_bank COUNT=2048
Vs174_n_12 s174_n_12 0 DC 0 AC 1
Xs174_n_12 s174_n_12 0 adc_mim_bank COUNT=1
Vs175_p_0 s175_p_0 0 DC 0 AC 1
Xs175_p_0 s175_p_0 0 adc_mim_bank COUNT=1
Vs175_p_1 s175_p_1 0 DC 0 AC 1
Xs175_p_1 s175_p_1 0 adc_mim_bank COUNT=2
Vs175_p_2 s175_p_2 0 DC 0 AC 1
Xs175_p_2 s175_p_2 0 adc_mim_bank COUNT=4
Vs175_p_3 s175_p_3 0 DC 0 AC 1
Xs175_p_3 s175_p_3 0 adc_mim_bank COUNT=8
Vs175_p_4 s175_p_4 0 DC 0 AC 1
Xs175_p_4 s175_p_4 0 adc_mim_bank COUNT=16
Vs175_p_5 s175_p_5 0 DC 0 AC 1
Xs175_p_5 s175_p_5 0 adc_mim_bank COUNT=32
Vs175_p_6 s175_p_6 0 DC 0 AC 1
Xs175_p_6 s175_p_6 0 adc_mim_bank COUNT=64
Vs175_p_7 s175_p_7 0 DC 0 AC 1
Xs175_p_7 s175_p_7 0 adc_mim_bank COUNT=128
Vs175_p_8 s175_p_8 0 DC 0 AC 1
Xs175_p_8 s175_p_8 0 adc_mim_bank COUNT=256
Vs175_p_9 s175_p_9 0 DC 0 AC 1
Xs175_p_9 s175_p_9 0 adc_mim_bank COUNT=512
Vs175_p_10 s175_p_10 0 DC 0 AC 1
Xs175_p_10 s175_p_10 0 adc_mim_bank COUNT=1024
Vs175_p_11 s175_p_11 0 DC 0 AC 1
Xs175_p_11 s175_p_11 0 adc_mim_bank COUNT=2048
Vs175_p_12 s175_p_12 0 DC 0 AC 1
Xs175_p_12 s175_p_12 0 adc_mim_bank COUNT=1
Vs175_n_0 s175_n_0 0 DC 0 AC 1
Xs175_n_0 s175_n_0 0 adc_mim_bank COUNT=1
Vs175_n_1 s175_n_1 0 DC 0 AC 1
Xs175_n_1 s175_n_1 0 adc_mim_bank COUNT=2
Vs175_n_2 s175_n_2 0 DC 0 AC 1
Xs175_n_2 s175_n_2 0 adc_mim_bank COUNT=4
Vs175_n_3 s175_n_3 0 DC 0 AC 1
Xs175_n_3 s175_n_3 0 adc_mim_bank COUNT=8
Vs175_n_4 s175_n_4 0 DC 0 AC 1
Xs175_n_4 s175_n_4 0 adc_mim_bank COUNT=16
Vs175_n_5 s175_n_5 0 DC 0 AC 1
Xs175_n_5 s175_n_5 0 adc_mim_bank COUNT=32
Vs175_n_6 s175_n_6 0 DC 0 AC 1
Xs175_n_6 s175_n_6 0 adc_mim_bank COUNT=64
Vs175_n_7 s175_n_7 0 DC 0 AC 1
Xs175_n_7 s175_n_7 0 adc_mim_bank COUNT=128
Vs175_n_8 s175_n_8 0 DC 0 AC 1
Xs175_n_8 s175_n_8 0 adc_mim_bank COUNT=256
Vs175_n_9 s175_n_9 0 DC 0 AC 1
Xs175_n_9 s175_n_9 0 adc_mim_bank COUNT=512
Vs175_n_10 s175_n_10 0 DC 0 AC 1
Xs175_n_10 s175_n_10 0 adc_mim_bank COUNT=1024
Vs175_n_11 s175_n_11 0 DC 0 AC 1
Xs175_n_11 s175_n_11 0 adc_mim_bank COUNT=2048
Vs175_n_12 s175_n_12 0 DC 0 AC 1
Xs175_n_12 s175_n_12 0 adc_mim_bank COUNT=1
Vs176_p_0 s176_p_0 0 DC 0 AC 1
Xs176_p_0 s176_p_0 0 adc_mim_bank COUNT=1
Vs176_p_1 s176_p_1 0 DC 0 AC 1
Xs176_p_1 s176_p_1 0 adc_mim_bank COUNT=2
Vs176_p_2 s176_p_2 0 DC 0 AC 1
Xs176_p_2 s176_p_2 0 adc_mim_bank COUNT=4
Vs176_p_3 s176_p_3 0 DC 0 AC 1
Xs176_p_3 s176_p_3 0 adc_mim_bank COUNT=8
Vs176_p_4 s176_p_4 0 DC 0 AC 1
Xs176_p_4 s176_p_4 0 adc_mim_bank COUNT=16
Vs176_p_5 s176_p_5 0 DC 0 AC 1
Xs176_p_5 s176_p_5 0 adc_mim_bank COUNT=32
Vs176_p_6 s176_p_6 0 DC 0 AC 1
Xs176_p_6 s176_p_6 0 adc_mim_bank COUNT=64
Vs176_p_7 s176_p_7 0 DC 0 AC 1
Xs176_p_7 s176_p_7 0 adc_mim_bank COUNT=128
Vs176_p_8 s176_p_8 0 DC 0 AC 1
Xs176_p_8 s176_p_8 0 adc_mim_bank COUNT=256
Vs176_p_9 s176_p_9 0 DC 0 AC 1
Xs176_p_9 s176_p_9 0 adc_mim_bank COUNT=512
Vs176_p_10 s176_p_10 0 DC 0 AC 1
Xs176_p_10 s176_p_10 0 adc_mim_bank COUNT=1024
Vs176_p_11 s176_p_11 0 DC 0 AC 1
Xs176_p_11 s176_p_11 0 adc_mim_bank COUNT=2048
Vs176_p_12 s176_p_12 0 DC 0 AC 1
Xs176_p_12 s176_p_12 0 adc_mim_bank COUNT=1
Vs176_n_0 s176_n_0 0 DC 0 AC 1
Xs176_n_0 s176_n_0 0 adc_mim_bank COUNT=1
Vs176_n_1 s176_n_1 0 DC 0 AC 1
Xs176_n_1 s176_n_1 0 adc_mim_bank COUNT=2
Vs176_n_2 s176_n_2 0 DC 0 AC 1
Xs176_n_2 s176_n_2 0 adc_mim_bank COUNT=4
Vs176_n_3 s176_n_3 0 DC 0 AC 1
Xs176_n_3 s176_n_3 0 adc_mim_bank COUNT=8
Vs176_n_4 s176_n_4 0 DC 0 AC 1
Xs176_n_4 s176_n_4 0 adc_mim_bank COUNT=16
Vs176_n_5 s176_n_5 0 DC 0 AC 1
Xs176_n_5 s176_n_5 0 adc_mim_bank COUNT=32
Vs176_n_6 s176_n_6 0 DC 0 AC 1
Xs176_n_6 s176_n_6 0 adc_mim_bank COUNT=64
Vs176_n_7 s176_n_7 0 DC 0 AC 1
Xs176_n_7 s176_n_7 0 adc_mim_bank COUNT=128
Vs176_n_8 s176_n_8 0 DC 0 AC 1
Xs176_n_8 s176_n_8 0 adc_mim_bank COUNT=256
Vs176_n_9 s176_n_9 0 DC 0 AC 1
Xs176_n_9 s176_n_9 0 adc_mim_bank COUNT=512
Vs176_n_10 s176_n_10 0 DC 0 AC 1
Xs176_n_10 s176_n_10 0 adc_mim_bank COUNT=1024
Vs176_n_11 s176_n_11 0 DC 0 AC 1
Xs176_n_11 s176_n_11 0 adc_mim_bank COUNT=2048
Vs176_n_12 s176_n_12 0 DC 0 AC 1
Xs176_n_12 s176_n_12 0 adc_mim_bank COUNT=1
Vs177_p_0 s177_p_0 0 DC 0 AC 1
Xs177_p_0 s177_p_0 0 adc_mim_bank COUNT=1
Vs177_p_1 s177_p_1 0 DC 0 AC 1
Xs177_p_1 s177_p_1 0 adc_mim_bank COUNT=2
Vs177_p_2 s177_p_2 0 DC 0 AC 1
Xs177_p_2 s177_p_2 0 adc_mim_bank COUNT=4
Vs177_p_3 s177_p_3 0 DC 0 AC 1
Xs177_p_3 s177_p_3 0 adc_mim_bank COUNT=8
Vs177_p_4 s177_p_4 0 DC 0 AC 1
Xs177_p_4 s177_p_4 0 adc_mim_bank COUNT=16
Vs177_p_5 s177_p_5 0 DC 0 AC 1
Xs177_p_5 s177_p_5 0 adc_mim_bank COUNT=32
Vs177_p_6 s177_p_6 0 DC 0 AC 1
Xs177_p_6 s177_p_6 0 adc_mim_bank COUNT=64
Vs177_p_7 s177_p_7 0 DC 0 AC 1
Xs177_p_7 s177_p_7 0 adc_mim_bank COUNT=128
Vs177_p_8 s177_p_8 0 DC 0 AC 1
Xs177_p_8 s177_p_8 0 adc_mim_bank COUNT=256
Vs177_p_9 s177_p_9 0 DC 0 AC 1
Xs177_p_9 s177_p_9 0 adc_mim_bank COUNT=512
Vs177_p_10 s177_p_10 0 DC 0 AC 1
Xs177_p_10 s177_p_10 0 adc_mim_bank COUNT=1024
Vs177_p_11 s177_p_11 0 DC 0 AC 1
Xs177_p_11 s177_p_11 0 adc_mim_bank COUNT=2048
Vs177_p_12 s177_p_12 0 DC 0 AC 1
Xs177_p_12 s177_p_12 0 adc_mim_bank COUNT=1
Vs177_n_0 s177_n_0 0 DC 0 AC 1
Xs177_n_0 s177_n_0 0 adc_mim_bank COUNT=1
Vs177_n_1 s177_n_1 0 DC 0 AC 1
Xs177_n_1 s177_n_1 0 adc_mim_bank COUNT=2
Vs177_n_2 s177_n_2 0 DC 0 AC 1
Xs177_n_2 s177_n_2 0 adc_mim_bank COUNT=4
Vs177_n_3 s177_n_3 0 DC 0 AC 1
Xs177_n_3 s177_n_3 0 adc_mim_bank COUNT=8
Vs177_n_4 s177_n_4 0 DC 0 AC 1
Xs177_n_4 s177_n_4 0 adc_mim_bank COUNT=16
Vs177_n_5 s177_n_5 0 DC 0 AC 1
Xs177_n_5 s177_n_5 0 adc_mim_bank COUNT=32
Vs177_n_6 s177_n_6 0 DC 0 AC 1
Xs177_n_6 s177_n_6 0 adc_mim_bank COUNT=64
Vs177_n_7 s177_n_7 0 DC 0 AC 1
Xs177_n_7 s177_n_7 0 adc_mim_bank COUNT=128
Vs177_n_8 s177_n_8 0 DC 0 AC 1
Xs177_n_8 s177_n_8 0 adc_mim_bank COUNT=256
Vs177_n_9 s177_n_9 0 DC 0 AC 1
Xs177_n_9 s177_n_9 0 adc_mim_bank COUNT=512
Vs177_n_10 s177_n_10 0 DC 0 AC 1
Xs177_n_10 s177_n_10 0 adc_mim_bank COUNT=1024
Vs177_n_11 s177_n_11 0 DC 0 AC 1
Xs177_n_11 s177_n_11 0 adc_mim_bank COUNT=2048
Vs177_n_12 s177_n_12 0 DC 0 AC 1
Xs177_n_12 s177_n_12 0 adc_mim_bank COUNT=1
Vs178_p_0 s178_p_0 0 DC 0 AC 1
Xs178_p_0 s178_p_0 0 adc_mim_bank COUNT=1
Vs178_p_1 s178_p_1 0 DC 0 AC 1
Xs178_p_1 s178_p_1 0 adc_mim_bank COUNT=2
Vs178_p_2 s178_p_2 0 DC 0 AC 1
Xs178_p_2 s178_p_2 0 adc_mim_bank COUNT=4
Vs178_p_3 s178_p_3 0 DC 0 AC 1
Xs178_p_3 s178_p_3 0 adc_mim_bank COUNT=8
Vs178_p_4 s178_p_4 0 DC 0 AC 1
Xs178_p_4 s178_p_4 0 adc_mim_bank COUNT=16
Vs178_p_5 s178_p_5 0 DC 0 AC 1
Xs178_p_5 s178_p_5 0 adc_mim_bank COUNT=32
Vs178_p_6 s178_p_6 0 DC 0 AC 1
Xs178_p_6 s178_p_6 0 adc_mim_bank COUNT=64
Vs178_p_7 s178_p_7 0 DC 0 AC 1
Xs178_p_7 s178_p_7 0 adc_mim_bank COUNT=128
Vs178_p_8 s178_p_8 0 DC 0 AC 1
Xs178_p_8 s178_p_8 0 adc_mim_bank COUNT=256
Vs178_p_9 s178_p_9 0 DC 0 AC 1
Xs178_p_9 s178_p_9 0 adc_mim_bank COUNT=512
Vs178_p_10 s178_p_10 0 DC 0 AC 1
Xs178_p_10 s178_p_10 0 adc_mim_bank COUNT=1024
Vs178_p_11 s178_p_11 0 DC 0 AC 1
Xs178_p_11 s178_p_11 0 adc_mim_bank COUNT=2048
Vs178_p_12 s178_p_12 0 DC 0 AC 1
Xs178_p_12 s178_p_12 0 adc_mim_bank COUNT=1
Vs178_n_0 s178_n_0 0 DC 0 AC 1
Xs178_n_0 s178_n_0 0 adc_mim_bank COUNT=1
Vs178_n_1 s178_n_1 0 DC 0 AC 1
Xs178_n_1 s178_n_1 0 adc_mim_bank COUNT=2
Vs178_n_2 s178_n_2 0 DC 0 AC 1
Xs178_n_2 s178_n_2 0 adc_mim_bank COUNT=4
Vs178_n_3 s178_n_3 0 DC 0 AC 1
Xs178_n_3 s178_n_3 0 adc_mim_bank COUNT=8
Vs178_n_4 s178_n_4 0 DC 0 AC 1
Xs178_n_4 s178_n_4 0 adc_mim_bank COUNT=16
Vs178_n_5 s178_n_5 0 DC 0 AC 1
Xs178_n_5 s178_n_5 0 adc_mim_bank COUNT=32
Vs178_n_6 s178_n_6 0 DC 0 AC 1
Xs178_n_6 s178_n_6 0 adc_mim_bank COUNT=64
Vs178_n_7 s178_n_7 0 DC 0 AC 1
Xs178_n_7 s178_n_7 0 adc_mim_bank COUNT=128
Vs178_n_8 s178_n_8 0 DC 0 AC 1
Xs178_n_8 s178_n_8 0 adc_mim_bank COUNT=256
Vs178_n_9 s178_n_9 0 DC 0 AC 1
Xs178_n_9 s178_n_9 0 adc_mim_bank COUNT=512
Vs178_n_10 s178_n_10 0 DC 0 AC 1
Xs178_n_10 s178_n_10 0 adc_mim_bank COUNT=1024
Vs178_n_11 s178_n_11 0 DC 0 AC 1
Xs178_n_11 s178_n_11 0 adc_mim_bank COUNT=2048
Vs178_n_12 s178_n_12 0 DC 0 AC 1
Xs178_n_12 s178_n_12 0 adc_mim_bank COUNT=1
Vs179_p_0 s179_p_0 0 DC 0 AC 1
Xs179_p_0 s179_p_0 0 adc_mim_bank COUNT=1
Vs179_p_1 s179_p_1 0 DC 0 AC 1
Xs179_p_1 s179_p_1 0 adc_mim_bank COUNT=2
Vs179_p_2 s179_p_2 0 DC 0 AC 1
Xs179_p_2 s179_p_2 0 adc_mim_bank COUNT=4
Vs179_p_3 s179_p_3 0 DC 0 AC 1
Xs179_p_3 s179_p_3 0 adc_mim_bank COUNT=8
Vs179_p_4 s179_p_4 0 DC 0 AC 1
Xs179_p_4 s179_p_4 0 adc_mim_bank COUNT=16
Vs179_p_5 s179_p_5 0 DC 0 AC 1
Xs179_p_5 s179_p_5 0 adc_mim_bank COUNT=32
Vs179_p_6 s179_p_6 0 DC 0 AC 1
Xs179_p_6 s179_p_6 0 adc_mim_bank COUNT=64
Vs179_p_7 s179_p_7 0 DC 0 AC 1
Xs179_p_7 s179_p_7 0 adc_mim_bank COUNT=128
Vs179_p_8 s179_p_8 0 DC 0 AC 1
Xs179_p_8 s179_p_8 0 adc_mim_bank COUNT=256
Vs179_p_9 s179_p_9 0 DC 0 AC 1
Xs179_p_9 s179_p_9 0 adc_mim_bank COUNT=512
Vs179_p_10 s179_p_10 0 DC 0 AC 1
Xs179_p_10 s179_p_10 0 adc_mim_bank COUNT=1024
Vs179_p_11 s179_p_11 0 DC 0 AC 1
Xs179_p_11 s179_p_11 0 adc_mim_bank COUNT=2048
Vs179_p_12 s179_p_12 0 DC 0 AC 1
Xs179_p_12 s179_p_12 0 adc_mim_bank COUNT=1
Vs179_n_0 s179_n_0 0 DC 0 AC 1
Xs179_n_0 s179_n_0 0 adc_mim_bank COUNT=1
Vs179_n_1 s179_n_1 0 DC 0 AC 1
Xs179_n_1 s179_n_1 0 adc_mim_bank COUNT=2
Vs179_n_2 s179_n_2 0 DC 0 AC 1
Xs179_n_2 s179_n_2 0 adc_mim_bank COUNT=4
Vs179_n_3 s179_n_3 0 DC 0 AC 1
Xs179_n_3 s179_n_3 0 adc_mim_bank COUNT=8
Vs179_n_4 s179_n_4 0 DC 0 AC 1
Xs179_n_4 s179_n_4 0 adc_mim_bank COUNT=16
Vs179_n_5 s179_n_5 0 DC 0 AC 1
Xs179_n_5 s179_n_5 0 adc_mim_bank COUNT=32
Vs179_n_6 s179_n_6 0 DC 0 AC 1
Xs179_n_6 s179_n_6 0 adc_mim_bank COUNT=64
Vs179_n_7 s179_n_7 0 DC 0 AC 1
Xs179_n_7 s179_n_7 0 adc_mim_bank COUNT=128
Vs179_n_8 s179_n_8 0 DC 0 AC 1
Xs179_n_8 s179_n_8 0 adc_mim_bank COUNT=256
Vs179_n_9 s179_n_9 0 DC 0 AC 1
Xs179_n_9 s179_n_9 0 adc_mim_bank COUNT=512
Vs179_n_10 s179_n_10 0 DC 0 AC 1
Xs179_n_10 s179_n_10 0 adc_mim_bank COUNT=1024
Vs179_n_11 s179_n_11 0 DC 0 AC 1
Xs179_n_11 s179_n_11 0 adc_mim_bank COUNT=2048
Vs179_n_12 s179_n_12 0 DC 0 AC 1
Xs179_n_12 s179_n_12 0 adc_mim_bank COUNT=1
Vs180_p_0 s180_p_0 0 DC 0 AC 1
Xs180_p_0 s180_p_0 0 adc_mim_bank COUNT=1
Vs180_p_1 s180_p_1 0 DC 0 AC 1
Xs180_p_1 s180_p_1 0 adc_mim_bank COUNT=2
Vs180_p_2 s180_p_2 0 DC 0 AC 1
Xs180_p_2 s180_p_2 0 adc_mim_bank COUNT=4
Vs180_p_3 s180_p_3 0 DC 0 AC 1
Xs180_p_3 s180_p_3 0 adc_mim_bank COUNT=8
Vs180_p_4 s180_p_4 0 DC 0 AC 1
Xs180_p_4 s180_p_4 0 adc_mim_bank COUNT=16
Vs180_p_5 s180_p_5 0 DC 0 AC 1
Xs180_p_5 s180_p_5 0 adc_mim_bank COUNT=32
Vs180_p_6 s180_p_6 0 DC 0 AC 1
Xs180_p_6 s180_p_6 0 adc_mim_bank COUNT=64
Vs180_p_7 s180_p_7 0 DC 0 AC 1
Xs180_p_7 s180_p_7 0 adc_mim_bank COUNT=128
Vs180_p_8 s180_p_8 0 DC 0 AC 1
Xs180_p_8 s180_p_8 0 adc_mim_bank COUNT=256
Vs180_p_9 s180_p_9 0 DC 0 AC 1
Xs180_p_9 s180_p_9 0 adc_mim_bank COUNT=512
Vs180_p_10 s180_p_10 0 DC 0 AC 1
Xs180_p_10 s180_p_10 0 adc_mim_bank COUNT=1024
Vs180_p_11 s180_p_11 0 DC 0 AC 1
Xs180_p_11 s180_p_11 0 adc_mim_bank COUNT=2048
Vs180_p_12 s180_p_12 0 DC 0 AC 1
Xs180_p_12 s180_p_12 0 adc_mim_bank COUNT=1
Vs180_n_0 s180_n_0 0 DC 0 AC 1
Xs180_n_0 s180_n_0 0 adc_mim_bank COUNT=1
Vs180_n_1 s180_n_1 0 DC 0 AC 1
Xs180_n_1 s180_n_1 0 adc_mim_bank COUNT=2
Vs180_n_2 s180_n_2 0 DC 0 AC 1
Xs180_n_2 s180_n_2 0 adc_mim_bank COUNT=4
Vs180_n_3 s180_n_3 0 DC 0 AC 1
Xs180_n_3 s180_n_3 0 adc_mim_bank COUNT=8
Vs180_n_4 s180_n_4 0 DC 0 AC 1
Xs180_n_4 s180_n_4 0 adc_mim_bank COUNT=16
Vs180_n_5 s180_n_5 0 DC 0 AC 1
Xs180_n_5 s180_n_5 0 adc_mim_bank COUNT=32
Vs180_n_6 s180_n_6 0 DC 0 AC 1
Xs180_n_6 s180_n_6 0 adc_mim_bank COUNT=64
Vs180_n_7 s180_n_7 0 DC 0 AC 1
Xs180_n_7 s180_n_7 0 adc_mim_bank COUNT=128
Vs180_n_8 s180_n_8 0 DC 0 AC 1
Xs180_n_8 s180_n_8 0 adc_mim_bank COUNT=256
Vs180_n_9 s180_n_9 0 DC 0 AC 1
Xs180_n_9 s180_n_9 0 adc_mim_bank COUNT=512
Vs180_n_10 s180_n_10 0 DC 0 AC 1
Xs180_n_10 s180_n_10 0 adc_mim_bank COUNT=1024
Vs180_n_11 s180_n_11 0 DC 0 AC 1
Xs180_n_11 s180_n_11 0 adc_mim_bank COUNT=2048
Vs180_n_12 s180_n_12 0 DC 0 AC 1
Xs180_n_12 s180_n_12 0 adc_mim_bank COUNT=1
Vs181_p_0 s181_p_0 0 DC 0 AC 1
Xs181_p_0 s181_p_0 0 adc_mim_bank COUNT=1
Vs181_p_1 s181_p_1 0 DC 0 AC 1
Xs181_p_1 s181_p_1 0 adc_mim_bank COUNT=2
Vs181_p_2 s181_p_2 0 DC 0 AC 1
Xs181_p_2 s181_p_2 0 adc_mim_bank COUNT=4
Vs181_p_3 s181_p_3 0 DC 0 AC 1
Xs181_p_3 s181_p_3 0 adc_mim_bank COUNT=8
Vs181_p_4 s181_p_4 0 DC 0 AC 1
Xs181_p_4 s181_p_4 0 adc_mim_bank COUNT=16
Vs181_p_5 s181_p_5 0 DC 0 AC 1
Xs181_p_5 s181_p_5 0 adc_mim_bank COUNT=32
Vs181_p_6 s181_p_6 0 DC 0 AC 1
Xs181_p_6 s181_p_6 0 adc_mim_bank COUNT=64
Vs181_p_7 s181_p_7 0 DC 0 AC 1
Xs181_p_7 s181_p_7 0 adc_mim_bank COUNT=128
Vs181_p_8 s181_p_8 0 DC 0 AC 1
Xs181_p_8 s181_p_8 0 adc_mim_bank COUNT=256
Vs181_p_9 s181_p_9 0 DC 0 AC 1
Xs181_p_9 s181_p_9 0 adc_mim_bank COUNT=512
Vs181_p_10 s181_p_10 0 DC 0 AC 1
Xs181_p_10 s181_p_10 0 adc_mim_bank COUNT=1024
Vs181_p_11 s181_p_11 0 DC 0 AC 1
Xs181_p_11 s181_p_11 0 adc_mim_bank COUNT=2048
Vs181_p_12 s181_p_12 0 DC 0 AC 1
Xs181_p_12 s181_p_12 0 adc_mim_bank COUNT=1
Vs181_n_0 s181_n_0 0 DC 0 AC 1
Xs181_n_0 s181_n_0 0 adc_mim_bank COUNT=1
Vs181_n_1 s181_n_1 0 DC 0 AC 1
Xs181_n_1 s181_n_1 0 adc_mim_bank COUNT=2
Vs181_n_2 s181_n_2 0 DC 0 AC 1
Xs181_n_2 s181_n_2 0 adc_mim_bank COUNT=4
Vs181_n_3 s181_n_3 0 DC 0 AC 1
Xs181_n_3 s181_n_3 0 adc_mim_bank COUNT=8
Vs181_n_4 s181_n_4 0 DC 0 AC 1
Xs181_n_4 s181_n_4 0 adc_mim_bank COUNT=16
Vs181_n_5 s181_n_5 0 DC 0 AC 1
Xs181_n_5 s181_n_5 0 adc_mim_bank COUNT=32
Vs181_n_6 s181_n_6 0 DC 0 AC 1
Xs181_n_6 s181_n_6 0 adc_mim_bank COUNT=64
Vs181_n_7 s181_n_7 0 DC 0 AC 1
Xs181_n_7 s181_n_7 0 adc_mim_bank COUNT=128
Vs181_n_8 s181_n_8 0 DC 0 AC 1
Xs181_n_8 s181_n_8 0 adc_mim_bank COUNT=256
Vs181_n_9 s181_n_9 0 DC 0 AC 1
Xs181_n_9 s181_n_9 0 adc_mim_bank COUNT=512
Vs181_n_10 s181_n_10 0 DC 0 AC 1
Xs181_n_10 s181_n_10 0 adc_mim_bank COUNT=1024
Vs181_n_11 s181_n_11 0 DC 0 AC 1
Xs181_n_11 s181_n_11 0 adc_mim_bank COUNT=2048
Vs181_n_12 s181_n_12 0 DC 0 AC 1
Xs181_n_12 s181_n_12 0 adc_mim_bank COUNT=1
Vs182_p_0 s182_p_0 0 DC 0 AC 1
Xs182_p_0 s182_p_0 0 adc_mim_bank COUNT=1
Vs182_p_1 s182_p_1 0 DC 0 AC 1
Xs182_p_1 s182_p_1 0 adc_mim_bank COUNT=2
Vs182_p_2 s182_p_2 0 DC 0 AC 1
Xs182_p_2 s182_p_2 0 adc_mim_bank COUNT=4
Vs182_p_3 s182_p_3 0 DC 0 AC 1
Xs182_p_3 s182_p_3 0 adc_mim_bank COUNT=8
Vs182_p_4 s182_p_4 0 DC 0 AC 1
Xs182_p_4 s182_p_4 0 adc_mim_bank COUNT=16
Vs182_p_5 s182_p_5 0 DC 0 AC 1
Xs182_p_5 s182_p_5 0 adc_mim_bank COUNT=32
Vs182_p_6 s182_p_6 0 DC 0 AC 1
Xs182_p_6 s182_p_6 0 adc_mim_bank COUNT=64
Vs182_p_7 s182_p_7 0 DC 0 AC 1
Xs182_p_7 s182_p_7 0 adc_mim_bank COUNT=128
Vs182_p_8 s182_p_8 0 DC 0 AC 1
Xs182_p_8 s182_p_8 0 adc_mim_bank COUNT=256
Vs182_p_9 s182_p_9 0 DC 0 AC 1
Xs182_p_9 s182_p_9 0 adc_mim_bank COUNT=512
Vs182_p_10 s182_p_10 0 DC 0 AC 1
Xs182_p_10 s182_p_10 0 adc_mim_bank COUNT=1024
Vs182_p_11 s182_p_11 0 DC 0 AC 1
Xs182_p_11 s182_p_11 0 adc_mim_bank COUNT=2048
Vs182_p_12 s182_p_12 0 DC 0 AC 1
Xs182_p_12 s182_p_12 0 adc_mim_bank COUNT=1
Vs182_n_0 s182_n_0 0 DC 0 AC 1
Xs182_n_0 s182_n_0 0 adc_mim_bank COUNT=1
Vs182_n_1 s182_n_1 0 DC 0 AC 1
Xs182_n_1 s182_n_1 0 adc_mim_bank COUNT=2
Vs182_n_2 s182_n_2 0 DC 0 AC 1
Xs182_n_2 s182_n_2 0 adc_mim_bank COUNT=4
Vs182_n_3 s182_n_3 0 DC 0 AC 1
Xs182_n_3 s182_n_3 0 adc_mim_bank COUNT=8
Vs182_n_4 s182_n_4 0 DC 0 AC 1
Xs182_n_4 s182_n_4 0 adc_mim_bank COUNT=16
Vs182_n_5 s182_n_5 0 DC 0 AC 1
Xs182_n_5 s182_n_5 0 adc_mim_bank COUNT=32
Vs182_n_6 s182_n_6 0 DC 0 AC 1
Xs182_n_6 s182_n_6 0 adc_mim_bank COUNT=64
Vs182_n_7 s182_n_7 0 DC 0 AC 1
Xs182_n_7 s182_n_7 0 adc_mim_bank COUNT=128
Vs182_n_8 s182_n_8 0 DC 0 AC 1
Xs182_n_8 s182_n_8 0 adc_mim_bank COUNT=256
Vs182_n_9 s182_n_9 0 DC 0 AC 1
Xs182_n_9 s182_n_9 0 adc_mim_bank COUNT=512
Vs182_n_10 s182_n_10 0 DC 0 AC 1
Xs182_n_10 s182_n_10 0 adc_mim_bank COUNT=1024
Vs182_n_11 s182_n_11 0 DC 0 AC 1
Xs182_n_11 s182_n_11 0 adc_mim_bank COUNT=2048
Vs182_n_12 s182_n_12 0 DC 0 AC 1
Xs182_n_12 s182_n_12 0 adc_mim_bank COUNT=1
Vs183_p_0 s183_p_0 0 DC 0 AC 1
Xs183_p_0 s183_p_0 0 adc_mim_bank COUNT=1
Vs183_p_1 s183_p_1 0 DC 0 AC 1
Xs183_p_1 s183_p_1 0 adc_mim_bank COUNT=2
Vs183_p_2 s183_p_2 0 DC 0 AC 1
Xs183_p_2 s183_p_2 0 adc_mim_bank COUNT=4
Vs183_p_3 s183_p_3 0 DC 0 AC 1
Xs183_p_3 s183_p_3 0 adc_mim_bank COUNT=8
Vs183_p_4 s183_p_4 0 DC 0 AC 1
Xs183_p_4 s183_p_4 0 adc_mim_bank COUNT=16
Vs183_p_5 s183_p_5 0 DC 0 AC 1
Xs183_p_5 s183_p_5 0 adc_mim_bank COUNT=32
Vs183_p_6 s183_p_6 0 DC 0 AC 1
Xs183_p_6 s183_p_6 0 adc_mim_bank COUNT=64
Vs183_p_7 s183_p_7 0 DC 0 AC 1
Xs183_p_7 s183_p_7 0 adc_mim_bank COUNT=128
Vs183_p_8 s183_p_8 0 DC 0 AC 1
Xs183_p_8 s183_p_8 0 adc_mim_bank COUNT=256
Vs183_p_9 s183_p_9 0 DC 0 AC 1
Xs183_p_9 s183_p_9 0 adc_mim_bank COUNT=512
Vs183_p_10 s183_p_10 0 DC 0 AC 1
Xs183_p_10 s183_p_10 0 adc_mim_bank COUNT=1024
Vs183_p_11 s183_p_11 0 DC 0 AC 1
Xs183_p_11 s183_p_11 0 adc_mim_bank COUNT=2048
Vs183_p_12 s183_p_12 0 DC 0 AC 1
Xs183_p_12 s183_p_12 0 adc_mim_bank COUNT=1
Vs183_n_0 s183_n_0 0 DC 0 AC 1
Xs183_n_0 s183_n_0 0 adc_mim_bank COUNT=1
Vs183_n_1 s183_n_1 0 DC 0 AC 1
Xs183_n_1 s183_n_1 0 adc_mim_bank COUNT=2
Vs183_n_2 s183_n_2 0 DC 0 AC 1
Xs183_n_2 s183_n_2 0 adc_mim_bank COUNT=4
Vs183_n_3 s183_n_3 0 DC 0 AC 1
Xs183_n_3 s183_n_3 0 adc_mim_bank COUNT=8
Vs183_n_4 s183_n_4 0 DC 0 AC 1
Xs183_n_4 s183_n_4 0 adc_mim_bank COUNT=16
Vs183_n_5 s183_n_5 0 DC 0 AC 1
Xs183_n_5 s183_n_5 0 adc_mim_bank COUNT=32
Vs183_n_6 s183_n_6 0 DC 0 AC 1
Xs183_n_6 s183_n_6 0 adc_mim_bank COUNT=64
Vs183_n_7 s183_n_7 0 DC 0 AC 1
Xs183_n_7 s183_n_7 0 adc_mim_bank COUNT=128
Vs183_n_8 s183_n_8 0 DC 0 AC 1
Xs183_n_8 s183_n_8 0 adc_mim_bank COUNT=256
Vs183_n_9 s183_n_9 0 DC 0 AC 1
Xs183_n_9 s183_n_9 0 adc_mim_bank COUNT=512
Vs183_n_10 s183_n_10 0 DC 0 AC 1
Xs183_n_10 s183_n_10 0 adc_mim_bank COUNT=1024
Vs183_n_11 s183_n_11 0 DC 0 AC 1
Xs183_n_11 s183_n_11 0 adc_mim_bank COUNT=2048
Vs183_n_12 s183_n_12 0 DC 0 AC 1
Xs183_n_12 s183_n_12 0 adc_mim_bank COUNT=1
Vs184_p_0 s184_p_0 0 DC 0 AC 1
Xs184_p_0 s184_p_0 0 adc_mim_bank COUNT=1
Vs184_p_1 s184_p_1 0 DC 0 AC 1
Xs184_p_1 s184_p_1 0 adc_mim_bank COUNT=2
Vs184_p_2 s184_p_2 0 DC 0 AC 1
Xs184_p_2 s184_p_2 0 adc_mim_bank COUNT=4
Vs184_p_3 s184_p_3 0 DC 0 AC 1
Xs184_p_3 s184_p_3 0 adc_mim_bank COUNT=8
Vs184_p_4 s184_p_4 0 DC 0 AC 1
Xs184_p_4 s184_p_4 0 adc_mim_bank COUNT=16
Vs184_p_5 s184_p_5 0 DC 0 AC 1
Xs184_p_5 s184_p_5 0 adc_mim_bank COUNT=32
Vs184_p_6 s184_p_6 0 DC 0 AC 1
Xs184_p_6 s184_p_6 0 adc_mim_bank COUNT=64
Vs184_p_7 s184_p_7 0 DC 0 AC 1
Xs184_p_7 s184_p_7 0 adc_mim_bank COUNT=128
Vs184_p_8 s184_p_8 0 DC 0 AC 1
Xs184_p_8 s184_p_8 0 adc_mim_bank COUNT=256
Vs184_p_9 s184_p_9 0 DC 0 AC 1
Xs184_p_9 s184_p_9 0 adc_mim_bank COUNT=512
Vs184_p_10 s184_p_10 0 DC 0 AC 1
Xs184_p_10 s184_p_10 0 adc_mim_bank COUNT=1024
Vs184_p_11 s184_p_11 0 DC 0 AC 1
Xs184_p_11 s184_p_11 0 adc_mim_bank COUNT=2048
Vs184_p_12 s184_p_12 0 DC 0 AC 1
Xs184_p_12 s184_p_12 0 adc_mim_bank COUNT=1
Vs184_n_0 s184_n_0 0 DC 0 AC 1
Xs184_n_0 s184_n_0 0 adc_mim_bank COUNT=1
Vs184_n_1 s184_n_1 0 DC 0 AC 1
Xs184_n_1 s184_n_1 0 adc_mim_bank COUNT=2
Vs184_n_2 s184_n_2 0 DC 0 AC 1
Xs184_n_2 s184_n_2 0 adc_mim_bank COUNT=4
Vs184_n_3 s184_n_3 0 DC 0 AC 1
Xs184_n_3 s184_n_3 0 adc_mim_bank COUNT=8
Vs184_n_4 s184_n_4 0 DC 0 AC 1
Xs184_n_4 s184_n_4 0 adc_mim_bank COUNT=16
Vs184_n_5 s184_n_5 0 DC 0 AC 1
Xs184_n_5 s184_n_5 0 adc_mim_bank COUNT=32
Vs184_n_6 s184_n_6 0 DC 0 AC 1
Xs184_n_6 s184_n_6 0 adc_mim_bank COUNT=64
Vs184_n_7 s184_n_7 0 DC 0 AC 1
Xs184_n_7 s184_n_7 0 adc_mim_bank COUNT=128
Vs184_n_8 s184_n_8 0 DC 0 AC 1
Xs184_n_8 s184_n_8 0 adc_mim_bank COUNT=256
Vs184_n_9 s184_n_9 0 DC 0 AC 1
Xs184_n_9 s184_n_9 0 adc_mim_bank COUNT=512
Vs184_n_10 s184_n_10 0 DC 0 AC 1
Xs184_n_10 s184_n_10 0 adc_mim_bank COUNT=1024
Vs184_n_11 s184_n_11 0 DC 0 AC 1
Xs184_n_11 s184_n_11 0 adc_mim_bank COUNT=2048
Vs184_n_12 s184_n_12 0 DC 0 AC 1
Xs184_n_12 s184_n_12 0 adc_mim_bank COUNT=1
Vs185_p_0 s185_p_0 0 DC 0 AC 1
Xs185_p_0 s185_p_0 0 adc_mim_bank COUNT=1
Vs185_p_1 s185_p_1 0 DC 0 AC 1
Xs185_p_1 s185_p_1 0 adc_mim_bank COUNT=2
Vs185_p_2 s185_p_2 0 DC 0 AC 1
Xs185_p_2 s185_p_2 0 adc_mim_bank COUNT=4
Vs185_p_3 s185_p_3 0 DC 0 AC 1
Xs185_p_3 s185_p_3 0 adc_mim_bank COUNT=8
Vs185_p_4 s185_p_4 0 DC 0 AC 1
Xs185_p_4 s185_p_4 0 adc_mim_bank COUNT=16
Vs185_p_5 s185_p_5 0 DC 0 AC 1
Xs185_p_5 s185_p_5 0 adc_mim_bank COUNT=32
Vs185_p_6 s185_p_6 0 DC 0 AC 1
Xs185_p_6 s185_p_6 0 adc_mim_bank COUNT=64
Vs185_p_7 s185_p_7 0 DC 0 AC 1
Xs185_p_7 s185_p_7 0 adc_mim_bank COUNT=128
Vs185_p_8 s185_p_8 0 DC 0 AC 1
Xs185_p_8 s185_p_8 0 adc_mim_bank COUNT=256
Vs185_p_9 s185_p_9 0 DC 0 AC 1
Xs185_p_9 s185_p_9 0 adc_mim_bank COUNT=512
Vs185_p_10 s185_p_10 0 DC 0 AC 1
Xs185_p_10 s185_p_10 0 adc_mim_bank COUNT=1024
Vs185_p_11 s185_p_11 0 DC 0 AC 1
Xs185_p_11 s185_p_11 0 adc_mim_bank COUNT=2048
Vs185_p_12 s185_p_12 0 DC 0 AC 1
Xs185_p_12 s185_p_12 0 adc_mim_bank COUNT=1
Vs185_n_0 s185_n_0 0 DC 0 AC 1
Xs185_n_0 s185_n_0 0 adc_mim_bank COUNT=1
Vs185_n_1 s185_n_1 0 DC 0 AC 1
Xs185_n_1 s185_n_1 0 adc_mim_bank COUNT=2
Vs185_n_2 s185_n_2 0 DC 0 AC 1
Xs185_n_2 s185_n_2 0 adc_mim_bank COUNT=4
Vs185_n_3 s185_n_3 0 DC 0 AC 1
Xs185_n_3 s185_n_3 0 adc_mim_bank COUNT=8
Vs185_n_4 s185_n_4 0 DC 0 AC 1
Xs185_n_4 s185_n_4 0 adc_mim_bank COUNT=16
Vs185_n_5 s185_n_5 0 DC 0 AC 1
Xs185_n_5 s185_n_5 0 adc_mim_bank COUNT=32
Vs185_n_6 s185_n_6 0 DC 0 AC 1
Xs185_n_6 s185_n_6 0 adc_mim_bank COUNT=64
Vs185_n_7 s185_n_7 0 DC 0 AC 1
Xs185_n_7 s185_n_7 0 adc_mim_bank COUNT=128
Vs185_n_8 s185_n_8 0 DC 0 AC 1
Xs185_n_8 s185_n_8 0 adc_mim_bank COUNT=256
Vs185_n_9 s185_n_9 0 DC 0 AC 1
Xs185_n_9 s185_n_9 0 adc_mim_bank COUNT=512
Vs185_n_10 s185_n_10 0 DC 0 AC 1
Xs185_n_10 s185_n_10 0 adc_mim_bank COUNT=1024
Vs185_n_11 s185_n_11 0 DC 0 AC 1
Xs185_n_11 s185_n_11 0 adc_mim_bank COUNT=2048
Vs185_n_12 s185_n_12 0 DC 0 AC 1
Xs185_n_12 s185_n_12 0 adc_mim_bank COUNT=1
Vs186_p_0 s186_p_0 0 DC 0 AC 1
Xs186_p_0 s186_p_0 0 adc_mim_bank COUNT=1
Vs186_p_1 s186_p_1 0 DC 0 AC 1
Xs186_p_1 s186_p_1 0 adc_mim_bank COUNT=2
Vs186_p_2 s186_p_2 0 DC 0 AC 1
Xs186_p_2 s186_p_2 0 adc_mim_bank COUNT=4
Vs186_p_3 s186_p_3 0 DC 0 AC 1
Xs186_p_3 s186_p_3 0 adc_mim_bank COUNT=8
Vs186_p_4 s186_p_4 0 DC 0 AC 1
Xs186_p_4 s186_p_4 0 adc_mim_bank COUNT=16
Vs186_p_5 s186_p_5 0 DC 0 AC 1
Xs186_p_5 s186_p_5 0 adc_mim_bank COUNT=32
Vs186_p_6 s186_p_6 0 DC 0 AC 1
Xs186_p_6 s186_p_6 0 adc_mim_bank COUNT=64
Vs186_p_7 s186_p_7 0 DC 0 AC 1
Xs186_p_7 s186_p_7 0 adc_mim_bank COUNT=128
Vs186_p_8 s186_p_8 0 DC 0 AC 1
Xs186_p_8 s186_p_8 0 adc_mim_bank COUNT=256
Vs186_p_9 s186_p_9 0 DC 0 AC 1
Xs186_p_9 s186_p_9 0 adc_mim_bank COUNT=512
Vs186_p_10 s186_p_10 0 DC 0 AC 1
Xs186_p_10 s186_p_10 0 adc_mim_bank COUNT=1024
Vs186_p_11 s186_p_11 0 DC 0 AC 1
Xs186_p_11 s186_p_11 0 adc_mim_bank COUNT=2048
Vs186_p_12 s186_p_12 0 DC 0 AC 1
Xs186_p_12 s186_p_12 0 adc_mim_bank COUNT=1
Vs186_n_0 s186_n_0 0 DC 0 AC 1
Xs186_n_0 s186_n_0 0 adc_mim_bank COUNT=1
Vs186_n_1 s186_n_1 0 DC 0 AC 1
Xs186_n_1 s186_n_1 0 adc_mim_bank COUNT=2
Vs186_n_2 s186_n_2 0 DC 0 AC 1
Xs186_n_2 s186_n_2 0 adc_mim_bank COUNT=4
Vs186_n_3 s186_n_3 0 DC 0 AC 1
Xs186_n_3 s186_n_3 0 adc_mim_bank COUNT=8
Vs186_n_4 s186_n_4 0 DC 0 AC 1
Xs186_n_4 s186_n_4 0 adc_mim_bank COUNT=16
Vs186_n_5 s186_n_5 0 DC 0 AC 1
Xs186_n_5 s186_n_5 0 adc_mim_bank COUNT=32
Vs186_n_6 s186_n_6 0 DC 0 AC 1
Xs186_n_6 s186_n_6 0 adc_mim_bank COUNT=64
Vs186_n_7 s186_n_7 0 DC 0 AC 1
Xs186_n_7 s186_n_7 0 adc_mim_bank COUNT=128
Vs186_n_8 s186_n_8 0 DC 0 AC 1
Xs186_n_8 s186_n_8 0 adc_mim_bank COUNT=256
Vs186_n_9 s186_n_9 0 DC 0 AC 1
Xs186_n_9 s186_n_9 0 adc_mim_bank COUNT=512
Vs186_n_10 s186_n_10 0 DC 0 AC 1
Xs186_n_10 s186_n_10 0 adc_mim_bank COUNT=1024
Vs186_n_11 s186_n_11 0 DC 0 AC 1
Xs186_n_11 s186_n_11 0 adc_mim_bank COUNT=2048
Vs186_n_12 s186_n_12 0 DC 0 AC 1
Xs186_n_12 s186_n_12 0 adc_mim_bank COUNT=1
Vs187_p_0 s187_p_0 0 DC 0 AC 1
Xs187_p_0 s187_p_0 0 adc_mim_bank COUNT=1
Vs187_p_1 s187_p_1 0 DC 0 AC 1
Xs187_p_1 s187_p_1 0 adc_mim_bank COUNT=2
Vs187_p_2 s187_p_2 0 DC 0 AC 1
Xs187_p_2 s187_p_2 0 adc_mim_bank COUNT=4
Vs187_p_3 s187_p_3 0 DC 0 AC 1
Xs187_p_3 s187_p_3 0 adc_mim_bank COUNT=8
Vs187_p_4 s187_p_4 0 DC 0 AC 1
Xs187_p_4 s187_p_4 0 adc_mim_bank COUNT=16
Vs187_p_5 s187_p_5 0 DC 0 AC 1
Xs187_p_5 s187_p_5 0 adc_mim_bank COUNT=32
Vs187_p_6 s187_p_6 0 DC 0 AC 1
Xs187_p_6 s187_p_6 0 adc_mim_bank COUNT=64
Vs187_p_7 s187_p_7 0 DC 0 AC 1
Xs187_p_7 s187_p_7 0 adc_mim_bank COUNT=128
Vs187_p_8 s187_p_8 0 DC 0 AC 1
Xs187_p_8 s187_p_8 0 adc_mim_bank COUNT=256
Vs187_p_9 s187_p_9 0 DC 0 AC 1
Xs187_p_9 s187_p_9 0 adc_mim_bank COUNT=512
Vs187_p_10 s187_p_10 0 DC 0 AC 1
Xs187_p_10 s187_p_10 0 adc_mim_bank COUNT=1024
Vs187_p_11 s187_p_11 0 DC 0 AC 1
Xs187_p_11 s187_p_11 0 adc_mim_bank COUNT=2048
Vs187_p_12 s187_p_12 0 DC 0 AC 1
Xs187_p_12 s187_p_12 0 adc_mim_bank COUNT=1
Vs187_n_0 s187_n_0 0 DC 0 AC 1
Xs187_n_0 s187_n_0 0 adc_mim_bank COUNT=1
Vs187_n_1 s187_n_1 0 DC 0 AC 1
Xs187_n_1 s187_n_1 0 adc_mim_bank COUNT=2
Vs187_n_2 s187_n_2 0 DC 0 AC 1
Xs187_n_2 s187_n_2 0 adc_mim_bank COUNT=4
Vs187_n_3 s187_n_3 0 DC 0 AC 1
Xs187_n_3 s187_n_3 0 adc_mim_bank COUNT=8
Vs187_n_4 s187_n_4 0 DC 0 AC 1
Xs187_n_4 s187_n_4 0 adc_mim_bank COUNT=16
Vs187_n_5 s187_n_5 0 DC 0 AC 1
Xs187_n_5 s187_n_5 0 adc_mim_bank COUNT=32
Vs187_n_6 s187_n_6 0 DC 0 AC 1
Xs187_n_6 s187_n_6 0 adc_mim_bank COUNT=64
Vs187_n_7 s187_n_7 0 DC 0 AC 1
Xs187_n_7 s187_n_7 0 adc_mim_bank COUNT=128
Vs187_n_8 s187_n_8 0 DC 0 AC 1
Xs187_n_8 s187_n_8 0 adc_mim_bank COUNT=256
Vs187_n_9 s187_n_9 0 DC 0 AC 1
Xs187_n_9 s187_n_9 0 adc_mim_bank COUNT=512
Vs187_n_10 s187_n_10 0 DC 0 AC 1
Xs187_n_10 s187_n_10 0 adc_mim_bank COUNT=1024
Vs187_n_11 s187_n_11 0 DC 0 AC 1
Xs187_n_11 s187_n_11 0 adc_mim_bank COUNT=2048
Vs187_n_12 s187_n_12 0 DC 0 AC 1
Xs187_n_12 s187_n_12 0 adc_mim_bank COUNT=1
Vs188_p_0 s188_p_0 0 DC 0 AC 1
Xs188_p_0 s188_p_0 0 adc_mim_bank COUNT=1
Vs188_p_1 s188_p_1 0 DC 0 AC 1
Xs188_p_1 s188_p_1 0 adc_mim_bank COUNT=2
Vs188_p_2 s188_p_2 0 DC 0 AC 1
Xs188_p_2 s188_p_2 0 adc_mim_bank COUNT=4
Vs188_p_3 s188_p_3 0 DC 0 AC 1
Xs188_p_3 s188_p_3 0 adc_mim_bank COUNT=8
Vs188_p_4 s188_p_4 0 DC 0 AC 1
Xs188_p_4 s188_p_4 0 adc_mim_bank COUNT=16
Vs188_p_5 s188_p_5 0 DC 0 AC 1
Xs188_p_5 s188_p_5 0 adc_mim_bank COUNT=32
Vs188_p_6 s188_p_6 0 DC 0 AC 1
Xs188_p_6 s188_p_6 0 adc_mim_bank COUNT=64
Vs188_p_7 s188_p_7 0 DC 0 AC 1
Xs188_p_7 s188_p_7 0 adc_mim_bank COUNT=128
Vs188_p_8 s188_p_8 0 DC 0 AC 1
Xs188_p_8 s188_p_8 0 adc_mim_bank COUNT=256
Vs188_p_9 s188_p_9 0 DC 0 AC 1
Xs188_p_9 s188_p_9 0 adc_mim_bank COUNT=512
Vs188_p_10 s188_p_10 0 DC 0 AC 1
Xs188_p_10 s188_p_10 0 adc_mim_bank COUNT=1024
Vs188_p_11 s188_p_11 0 DC 0 AC 1
Xs188_p_11 s188_p_11 0 adc_mim_bank COUNT=2048
Vs188_p_12 s188_p_12 0 DC 0 AC 1
Xs188_p_12 s188_p_12 0 adc_mim_bank COUNT=1
Vs188_n_0 s188_n_0 0 DC 0 AC 1
Xs188_n_0 s188_n_0 0 adc_mim_bank COUNT=1
Vs188_n_1 s188_n_1 0 DC 0 AC 1
Xs188_n_1 s188_n_1 0 adc_mim_bank COUNT=2
Vs188_n_2 s188_n_2 0 DC 0 AC 1
Xs188_n_2 s188_n_2 0 adc_mim_bank COUNT=4
Vs188_n_3 s188_n_3 0 DC 0 AC 1
Xs188_n_3 s188_n_3 0 adc_mim_bank COUNT=8
Vs188_n_4 s188_n_4 0 DC 0 AC 1
Xs188_n_4 s188_n_4 0 adc_mim_bank COUNT=16
Vs188_n_5 s188_n_5 0 DC 0 AC 1
Xs188_n_5 s188_n_5 0 adc_mim_bank COUNT=32
Vs188_n_6 s188_n_6 0 DC 0 AC 1
Xs188_n_6 s188_n_6 0 adc_mim_bank COUNT=64
Vs188_n_7 s188_n_7 0 DC 0 AC 1
Xs188_n_7 s188_n_7 0 adc_mim_bank COUNT=128
Vs188_n_8 s188_n_8 0 DC 0 AC 1
Xs188_n_8 s188_n_8 0 adc_mim_bank COUNT=256
Vs188_n_9 s188_n_9 0 DC 0 AC 1
Xs188_n_9 s188_n_9 0 adc_mim_bank COUNT=512
Vs188_n_10 s188_n_10 0 DC 0 AC 1
Xs188_n_10 s188_n_10 0 adc_mim_bank COUNT=1024
Vs188_n_11 s188_n_11 0 DC 0 AC 1
Xs188_n_11 s188_n_11 0 adc_mim_bank COUNT=2048
Vs188_n_12 s188_n_12 0 DC 0 AC 1
Xs188_n_12 s188_n_12 0 adc_mim_bank COUNT=1
Vs189_p_0 s189_p_0 0 DC 0 AC 1
Xs189_p_0 s189_p_0 0 adc_mim_bank COUNT=1
Vs189_p_1 s189_p_1 0 DC 0 AC 1
Xs189_p_1 s189_p_1 0 adc_mim_bank COUNT=2
Vs189_p_2 s189_p_2 0 DC 0 AC 1
Xs189_p_2 s189_p_2 0 adc_mim_bank COUNT=4
Vs189_p_3 s189_p_3 0 DC 0 AC 1
Xs189_p_3 s189_p_3 0 adc_mim_bank COUNT=8
Vs189_p_4 s189_p_4 0 DC 0 AC 1
Xs189_p_4 s189_p_4 0 adc_mim_bank COUNT=16
Vs189_p_5 s189_p_5 0 DC 0 AC 1
Xs189_p_5 s189_p_5 0 adc_mim_bank COUNT=32
Vs189_p_6 s189_p_6 0 DC 0 AC 1
Xs189_p_6 s189_p_6 0 adc_mim_bank COUNT=64
Vs189_p_7 s189_p_7 0 DC 0 AC 1
Xs189_p_7 s189_p_7 0 adc_mim_bank COUNT=128
Vs189_p_8 s189_p_8 0 DC 0 AC 1
Xs189_p_8 s189_p_8 0 adc_mim_bank COUNT=256
Vs189_p_9 s189_p_9 0 DC 0 AC 1
Xs189_p_9 s189_p_9 0 adc_mim_bank COUNT=512
Vs189_p_10 s189_p_10 0 DC 0 AC 1
Xs189_p_10 s189_p_10 0 adc_mim_bank COUNT=1024
Vs189_p_11 s189_p_11 0 DC 0 AC 1
Xs189_p_11 s189_p_11 0 adc_mim_bank COUNT=2048
Vs189_p_12 s189_p_12 0 DC 0 AC 1
Xs189_p_12 s189_p_12 0 adc_mim_bank COUNT=1
Vs189_n_0 s189_n_0 0 DC 0 AC 1
Xs189_n_0 s189_n_0 0 adc_mim_bank COUNT=1
Vs189_n_1 s189_n_1 0 DC 0 AC 1
Xs189_n_1 s189_n_1 0 adc_mim_bank COUNT=2
Vs189_n_2 s189_n_2 0 DC 0 AC 1
Xs189_n_2 s189_n_2 0 adc_mim_bank COUNT=4
Vs189_n_3 s189_n_3 0 DC 0 AC 1
Xs189_n_3 s189_n_3 0 adc_mim_bank COUNT=8
Vs189_n_4 s189_n_4 0 DC 0 AC 1
Xs189_n_4 s189_n_4 0 adc_mim_bank COUNT=16
Vs189_n_5 s189_n_5 0 DC 0 AC 1
Xs189_n_5 s189_n_5 0 adc_mim_bank COUNT=32
Vs189_n_6 s189_n_6 0 DC 0 AC 1
Xs189_n_6 s189_n_6 0 adc_mim_bank COUNT=64
Vs189_n_7 s189_n_7 0 DC 0 AC 1
Xs189_n_7 s189_n_7 0 adc_mim_bank COUNT=128
Vs189_n_8 s189_n_8 0 DC 0 AC 1
Xs189_n_8 s189_n_8 0 adc_mim_bank COUNT=256
Vs189_n_9 s189_n_9 0 DC 0 AC 1
Xs189_n_9 s189_n_9 0 adc_mim_bank COUNT=512
Vs189_n_10 s189_n_10 0 DC 0 AC 1
Xs189_n_10 s189_n_10 0 adc_mim_bank COUNT=1024
Vs189_n_11 s189_n_11 0 DC 0 AC 1
Xs189_n_11 s189_n_11 0 adc_mim_bank COUNT=2048
Vs189_n_12 s189_n_12 0 DC 0 AC 1
Xs189_n_12 s189_n_12 0 adc_mim_bank COUNT=1
Vs190_p_0 s190_p_0 0 DC 0 AC 1
Xs190_p_0 s190_p_0 0 adc_mim_bank COUNT=1
Vs190_p_1 s190_p_1 0 DC 0 AC 1
Xs190_p_1 s190_p_1 0 adc_mim_bank COUNT=2
Vs190_p_2 s190_p_2 0 DC 0 AC 1
Xs190_p_2 s190_p_2 0 adc_mim_bank COUNT=4
Vs190_p_3 s190_p_3 0 DC 0 AC 1
Xs190_p_3 s190_p_3 0 adc_mim_bank COUNT=8
Vs190_p_4 s190_p_4 0 DC 0 AC 1
Xs190_p_4 s190_p_4 0 adc_mim_bank COUNT=16
Vs190_p_5 s190_p_5 0 DC 0 AC 1
Xs190_p_5 s190_p_5 0 adc_mim_bank COUNT=32
Vs190_p_6 s190_p_6 0 DC 0 AC 1
Xs190_p_6 s190_p_6 0 adc_mim_bank COUNT=64
Vs190_p_7 s190_p_7 0 DC 0 AC 1
Xs190_p_7 s190_p_7 0 adc_mim_bank COUNT=128
Vs190_p_8 s190_p_8 0 DC 0 AC 1
Xs190_p_8 s190_p_8 0 adc_mim_bank COUNT=256
Vs190_p_9 s190_p_9 0 DC 0 AC 1
Xs190_p_9 s190_p_9 0 adc_mim_bank COUNT=512
Vs190_p_10 s190_p_10 0 DC 0 AC 1
Xs190_p_10 s190_p_10 0 adc_mim_bank COUNT=1024
Vs190_p_11 s190_p_11 0 DC 0 AC 1
Xs190_p_11 s190_p_11 0 adc_mim_bank COUNT=2048
Vs190_p_12 s190_p_12 0 DC 0 AC 1
Xs190_p_12 s190_p_12 0 adc_mim_bank COUNT=1
Vs190_n_0 s190_n_0 0 DC 0 AC 1
Xs190_n_0 s190_n_0 0 adc_mim_bank COUNT=1
Vs190_n_1 s190_n_1 0 DC 0 AC 1
Xs190_n_1 s190_n_1 0 adc_mim_bank COUNT=2
Vs190_n_2 s190_n_2 0 DC 0 AC 1
Xs190_n_2 s190_n_2 0 adc_mim_bank COUNT=4
Vs190_n_3 s190_n_3 0 DC 0 AC 1
Xs190_n_3 s190_n_3 0 adc_mim_bank COUNT=8
Vs190_n_4 s190_n_4 0 DC 0 AC 1
Xs190_n_4 s190_n_4 0 adc_mim_bank COUNT=16
Vs190_n_5 s190_n_5 0 DC 0 AC 1
Xs190_n_5 s190_n_5 0 adc_mim_bank COUNT=32
Vs190_n_6 s190_n_6 0 DC 0 AC 1
Xs190_n_6 s190_n_6 0 adc_mim_bank COUNT=64
Vs190_n_7 s190_n_7 0 DC 0 AC 1
Xs190_n_7 s190_n_7 0 adc_mim_bank COUNT=128
Vs190_n_8 s190_n_8 0 DC 0 AC 1
Xs190_n_8 s190_n_8 0 adc_mim_bank COUNT=256
Vs190_n_9 s190_n_9 0 DC 0 AC 1
Xs190_n_9 s190_n_9 0 adc_mim_bank COUNT=512
Vs190_n_10 s190_n_10 0 DC 0 AC 1
Xs190_n_10 s190_n_10 0 adc_mim_bank COUNT=1024
Vs190_n_11 s190_n_11 0 DC 0 AC 1
Xs190_n_11 s190_n_11 0 adc_mim_bank COUNT=2048
Vs190_n_12 s190_n_12 0 DC 0 AC 1
Xs190_n_12 s190_n_12 0 adc_mim_bank COUNT=1
Vs191_p_0 s191_p_0 0 DC 0 AC 1
Xs191_p_0 s191_p_0 0 adc_mim_bank COUNT=1
Vs191_p_1 s191_p_1 0 DC 0 AC 1
Xs191_p_1 s191_p_1 0 adc_mim_bank COUNT=2
Vs191_p_2 s191_p_2 0 DC 0 AC 1
Xs191_p_2 s191_p_2 0 adc_mim_bank COUNT=4
Vs191_p_3 s191_p_3 0 DC 0 AC 1
Xs191_p_3 s191_p_3 0 adc_mim_bank COUNT=8
Vs191_p_4 s191_p_4 0 DC 0 AC 1
Xs191_p_4 s191_p_4 0 adc_mim_bank COUNT=16
Vs191_p_5 s191_p_5 0 DC 0 AC 1
Xs191_p_5 s191_p_5 0 adc_mim_bank COUNT=32
Vs191_p_6 s191_p_6 0 DC 0 AC 1
Xs191_p_6 s191_p_6 0 adc_mim_bank COUNT=64
Vs191_p_7 s191_p_7 0 DC 0 AC 1
Xs191_p_7 s191_p_7 0 adc_mim_bank COUNT=128
Vs191_p_8 s191_p_8 0 DC 0 AC 1
Xs191_p_8 s191_p_8 0 adc_mim_bank COUNT=256
Vs191_p_9 s191_p_9 0 DC 0 AC 1
Xs191_p_9 s191_p_9 0 adc_mim_bank COUNT=512
Vs191_p_10 s191_p_10 0 DC 0 AC 1
Xs191_p_10 s191_p_10 0 adc_mim_bank COUNT=1024
Vs191_p_11 s191_p_11 0 DC 0 AC 1
Xs191_p_11 s191_p_11 0 adc_mim_bank COUNT=2048
Vs191_p_12 s191_p_12 0 DC 0 AC 1
Xs191_p_12 s191_p_12 0 adc_mim_bank COUNT=1
Vs191_n_0 s191_n_0 0 DC 0 AC 1
Xs191_n_0 s191_n_0 0 adc_mim_bank COUNT=1
Vs191_n_1 s191_n_1 0 DC 0 AC 1
Xs191_n_1 s191_n_1 0 adc_mim_bank COUNT=2
Vs191_n_2 s191_n_2 0 DC 0 AC 1
Xs191_n_2 s191_n_2 0 adc_mim_bank COUNT=4
Vs191_n_3 s191_n_3 0 DC 0 AC 1
Xs191_n_3 s191_n_3 0 adc_mim_bank COUNT=8
Vs191_n_4 s191_n_4 0 DC 0 AC 1
Xs191_n_4 s191_n_4 0 adc_mim_bank COUNT=16
Vs191_n_5 s191_n_5 0 DC 0 AC 1
Xs191_n_5 s191_n_5 0 adc_mim_bank COUNT=32
Vs191_n_6 s191_n_6 0 DC 0 AC 1
Xs191_n_6 s191_n_6 0 adc_mim_bank COUNT=64
Vs191_n_7 s191_n_7 0 DC 0 AC 1
Xs191_n_7 s191_n_7 0 adc_mim_bank COUNT=128
Vs191_n_8 s191_n_8 0 DC 0 AC 1
Xs191_n_8 s191_n_8 0 adc_mim_bank COUNT=256
Vs191_n_9 s191_n_9 0 DC 0 AC 1
Xs191_n_9 s191_n_9 0 adc_mim_bank COUNT=512
Vs191_n_10 s191_n_10 0 DC 0 AC 1
Xs191_n_10 s191_n_10 0 adc_mim_bank COUNT=1024
Vs191_n_11 s191_n_11 0 DC 0 AC 1
Xs191_n_11 s191_n_11 0 adc_mim_bank COUNT=2048
Vs191_n_12 s191_n_12 0 DC 0 AC 1
Xs191_n_12 s191_n_12 0 adc_mim_bank COUNT=1
Vs192_p_0 s192_p_0 0 DC 0 AC 1
Xs192_p_0 s192_p_0 0 adc_mim_bank COUNT=1
Vs192_p_1 s192_p_1 0 DC 0 AC 1
Xs192_p_1 s192_p_1 0 adc_mim_bank COUNT=2
Vs192_p_2 s192_p_2 0 DC 0 AC 1
Xs192_p_2 s192_p_2 0 adc_mim_bank COUNT=4
Vs192_p_3 s192_p_3 0 DC 0 AC 1
Xs192_p_3 s192_p_3 0 adc_mim_bank COUNT=8
Vs192_p_4 s192_p_4 0 DC 0 AC 1
Xs192_p_4 s192_p_4 0 adc_mim_bank COUNT=16
Vs192_p_5 s192_p_5 0 DC 0 AC 1
Xs192_p_5 s192_p_5 0 adc_mim_bank COUNT=32
Vs192_p_6 s192_p_6 0 DC 0 AC 1
Xs192_p_6 s192_p_6 0 adc_mim_bank COUNT=64
Vs192_p_7 s192_p_7 0 DC 0 AC 1
Xs192_p_7 s192_p_7 0 adc_mim_bank COUNT=128
Vs192_p_8 s192_p_8 0 DC 0 AC 1
Xs192_p_8 s192_p_8 0 adc_mim_bank COUNT=256
Vs192_p_9 s192_p_9 0 DC 0 AC 1
Xs192_p_9 s192_p_9 0 adc_mim_bank COUNT=512
Vs192_p_10 s192_p_10 0 DC 0 AC 1
Xs192_p_10 s192_p_10 0 adc_mim_bank COUNT=1024
Vs192_p_11 s192_p_11 0 DC 0 AC 1
Xs192_p_11 s192_p_11 0 adc_mim_bank COUNT=2048
Vs192_p_12 s192_p_12 0 DC 0 AC 1
Xs192_p_12 s192_p_12 0 adc_mim_bank COUNT=1
Vs192_n_0 s192_n_0 0 DC 0 AC 1
Xs192_n_0 s192_n_0 0 adc_mim_bank COUNT=1
Vs192_n_1 s192_n_1 0 DC 0 AC 1
Xs192_n_1 s192_n_1 0 adc_mim_bank COUNT=2
Vs192_n_2 s192_n_2 0 DC 0 AC 1
Xs192_n_2 s192_n_2 0 adc_mim_bank COUNT=4
Vs192_n_3 s192_n_3 0 DC 0 AC 1
Xs192_n_3 s192_n_3 0 adc_mim_bank COUNT=8
Vs192_n_4 s192_n_4 0 DC 0 AC 1
Xs192_n_4 s192_n_4 0 adc_mim_bank COUNT=16
Vs192_n_5 s192_n_5 0 DC 0 AC 1
Xs192_n_5 s192_n_5 0 adc_mim_bank COUNT=32
Vs192_n_6 s192_n_6 0 DC 0 AC 1
Xs192_n_6 s192_n_6 0 adc_mim_bank COUNT=64
Vs192_n_7 s192_n_7 0 DC 0 AC 1
Xs192_n_7 s192_n_7 0 adc_mim_bank COUNT=128
Vs192_n_8 s192_n_8 0 DC 0 AC 1
Xs192_n_8 s192_n_8 0 adc_mim_bank COUNT=256
Vs192_n_9 s192_n_9 0 DC 0 AC 1
Xs192_n_9 s192_n_9 0 adc_mim_bank COUNT=512
Vs192_n_10 s192_n_10 0 DC 0 AC 1
Xs192_n_10 s192_n_10 0 adc_mim_bank COUNT=1024
Vs192_n_11 s192_n_11 0 DC 0 AC 1
Xs192_n_11 s192_n_11 0 adc_mim_bank COUNT=2048
Vs192_n_12 s192_n_12 0 DC 0 AC 1
Xs192_n_12 s192_n_12 0 adc_mim_bank COUNT=1
Vs193_p_0 s193_p_0 0 DC 0 AC 1
Xs193_p_0 s193_p_0 0 adc_mim_bank COUNT=1
Vs193_p_1 s193_p_1 0 DC 0 AC 1
Xs193_p_1 s193_p_1 0 adc_mim_bank COUNT=2
Vs193_p_2 s193_p_2 0 DC 0 AC 1
Xs193_p_2 s193_p_2 0 adc_mim_bank COUNT=4
Vs193_p_3 s193_p_3 0 DC 0 AC 1
Xs193_p_3 s193_p_3 0 adc_mim_bank COUNT=8
Vs193_p_4 s193_p_4 0 DC 0 AC 1
Xs193_p_4 s193_p_4 0 adc_mim_bank COUNT=16
Vs193_p_5 s193_p_5 0 DC 0 AC 1
Xs193_p_5 s193_p_5 0 adc_mim_bank COUNT=32
Vs193_p_6 s193_p_6 0 DC 0 AC 1
Xs193_p_6 s193_p_6 0 adc_mim_bank COUNT=64
Vs193_p_7 s193_p_7 0 DC 0 AC 1
Xs193_p_7 s193_p_7 0 adc_mim_bank COUNT=128
Vs193_p_8 s193_p_8 0 DC 0 AC 1
Xs193_p_8 s193_p_8 0 adc_mim_bank COUNT=256
Vs193_p_9 s193_p_9 0 DC 0 AC 1
Xs193_p_9 s193_p_9 0 adc_mim_bank COUNT=512
Vs193_p_10 s193_p_10 0 DC 0 AC 1
Xs193_p_10 s193_p_10 0 adc_mim_bank COUNT=1024
Vs193_p_11 s193_p_11 0 DC 0 AC 1
Xs193_p_11 s193_p_11 0 adc_mim_bank COUNT=2048
Vs193_p_12 s193_p_12 0 DC 0 AC 1
Xs193_p_12 s193_p_12 0 adc_mim_bank COUNT=1
Vs193_n_0 s193_n_0 0 DC 0 AC 1
Xs193_n_0 s193_n_0 0 adc_mim_bank COUNT=1
Vs193_n_1 s193_n_1 0 DC 0 AC 1
Xs193_n_1 s193_n_1 0 adc_mim_bank COUNT=2
Vs193_n_2 s193_n_2 0 DC 0 AC 1
Xs193_n_2 s193_n_2 0 adc_mim_bank COUNT=4
Vs193_n_3 s193_n_3 0 DC 0 AC 1
Xs193_n_3 s193_n_3 0 adc_mim_bank COUNT=8
Vs193_n_4 s193_n_4 0 DC 0 AC 1
Xs193_n_4 s193_n_4 0 adc_mim_bank COUNT=16
Vs193_n_5 s193_n_5 0 DC 0 AC 1
Xs193_n_5 s193_n_5 0 adc_mim_bank COUNT=32
Vs193_n_6 s193_n_6 0 DC 0 AC 1
Xs193_n_6 s193_n_6 0 adc_mim_bank COUNT=64
Vs193_n_7 s193_n_7 0 DC 0 AC 1
Xs193_n_7 s193_n_7 0 adc_mim_bank COUNT=128
Vs193_n_8 s193_n_8 0 DC 0 AC 1
Xs193_n_8 s193_n_8 0 adc_mim_bank COUNT=256
Vs193_n_9 s193_n_9 0 DC 0 AC 1
Xs193_n_9 s193_n_9 0 adc_mim_bank COUNT=512
Vs193_n_10 s193_n_10 0 DC 0 AC 1
Xs193_n_10 s193_n_10 0 adc_mim_bank COUNT=1024
Vs193_n_11 s193_n_11 0 DC 0 AC 1
Xs193_n_11 s193_n_11 0 adc_mim_bank COUNT=2048
Vs193_n_12 s193_n_12 0 DC 0 AC 1
Xs193_n_12 s193_n_12 0 adc_mim_bank COUNT=1
Vs194_p_0 s194_p_0 0 DC 0 AC 1
Xs194_p_0 s194_p_0 0 adc_mim_bank COUNT=1
Vs194_p_1 s194_p_1 0 DC 0 AC 1
Xs194_p_1 s194_p_1 0 adc_mim_bank COUNT=2
Vs194_p_2 s194_p_2 0 DC 0 AC 1
Xs194_p_2 s194_p_2 0 adc_mim_bank COUNT=4
Vs194_p_3 s194_p_3 0 DC 0 AC 1
Xs194_p_3 s194_p_3 0 adc_mim_bank COUNT=8
Vs194_p_4 s194_p_4 0 DC 0 AC 1
Xs194_p_4 s194_p_4 0 adc_mim_bank COUNT=16
Vs194_p_5 s194_p_5 0 DC 0 AC 1
Xs194_p_5 s194_p_5 0 adc_mim_bank COUNT=32
Vs194_p_6 s194_p_6 0 DC 0 AC 1
Xs194_p_6 s194_p_6 0 adc_mim_bank COUNT=64
Vs194_p_7 s194_p_7 0 DC 0 AC 1
Xs194_p_7 s194_p_7 0 adc_mim_bank COUNT=128
Vs194_p_8 s194_p_8 0 DC 0 AC 1
Xs194_p_8 s194_p_8 0 adc_mim_bank COUNT=256
Vs194_p_9 s194_p_9 0 DC 0 AC 1
Xs194_p_9 s194_p_9 0 adc_mim_bank COUNT=512
Vs194_p_10 s194_p_10 0 DC 0 AC 1
Xs194_p_10 s194_p_10 0 adc_mim_bank COUNT=1024
Vs194_p_11 s194_p_11 0 DC 0 AC 1
Xs194_p_11 s194_p_11 0 adc_mim_bank COUNT=2048
Vs194_p_12 s194_p_12 0 DC 0 AC 1
Xs194_p_12 s194_p_12 0 adc_mim_bank COUNT=1
Vs194_n_0 s194_n_0 0 DC 0 AC 1
Xs194_n_0 s194_n_0 0 adc_mim_bank COUNT=1
Vs194_n_1 s194_n_1 0 DC 0 AC 1
Xs194_n_1 s194_n_1 0 adc_mim_bank COUNT=2
Vs194_n_2 s194_n_2 0 DC 0 AC 1
Xs194_n_2 s194_n_2 0 adc_mim_bank COUNT=4
Vs194_n_3 s194_n_3 0 DC 0 AC 1
Xs194_n_3 s194_n_3 0 adc_mim_bank COUNT=8
Vs194_n_4 s194_n_4 0 DC 0 AC 1
Xs194_n_4 s194_n_4 0 adc_mim_bank COUNT=16
Vs194_n_5 s194_n_5 0 DC 0 AC 1
Xs194_n_5 s194_n_5 0 adc_mim_bank COUNT=32
Vs194_n_6 s194_n_6 0 DC 0 AC 1
Xs194_n_6 s194_n_6 0 adc_mim_bank COUNT=64
Vs194_n_7 s194_n_7 0 DC 0 AC 1
Xs194_n_7 s194_n_7 0 adc_mim_bank COUNT=128
Vs194_n_8 s194_n_8 0 DC 0 AC 1
Xs194_n_8 s194_n_8 0 adc_mim_bank COUNT=256
Vs194_n_9 s194_n_9 0 DC 0 AC 1
Xs194_n_9 s194_n_9 0 adc_mim_bank COUNT=512
Vs194_n_10 s194_n_10 0 DC 0 AC 1
Xs194_n_10 s194_n_10 0 adc_mim_bank COUNT=1024
Vs194_n_11 s194_n_11 0 DC 0 AC 1
Xs194_n_11 s194_n_11 0 adc_mim_bank COUNT=2048
Vs194_n_12 s194_n_12 0 DC 0 AC 1
Xs194_n_12 s194_n_12 0 adc_mim_bank COUNT=1
Vs195_p_0 s195_p_0 0 DC 0 AC 1
Xs195_p_0 s195_p_0 0 adc_mim_bank COUNT=1
Vs195_p_1 s195_p_1 0 DC 0 AC 1
Xs195_p_1 s195_p_1 0 adc_mim_bank COUNT=2
Vs195_p_2 s195_p_2 0 DC 0 AC 1
Xs195_p_2 s195_p_2 0 adc_mim_bank COUNT=4
Vs195_p_3 s195_p_3 0 DC 0 AC 1
Xs195_p_3 s195_p_3 0 adc_mim_bank COUNT=8
Vs195_p_4 s195_p_4 0 DC 0 AC 1
Xs195_p_4 s195_p_4 0 adc_mim_bank COUNT=16
Vs195_p_5 s195_p_5 0 DC 0 AC 1
Xs195_p_5 s195_p_5 0 adc_mim_bank COUNT=32
Vs195_p_6 s195_p_6 0 DC 0 AC 1
Xs195_p_6 s195_p_6 0 adc_mim_bank COUNT=64
Vs195_p_7 s195_p_7 0 DC 0 AC 1
Xs195_p_7 s195_p_7 0 adc_mim_bank COUNT=128
Vs195_p_8 s195_p_8 0 DC 0 AC 1
Xs195_p_8 s195_p_8 0 adc_mim_bank COUNT=256
Vs195_p_9 s195_p_9 0 DC 0 AC 1
Xs195_p_9 s195_p_9 0 adc_mim_bank COUNT=512
Vs195_p_10 s195_p_10 0 DC 0 AC 1
Xs195_p_10 s195_p_10 0 adc_mim_bank COUNT=1024
Vs195_p_11 s195_p_11 0 DC 0 AC 1
Xs195_p_11 s195_p_11 0 adc_mim_bank COUNT=2048
Vs195_p_12 s195_p_12 0 DC 0 AC 1
Xs195_p_12 s195_p_12 0 adc_mim_bank COUNT=1
Vs195_n_0 s195_n_0 0 DC 0 AC 1
Xs195_n_0 s195_n_0 0 adc_mim_bank COUNT=1
Vs195_n_1 s195_n_1 0 DC 0 AC 1
Xs195_n_1 s195_n_1 0 adc_mim_bank COUNT=2
Vs195_n_2 s195_n_2 0 DC 0 AC 1
Xs195_n_2 s195_n_2 0 adc_mim_bank COUNT=4
Vs195_n_3 s195_n_3 0 DC 0 AC 1
Xs195_n_3 s195_n_3 0 adc_mim_bank COUNT=8
Vs195_n_4 s195_n_4 0 DC 0 AC 1
Xs195_n_4 s195_n_4 0 adc_mim_bank COUNT=16
Vs195_n_5 s195_n_5 0 DC 0 AC 1
Xs195_n_5 s195_n_5 0 adc_mim_bank COUNT=32
Vs195_n_6 s195_n_6 0 DC 0 AC 1
Xs195_n_6 s195_n_6 0 adc_mim_bank COUNT=64
Vs195_n_7 s195_n_7 0 DC 0 AC 1
Xs195_n_7 s195_n_7 0 adc_mim_bank COUNT=128
Vs195_n_8 s195_n_8 0 DC 0 AC 1
Xs195_n_8 s195_n_8 0 adc_mim_bank COUNT=256
Vs195_n_9 s195_n_9 0 DC 0 AC 1
Xs195_n_9 s195_n_9 0 adc_mim_bank COUNT=512
Vs195_n_10 s195_n_10 0 DC 0 AC 1
Xs195_n_10 s195_n_10 0 adc_mim_bank COUNT=1024
Vs195_n_11 s195_n_11 0 DC 0 AC 1
Xs195_n_11 s195_n_11 0 adc_mim_bank COUNT=2048
Vs195_n_12 s195_n_12 0 DC 0 AC 1
Xs195_n_12 s195_n_12 0 adc_mim_bank COUNT=1
Vs196_p_0 s196_p_0 0 DC 0 AC 1
Xs196_p_0 s196_p_0 0 adc_mim_bank COUNT=1
Vs196_p_1 s196_p_1 0 DC 0 AC 1
Xs196_p_1 s196_p_1 0 adc_mim_bank COUNT=2
Vs196_p_2 s196_p_2 0 DC 0 AC 1
Xs196_p_2 s196_p_2 0 adc_mim_bank COUNT=4
Vs196_p_3 s196_p_3 0 DC 0 AC 1
Xs196_p_3 s196_p_3 0 adc_mim_bank COUNT=8
Vs196_p_4 s196_p_4 0 DC 0 AC 1
Xs196_p_4 s196_p_4 0 adc_mim_bank COUNT=16
Vs196_p_5 s196_p_5 0 DC 0 AC 1
Xs196_p_5 s196_p_5 0 adc_mim_bank COUNT=32
Vs196_p_6 s196_p_6 0 DC 0 AC 1
Xs196_p_6 s196_p_6 0 adc_mim_bank COUNT=64
Vs196_p_7 s196_p_7 0 DC 0 AC 1
Xs196_p_7 s196_p_7 0 adc_mim_bank COUNT=128
Vs196_p_8 s196_p_8 0 DC 0 AC 1
Xs196_p_8 s196_p_8 0 adc_mim_bank COUNT=256
Vs196_p_9 s196_p_9 0 DC 0 AC 1
Xs196_p_9 s196_p_9 0 adc_mim_bank COUNT=512
Vs196_p_10 s196_p_10 0 DC 0 AC 1
Xs196_p_10 s196_p_10 0 adc_mim_bank COUNT=1024
Vs196_p_11 s196_p_11 0 DC 0 AC 1
Xs196_p_11 s196_p_11 0 adc_mim_bank COUNT=2048
Vs196_p_12 s196_p_12 0 DC 0 AC 1
Xs196_p_12 s196_p_12 0 adc_mim_bank COUNT=1
Vs196_n_0 s196_n_0 0 DC 0 AC 1
Xs196_n_0 s196_n_0 0 adc_mim_bank COUNT=1
Vs196_n_1 s196_n_1 0 DC 0 AC 1
Xs196_n_1 s196_n_1 0 adc_mim_bank COUNT=2
Vs196_n_2 s196_n_2 0 DC 0 AC 1
Xs196_n_2 s196_n_2 0 adc_mim_bank COUNT=4
Vs196_n_3 s196_n_3 0 DC 0 AC 1
Xs196_n_3 s196_n_3 0 adc_mim_bank COUNT=8
Vs196_n_4 s196_n_4 0 DC 0 AC 1
Xs196_n_4 s196_n_4 0 adc_mim_bank COUNT=16
Vs196_n_5 s196_n_5 0 DC 0 AC 1
Xs196_n_5 s196_n_5 0 adc_mim_bank COUNT=32
Vs196_n_6 s196_n_6 0 DC 0 AC 1
Xs196_n_6 s196_n_6 0 adc_mim_bank COUNT=64
Vs196_n_7 s196_n_7 0 DC 0 AC 1
Xs196_n_7 s196_n_7 0 adc_mim_bank COUNT=128
Vs196_n_8 s196_n_8 0 DC 0 AC 1
Xs196_n_8 s196_n_8 0 adc_mim_bank COUNT=256
Vs196_n_9 s196_n_9 0 DC 0 AC 1
Xs196_n_9 s196_n_9 0 adc_mim_bank COUNT=512
Vs196_n_10 s196_n_10 0 DC 0 AC 1
Xs196_n_10 s196_n_10 0 adc_mim_bank COUNT=1024
Vs196_n_11 s196_n_11 0 DC 0 AC 1
Xs196_n_11 s196_n_11 0 adc_mim_bank COUNT=2048
Vs196_n_12 s196_n_12 0 DC 0 AC 1
Xs196_n_12 s196_n_12 0 adc_mim_bank COUNT=1
Vs197_p_0 s197_p_0 0 DC 0 AC 1
Xs197_p_0 s197_p_0 0 adc_mim_bank COUNT=1
Vs197_p_1 s197_p_1 0 DC 0 AC 1
Xs197_p_1 s197_p_1 0 adc_mim_bank COUNT=2
Vs197_p_2 s197_p_2 0 DC 0 AC 1
Xs197_p_2 s197_p_2 0 adc_mim_bank COUNT=4
Vs197_p_3 s197_p_3 0 DC 0 AC 1
Xs197_p_3 s197_p_3 0 adc_mim_bank COUNT=8
Vs197_p_4 s197_p_4 0 DC 0 AC 1
Xs197_p_4 s197_p_4 0 adc_mim_bank COUNT=16
Vs197_p_5 s197_p_5 0 DC 0 AC 1
Xs197_p_5 s197_p_5 0 adc_mim_bank COUNT=32
Vs197_p_6 s197_p_6 0 DC 0 AC 1
Xs197_p_6 s197_p_6 0 adc_mim_bank COUNT=64
Vs197_p_7 s197_p_7 0 DC 0 AC 1
Xs197_p_7 s197_p_7 0 adc_mim_bank COUNT=128
Vs197_p_8 s197_p_8 0 DC 0 AC 1
Xs197_p_8 s197_p_8 0 adc_mim_bank COUNT=256
Vs197_p_9 s197_p_9 0 DC 0 AC 1
Xs197_p_9 s197_p_9 0 adc_mim_bank COUNT=512
Vs197_p_10 s197_p_10 0 DC 0 AC 1
Xs197_p_10 s197_p_10 0 adc_mim_bank COUNT=1024
Vs197_p_11 s197_p_11 0 DC 0 AC 1
Xs197_p_11 s197_p_11 0 adc_mim_bank COUNT=2048
Vs197_p_12 s197_p_12 0 DC 0 AC 1
Xs197_p_12 s197_p_12 0 adc_mim_bank COUNT=1
Vs197_n_0 s197_n_0 0 DC 0 AC 1
Xs197_n_0 s197_n_0 0 adc_mim_bank COUNT=1
Vs197_n_1 s197_n_1 0 DC 0 AC 1
Xs197_n_1 s197_n_1 0 adc_mim_bank COUNT=2
Vs197_n_2 s197_n_2 0 DC 0 AC 1
Xs197_n_2 s197_n_2 0 adc_mim_bank COUNT=4
Vs197_n_3 s197_n_3 0 DC 0 AC 1
Xs197_n_3 s197_n_3 0 adc_mim_bank COUNT=8
Vs197_n_4 s197_n_4 0 DC 0 AC 1
Xs197_n_4 s197_n_4 0 adc_mim_bank COUNT=16
Vs197_n_5 s197_n_5 0 DC 0 AC 1
Xs197_n_5 s197_n_5 0 adc_mim_bank COUNT=32
Vs197_n_6 s197_n_6 0 DC 0 AC 1
Xs197_n_6 s197_n_6 0 adc_mim_bank COUNT=64
Vs197_n_7 s197_n_7 0 DC 0 AC 1
Xs197_n_7 s197_n_7 0 adc_mim_bank COUNT=128
Vs197_n_8 s197_n_8 0 DC 0 AC 1
Xs197_n_8 s197_n_8 0 adc_mim_bank COUNT=256
Vs197_n_9 s197_n_9 0 DC 0 AC 1
Xs197_n_9 s197_n_9 0 adc_mim_bank COUNT=512
Vs197_n_10 s197_n_10 0 DC 0 AC 1
Xs197_n_10 s197_n_10 0 adc_mim_bank COUNT=1024
Vs197_n_11 s197_n_11 0 DC 0 AC 1
Xs197_n_11 s197_n_11 0 adc_mim_bank COUNT=2048
Vs197_n_12 s197_n_12 0 DC 0 AC 1
Xs197_n_12 s197_n_12 0 adc_mim_bank COUNT=1
Vs198_p_0 s198_p_0 0 DC 0 AC 1
Xs198_p_0 s198_p_0 0 adc_mim_bank COUNT=1
Vs198_p_1 s198_p_1 0 DC 0 AC 1
Xs198_p_1 s198_p_1 0 adc_mim_bank COUNT=2
Vs198_p_2 s198_p_2 0 DC 0 AC 1
Xs198_p_2 s198_p_2 0 adc_mim_bank COUNT=4
Vs198_p_3 s198_p_3 0 DC 0 AC 1
Xs198_p_3 s198_p_3 0 adc_mim_bank COUNT=8
Vs198_p_4 s198_p_4 0 DC 0 AC 1
Xs198_p_4 s198_p_4 0 adc_mim_bank COUNT=16
Vs198_p_5 s198_p_5 0 DC 0 AC 1
Xs198_p_5 s198_p_5 0 adc_mim_bank COUNT=32
Vs198_p_6 s198_p_6 0 DC 0 AC 1
Xs198_p_6 s198_p_6 0 adc_mim_bank COUNT=64
Vs198_p_7 s198_p_7 0 DC 0 AC 1
Xs198_p_7 s198_p_7 0 adc_mim_bank COUNT=128
Vs198_p_8 s198_p_8 0 DC 0 AC 1
Xs198_p_8 s198_p_8 0 adc_mim_bank COUNT=256
Vs198_p_9 s198_p_9 0 DC 0 AC 1
Xs198_p_9 s198_p_9 0 adc_mim_bank COUNT=512
Vs198_p_10 s198_p_10 0 DC 0 AC 1
Xs198_p_10 s198_p_10 0 adc_mim_bank COUNT=1024
Vs198_p_11 s198_p_11 0 DC 0 AC 1
Xs198_p_11 s198_p_11 0 adc_mim_bank COUNT=2048
Vs198_p_12 s198_p_12 0 DC 0 AC 1
Xs198_p_12 s198_p_12 0 adc_mim_bank COUNT=1
Vs198_n_0 s198_n_0 0 DC 0 AC 1
Xs198_n_0 s198_n_0 0 adc_mim_bank COUNT=1
Vs198_n_1 s198_n_1 0 DC 0 AC 1
Xs198_n_1 s198_n_1 0 adc_mim_bank COUNT=2
Vs198_n_2 s198_n_2 0 DC 0 AC 1
Xs198_n_2 s198_n_2 0 adc_mim_bank COUNT=4
Vs198_n_3 s198_n_3 0 DC 0 AC 1
Xs198_n_3 s198_n_3 0 adc_mim_bank COUNT=8
Vs198_n_4 s198_n_4 0 DC 0 AC 1
Xs198_n_4 s198_n_4 0 adc_mim_bank COUNT=16
Vs198_n_5 s198_n_5 0 DC 0 AC 1
Xs198_n_5 s198_n_5 0 adc_mim_bank COUNT=32
Vs198_n_6 s198_n_6 0 DC 0 AC 1
Xs198_n_6 s198_n_6 0 adc_mim_bank COUNT=64
Vs198_n_7 s198_n_7 0 DC 0 AC 1
Xs198_n_7 s198_n_7 0 adc_mim_bank COUNT=128
Vs198_n_8 s198_n_8 0 DC 0 AC 1
Xs198_n_8 s198_n_8 0 adc_mim_bank COUNT=256
Vs198_n_9 s198_n_9 0 DC 0 AC 1
Xs198_n_9 s198_n_9 0 adc_mim_bank COUNT=512
Vs198_n_10 s198_n_10 0 DC 0 AC 1
Xs198_n_10 s198_n_10 0 adc_mim_bank COUNT=1024
Vs198_n_11 s198_n_11 0 DC 0 AC 1
Xs198_n_11 s198_n_11 0 adc_mim_bank COUNT=2048
Vs198_n_12 s198_n_12 0 DC 0 AC 1
Xs198_n_12 s198_n_12 0 adc_mim_bank COUNT=1
Vs199_p_0 s199_p_0 0 DC 0 AC 1
Xs199_p_0 s199_p_0 0 adc_mim_bank COUNT=1
Vs199_p_1 s199_p_1 0 DC 0 AC 1
Xs199_p_1 s199_p_1 0 adc_mim_bank COUNT=2
Vs199_p_2 s199_p_2 0 DC 0 AC 1
Xs199_p_2 s199_p_2 0 adc_mim_bank COUNT=4
Vs199_p_3 s199_p_3 0 DC 0 AC 1
Xs199_p_3 s199_p_3 0 adc_mim_bank COUNT=8
Vs199_p_4 s199_p_4 0 DC 0 AC 1
Xs199_p_4 s199_p_4 0 adc_mim_bank COUNT=16
Vs199_p_5 s199_p_5 0 DC 0 AC 1
Xs199_p_5 s199_p_5 0 adc_mim_bank COUNT=32
Vs199_p_6 s199_p_6 0 DC 0 AC 1
Xs199_p_6 s199_p_6 0 adc_mim_bank COUNT=64
Vs199_p_7 s199_p_7 0 DC 0 AC 1
Xs199_p_7 s199_p_7 0 adc_mim_bank COUNT=128
Vs199_p_8 s199_p_8 0 DC 0 AC 1
Xs199_p_8 s199_p_8 0 adc_mim_bank COUNT=256
Vs199_p_9 s199_p_9 0 DC 0 AC 1
Xs199_p_9 s199_p_9 0 adc_mim_bank COUNT=512
Vs199_p_10 s199_p_10 0 DC 0 AC 1
Xs199_p_10 s199_p_10 0 adc_mim_bank COUNT=1024
Vs199_p_11 s199_p_11 0 DC 0 AC 1
Xs199_p_11 s199_p_11 0 adc_mim_bank COUNT=2048
Vs199_p_12 s199_p_12 0 DC 0 AC 1
Xs199_p_12 s199_p_12 0 adc_mim_bank COUNT=1
Vs199_n_0 s199_n_0 0 DC 0 AC 1
Xs199_n_0 s199_n_0 0 adc_mim_bank COUNT=1
Vs199_n_1 s199_n_1 0 DC 0 AC 1
Xs199_n_1 s199_n_1 0 adc_mim_bank COUNT=2
Vs199_n_2 s199_n_2 0 DC 0 AC 1
Xs199_n_2 s199_n_2 0 adc_mim_bank COUNT=4
Vs199_n_3 s199_n_3 0 DC 0 AC 1
Xs199_n_3 s199_n_3 0 adc_mim_bank COUNT=8
Vs199_n_4 s199_n_4 0 DC 0 AC 1
Xs199_n_4 s199_n_4 0 adc_mim_bank COUNT=16
Vs199_n_5 s199_n_5 0 DC 0 AC 1
Xs199_n_5 s199_n_5 0 adc_mim_bank COUNT=32
Vs199_n_6 s199_n_6 0 DC 0 AC 1
Xs199_n_6 s199_n_6 0 adc_mim_bank COUNT=64
Vs199_n_7 s199_n_7 0 DC 0 AC 1
Xs199_n_7 s199_n_7 0 adc_mim_bank COUNT=128
Vs199_n_8 s199_n_8 0 DC 0 AC 1
Xs199_n_8 s199_n_8 0 adc_mim_bank COUNT=256
Vs199_n_9 s199_n_9 0 DC 0 AC 1
Xs199_n_9 s199_n_9 0 adc_mim_bank COUNT=512
Vs199_n_10 s199_n_10 0 DC 0 AC 1
Xs199_n_10 s199_n_10 0 adc_mim_bank COUNT=1024
Vs199_n_11 s199_n_11 0 DC 0 AC 1
Xs199_n_11 s199_n_11 0 adc_mim_bank COUNT=2048
Vs199_n_12 s199_n_12 0 DC 0 AC 1
Xs199_n_12 s199_n_12 0 adc_mim_bank COUNT=1
.control
set num_threads=1
set wr_singlescale
set wr_vecnames
set numdgt=12
setseed 1309026
reset
ac lin 1 1000 1000
wrdata /repo/v2/analog/adc/results/cdac_mc_0.tsv imag(i(vs0_p_0)) imag(i(vs0_p_1)) imag(i(vs0_p_2)) imag(i(vs0_p_3)) imag(i(vs0_p_4)) imag(i(vs0_p_5)) imag(i(vs0_p_6)) imag(i(vs0_p_7)) imag(i(vs0_p_8)) imag(i(vs0_p_9)) imag(i(vs0_p_10)) imag(i(vs0_p_11)) imag(i(vs0_p_12)) imag(i(vs0_n_0)) imag(i(vs0_n_1)) imag(i(vs0_n_2)) imag(i(vs0_n_3)) imag(i(vs0_n_4)) imag(i(vs0_n_5)) imag(i(vs0_n_6)) imag(i(vs0_n_7)) imag(i(vs0_n_8)) imag(i(vs0_n_9)) imag(i(vs0_n_10)) imag(i(vs0_n_11)) imag(i(vs0_n_12))
wrdata /repo/v2/analog/adc/results/cdac_mc_1.tsv imag(i(vs1_p_0)) imag(i(vs1_p_1)) imag(i(vs1_p_2)) imag(i(vs1_p_3)) imag(i(vs1_p_4)) imag(i(vs1_p_5)) imag(i(vs1_p_6)) imag(i(vs1_p_7)) imag(i(vs1_p_8)) imag(i(vs1_p_9)) imag(i(vs1_p_10)) imag(i(vs1_p_11)) imag(i(vs1_p_12)) imag(i(vs1_n_0)) imag(i(vs1_n_1)) imag(i(vs1_n_2)) imag(i(vs1_n_3)) imag(i(vs1_n_4)) imag(i(vs1_n_5)) imag(i(vs1_n_6)) imag(i(vs1_n_7)) imag(i(vs1_n_8)) imag(i(vs1_n_9)) imag(i(vs1_n_10)) imag(i(vs1_n_11)) imag(i(vs1_n_12))
wrdata /repo/v2/analog/adc/results/cdac_mc_2.tsv imag(i(vs2_p_0)) imag(i(vs2_p_1)) imag(i(vs2_p_2)) imag(i(vs2_p_3)) imag(i(vs2_p_4)) imag(i(vs2_p_5)) imag(i(vs2_p_6)) imag(i(vs2_p_7)) imag(i(vs2_p_8)) imag(i(vs2_p_9)) imag(i(vs2_p_10)) imag(i(vs2_p_11)) imag(i(vs2_p_12)) imag(i(vs2_n_0)) imag(i(vs2_n_1)) imag(i(vs2_n_2)) imag(i(vs2_n_3)) imag(i(vs2_n_4)) imag(i(vs2_n_5)) imag(i(vs2_n_6)) imag(i(vs2_n_7)) imag(i(vs2_n_8)) imag(i(vs2_n_9)) imag(i(vs2_n_10)) imag(i(vs2_n_11)) imag(i(vs2_n_12))
wrdata /repo/v2/analog/adc/results/cdac_mc_3.tsv imag(i(vs3_p_0)) imag(i(vs3_p_1)) imag(i(vs3_p_2)) imag(i(vs3_p_3)) imag(i(vs3_p_4)) imag(i(vs3_p_5)) imag(i(vs3_p_6)) imag(i(vs3_p_7)) imag(i(vs3_p_8)) imag(i(vs3_p_9)) imag(i(vs3_p_10)) imag(i(vs3_p_11)) imag(i(vs3_p_12)) imag(i(vs3_n_0)) imag(i(vs3_n_1)) imag(i(vs3_n_2)) imag(i(vs3_n_3)) imag(i(vs3_n_4)) imag(i(vs3_n_5)) imag(i(vs3_n_6)) imag(i(vs3_n_7)) imag(i(vs3_n_8)) imag(i(vs3_n_9)) imag(i(vs3_n_10)) imag(i(vs3_n_11)) imag(i(vs3_n_12))
wrdata /repo/v2/analog/adc/results/cdac_mc_4.tsv imag(i(vs4_p_0)) imag(i(vs4_p_1)) imag(i(vs4_p_2)) imag(i(vs4_p_3)) imag(i(vs4_p_4)) imag(i(vs4_p_5)) imag(i(vs4_p_6)) imag(i(vs4_p_7)) imag(i(vs4_p_8)) imag(i(vs4_p_9)) imag(i(vs4_p_10)) imag(i(vs4_p_11)) imag(i(vs4_p_12)) imag(i(vs4_n_0)) imag(i(vs4_n_1)) imag(i(vs4_n_2)) imag(i(vs4_n_3)) imag(i(vs4_n_4)) imag(i(vs4_n_5)) imag(i(vs4_n_6)) imag(i(vs4_n_7)) imag(i(vs4_n_8)) imag(i(vs4_n_9)) imag(i(vs4_n_10)) imag(i(vs4_n_11)) imag(i(vs4_n_12))
wrdata /repo/v2/analog/adc/results/cdac_mc_5.tsv imag(i(vs5_p_0)) imag(i(vs5_p_1)) imag(i(vs5_p_2)) imag(i(vs5_p_3)) imag(i(vs5_p_4)) imag(i(vs5_p_5)) imag(i(vs5_p_6)) imag(i(vs5_p_7)) imag(i(vs5_p_8)) imag(i(vs5_p_9)) imag(i(vs5_p_10)) imag(i(vs5_p_11)) imag(i(vs5_p_12)) imag(i(vs5_n_0)) imag(i(vs5_n_1)) imag(i(vs5_n_2)) imag(i(vs5_n_3)) imag(i(vs5_n_4)) imag(i(vs5_n_5)) imag(i(vs5_n_6)) imag(i(vs5_n_7)) imag(i(vs5_n_8)) imag(i(vs5_n_9)) imag(i(vs5_n_10)) imag(i(vs5_n_11)) imag(i(vs5_n_12))
wrdata /repo/v2/analog/adc/results/cdac_mc_6.tsv imag(i(vs6_p_0)) imag(i(vs6_p_1)) imag(i(vs6_p_2)) imag(i(vs6_p_3)) imag(i(vs6_p_4)) imag(i(vs6_p_5)) imag(i(vs6_p_6)) imag(i(vs6_p_7)) imag(i(vs6_p_8)) imag(i(vs6_p_9)) imag(i(vs6_p_10)) imag(i(vs6_p_11)) imag(i(vs6_p_12)) imag(i(vs6_n_0)) imag(i(vs6_n_1)) imag(i(vs6_n_2)) imag(i(vs6_n_3)) imag(i(vs6_n_4)) imag(i(vs6_n_5)) imag(i(vs6_n_6)) imag(i(vs6_n_7)) imag(i(vs6_n_8)) imag(i(vs6_n_9)) imag(i(vs6_n_10)) imag(i(vs6_n_11)) imag(i(vs6_n_12))
wrdata /repo/v2/analog/adc/results/cdac_mc_7.tsv imag(i(vs7_p_0)) imag(i(vs7_p_1)) imag(i(vs7_p_2)) imag(i(vs7_p_3)) imag(i(vs7_p_4)) imag(i(vs7_p_5)) imag(i(vs7_p_6)) imag(i(vs7_p_7)) imag(i(vs7_p_8)) imag(i(vs7_p_9)) imag(i(vs7_p_10)) imag(i(vs7_p_11)) imag(i(vs7_p_12)) imag(i(vs7_n_0)) imag(i(vs7_n_1)) imag(i(vs7_n_2)) imag(i(vs7_n_3)) imag(i(vs7_n_4)) imag(i(vs7_n_5)) imag(i(vs7_n_6)) imag(i(vs7_n_7)) imag(i(vs7_n_8)) imag(i(vs7_n_9)) imag(i(vs7_n_10)) imag(i(vs7_n_11)) imag(i(vs7_n_12))
wrdata /repo/v2/analog/adc/results/cdac_mc_8.tsv imag(i(vs8_p_0)) imag(i(vs8_p_1)) imag(i(vs8_p_2)) imag(i(vs8_p_3)) imag(i(vs8_p_4)) imag(i(vs8_p_5)) imag(i(vs8_p_6)) imag(i(vs8_p_7)) imag(i(vs8_p_8)) imag(i(vs8_p_9)) imag(i(vs8_p_10)) imag(i(vs8_p_11)) imag(i(vs8_p_12)) imag(i(vs8_n_0)) imag(i(vs8_n_1)) imag(i(vs8_n_2)) imag(i(vs8_n_3)) imag(i(vs8_n_4)) imag(i(vs8_n_5)) imag(i(vs8_n_6)) imag(i(vs8_n_7)) imag(i(vs8_n_8)) imag(i(vs8_n_9)) imag(i(vs8_n_10)) imag(i(vs8_n_11)) imag(i(vs8_n_12))
wrdata /repo/v2/analog/adc/results/cdac_mc_9.tsv imag(i(vs9_p_0)) imag(i(vs9_p_1)) imag(i(vs9_p_2)) imag(i(vs9_p_3)) imag(i(vs9_p_4)) imag(i(vs9_p_5)) imag(i(vs9_p_6)) imag(i(vs9_p_7)) imag(i(vs9_p_8)) imag(i(vs9_p_9)) imag(i(vs9_p_10)) imag(i(vs9_p_11)) imag(i(vs9_p_12)) imag(i(vs9_n_0)) imag(i(vs9_n_1)) imag(i(vs9_n_2)) imag(i(vs9_n_3)) imag(i(vs9_n_4)) imag(i(vs9_n_5)) imag(i(vs9_n_6)) imag(i(vs9_n_7)) imag(i(vs9_n_8)) imag(i(vs9_n_9)) imag(i(vs9_n_10)) imag(i(vs9_n_11)) imag(i(vs9_n_12))
wrdata /repo/v2/analog/adc/results/cdac_mc_10.tsv imag(i(vs10_p_0)) imag(i(vs10_p_1)) imag(i(vs10_p_2)) imag(i(vs10_p_3)) imag(i(vs10_p_4)) imag(i(vs10_p_5)) imag(i(vs10_p_6)) imag(i(vs10_p_7)) imag(i(vs10_p_8)) imag(i(vs10_p_9)) imag(i(vs10_p_10)) imag(i(vs10_p_11)) imag(i(vs10_p_12)) imag(i(vs10_n_0)) imag(i(vs10_n_1)) imag(i(vs10_n_2)) imag(i(vs10_n_3)) imag(i(vs10_n_4)) imag(i(vs10_n_5)) imag(i(vs10_n_6)) imag(i(vs10_n_7)) imag(i(vs10_n_8)) imag(i(vs10_n_9)) imag(i(vs10_n_10)) imag(i(vs10_n_11)) imag(i(vs10_n_12))
wrdata /repo/v2/analog/adc/results/cdac_mc_11.tsv imag(i(vs11_p_0)) imag(i(vs11_p_1)) imag(i(vs11_p_2)) imag(i(vs11_p_3)) imag(i(vs11_p_4)) imag(i(vs11_p_5)) imag(i(vs11_p_6)) imag(i(vs11_p_7)) imag(i(vs11_p_8)) imag(i(vs11_p_9)) imag(i(vs11_p_10)) imag(i(vs11_p_11)) imag(i(vs11_p_12)) imag(i(vs11_n_0)) imag(i(vs11_n_1)) imag(i(vs11_n_2)) imag(i(vs11_n_3)) imag(i(vs11_n_4)) imag(i(vs11_n_5)) imag(i(vs11_n_6)) imag(i(vs11_n_7)) imag(i(vs11_n_8)) imag(i(vs11_n_9)) imag(i(vs11_n_10)) imag(i(vs11_n_11)) imag(i(vs11_n_12))
wrdata /repo/v2/analog/adc/results/cdac_mc_12.tsv imag(i(vs12_p_0)) imag(i(vs12_p_1)) imag(i(vs12_p_2)) imag(i(vs12_p_3)) imag(i(vs12_p_4)) imag(i(vs12_p_5)) imag(i(vs12_p_6)) imag(i(vs12_p_7)) imag(i(vs12_p_8)) imag(i(vs12_p_9)) imag(i(vs12_p_10)) imag(i(vs12_p_11)) imag(i(vs12_p_12)) imag(i(vs12_n_0)) imag(i(vs12_n_1)) imag(i(vs12_n_2)) imag(i(vs12_n_3)) imag(i(vs12_n_4)) imag(i(vs12_n_5)) imag(i(vs12_n_6)) imag(i(vs12_n_7)) imag(i(vs12_n_8)) imag(i(vs12_n_9)) imag(i(vs12_n_10)) imag(i(vs12_n_11)) imag(i(vs12_n_12))
wrdata /repo/v2/analog/adc/results/cdac_mc_13.tsv imag(i(vs13_p_0)) imag(i(vs13_p_1)) imag(i(vs13_p_2)) imag(i(vs13_p_3)) imag(i(vs13_p_4)) imag(i(vs13_p_5)) imag(i(vs13_p_6)) imag(i(vs13_p_7)) imag(i(vs13_p_8)) imag(i(vs13_p_9)) imag(i(vs13_p_10)) imag(i(vs13_p_11)) imag(i(vs13_p_12)) imag(i(vs13_n_0)) imag(i(vs13_n_1)) imag(i(vs13_n_2)) imag(i(vs13_n_3)) imag(i(vs13_n_4)) imag(i(vs13_n_5)) imag(i(vs13_n_6)) imag(i(vs13_n_7)) imag(i(vs13_n_8)) imag(i(vs13_n_9)) imag(i(vs13_n_10)) imag(i(vs13_n_11)) imag(i(vs13_n_12))
wrdata /repo/v2/analog/adc/results/cdac_mc_14.tsv imag(i(vs14_p_0)) imag(i(vs14_p_1)) imag(i(vs14_p_2)) imag(i(vs14_p_3)) imag(i(vs14_p_4)) imag(i(vs14_p_5)) imag(i(vs14_p_6)) imag(i(vs14_p_7)) imag(i(vs14_p_8)) imag(i(vs14_p_9)) imag(i(vs14_p_10)) imag(i(vs14_p_11)) imag(i(vs14_p_12)) imag(i(vs14_n_0)) imag(i(vs14_n_1)) imag(i(vs14_n_2)) imag(i(vs14_n_3)) imag(i(vs14_n_4)) imag(i(vs14_n_5)) imag(i(vs14_n_6)) imag(i(vs14_n_7)) imag(i(vs14_n_8)) imag(i(vs14_n_9)) imag(i(vs14_n_10)) imag(i(vs14_n_11)) imag(i(vs14_n_12))
wrdata /repo/v2/analog/adc/results/cdac_mc_15.tsv imag(i(vs15_p_0)) imag(i(vs15_p_1)) imag(i(vs15_p_2)) imag(i(vs15_p_3)) imag(i(vs15_p_4)) imag(i(vs15_p_5)) imag(i(vs15_p_6)) imag(i(vs15_p_7)) imag(i(vs15_p_8)) imag(i(vs15_p_9)) imag(i(vs15_p_10)) imag(i(vs15_p_11)) imag(i(vs15_p_12)) imag(i(vs15_n_0)) imag(i(vs15_n_1)) imag(i(vs15_n_2)) imag(i(vs15_n_3)) imag(i(vs15_n_4)) imag(i(vs15_n_5)) imag(i(vs15_n_6)) imag(i(vs15_n_7)) imag(i(vs15_n_8)) imag(i(vs15_n_9)) imag(i(vs15_n_10)) imag(i(vs15_n_11)) imag(i(vs15_n_12))
wrdata /repo/v2/analog/adc/results/cdac_mc_16.tsv imag(i(vs16_p_0)) imag(i(vs16_p_1)) imag(i(vs16_p_2)) imag(i(vs16_p_3)) imag(i(vs16_p_4)) imag(i(vs16_p_5)) imag(i(vs16_p_6)) imag(i(vs16_p_7)) imag(i(vs16_p_8)) imag(i(vs16_p_9)) imag(i(vs16_p_10)) imag(i(vs16_p_11)) imag(i(vs16_p_12)) imag(i(vs16_n_0)) imag(i(vs16_n_1)) imag(i(vs16_n_2)) imag(i(vs16_n_3)) imag(i(vs16_n_4)) imag(i(vs16_n_5)) imag(i(vs16_n_6)) imag(i(vs16_n_7)) imag(i(vs16_n_8)) imag(i(vs16_n_9)) imag(i(vs16_n_10)) imag(i(vs16_n_11)) imag(i(vs16_n_12))
wrdata /repo/v2/analog/adc/results/cdac_mc_17.tsv imag(i(vs17_p_0)) imag(i(vs17_p_1)) imag(i(vs17_p_2)) imag(i(vs17_p_3)) imag(i(vs17_p_4)) imag(i(vs17_p_5)) imag(i(vs17_p_6)) imag(i(vs17_p_7)) imag(i(vs17_p_8)) imag(i(vs17_p_9)) imag(i(vs17_p_10)) imag(i(vs17_p_11)) imag(i(vs17_p_12)) imag(i(vs17_n_0)) imag(i(vs17_n_1)) imag(i(vs17_n_2)) imag(i(vs17_n_3)) imag(i(vs17_n_4)) imag(i(vs17_n_5)) imag(i(vs17_n_6)) imag(i(vs17_n_7)) imag(i(vs17_n_8)) imag(i(vs17_n_9)) imag(i(vs17_n_10)) imag(i(vs17_n_11)) imag(i(vs17_n_12))
wrdata /repo/v2/analog/adc/results/cdac_mc_18.tsv imag(i(vs18_p_0)) imag(i(vs18_p_1)) imag(i(vs18_p_2)) imag(i(vs18_p_3)) imag(i(vs18_p_4)) imag(i(vs18_p_5)) imag(i(vs18_p_6)) imag(i(vs18_p_7)) imag(i(vs18_p_8)) imag(i(vs18_p_9)) imag(i(vs18_p_10)) imag(i(vs18_p_11)) imag(i(vs18_p_12)) imag(i(vs18_n_0)) imag(i(vs18_n_1)) imag(i(vs18_n_2)) imag(i(vs18_n_3)) imag(i(vs18_n_4)) imag(i(vs18_n_5)) imag(i(vs18_n_6)) imag(i(vs18_n_7)) imag(i(vs18_n_8)) imag(i(vs18_n_9)) imag(i(vs18_n_10)) imag(i(vs18_n_11)) imag(i(vs18_n_12))
wrdata /repo/v2/analog/adc/results/cdac_mc_19.tsv imag(i(vs19_p_0)) imag(i(vs19_p_1)) imag(i(vs19_p_2)) imag(i(vs19_p_3)) imag(i(vs19_p_4)) imag(i(vs19_p_5)) imag(i(vs19_p_6)) imag(i(vs19_p_7)) imag(i(vs19_p_8)) imag(i(vs19_p_9)) imag(i(vs19_p_10)) imag(i(vs19_p_11)) imag(i(vs19_p_12)) imag(i(vs19_n_0)) imag(i(vs19_n_1)) imag(i(vs19_n_2)) imag(i(vs19_n_3)) imag(i(vs19_n_4)) imag(i(vs19_n_5)) imag(i(vs19_n_6)) imag(i(vs19_n_7)) imag(i(vs19_n_8)) imag(i(vs19_n_9)) imag(i(vs19_n_10)) imag(i(vs19_n_11)) imag(i(vs19_n_12))
wrdata /repo/v2/analog/adc/results/cdac_mc_20.tsv imag(i(vs20_p_0)) imag(i(vs20_p_1)) imag(i(vs20_p_2)) imag(i(vs20_p_3)) imag(i(vs20_p_4)) imag(i(vs20_p_5)) imag(i(vs20_p_6)) imag(i(vs20_p_7)) imag(i(vs20_p_8)) imag(i(vs20_p_9)) imag(i(vs20_p_10)) imag(i(vs20_p_11)) imag(i(vs20_p_12)) imag(i(vs20_n_0)) imag(i(vs20_n_1)) imag(i(vs20_n_2)) imag(i(vs20_n_3)) imag(i(vs20_n_4)) imag(i(vs20_n_5)) imag(i(vs20_n_6)) imag(i(vs20_n_7)) imag(i(vs20_n_8)) imag(i(vs20_n_9)) imag(i(vs20_n_10)) imag(i(vs20_n_11)) imag(i(vs20_n_12))
wrdata /repo/v2/analog/adc/results/cdac_mc_21.tsv imag(i(vs21_p_0)) imag(i(vs21_p_1)) imag(i(vs21_p_2)) imag(i(vs21_p_3)) imag(i(vs21_p_4)) imag(i(vs21_p_5)) imag(i(vs21_p_6)) imag(i(vs21_p_7)) imag(i(vs21_p_8)) imag(i(vs21_p_9)) imag(i(vs21_p_10)) imag(i(vs21_p_11)) imag(i(vs21_p_12)) imag(i(vs21_n_0)) imag(i(vs21_n_1)) imag(i(vs21_n_2)) imag(i(vs21_n_3)) imag(i(vs21_n_4)) imag(i(vs21_n_5)) imag(i(vs21_n_6)) imag(i(vs21_n_7)) imag(i(vs21_n_8)) imag(i(vs21_n_9)) imag(i(vs21_n_10)) imag(i(vs21_n_11)) imag(i(vs21_n_12))
wrdata /repo/v2/analog/adc/results/cdac_mc_22.tsv imag(i(vs22_p_0)) imag(i(vs22_p_1)) imag(i(vs22_p_2)) imag(i(vs22_p_3)) imag(i(vs22_p_4)) imag(i(vs22_p_5)) imag(i(vs22_p_6)) imag(i(vs22_p_7)) imag(i(vs22_p_8)) imag(i(vs22_p_9)) imag(i(vs22_p_10)) imag(i(vs22_p_11)) imag(i(vs22_p_12)) imag(i(vs22_n_0)) imag(i(vs22_n_1)) imag(i(vs22_n_2)) imag(i(vs22_n_3)) imag(i(vs22_n_4)) imag(i(vs22_n_5)) imag(i(vs22_n_6)) imag(i(vs22_n_7)) imag(i(vs22_n_8)) imag(i(vs22_n_9)) imag(i(vs22_n_10)) imag(i(vs22_n_11)) imag(i(vs22_n_12))
wrdata /repo/v2/analog/adc/results/cdac_mc_23.tsv imag(i(vs23_p_0)) imag(i(vs23_p_1)) imag(i(vs23_p_2)) imag(i(vs23_p_3)) imag(i(vs23_p_4)) imag(i(vs23_p_5)) imag(i(vs23_p_6)) imag(i(vs23_p_7)) imag(i(vs23_p_8)) imag(i(vs23_p_9)) imag(i(vs23_p_10)) imag(i(vs23_p_11)) imag(i(vs23_p_12)) imag(i(vs23_n_0)) imag(i(vs23_n_1)) imag(i(vs23_n_2)) imag(i(vs23_n_3)) imag(i(vs23_n_4)) imag(i(vs23_n_5)) imag(i(vs23_n_6)) imag(i(vs23_n_7)) imag(i(vs23_n_8)) imag(i(vs23_n_9)) imag(i(vs23_n_10)) imag(i(vs23_n_11)) imag(i(vs23_n_12))
wrdata /repo/v2/analog/adc/results/cdac_mc_24.tsv imag(i(vs24_p_0)) imag(i(vs24_p_1)) imag(i(vs24_p_2)) imag(i(vs24_p_3)) imag(i(vs24_p_4)) imag(i(vs24_p_5)) imag(i(vs24_p_6)) imag(i(vs24_p_7)) imag(i(vs24_p_8)) imag(i(vs24_p_9)) imag(i(vs24_p_10)) imag(i(vs24_p_11)) imag(i(vs24_p_12)) imag(i(vs24_n_0)) imag(i(vs24_n_1)) imag(i(vs24_n_2)) imag(i(vs24_n_3)) imag(i(vs24_n_4)) imag(i(vs24_n_5)) imag(i(vs24_n_6)) imag(i(vs24_n_7)) imag(i(vs24_n_8)) imag(i(vs24_n_9)) imag(i(vs24_n_10)) imag(i(vs24_n_11)) imag(i(vs24_n_12))
wrdata /repo/v2/analog/adc/results/cdac_mc_25.tsv imag(i(vs25_p_0)) imag(i(vs25_p_1)) imag(i(vs25_p_2)) imag(i(vs25_p_3)) imag(i(vs25_p_4)) imag(i(vs25_p_5)) imag(i(vs25_p_6)) imag(i(vs25_p_7)) imag(i(vs25_p_8)) imag(i(vs25_p_9)) imag(i(vs25_p_10)) imag(i(vs25_p_11)) imag(i(vs25_p_12)) imag(i(vs25_n_0)) imag(i(vs25_n_1)) imag(i(vs25_n_2)) imag(i(vs25_n_3)) imag(i(vs25_n_4)) imag(i(vs25_n_5)) imag(i(vs25_n_6)) imag(i(vs25_n_7)) imag(i(vs25_n_8)) imag(i(vs25_n_9)) imag(i(vs25_n_10)) imag(i(vs25_n_11)) imag(i(vs25_n_12))
wrdata /repo/v2/analog/adc/results/cdac_mc_26.tsv imag(i(vs26_p_0)) imag(i(vs26_p_1)) imag(i(vs26_p_2)) imag(i(vs26_p_3)) imag(i(vs26_p_4)) imag(i(vs26_p_5)) imag(i(vs26_p_6)) imag(i(vs26_p_7)) imag(i(vs26_p_8)) imag(i(vs26_p_9)) imag(i(vs26_p_10)) imag(i(vs26_p_11)) imag(i(vs26_p_12)) imag(i(vs26_n_0)) imag(i(vs26_n_1)) imag(i(vs26_n_2)) imag(i(vs26_n_3)) imag(i(vs26_n_4)) imag(i(vs26_n_5)) imag(i(vs26_n_6)) imag(i(vs26_n_7)) imag(i(vs26_n_8)) imag(i(vs26_n_9)) imag(i(vs26_n_10)) imag(i(vs26_n_11)) imag(i(vs26_n_12))
wrdata /repo/v2/analog/adc/results/cdac_mc_27.tsv imag(i(vs27_p_0)) imag(i(vs27_p_1)) imag(i(vs27_p_2)) imag(i(vs27_p_3)) imag(i(vs27_p_4)) imag(i(vs27_p_5)) imag(i(vs27_p_6)) imag(i(vs27_p_7)) imag(i(vs27_p_8)) imag(i(vs27_p_9)) imag(i(vs27_p_10)) imag(i(vs27_p_11)) imag(i(vs27_p_12)) imag(i(vs27_n_0)) imag(i(vs27_n_1)) imag(i(vs27_n_2)) imag(i(vs27_n_3)) imag(i(vs27_n_4)) imag(i(vs27_n_5)) imag(i(vs27_n_6)) imag(i(vs27_n_7)) imag(i(vs27_n_8)) imag(i(vs27_n_9)) imag(i(vs27_n_10)) imag(i(vs27_n_11)) imag(i(vs27_n_12))
wrdata /repo/v2/analog/adc/results/cdac_mc_28.tsv imag(i(vs28_p_0)) imag(i(vs28_p_1)) imag(i(vs28_p_2)) imag(i(vs28_p_3)) imag(i(vs28_p_4)) imag(i(vs28_p_5)) imag(i(vs28_p_6)) imag(i(vs28_p_7)) imag(i(vs28_p_8)) imag(i(vs28_p_9)) imag(i(vs28_p_10)) imag(i(vs28_p_11)) imag(i(vs28_p_12)) imag(i(vs28_n_0)) imag(i(vs28_n_1)) imag(i(vs28_n_2)) imag(i(vs28_n_3)) imag(i(vs28_n_4)) imag(i(vs28_n_5)) imag(i(vs28_n_6)) imag(i(vs28_n_7)) imag(i(vs28_n_8)) imag(i(vs28_n_9)) imag(i(vs28_n_10)) imag(i(vs28_n_11)) imag(i(vs28_n_12))
wrdata /repo/v2/analog/adc/results/cdac_mc_29.tsv imag(i(vs29_p_0)) imag(i(vs29_p_1)) imag(i(vs29_p_2)) imag(i(vs29_p_3)) imag(i(vs29_p_4)) imag(i(vs29_p_5)) imag(i(vs29_p_6)) imag(i(vs29_p_7)) imag(i(vs29_p_8)) imag(i(vs29_p_9)) imag(i(vs29_p_10)) imag(i(vs29_p_11)) imag(i(vs29_p_12)) imag(i(vs29_n_0)) imag(i(vs29_n_1)) imag(i(vs29_n_2)) imag(i(vs29_n_3)) imag(i(vs29_n_4)) imag(i(vs29_n_5)) imag(i(vs29_n_6)) imag(i(vs29_n_7)) imag(i(vs29_n_8)) imag(i(vs29_n_9)) imag(i(vs29_n_10)) imag(i(vs29_n_11)) imag(i(vs29_n_12))
wrdata /repo/v2/analog/adc/results/cdac_mc_30.tsv imag(i(vs30_p_0)) imag(i(vs30_p_1)) imag(i(vs30_p_2)) imag(i(vs30_p_3)) imag(i(vs30_p_4)) imag(i(vs30_p_5)) imag(i(vs30_p_6)) imag(i(vs30_p_7)) imag(i(vs30_p_8)) imag(i(vs30_p_9)) imag(i(vs30_p_10)) imag(i(vs30_p_11)) imag(i(vs30_p_12)) imag(i(vs30_n_0)) imag(i(vs30_n_1)) imag(i(vs30_n_2)) imag(i(vs30_n_3)) imag(i(vs30_n_4)) imag(i(vs30_n_5)) imag(i(vs30_n_6)) imag(i(vs30_n_7)) imag(i(vs30_n_8)) imag(i(vs30_n_9)) imag(i(vs30_n_10)) imag(i(vs30_n_11)) imag(i(vs30_n_12))
wrdata /repo/v2/analog/adc/results/cdac_mc_31.tsv imag(i(vs31_p_0)) imag(i(vs31_p_1)) imag(i(vs31_p_2)) imag(i(vs31_p_3)) imag(i(vs31_p_4)) imag(i(vs31_p_5)) imag(i(vs31_p_6)) imag(i(vs31_p_7)) imag(i(vs31_p_8)) imag(i(vs31_p_9)) imag(i(vs31_p_10)) imag(i(vs31_p_11)) imag(i(vs31_p_12)) imag(i(vs31_n_0)) imag(i(vs31_n_1)) imag(i(vs31_n_2)) imag(i(vs31_n_3)) imag(i(vs31_n_4)) imag(i(vs31_n_5)) imag(i(vs31_n_6)) imag(i(vs31_n_7)) imag(i(vs31_n_8)) imag(i(vs31_n_9)) imag(i(vs31_n_10)) imag(i(vs31_n_11)) imag(i(vs31_n_12))
wrdata /repo/v2/analog/adc/results/cdac_mc_32.tsv imag(i(vs32_p_0)) imag(i(vs32_p_1)) imag(i(vs32_p_2)) imag(i(vs32_p_3)) imag(i(vs32_p_4)) imag(i(vs32_p_5)) imag(i(vs32_p_6)) imag(i(vs32_p_7)) imag(i(vs32_p_8)) imag(i(vs32_p_9)) imag(i(vs32_p_10)) imag(i(vs32_p_11)) imag(i(vs32_p_12)) imag(i(vs32_n_0)) imag(i(vs32_n_1)) imag(i(vs32_n_2)) imag(i(vs32_n_3)) imag(i(vs32_n_4)) imag(i(vs32_n_5)) imag(i(vs32_n_6)) imag(i(vs32_n_7)) imag(i(vs32_n_8)) imag(i(vs32_n_9)) imag(i(vs32_n_10)) imag(i(vs32_n_11)) imag(i(vs32_n_12))
wrdata /repo/v2/analog/adc/results/cdac_mc_33.tsv imag(i(vs33_p_0)) imag(i(vs33_p_1)) imag(i(vs33_p_2)) imag(i(vs33_p_3)) imag(i(vs33_p_4)) imag(i(vs33_p_5)) imag(i(vs33_p_6)) imag(i(vs33_p_7)) imag(i(vs33_p_8)) imag(i(vs33_p_9)) imag(i(vs33_p_10)) imag(i(vs33_p_11)) imag(i(vs33_p_12)) imag(i(vs33_n_0)) imag(i(vs33_n_1)) imag(i(vs33_n_2)) imag(i(vs33_n_3)) imag(i(vs33_n_4)) imag(i(vs33_n_5)) imag(i(vs33_n_6)) imag(i(vs33_n_7)) imag(i(vs33_n_8)) imag(i(vs33_n_9)) imag(i(vs33_n_10)) imag(i(vs33_n_11)) imag(i(vs33_n_12))
wrdata /repo/v2/analog/adc/results/cdac_mc_34.tsv imag(i(vs34_p_0)) imag(i(vs34_p_1)) imag(i(vs34_p_2)) imag(i(vs34_p_3)) imag(i(vs34_p_4)) imag(i(vs34_p_5)) imag(i(vs34_p_6)) imag(i(vs34_p_7)) imag(i(vs34_p_8)) imag(i(vs34_p_9)) imag(i(vs34_p_10)) imag(i(vs34_p_11)) imag(i(vs34_p_12)) imag(i(vs34_n_0)) imag(i(vs34_n_1)) imag(i(vs34_n_2)) imag(i(vs34_n_3)) imag(i(vs34_n_4)) imag(i(vs34_n_5)) imag(i(vs34_n_6)) imag(i(vs34_n_7)) imag(i(vs34_n_8)) imag(i(vs34_n_9)) imag(i(vs34_n_10)) imag(i(vs34_n_11)) imag(i(vs34_n_12))
wrdata /repo/v2/analog/adc/results/cdac_mc_35.tsv imag(i(vs35_p_0)) imag(i(vs35_p_1)) imag(i(vs35_p_2)) imag(i(vs35_p_3)) imag(i(vs35_p_4)) imag(i(vs35_p_5)) imag(i(vs35_p_6)) imag(i(vs35_p_7)) imag(i(vs35_p_8)) imag(i(vs35_p_9)) imag(i(vs35_p_10)) imag(i(vs35_p_11)) imag(i(vs35_p_12)) imag(i(vs35_n_0)) imag(i(vs35_n_1)) imag(i(vs35_n_2)) imag(i(vs35_n_3)) imag(i(vs35_n_4)) imag(i(vs35_n_5)) imag(i(vs35_n_6)) imag(i(vs35_n_7)) imag(i(vs35_n_8)) imag(i(vs35_n_9)) imag(i(vs35_n_10)) imag(i(vs35_n_11)) imag(i(vs35_n_12))
wrdata /repo/v2/analog/adc/results/cdac_mc_36.tsv imag(i(vs36_p_0)) imag(i(vs36_p_1)) imag(i(vs36_p_2)) imag(i(vs36_p_3)) imag(i(vs36_p_4)) imag(i(vs36_p_5)) imag(i(vs36_p_6)) imag(i(vs36_p_7)) imag(i(vs36_p_8)) imag(i(vs36_p_9)) imag(i(vs36_p_10)) imag(i(vs36_p_11)) imag(i(vs36_p_12)) imag(i(vs36_n_0)) imag(i(vs36_n_1)) imag(i(vs36_n_2)) imag(i(vs36_n_3)) imag(i(vs36_n_4)) imag(i(vs36_n_5)) imag(i(vs36_n_6)) imag(i(vs36_n_7)) imag(i(vs36_n_8)) imag(i(vs36_n_9)) imag(i(vs36_n_10)) imag(i(vs36_n_11)) imag(i(vs36_n_12))
wrdata /repo/v2/analog/adc/results/cdac_mc_37.tsv imag(i(vs37_p_0)) imag(i(vs37_p_1)) imag(i(vs37_p_2)) imag(i(vs37_p_3)) imag(i(vs37_p_4)) imag(i(vs37_p_5)) imag(i(vs37_p_6)) imag(i(vs37_p_7)) imag(i(vs37_p_8)) imag(i(vs37_p_9)) imag(i(vs37_p_10)) imag(i(vs37_p_11)) imag(i(vs37_p_12)) imag(i(vs37_n_0)) imag(i(vs37_n_1)) imag(i(vs37_n_2)) imag(i(vs37_n_3)) imag(i(vs37_n_4)) imag(i(vs37_n_5)) imag(i(vs37_n_6)) imag(i(vs37_n_7)) imag(i(vs37_n_8)) imag(i(vs37_n_9)) imag(i(vs37_n_10)) imag(i(vs37_n_11)) imag(i(vs37_n_12))
wrdata /repo/v2/analog/adc/results/cdac_mc_38.tsv imag(i(vs38_p_0)) imag(i(vs38_p_1)) imag(i(vs38_p_2)) imag(i(vs38_p_3)) imag(i(vs38_p_4)) imag(i(vs38_p_5)) imag(i(vs38_p_6)) imag(i(vs38_p_7)) imag(i(vs38_p_8)) imag(i(vs38_p_9)) imag(i(vs38_p_10)) imag(i(vs38_p_11)) imag(i(vs38_p_12)) imag(i(vs38_n_0)) imag(i(vs38_n_1)) imag(i(vs38_n_2)) imag(i(vs38_n_3)) imag(i(vs38_n_4)) imag(i(vs38_n_5)) imag(i(vs38_n_6)) imag(i(vs38_n_7)) imag(i(vs38_n_8)) imag(i(vs38_n_9)) imag(i(vs38_n_10)) imag(i(vs38_n_11)) imag(i(vs38_n_12))
wrdata /repo/v2/analog/adc/results/cdac_mc_39.tsv imag(i(vs39_p_0)) imag(i(vs39_p_1)) imag(i(vs39_p_2)) imag(i(vs39_p_3)) imag(i(vs39_p_4)) imag(i(vs39_p_5)) imag(i(vs39_p_6)) imag(i(vs39_p_7)) imag(i(vs39_p_8)) imag(i(vs39_p_9)) imag(i(vs39_p_10)) imag(i(vs39_p_11)) imag(i(vs39_p_12)) imag(i(vs39_n_0)) imag(i(vs39_n_1)) imag(i(vs39_n_2)) imag(i(vs39_n_3)) imag(i(vs39_n_4)) imag(i(vs39_n_5)) imag(i(vs39_n_6)) imag(i(vs39_n_7)) imag(i(vs39_n_8)) imag(i(vs39_n_9)) imag(i(vs39_n_10)) imag(i(vs39_n_11)) imag(i(vs39_n_12))
wrdata /repo/v2/analog/adc/results/cdac_mc_40.tsv imag(i(vs40_p_0)) imag(i(vs40_p_1)) imag(i(vs40_p_2)) imag(i(vs40_p_3)) imag(i(vs40_p_4)) imag(i(vs40_p_5)) imag(i(vs40_p_6)) imag(i(vs40_p_7)) imag(i(vs40_p_8)) imag(i(vs40_p_9)) imag(i(vs40_p_10)) imag(i(vs40_p_11)) imag(i(vs40_p_12)) imag(i(vs40_n_0)) imag(i(vs40_n_1)) imag(i(vs40_n_2)) imag(i(vs40_n_3)) imag(i(vs40_n_4)) imag(i(vs40_n_5)) imag(i(vs40_n_6)) imag(i(vs40_n_7)) imag(i(vs40_n_8)) imag(i(vs40_n_9)) imag(i(vs40_n_10)) imag(i(vs40_n_11)) imag(i(vs40_n_12))
wrdata /repo/v2/analog/adc/results/cdac_mc_41.tsv imag(i(vs41_p_0)) imag(i(vs41_p_1)) imag(i(vs41_p_2)) imag(i(vs41_p_3)) imag(i(vs41_p_4)) imag(i(vs41_p_5)) imag(i(vs41_p_6)) imag(i(vs41_p_7)) imag(i(vs41_p_8)) imag(i(vs41_p_9)) imag(i(vs41_p_10)) imag(i(vs41_p_11)) imag(i(vs41_p_12)) imag(i(vs41_n_0)) imag(i(vs41_n_1)) imag(i(vs41_n_2)) imag(i(vs41_n_3)) imag(i(vs41_n_4)) imag(i(vs41_n_5)) imag(i(vs41_n_6)) imag(i(vs41_n_7)) imag(i(vs41_n_8)) imag(i(vs41_n_9)) imag(i(vs41_n_10)) imag(i(vs41_n_11)) imag(i(vs41_n_12))
wrdata /repo/v2/analog/adc/results/cdac_mc_42.tsv imag(i(vs42_p_0)) imag(i(vs42_p_1)) imag(i(vs42_p_2)) imag(i(vs42_p_3)) imag(i(vs42_p_4)) imag(i(vs42_p_5)) imag(i(vs42_p_6)) imag(i(vs42_p_7)) imag(i(vs42_p_8)) imag(i(vs42_p_9)) imag(i(vs42_p_10)) imag(i(vs42_p_11)) imag(i(vs42_p_12)) imag(i(vs42_n_0)) imag(i(vs42_n_1)) imag(i(vs42_n_2)) imag(i(vs42_n_3)) imag(i(vs42_n_4)) imag(i(vs42_n_5)) imag(i(vs42_n_6)) imag(i(vs42_n_7)) imag(i(vs42_n_8)) imag(i(vs42_n_9)) imag(i(vs42_n_10)) imag(i(vs42_n_11)) imag(i(vs42_n_12))
wrdata /repo/v2/analog/adc/results/cdac_mc_43.tsv imag(i(vs43_p_0)) imag(i(vs43_p_1)) imag(i(vs43_p_2)) imag(i(vs43_p_3)) imag(i(vs43_p_4)) imag(i(vs43_p_5)) imag(i(vs43_p_6)) imag(i(vs43_p_7)) imag(i(vs43_p_8)) imag(i(vs43_p_9)) imag(i(vs43_p_10)) imag(i(vs43_p_11)) imag(i(vs43_p_12)) imag(i(vs43_n_0)) imag(i(vs43_n_1)) imag(i(vs43_n_2)) imag(i(vs43_n_3)) imag(i(vs43_n_4)) imag(i(vs43_n_5)) imag(i(vs43_n_6)) imag(i(vs43_n_7)) imag(i(vs43_n_8)) imag(i(vs43_n_9)) imag(i(vs43_n_10)) imag(i(vs43_n_11)) imag(i(vs43_n_12))
wrdata /repo/v2/analog/adc/results/cdac_mc_44.tsv imag(i(vs44_p_0)) imag(i(vs44_p_1)) imag(i(vs44_p_2)) imag(i(vs44_p_3)) imag(i(vs44_p_4)) imag(i(vs44_p_5)) imag(i(vs44_p_6)) imag(i(vs44_p_7)) imag(i(vs44_p_8)) imag(i(vs44_p_9)) imag(i(vs44_p_10)) imag(i(vs44_p_11)) imag(i(vs44_p_12)) imag(i(vs44_n_0)) imag(i(vs44_n_1)) imag(i(vs44_n_2)) imag(i(vs44_n_3)) imag(i(vs44_n_4)) imag(i(vs44_n_5)) imag(i(vs44_n_6)) imag(i(vs44_n_7)) imag(i(vs44_n_8)) imag(i(vs44_n_9)) imag(i(vs44_n_10)) imag(i(vs44_n_11)) imag(i(vs44_n_12))
wrdata /repo/v2/analog/adc/results/cdac_mc_45.tsv imag(i(vs45_p_0)) imag(i(vs45_p_1)) imag(i(vs45_p_2)) imag(i(vs45_p_3)) imag(i(vs45_p_4)) imag(i(vs45_p_5)) imag(i(vs45_p_6)) imag(i(vs45_p_7)) imag(i(vs45_p_8)) imag(i(vs45_p_9)) imag(i(vs45_p_10)) imag(i(vs45_p_11)) imag(i(vs45_p_12)) imag(i(vs45_n_0)) imag(i(vs45_n_1)) imag(i(vs45_n_2)) imag(i(vs45_n_3)) imag(i(vs45_n_4)) imag(i(vs45_n_5)) imag(i(vs45_n_6)) imag(i(vs45_n_7)) imag(i(vs45_n_8)) imag(i(vs45_n_9)) imag(i(vs45_n_10)) imag(i(vs45_n_11)) imag(i(vs45_n_12))
wrdata /repo/v2/analog/adc/results/cdac_mc_46.tsv imag(i(vs46_p_0)) imag(i(vs46_p_1)) imag(i(vs46_p_2)) imag(i(vs46_p_3)) imag(i(vs46_p_4)) imag(i(vs46_p_5)) imag(i(vs46_p_6)) imag(i(vs46_p_7)) imag(i(vs46_p_8)) imag(i(vs46_p_9)) imag(i(vs46_p_10)) imag(i(vs46_p_11)) imag(i(vs46_p_12)) imag(i(vs46_n_0)) imag(i(vs46_n_1)) imag(i(vs46_n_2)) imag(i(vs46_n_3)) imag(i(vs46_n_4)) imag(i(vs46_n_5)) imag(i(vs46_n_6)) imag(i(vs46_n_7)) imag(i(vs46_n_8)) imag(i(vs46_n_9)) imag(i(vs46_n_10)) imag(i(vs46_n_11)) imag(i(vs46_n_12))
wrdata /repo/v2/analog/adc/results/cdac_mc_47.tsv imag(i(vs47_p_0)) imag(i(vs47_p_1)) imag(i(vs47_p_2)) imag(i(vs47_p_3)) imag(i(vs47_p_4)) imag(i(vs47_p_5)) imag(i(vs47_p_6)) imag(i(vs47_p_7)) imag(i(vs47_p_8)) imag(i(vs47_p_9)) imag(i(vs47_p_10)) imag(i(vs47_p_11)) imag(i(vs47_p_12)) imag(i(vs47_n_0)) imag(i(vs47_n_1)) imag(i(vs47_n_2)) imag(i(vs47_n_3)) imag(i(vs47_n_4)) imag(i(vs47_n_5)) imag(i(vs47_n_6)) imag(i(vs47_n_7)) imag(i(vs47_n_8)) imag(i(vs47_n_9)) imag(i(vs47_n_10)) imag(i(vs47_n_11)) imag(i(vs47_n_12))
wrdata /repo/v2/analog/adc/results/cdac_mc_48.tsv imag(i(vs48_p_0)) imag(i(vs48_p_1)) imag(i(vs48_p_2)) imag(i(vs48_p_3)) imag(i(vs48_p_4)) imag(i(vs48_p_5)) imag(i(vs48_p_6)) imag(i(vs48_p_7)) imag(i(vs48_p_8)) imag(i(vs48_p_9)) imag(i(vs48_p_10)) imag(i(vs48_p_11)) imag(i(vs48_p_12)) imag(i(vs48_n_0)) imag(i(vs48_n_1)) imag(i(vs48_n_2)) imag(i(vs48_n_3)) imag(i(vs48_n_4)) imag(i(vs48_n_5)) imag(i(vs48_n_6)) imag(i(vs48_n_7)) imag(i(vs48_n_8)) imag(i(vs48_n_9)) imag(i(vs48_n_10)) imag(i(vs48_n_11)) imag(i(vs48_n_12))
wrdata /repo/v2/analog/adc/results/cdac_mc_49.tsv imag(i(vs49_p_0)) imag(i(vs49_p_1)) imag(i(vs49_p_2)) imag(i(vs49_p_3)) imag(i(vs49_p_4)) imag(i(vs49_p_5)) imag(i(vs49_p_6)) imag(i(vs49_p_7)) imag(i(vs49_p_8)) imag(i(vs49_p_9)) imag(i(vs49_p_10)) imag(i(vs49_p_11)) imag(i(vs49_p_12)) imag(i(vs49_n_0)) imag(i(vs49_n_1)) imag(i(vs49_n_2)) imag(i(vs49_n_3)) imag(i(vs49_n_4)) imag(i(vs49_n_5)) imag(i(vs49_n_6)) imag(i(vs49_n_7)) imag(i(vs49_n_8)) imag(i(vs49_n_9)) imag(i(vs49_n_10)) imag(i(vs49_n_11)) imag(i(vs49_n_12))
wrdata /repo/v2/analog/adc/results/cdac_mc_50.tsv imag(i(vs50_p_0)) imag(i(vs50_p_1)) imag(i(vs50_p_2)) imag(i(vs50_p_3)) imag(i(vs50_p_4)) imag(i(vs50_p_5)) imag(i(vs50_p_6)) imag(i(vs50_p_7)) imag(i(vs50_p_8)) imag(i(vs50_p_9)) imag(i(vs50_p_10)) imag(i(vs50_p_11)) imag(i(vs50_p_12)) imag(i(vs50_n_0)) imag(i(vs50_n_1)) imag(i(vs50_n_2)) imag(i(vs50_n_3)) imag(i(vs50_n_4)) imag(i(vs50_n_5)) imag(i(vs50_n_6)) imag(i(vs50_n_7)) imag(i(vs50_n_8)) imag(i(vs50_n_9)) imag(i(vs50_n_10)) imag(i(vs50_n_11)) imag(i(vs50_n_12))
wrdata /repo/v2/analog/adc/results/cdac_mc_51.tsv imag(i(vs51_p_0)) imag(i(vs51_p_1)) imag(i(vs51_p_2)) imag(i(vs51_p_3)) imag(i(vs51_p_4)) imag(i(vs51_p_5)) imag(i(vs51_p_6)) imag(i(vs51_p_7)) imag(i(vs51_p_8)) imag(i(vs51_p_9)) imag(i(vs51_p_10)) imag(i(vs51_p_11)) imag(i(vs51_p_12)) imag(i(vs51_n_0)) imag(i(vs51_n_1)) imag(i(vs51_n_2)) imag(i(vs51_n_3)) imag(i(vs51_n_4)) imag(i(vs51_n_5)) imag(i(vs51_n_6)) imag(i(vs51_n_7)) imag(i(vs51_n_8)) imag(i(vs51_n_9)) imag(i(vs51_n_10)) imag(i(vs51_n_11)) imag(i(vs51_n_12))
wrdata /repo/v2/analog/adc/results/cdac_mc_52.tsv imag(i(vs52_p_0)) imag(i(vs52_p_1)) imag(i(vs52_p_2)) imag(i(vs52_p_3)) imag(i(vs52_p_4)) imag(i(vs52_p_5)) imag(i(vs52_p_6)) imag(i(vs52_p_7)) imag(i(vs52_p_8)) imag(i(vs52_p_9)) imag(i(vs52_p_10)) imag(i(vs52_p_11)) imag(i(vs52_p_12)) imag(i(vs52_n_0)) imag(i(vs52_n_1)) imag(i(vs52_n_2)) imag(i(vs52_n_3)) imag(i(vs52_n_4)) imag(i(vs52_n_5)) imag(i(vs52_n_6)) imag(i(vs52_n_7)) imag(i(vs52_n_8)) imag(i(vs52_n_9)) imag(i(vs52_n_10)) imag(i(vs52_n_11)) imag(i(vs52_n_12))
wrdata /repo/v2/analog/adc/results/cdac_mc_53.tsv imag(i(vs53_p_0)) imag(i(vs53_p_1)) imag(i(vs53_p_2)) imag(i(vs53_p_3)) imag(i(vs53_p_4)) imag(i(vs53_p_5)) imag(i(vs53_p_6)) imag(i(vs53_p_7)) imag(i(vs53_p_8)) imag(i(vs53_p_9)) imag(i(vs53_p_10)) imag(i(vs53_p_11)) imag(i(vs53_p_12)) imag(i(vs53_n_0)) imag(i(vs53_n_1)) imag(i(vs53_n_2)) imag(i(vs53_n_3)) imag(i(vs53_n_4)) imag(i(vs53_n_5)) imag(i(vs53_n_6)) imag(i(vs53_n_7)) imag(i(vs53_n_8)) imag(i(vs53_n_9)) imag(i(vs53_n_10)) imag(i(vs53_n_11)) imag(i(vs53_n_12))
wrdata /repo/v2/analog/adc/results/cdac_mc_54.tsv imag(i(vs54_p_0)) imag(i(vs54_p_1)) imag(i(vs54_p_2)) imag(i(vs54_p_3)) imag(i(vs54_p_4)) imag(i(vs54_p_5)) imag(i(vs54_p_6)) imag(i(vs54_p_7)) imag(i(vs54_p_8)) imag(i(vs54_p_9)) imag(i(vs54_p_10)) imag(i(vs54_p_11)) imag(i(vs54_p_12)) imag(i(vs54_n_0)) imag(i(vs54_n_1)) imag(i(vs54_n_2)) imag(i(vs54_n_3)) imag(i(vs54_n_4)) imag(i(vs54_n_5)) imag(i(vs54_n_6)) imag(i(vs54_n_7)) imag(i(vs54_n_8)) imag(i(vs54_n_9)) imag(i(vs54_n_10)) imag(i(vs54_n_11)) imag(i(vs54_n_12))
wrdata /repo/v2/analog/adc/results/cdac_mc_55.tsv imag(i(vs55_p_0)) imag(i(vs55_p_1)) imag(i(vs55_p_2)) imag(i(vs55_p_3)) imag(i(vs55_p_4)) imag(i(vs55_p_5)) imag(i(vs55_p_6)) imag(i(vs55_p_7)) imag(i(vs55_p_8)) imag(i(vs55_p_9)) imag(i(vs55_p_10)) imag(i(vs55_p_11)) imag(i(vs55_p_12)) imag(i(vs55_n_0)) imag(i(vs55_n_1)) imag(i(vs55_n_2)) imag(i(vs55_n_3)) imag(i(vs55_n_4)) imag(i(vs55_n_5)) imag(i(vs55_n_6)) imag(i(vs55_n_7)) imag(i(vs55_n_8)) imag(i(vs55_n_9)) imag(i(vs55_n_10)) imag(i(vs55_n_11)) imag(i(vs55_n_12))
wrdata /repo/v2/analog/adc/results/cdac_mc_56.tsv imag(i(vs56_p_0)) imag(i(vs56_p_1)) imag(i(vs56_p_2)) imag(i(vs56_p_3)) imag(i(vs56_p_4)) imag(i(vs56_p_5)) imag(i(vs56_p_6)) imag(i(vs56_p_7)) imag(i(vs56_p_8)) imag(i(vs56_p_9)) imag(i(vs56_p_10)) imag(i(vs56_p_11)) imag(i(vs56_p_12)) imag(i(vs56_n_0)) imag(i(vs56_n_1)) imag(i(vs56_n_2)) imag(i(vs56_n_3)) imag(i(vs56_n_4)) imag(i(vs56_n_5)) imag(i(vs56_n_6)) imag(i(vs56_n_7)) imag(i(vs56_n_8)) imag(i(vs56_n_9)) imag(i(vs56_n_10)) imag(i(vs56_n_11)) imag(i(vs56_n_12))
wrdata /repo/v2/analog/adc/results/cdac_mc_57.tsv imag(i(vs57_p_0)) imag(i(vs57_p_1)) imag(i(vs57_p_2)) imag(i(vs57_p_3)) imag(i(vs57_p_4)) imag(i(vs57_p_5)) imag(i(vs57_p_6)) imag(i(vs57_p_7)) imag(i(vs57_p_8)) imag(i(vs57_p_9)) imag(i(vs57_p_10)) imag(i(vs57_p_11)) imag(i(vs57_p_12)) imag(i(vs57_n_0)) imag(i(vs57_n_1)) imag(i(vs57_n_2)) imag(i(vs57_n_3)) imag(i(vs57_n_4)) imag(i(vs57_n_5)) imag(i(vs57_n_6)) imag(i(vs57_n_7)) imag(i(vs57_n_8)) imag(i(vs57_n_9)) imag(i(vs57_n_10)) imag(i(vs57_n_11)) imag(i(vs57_n_12))
wrdata /repo/v2/analog/adc/results/cdac_mc_58.tsv imag(i(vs58_p_0)) imag(i(vs58_p_1)) imag(i(vs58_p_2)) imag(i(vs58_p_3)) imag(i(vs58_p_4)) imag(i(vs58_p_5)) imag(i(vs58_p_6)) imag(i(vs58_p_7)) imag(i(vs58_p_8)) imag(i(vs58_p_9)) imag(i(vs58_p_10)) imag(i(vs58_p_11)) imag(i(vs58_p_12)) imag(i(vs58_n_0)) imag(i(vs58_n_1)) imag(i(vs58_n_2)) imag(i(vs58_n_3)) imag(i(vs58_n_4)) imag(i(vs58_n_5)) imag(i(vs58_n_6)) imag(i(vs58_n_7)) imag(i(vs58_n_8)) imag(i(vs58_n_9)) imag(i(vs58_n_10)) imag(i(vs58_n_11)) imag(i(vs58_n_12))
wrdata /repo/v2/analog/adc/results/cdac_mc_59.tsv imag(i(vs59_p_0)) imag(i(vs59_p_1)) imag(i(vs59_p_2)) imag(i(vs59_p_3)) imag(i(vs59_p_4)) imag(i(vs59_p_5)) imag(i(vs59_p_6)) imag(i(vs59_p_7)) imag(i(vs59_p_8)) imag(i(vs59_p_9)) imag(i(vs59_p_10)) imag(i(vs59_p_11)) imag(i(vs59_p_12)) imag(i(vs59_n_0)) imag(i(vs59_n_1)) imag(i(vs59_n_2)) imag(i(vs59_n_3)) imag(i(vs59_n_4)) imag(i(vs59_n_5)) imag(i(vs59_n_6)) imag(i(vs59_n_7)) imag(i(vs59_n_8)) imag(i(vs59_n_9)) imag(i(vs59_n_10)) imag(i(vs59_n_11)) imag(i(vs59_n_12))
wrdata /repo/v2/analog/adc/results/cdac_mc_60.tsv imag(i(vs60_p_0)) imag(i(vs60_p_1)) imag(i(vs60_p_2)) imag(i(vs60_p_3)) imag(i(vs60_p_4)) imag(i(vs60_p_5)) imag(i(vs60_p_6)) imag(i(vs60_p_7)) imag(i(vs60_p_8)) imag(i(vs60_p_9)) imag(i(vs60_p_10)) imag(i(vs60_p_11)) imag(i(vs60_p_12)) imag(i(vs60_n_0)) imag(i(vs60_n_1)) imag(i(vs60_n_2)) imag(i(vs60_n_3)) imag(i(vs60_n_4)) imag(i(vs60_n_5)) imag(i(vs60_n_6)) imag(i(vs60_n_7)) imag(i(vs60_n_8)) imag(i(vs60_n_9)) imag(i(vs60_n_10)) imag(i(vs60_n_11)) imag(i(vs60_n_12))
wrdata /repo/v2/analog/adc/results/cdac_mc_61.tsv imag(i(vs61_p_0)) imag(i(vs61_p_1)) imag(i(vs61_p_2)) imag(i(vs61_p_3)) imag(i(vs61_p_4)) imag(i(vs61_p_5)) imag(i(vs61_p_6)) imag(i(vs61_p_7)) imag(i(vs61_p_8)) imag(i(vs61_p_9)) imag(i(vs61_p_10)) imag(i(vs61_p_11)) imag(i(vs61_p_12)) imag(i(vs61_n_0)) imag(i(vs61_n_1)) imag(i(vs61_n_2)) imag(i(vs61_n_3)) imag(i(vs61_n_4)) imag(i(vs61_n_5)) imag(i(vs61_n_6)) imag(i(vs61_n_7)) imag(i(vs61_n_8)) imag(i(vs61_n_9)) imag(i(vs61_n_10)) imag(i(vs61_n_11)) imag(i(vs61_n_12))
wrdata /repo/v2/analog/adc/results/cdac_mc_62.tsv imag(i(vs62_p_0)) imag(i(vs62_p_1)) imag(i(vs62_p_2)) imag(i(vs62_p_3)) imag(i(vs62_p_4)) imag(i(vs62_p_5)) imag(i(vs62_p_6)) imag(i(vs62_p_7)) imag(i(vs62_p_8)) imag(i(vs62_p_9)) imag(i(vs62_p_10)) imag(i(vs62_p_11)) imag(i(vs62_p_12)) imag(i(vs62_n_0)) imag(i(vs62_n_1)) imag(i(vs62_n_2)) imag(i(vs62_n_3)) imag(i(vs62_n_4)) imag(i(vs62_n_5)) imag(i(vs62_n_6)) imag(i(vs62_n_7)) imag(i(vs62_n_8)) imag(i(vs62_n_9)) imag(i(vs62_n_10)) imag(i(vs62_n_11)) imag(i(vs62_n_12))
wrdata /repo/v2/analog/adc/results/cdac_mc_63.tsv imag(i(vs63_p_0)) imag(i(vs63_p_1)) imag(i(vs63_p_2)) imag(i(vs63_p_3)) imag(i(vs63_p_4)) imag(i(vs63_p_5)) imag(i(vs63_p_6)) imag(i(vs63_p_7)) imag(i(vs63_p_8)) imag(i(vs63_p_9)) imag(i(vs63_p_10)) imag(i(vs63_p_11)) imag(i(vs63_p_12)) imag(i(vs63_n_0)) imag(i(vs63_n_1)) imag(i(vs63_n_2)) imag(i(vs63_n_3)) imag(i(vs63_n_4)) imag(i(vs63_n_5)) imag(i(vs63_n_6)) imag(i(vs63_n_7)) imag(i(vs63_n_8)) imag(i(vs63_n_9)) imag(i(vs63_n_10)) imag(i(vs63_n_11)) imag(i(vs63_n_12))
wrdata /repo/v2/analog/adc/results/cdac_mc_64.tsv imag(i(vs64_p_0)) imag(i(vs64_p_1)) imag(i(vs64_p_2)) imag(i(vs64_p_3)) imag(i(vs64_p_4)) imag(i(vs64_p_5)) imag(i(vs64_p_6)) imag(i(vs64_p_7)) imag(i(vs64_p_8)) imag(i(vs64_p_9)) imag(i(vs64_p_10)) imag(i(vs64_p_11)) imag(i(vs64_p_12)) imag(i(vs64_n_0)) imag(i(vs64_n_1)) imag(i(vs64_n_2)) imag(i(vs64_n_3)) imag(i(vs64_n_4)) imag(i(vs64_n_5)) imag(i(vs64_n_6)) imag(i(vs64_n_7)) imag(i(vs64_n_8)) imag(i(vs64_n_9)) imag(i(vs64_n_10)) imag(i(vs64_n_11)) imag(i(vs64_n_12))
wrdata /repo/v2/analog/adc/results/cdac_mc_65.tsv imag(i(vs65_p_0)) imag(i(vs65_p_1)) imag(i(vs65_p_2)) imag(i(vs65_p_3)) imag(i(vs65_p_4)) imag(i(vs65_p_5)) imag(i(vs65_p_6)) imag(i(vs65_p_7)) imag(i(vs65_p_8)) imag(i(vs65_p_9)) imag(i(vs65_p_10)) imag(i(vs65_p_11)) imag(i(vs65_p_12)) imag(i(vs65_n_0)) imag(i(vs65_n_1)) imag(i(vs65_n_2)) imag(i(vs65_n_3)) imag(i(vs65_n_4)) imag(i(vs65_n_5)) imag(i(vs65_n_6)) imag(i(vs65_n_7)) imag(i(vs65_n_8)) imag(i(vs65_n_9)) imag(i(vs65_n_10)) imag(i(vs65_n_11)) imag(i(vs65_n_12))
wrdata /repo/v2/analog/adc/results/cdac_mc_66.tsv imag(i(vs66_p_0)) imag(i(vs66_p_1)) imag(i(vs66_p_2)) imag(i(vs66_p_3)) imag(i(vs66_p_4)) imag(i(vs66_p_5)) imag(i(vs66_p_6)) imag(i(vs66_p_7)) imag(i(vs66_p_8)) imag(i(vs66_p_9)) imag(i(vs66_p_10)) imag(i(vs66_p_11)) imag(i(vs66_p_12)) imag(i(vs66_n_0)) imag(i(vs66_n_1)) imag(i(vs66_n_2)) imag(i(vs66_n_3)) imag(i(vs66_n_4)) imag(i(vs66_n_5)) imag(i(vs66_n_6)) imag(i(vs66_n_7)) imag(i(vs66_n_8)) imag(i(vs66_n_9)) imag(i(vs66_n_10)) imag(i(vs66_n_11)) imag(i(vs66_n_12))
wrdata /repo/v2/analog/adc/results/cdac_mc_67.tsv imag(i(vs67_p_0)) imag(i(vs67_p_1)) imag(i(vs67_p_2)) imag(i(vs67_p_3)) imag(i(vs67_p_4)) imag(i(vs67_p_5)) imag(i(vs67_p_6)) imag(i(vs67_p_7)) imag(i(vs67_p_8)) imag(i(vs67_p_9)) imag(i(vs67_p_10)) imag(i(vs67_p_11)) imag(i(vs67_p_12)) imag(i(vs67_n_0)) imag(i(vs67_n_1)) imag(i(vs67_n_2)) imag(i(vs67_n_3)) imag(i(vs67_n_4)) imag(i(vs67_n_5)) imag(i(vs67_n_6)) imag(i(vs67_n_7)) imag(i(vs67_n_8)) imag(i(vs67_n_9)) imag(i(vs67_n_10)) imag(i(vs67_n_11)) imag(i(vs67_n_12))
wrdata /repo/v2/analog/adc/results/cdac_mc_68.tsv imag(i(vs68_p_0)) imag(i(vs68_p_1)) imag(i(vs68_p_2)) imag(i(vs68_p_3)) imag(i(vs68_p_4)) imag(i(vs68_p_5)) imag(i(vs68_p_6)) imag(i(vs68_p_7)) imag(i(vs68_p_8)) imag(i(vs68_p_9)) imag(i(vs68_p_10)) imag(i(vs68_p_11)) imag(i(vs68_p_12)) imag(i(vs68_n_0)) imag(i(vs68_n_1)) imag(i(vs68_n_2)) imag(i(vs68_n_3)) imag(i(vs68_n_4)) imag(i(vs68_n_5)) imag(i(vs68_n_6)) imag(i(vs68_n_7)) imag(i(vs68_n_8)) imag(i(vs68_n_9)) imag(i(vs68_n_10)) imag(i(vs68_n_11)) imag(i(vs68_n_12))
wrdata /repo/v2/analog/adc/results/cdac_mc_69.tsv imag(i(vs69_p_0)) imag(i(vs69_p_1)) imag(i(vs69_p_2)) imag(i(vs69_p_3)) imag(i(vs69_p_4)) imag(i(vs69_p_5)) imag(i(vs69_p_6)) imag(i(vs69_p_7)) imag(i(vs69_p_8)) imag(i(vs69_p_9)) imag(i(vs69_p_10)) imag(i(vs69_p_11)) imag(i(vs69_p_12)) imag(i(vs69_n_0)) imag(i(vs69_n_1)) imag(i(vs69_n_2)) imag(i(vs69_n_3)) imag(i(vs69_n_4)) imag(i(vs69_n_5)) imag(i(vs69_n_6)) imag(i(vs69_n_7)) imag(i(vs69_n_8)) imag(i(vs69_n_9)) imag(i(vs69_n_10)) imag(i(vs69_n_11)) imag(i(vs69_n_12))
wrdata /repo/v2/analog/adc/results/cdac_mc_70.tsv imag(i(vs70_p_0)) imag(i(vs70_p_1)) imag(i(vs70_p_2)) imag(i(vs70_p_3)) imag(i(vs70_p_4)) imag(i(vs70_p_5)) imag(i(vs70_p_6)) imag(i(vs70_p_7)) imag(i(vs70_p_8)) imag(i(vs70_p_9)) imag(i(vs70_p_10)) imag(i(vs70_p_11)) imag(i(vs70_p_12)) imag(i(vs70_n_0)) imag(i(vs70_n_1)) imag(i(vs70_n_2)) imag(i(vs70_n_3)) imag(i(vs70_n_4)) imag(i(vs70_n_5)) imag(i(vs70_n_6)) imag(i(vs70_n_7)) imag(i(vs70_n_8)) imag(i(vs70_n_9)) imag(i(vs70_n_10)) imag(i(vs70_n_11)) imag(i(vs70_n_12))
wrdata /repo/v2/analog/adc/results/cdac_mc_71.tsv imag(i(vs71_p_0)) imag(i(vs71_p_1)) imag(i(vs71_p_2)) imag(i(vs71_p_3)) imag(i(vs71_p_4)) imag(i(vs71_p_5)) imag(i(vs71_p_6)) imag(i(vs71_p_7)) imag(i(vs71_p_8)) imag(i(vs71_p_9)) imag(i(vs71_p_10)) imag(i(vs71_p_11)) imag(i(vs71_p_12)) imag(i(vs71_n_0)) imag(i(vs71_n_1)) imag(i(vs71_n_2)) imag(i(vs71_n_3)) imag(i(vs71_n_4)) imag(i(vs71_n_5)) imag(i(vs71_n_6)) imag(i(vs71_n_7)) imag(i(vs71_n_8)) imag(i(vs71_n_9)) imag(i(vs71_n_10)) imag(i(vs71_n_11)) imag(i(vs71_n_12))
wrdata /repo/v2/analog/adc/results/cdac_mc_72.tsv imag(i(vs72_p_0)) imag(i(vs72_p_1)) imag(i(vs72_p_2)) imag(i(vs72_p_3)) imag(i(vs72_p_4)) imag(i(vs72_p_5)) imag(i(vs72_p_6)) imag(i(vs72_p_7)) imag(i(vs72_p_8)) imag(i(vs72_p_9)) imag(i(vs72_p_10)) imag(i(vs72_p_11)) imag(i(vs72_p_12)) imag(i(vs72_n_0)) imag(i(vs72_n_1)) imag(i(vs72_n_2)) imag(i(vs72_n_3)) imag(i(vs72_n_4)) imag(i(vs72_n_5)) imag(i(vs72_n_6)) imag(i(vs72_n_7)) imag(i(vs72_n_8)) imag(i(vs72_n_9)) imag(i(vs72_n_10)) imag(i(vs72_n_11)) imag(i(vs72_n_12))
wrdata /repo/v2/analog/adc/results/cdac_mc_73.tsv imag(i(vs73_p_0)) imag(i(vs73_p_1)) imag(i(vs73_p_2)) imag(i(vs73_p_3)) imag(i(vs73_p_4)) imag(i(vs73_p_5)) imag(i(vs73_p_6)) imag(i(vs73_p_7)) imag(i(vs73_p_8)) imag(i(vs73_p_9)) imag(i(vs73_p_10)) imag(i(vs73_p_11)) imag(i(vs73_p_12)) imag(i(vs73_n_0)) imag(i(vs73_n_1)) imag(i(vs73_n_2)) imag(i(vs73_n_3)) imag(i(vs73_n_4)) imag(i(vs73_n_5)) imag(i(vs73_n_6)) imag(i(vs73_n_7)) imag(i(vs73_n_8)) imag(i(vs73_n_9)) imag(i(vs73_n_10)) imag(i(vs73_n_11)) imag(i(vs73_n_12))
wrdata /repo/v2/analog/adc/results/cdac_mc_74.tsv imag(i(vs74_p_0)) imag(i(vs74_p_1)) imag(i(vs74_p_2)) imag(i(vs74_p_3)) imag(i(vs74_p_4)) imag(i(vs74_p_5)) imag(i(vs74_p_6)) imag(i(vs74_p_7)) imag(i(vs74_p_8)) imag(i(vs74_p_9)) imag(i(vs74_p_10)) imag(i(vs74_p_11)) imag(i(vs74_p_12)) imag(i(vs74_n_0)) imag(i(vs74_n_1)) imag(i(vs74_n_2)) imag(i(vs74_n_3)) imag(i(vs74_n_4)) imag(i(vs74_n_5)) imag(i(vs74_n_6)) imag(i(vs74_n_7)) imag(i(vs74_n_8)) imag(i(vs74_n_9)) imag(i(vs74_n_10)) imag(i(vs74_n_11)) imag(i(vs74_n_12))
wrdata /repo/v2/analog/adc/results/cdac_mc_75.tsv imag(i(vs75_p_0)) imag(i(vs75_p_1)) imag(i(vs75_p_2)) imag(i(vs75_p_3)) imag(i(vs75_p_4)) imag(i(vs75_p_5)) imag(i(vs75_p_6)) imag(i(vs75_p_7)) imag(i(vs75_p_8)) imag(i(vs75_p_9)) imag(i(vs75_p_10)) imag(i(vs75_p_11)) imag(i(vs75_p_12)) imag(i(vs75_n_0)) imag(i(vs75_n_1)) imag(i(vs75_n_2)) imag(i(vs75_n_3)) imag(i(vs75_n_4)) imag(i(vs75_n_5)) imag(i(vs75_n_6)) imag(i(vs75_n_7)) imag(i(vs75_n_8)) imag(i(vs75_n_9)) imag(i(vs75_n_10)) imag(i(vs75_n_11)) imag(i(vs75_n_12))
wrdata /repo/v2/analog/adc/results/cdac_mc_76.tsv imag(i(vs76_p_0)) imag(i(vs76_p_1)) imag(i(vs76_p_2)) imag(i(vs76_p_3)) imag(i(vs76_p_4)) imag(i(vs76_p_5)) imag(i(vs76_p_6)) imag(i(vs76_p_7)) imag(i(vs76_p_8)) imag(i(vs76_p_9)) imag(i(vs76_p_10)) imag(i(vs76_p_11)) imag(i(vs76_p_12)) imag(i(vs76_n_0)) imag(i(vs76_n_1)) imag(i(vs76_n_2)) imag(i(vs76_n_3)) imag(i(vs76_n_4)) imag(i(vs76_n_5)) imag(i(vs76_n_6)) imag(i(vs76_n_7)) imag(i(vs76_n_8)) imag(i(vs76_n_9)) imag(i(vs76_n_10)) imag(i(vs76_n_11)) imag(i(vs76_n_12))
wrdata /repo/v2/analog/adc/results/cdac_mc_77.tsv imag(i(vs77_p_0)) imag(i(vs77_p_1)) imag(i(vs77_p_2)) imag(i(vs77_p_3)) imag(i(vs77_p_4)) imag(i(vs77_p_5)) imag(i(vs77_p_6)) imag(i(vs77_p_7)) imag(i(vs77_p_8)) imag(i(vs77_p_9)) imag(i(vs77_p_10)) imag(i(vs77_p_11)) imag(i(vs77_p_12)) imag(i(vs77_n_0)) imag(i(vs77_n_1)) imag(i(vs77_n_2)) imag(i(vs77_n_3)) imag(i(vs77_n_4)) imag(i(vs77_n_5)) imag(i(vs77_n_6)) imag(i(vs77_n_7)) imag(i(vs77_n_8)) imag(i(vs77_n_9)) imag(i(vs77_n_10)) imag(i(vs77_n_11)) imag(i(vs77_n_12))
wrdata /repo/v2/analog/adc/results/cdac_mc_78.tsv imag(i(vs78_p_0)) imag(i(vs78_p_1)) imag(i(vs78_p_2)) imag(i(vs78_p_3)) imag(i(vs78_p_4)) imag(i(vs78_p_5)) imag(i(vs78_p_6)) imag(i(vs78_p_7)) imag(i(vs78_p_8)) imag(i(vs78_p_9)) imag(i(vs78_p_10)) imag(i(vs78_p_11)) imag(i(vs78_p_12)) imag(i(vs78_n_0)) imag(i(vs78_n_1)) imag(i(vs78_n_2)) imag(i(vs78_n_3)) imag(i(vs78_n_4)) imag(i(vs78_n_5)) imag(i(vs78_n_6)) imag(i(vs78_n_7)) imag(i(vs78_n_8)) imag(i(vs78_n_9)) imag(i(vs78_n_10)) imag(i(vs78_n_11)) imag(i(vs78_n_12))
wrdata /repo/v2/analog/adc/results/cdac_mc_79.tsv imag(i(vs79_p_0)) imag(i(vs79_p_1)) imag(i(vs79_p_2)) imag(i(vs79_p_3)) imag(i(vs79_p_4)) imag(i(vs79_p_5)) imag(i(vs79_p_6)) imag(i(vs79_p_7)) imag(i(vs79_p_8)) imag(i(vs79_p_9)) imag(i(vs79_p_10)) imag(i(vs79_p_11)) imag(i(vs79_p_12)) imag(i(vs79_n_0)) imag(i(vs79_n_1)) imag(i(vs79_n_2)) imag(i(vs79_n_3)) imag(i(vs79_n_4)) imag(i(vs79_n_5)) imag(i(vs79_n_6)) imag(i(vs79_n_7)) imag(i(vs79_n_8)) imag(i(vs79_n_9)) imag(i(vs79_n_10)) imag(i(vs79_n_11)) imag(i(vs79_n_12))
wrdata /repo/v2/analog/adc/results/cdac_mc_80.tsv imag(i(vs80_p_0)) imag(i(vs80_p_1)) imag(i(vs80_p_2)) imag(i(vs80_p_3)) imag(i(vs80_p_4)) imag(i(vs80_p_5)) imag(i(vs80_p_6)) imag(i(vs80_p_7)) imag(i(vs80_p_8)) imag(i(vs80_p_9)) imag(i(vs80_p_10)) imag(i(vs80_p_11)) imag(i(vs80_p_12)) imag(i(vs80_n_0)) imag(i(vs80_n_1)) imag(i(vs80_n_2)) imag(i(vs80_n_3)) imag(i(vs80_n_4)) imag(i(vs80_n_5)) imag(i(vs80_n_6)) imag(i(vs80_n_7)) imag(i(vs80_n_8)) imag(i(vs80_n_9)) imag(i(vs80_n_10)) imag(i(vs80_n_11)) imag(i(vs80_n_12))
wrdata /repo/v2/analog/adc/results/cdac_mc_81.tsv imag(i(vs81_p_0)) imag(i(vs81_p_1)) imag(i(vs81_p_2)) imag(i(vs81_p_3)) imag(i(vs81_p_4)) imag(i(vs81_p_5)) imag(i(vs81_p_6)) imag(i(vs81_p_7)) imag(i(vs81_p_8)) imag(i(vs81_p_9)) imag(i(vs81_p_10)) imag(i(vs81_p_11)) imag(i(vs81_p_12)) imag(i(vs81_n_0)) imag(i(vs81_n_1)) imag(i(vs81_n_2)) imag(i(vs81_n_3)) imag(i(vs81_n_4)) imag(i(vs81_n_5)) imag(i(vs81_n_6)) imag(i(vs81_n_7)) imag(i(vs81_n_8)) imag(i(vs81_n_9)) imag(i(vs81_n_10)) imag(i(vs81_n_11)) imag(i(vs81_n_12))
wrdata /repo/v2/analog/adc/results/cdac_mc_82.tsv imag(i(vs82_p_0)) imag(i(vs82_p_1)) imag(i(vs82_p_2)) imag(i(vs82_p_3)) imag(i(vs82_p_4)) imag(i(vs82_p_5)) imag(i(vs82_p_6)) imag(i(vs82_p_7)) imag(i(vs82_p_8)) imag(i(vs82_p_9)) imag(i(vs82_p_10)) imag(i(vs82_p_11)) imag(i(vs82_p_12)) imag(i(vs82_n_0)) imag(i(vs82_n_1)) imag(i(vs82_n_2)) imag(i(vs82_n_3)) imag(i(vs82_n_4)) imag(i(vs82_n_5)) imag(i(vs82_n_6)) imag(i(vs82_n_7)) imag(i(vs82_n_8)) imag(i(vs82_n_9)) imag(i(vs82_n_10)) imag(i(vs82_n_11)) imag(i(vs82_n_12))
wrdata /repo/v2/analog/adc/results/cdac_mc_83.tsv imag(i(vs83_p_0)) imag(i(vs83_p_1)) imag(i(vs83_p_2)) imag(i(vs83_p_3)) imag(i(vs83_p_4)) imag(i(vs83_p_5)) imag(i(vs83_p_6)) imag(i(vs83_p_7)) imag(i(vs83_p_8)) imag(i(vs83_p_9)) imag(i(vs83_p_10)) imag(i(vs83_p_11)) imag(i(vs83_p_12)) imag(i(vs83_n_0)) imag(i(vs83_n_1)) imag(i(vs83_n_2)) imag(i(vs83_n_3)) imag(i(vs83_n_4)) imag(i(vs83_n_5)) imag(i(vs83_n_6)) imag(i(vs83_n_7)) imag(i(vs83_n_8)) imag(i(vs83_n_9)) imag(i(vs83_n_10)) imag(i(vs83_n_11)) imag(i(vs83_n_12))
wrdata /repo/v2/analog/adc/results/cdac_mc_84.tsv imag(i(vs84_p_0)) imag(i(vs84_p_1)) imag(i(vs84_p_2)) imag(i(vs84_p_3)) imag(i(vs84_p_4)) imag(i(vs84_p_5)) imag(i(vs84_p_6)) imag(i(vs84_p_7)) imag(i(vs84_p_8)) imag(i(vs84_p_9)) imag(i(vs84_p_10)) imag(i(vs84_p_11)) imag(i(vs84_p_12)) imag(i(vs84_n_0)) imag(i(vs84_n_1)) imag(i(vs84_n_2)) imag(i(vs84_n_3)) imag(i(vs84_n_4)) imag(i(vs84_n_5)) imag(i(vs84_n_6)) imag(i(vs84_n_7)) imag(i(vs84_n_8)) imag(i(vs84_n_9)) imag(i(vs84_n_10)) imag(i(vs84_n_11)) imag(i(vs84_n_12))
wrdata /repo/v2/analog/adc/results/cdac_mc_85.tsv imag(i(vs85_p_0)) imag(i(vs85_p_1)) imag(i(vs85_p_2)) imag(i(vs85_p_3)) imag(i(vs85_p_4)) imag(i(vs85_p_5)) imag(i(vs85_p_6)) imag(i(vs85_p_7)) imag(i(vs85_p_8)) imag(i(vs85_p_9)) imag(i(vs85_p_10)) imag(i(vs85_p_11)) imag(i(vs85_p_12)) imag(i(vs85_n_0)) imag(i(vs85_n_1)) imag(i(vs85_n_2)) imag(i(vs85_n_3)) imag(i(vs85_n_4)) imag(i(vs85_n_5)) imag(i(vs85_n_6)) imag(i(vs85_n_7)) imag(i(vs85_n_8)) imag(i(vs85_n_9)) imag(i(vs85_n_10)) imag(i(vs85_n_11)) imag(i(vs85_n_12))
wrdata /repo/v2/analog/adc/results/cdac_mc_86.tsv imag(i(vs86_p_0)) imag(i(vs86_p_1)) imag(i(vs86_p_2)) imag(i(vs86_p_3)) imag(i(vs86_p_4)) imag(i(vs86_p_5)) imag(i(vs86_p_6)) imag(i(vs86_p_7)) imag(i(vs86_p_8)) imag(i(vs86_p_9)) imag(i(vs86_p_10)) imag(i(vs86_p_11)) imag(i(vs86_p_12)) imag(i(vs86_n_0)) imag(i(vs86_n_1)) imag(i(vs86_n_2)) imag(i(vs86_n_3)) imag(i(vs86_n_4)) imag(i(vs86_n_5)) imag(i(vs86_n_6)) imag(i(vs86_n_7)) imag(i(vs86_n_8)) imag(i(vs86_n_9)) imag(i(vs86_n_10)) imag(i(vs86_n_11)) imag(i(vs86_n_12))
wrdata /repo/v2/analog/adc/results/cdac_mc_87.tsv imag(i(vs87_p_0)) imag(i(vs87_p_1)) imag(i(vs87_p_2)) imag(i(vs87_p_3)) imag(i(vs87_p_4)) imag(i(vs87_p_5)) imag(i(vs87_p_6)) imag(i(vs87_p_7)) imag(i(vs87_p_8)) imag(i(vs87_p_9)) imag(i(vs87_p_10)) imag(i(vs87_p_11)) imag(i(vs87_p_12)) imag(i(vs87_n_0)) imag(i(vs87_n_1)) imag(i(vs87_n_2)) imag(i(vs87_n_3)) imag(i(vs87_n_4)) imag(i(vs87_n_5)) imag(i(vs87_n_6)) imag(i(vs87_n_7)) imag(i(vs87_n_8)) imag(i(vs87_n_9)) imag(i(vs87_n_10)) imag(i(vs87_n_11)) imag(i(vs87_n_12))
wrdata /repo/v2/analog/adc/results/cdac_mc_88.tsv imag(i(vs88_p_0)) imag(i(vs88_p_1)) imag(i(vs88_p_2)) imag(i(vs88_p_3)) imag(i(vs88_p_4)) imag(i(vs88_p_5)) imag(i(vs88_p_6)) imag(i(vs88_p_7)) imag(i(vs88_p_8)) imag(i(vs88_p_9)) imag(i(vs88_p_10)) imag(i(vs88_p_11)) imag(i(vs88_p_12)) imag(i(vs88_n_0)) imag(i(vs88_n_1)) imag(i(vs88_n_2)) imag(i(vs88_n_3)) imag(i(vs88_n_4)) imag(i(vs88_n_5)) imag(i(vs88_n_6)) imag(i(vs88_n_7)) imag(i(vs88_n_8)) imag(i(vs88_n_9)) imag(i(vs88_n_10)) imag(i(vs88_n_11)) imag(i(vs88_n_12))
wrdata /repo/v2/analog/adc/results/cdac_mc_89.tsv imag(i(vs89_p_0)) imag(i(vs89_p_1)) imag(i(vs89_p_2)) imag(i(vs89_p_3)) imag(i(vs89_p_4)) imag(i(vs89_p_5)) imag(i(vs89_p_6)) imag(i(vs89_p_7)) imag(i(vs89_p_8)) imag(i(vs89_p_9)) imag(i(vs89_p_10)) imag(i(vs89_p_11)) imag(i(vs89_p_12)) imag(i(vs89_n_0)) imag(i(vs89_n_1)) imag(i(vs89_n_2)) imag(i(vs89_n_3)) imag(i(vs89_n_4)) imag(i(vs89_n_5)) imag(i(vs89_n_6)) imag(i(vs89_n_7)) imag(i(vs89_n_8)) imag(i(vs89_n_9)) imag(i(vs89_n_10)) imag(i(vs89_n_11)) imag(i(vs89_n_12))
wrdata /repo/v2/analog/adc/results/cdac_mc_90.tsv imag(i(vs90_p_0)) imag(i(vs90_p_1)) imag(i(vs90_p_2)) imag(i(vs90_p_3)) imag(i(vs90_p_4)) imag(i(vs90_p_5)) imag(i(vs90_p_6)) imag(i(vs90_p_7)) imag(i(vs90_p_8)) imag(i(vs90_p_9)) imag(i(vs90_p_10)) imag(i(vs90_p_11)) imag(i(vs90_p_12)) imag(i(vs90_n_0)) imag(i(vs90_n_1)) imag(i(vs90_n_2)) imag(i(vs90_n_3)) imag(i(vs90_n_4)) imag(i(vs90_n_5)) imag(i(vs90_n_6)) imag(i(vs90_n_7)) imag(i(vs90_n_8)) imag(i(vs90_n_9)) imag(i(vs90_n_10)) imag(i(vs90_n_11)) imag(i(vs90_n_12))
wrdata /repo/v2/analog/adc/results/cdac_mc_91.tsv imag(i(vs91_p_0)) imag(i(vs91_p_1)) imag(i(vs91_p_2)) imag(i(vs91_p_3)) imag(i(vs91_p_4)) imag(i(vs91_p_5)) imag(i(vs91_p_6)) imag(i(vs91_p_7)) imag(i(vs91_p_8)) imag(i(vs91_p_9)) imag(i(vs91_p_10)) imag(i(vs91_p_11)) imag(i(vs91_p_12)) imag(i(vs91_n_0)) imag(i(vs91_n_1)) imag(i(vs91_n_2)) imag(i(vs91_n_3)) imag(i(vs91_n_4)) imag(i(vs91_n_5)) imag(i(vs91_n_6)) imag(i(vs91_n_7)) imag(i(vs91_n_8)) imag(i(vs91_n_9)) imag(i(vs91_n_10)) imag(i(vs91_n_11)) imag(i(vs91_n_12))
wrdata /repo/v2/analog/adc/results/cdac_mc_92.tsv imag(i(vs92_p_0)) imag(i(vs92_p_1)) imag(i(vs92_p_2)) imag(i(vs92_p_3)) imag(i(vs92_p_4)) imag(i(vs92_p_5)) imag(i(vs92_p_6)) imag(i(vs92_p_7)) imag(i(vs92_p_8)) imag(i(vs92_p_9)) imag(i(vs92_p_10)) imag(i(vs92_p_11)) imag(i(vs92_p_12)) imag(i(vs92_n_0)) imag(i(vs92_n_1)) imag(i(vs92_n_2)) imag(i(vs92_n_3)) imag(i(vs92_n_4)) imag(i(vs92_n_5)) imag(i(vs92_n_6)) imag(i(vs92_n_7)) imag(i(vs92_n_8)) imag(i(vs92_n_9)) imag(i(vs92_n_10)) imag(i(vs92_n_11)) imag(i(vs92_n_12))
wrdata /repo/v2/analog/adc/results/cdac_mc_93.tsv imag(i(vs93_p_0)) imag(i(vs93_p_1)) imag(i(vs93_p_2)) imag(i(vs93_p_3)) imag(i(vs93_p_4)) imag(i(vs93_p_5)) imag(i(vs93_p_6)) imag(i(vs93_p_7)) imag(i(vs93_p_8)) imag(i(vs93_p_9)) imag(i(vs93_p_10)) imag(i(vs93_p_11)) imag(i(vs93_p_12)) imag(i(vs93_n_0)) imag(i(vs93_n_1)) imag(i(vs93_n_2)) imag(i(vs93_n_3)) imag(i(vs93_n_4)) imag(i(vs93_n_5)) imag(i(vs93_n_6)) imag(i(vs93_n_7)) imag(i(vs93_n_8)) imag(i(vs93_n_9)) imag(i(vs93_n_10)) imag(i(vs93_n_11)) imag(i(vs93_n_12))
wrdata /repo/v2/analog/adc/results/cdac_mc_94.tsv imag(i(vs94_p_0)) imag(i(vs94_p_1)) imag(i(vs94_p_2)) imag(i(vs94_p_3)) imag(i(vs94_p_4)) imag(i(vs94_p_5)) imag(i(vs94_p_6)) imag(i(vs94_p_7)) imag(i(vs94_p_8)) imag(i(vs94_p_9)) imag(i(vs94_p_10)) imag(i(vs94_p_11)) imag(i(vs94_p_12)) imag(i(vs94_n_0)) imag(i(vs94_n_1)) imag(i(vs94_n_2)) imag(i(vs94_n_3)) imag(i(vs94_n_4)) imag(i(vs94_n_5)) imag(i(vs94_n_6)) imag(i(vs94_n_7)) imag(i(vs94_n_8)) imag(i(vs94_n_9)) imag(i(vs94_n_10)) imag(i(vs94_n_11)) imag(i(vs94_n_12))
wrdata /repo/v2/analog/adc/results/cdac_mc_95.tsv imag(i(vs95_p_0)) imag(i(vs95_p_1)) imag(i(vs95_p_2)) imag(i(vs95_p_3)) imag(i(vs95_p_4)) imag(i(vs95_p_5)) imag(i(vs95_p_6)) imag(i(vs95_p_7)) imag(i(vs95_p_8)) imag(i(vs95_p_9)) imag(i(vs95_p_10)) imag(i(vs95_p_11)) imag(i(vs95_p_12)) imag(i(vs95_n_0)) imag(i(vs95_n_1)) imag(i(vs95_n_2)) imag(i(vs95_n_3)) imag(i(vs95_n_4)) imag(i(vs95_n_5)) imag(i(vs95_n_6)) imag(i(vs95_n_7)) imag(i(vs95_n_8)) imag(i(vs95_n_9)) imag(i(vs95_n_10)) imag(i(vs95_n_11)) imag(i(vs95_n_12))
wrdata /repo/v2/analog/adc/results/cdac_mc_96.tsv imag(i(vs96_p_0)) imag(i(vs96_p_1)) imag(i(vs96_p_2)) imag(i(vs96_p_3)) imag(i(vs96_p_4)) imag(i(vs96_p_5)) imag(i(vs96_p_6)) imag(i(vs96_p_7)) imag(i(vs96_p_8)) imag(i(vs96_p_9)) imag(i(vs96_p_10)) imag(i(vs96_p_11)) imag(i(vs96_p_12)) imag(i(vs96_n_0)) imag(i(vs96_n_1)) imag(i(vs96_n_2)) imag(i(vs96_n_3)) imag(i(vs96_n_4)) imag(i(vs96_n_5)) imag(i(vs96_n_6)) imag(i(vs96_n_7)) imag(i(vs96_n_8)) imag(i(vs96_n_9)) imag(i(vs96_n_10)) imag(i(vs96_n_11)) imag(i(vs96_n_12))
wrdata /repo/v2/analog/adc/results/cdac_mc_97.tsv imag(i(vs97_p_0)) imag(i(vs97_p_1)) imag(i(vs97_p_2)) imag(i(vs97_p_3)) imag(i(vs97_p_4)) imag(i(vs97_p_5)) imag(i(vs97_p_6)) imag(i(vs97_p_7)) imag(i(vs97_p_8)) imag(i(vs97_p_9)) imag(i(vs97_p_10)) imag(i(vs97_p_11)) imag(i(vs97_p_12)) imag(i(vs97_n_0)) imag(i(vs97_n_1)) imag(i(vs97_n_2)) imag(i(vs97_n_3)) imag(i(vs97_n_4)) imag(i(vs97_n_5)) imag(i(vs97_n_6)) imag(i(vs97_n_7)) imag(i(vs97_n_8)) imag(i(vs97_n_9)) imag(i(vs97_n_10)) imag(i(vs97_n_11)) imag(i(vs97_n_12))
wrdata /repo/v2/analog/adc/results/cdac_mc_98.tsv imag(i(vs98_p_0)) imag(i(vs98_p_1)) imag(i(vs98_p_2)) imag(i(vs98_p_3)) imag(i(vs98_p_4)) imag(i(vs98_p_5)) imag(i(vs98_p_6)) imag(i(vs98_p_7)) imag(i(vs98_p_8)) imag(i(vs98_p_9)) imag(i(vs98_p_10)) imag(i(vs98_p_11)) imag(i(vs98_p_12)) imag(i(vs98_n_0)) imag(i(vs98_n_1)) imag(i(vs98_n_2)) imag(i(vs98_n_3)) imag(i(vs98_n_4)) imag(i(vs98_n_5)) imag(i(vs98_n_6)) imag(i(vs98_n_7)) imag(i(vs98_n_8)) imag(i(vs98_n_9)) imag(i(vs98_n_10)) imag(i(vs98_n_11)) imag(i(vs98_n_12))
wrdata /repo/v2/analog/adc/results/cdac_mc_99.tsv imag(i(vs99_p_0)) imag(i(vs99_p_1)) imag(i(vs99_p_2)) imag(i(vs99_p_3)) imag(i(vs99_p_4)) imag(i(vs99_p_5)) imag(i(vs99_p_6)) imag(i(vs99_p_7)) imag(i(vs99_p_8)) imag(i(vs99_p_9)) imag(i(vs99_p_10)) imag(i(vs99_p_11)) imag(i(vs99_p_12)) imag(i(vs99_n_0)) imag(i(vs99_n_1)) imag(i(vs99_n_2)) imag(i(vs99_n_3)) imag(i(vs99_n_4)) imag(i(vs99_n_5)) imag(i(vs99_n_6)) imag(i(vs99_n_7)) imag(i(vs99_n_8)) imag(i(vs99_n_9)) imag(i(vs99_n_10)) imag(i(vs99_n_11)) imag(i(vs99_n_12))
wrdata /repo/v2/analog/adc/results/cdac_mc_100.tsv imag(i(vs100_p_0)) imag(i(vs100_p_1)) imag(i(vs100_p_2)) imag(i(vs100_p_3)) imag(i(vs100_p_4)) imag(i(vs100_p_5)) imag(i(vs100_p_6)) imag(i(vs100_p_7)) imag(i(vs100_p_8)) imag(i(vs100_p_9)) imag(i(vs100_p_10)) imag(i(vs100_p_11)) imag(i(vs100_p_12)) imag(i(vs100_n_0)) imag(i(vs100_n_1)) imag(i(vs100_n_2)) imag(i(vs100_n_3)) imag(i(vs100_n_4)) imag(i(vs100_n_5)) imag(i(vs100_n_6)) imag(i(vs100_n_7)) imag(i(vs100_n_8)) imag(i(vs100_n_9)) imag(i(vs100_n_10)) imag(i(vs100_n_11)) imag(i(vs100_n_12))
wrdata /repo/v2/analog/adc/results/cdac_mc_101.tsv imag(i(vs101_p_0)) imag(i(vs101_p_1)) imag(i(vs101_p_2)) imag(i(vs101_p_3)) imag(i(vs101_p_4)) imag(i(vs101_p_5)) imag(i(vs101_p_6)) imag(i(vs101_p_7)) imag(i(vs101_p_8)) imag(i(vs101_p_9)) imag(i(vs101_p_10)) imag(i(vs101_p_11)) imag(i(vs101_p_12)) imag(i(vs101_n_0)) imag(i(vs101_n_1)) imag(i(vs101_n_2)) imag(i(vs101_n_3)) imag(i(vs101_n_4)) imag(i(vs101_n_5)) imag(i(vs101_n_6)) imag(i(vs101_n_7)) imag(i(vs101_n_8)) imag(i(vs101_n_9)) imag(i(vs101_n_10)) imag(i(vs101_n_11)) imag(i(vs101_n_12))
wrdata /repo/v2/analog/adc/results/cdac_mc_102.tsv imag(i(vs102_p_0)) imag(i(vs102_p_1)) imag(i(vs102_p_2)) imag(i(vs102_p_3)) imag(i(vs102_p_4)) imag(i(vs102_p_5)) imag(i(vs102_p_6)) imag(i(vs102_p_7)) imag(i(vs102_p_8)) imag(i(vs102_p_9)) imag(i(vs102_p_10)) imag(i(vs102_p_11)) imag(i(vs102_p_12)) imag(i(vs102_n_0)) imag(i(vs102_n_1)) imag(i(vs102_n_2)) imag(i(vs102_n_3)) imag(i(vs102_n_4)) imag(i(vs102_n_5)) imag(i(vs102_n_6)) imag(i(vs102_n_7)) imag(i(vs102_n_8)) imag(i(vs102_n_9)) imag(i(vs102_n_10)) imag(i(vs102_n_11)) imag(i(vs102_n_12))
wrdata /repo/v2/analog/adc/results/cdac_mc_103.tsv imag(i(vs103_p_0)) imag(i(vs103_p_1)) imag(i(vs103_p_2)) imag(i(vs103_p_3)) imag(i(vs103_p_4)) imag(i(vs103_p_5)) imag(i(vs103_p_6)) imag(i(vs103_p_7)) imag(i(vs103_p_8)) imag(i(vs103_p_9)) imag(i(vs103_p_10)) imag(i(vs103_p_11)) imag(i(vs103_p_12)) imag(i(vs103_n_0)) imag(i(vs103_n_1)) imag(i(vs103_n_2)) imag(i(vs103_n_3)) imag(i(vs103_n_4)) imag(i(vs103_n_5)) imag(i(vs103_n_6)) imag(i(vs103_n_7)) imag(i(vs103_n_8)) imag(i(vs103_n_9)) imag(i(vs103_n_10)) imag(i(vs103_n_11)) imag(i(vs103_n_12))
wrdata /repo/v2/analog/adc/results/cdac_mc_104.tsv imag(i(vs104_p_0)) imag(i(vs104_p_1)) imag(i(vs104_p_2)) imag(i(vs104_p_3)) imag(i(vs104_p_4)) imag(i(vs104_p_5)) imag(i(vs104_p_6)) imag(i(vs104_p_7)) imag(i(vs104_p_8)) imag(i(vs104_p_9)) imag(i(vs104_p_10)) imag(i(vs104_p_11)) imag(i(vs104_p_12)) imag(i(vs104_n_0)) imag(i(vs104_n_1)) imag(i(vs104_n_2)) imag(i(vs104_n_3)) imag(i(vs104_n_4)) imag(i(vs104_n_5)) imag(i(vs104_n_6)) imag(i(vs104_n_7)) imag(i(vs104_n_8)) imag(i(vs104_n_9)) imag(i(vs104_n_10)) imag(i(vs104_n_11)) imag(i(vs104_n_12))
wrdata /repo/v2/analog/adc/results/cdac_mc_105.tsv imag(i(vs105_p_0)) imag(i(vs105_p_1)) imag(i(vs105_p_2)) imag(i(vs105_p_3)) imag(i(vs105_p_4)) imag(i(vs105_p_5)) imag(i(vs105_p_6)) imag(i(vs105_p_7)) imag(i(vs105_p_8)) imag(i(vs105_p_9)) imag(i(vs105_p_10)) imag(i(vs105_p_11)) imag(i(vs105_p_12)) imag(i(vs105_n_0)) imag(i(vs105_n_1)) imag(i(vs105_n_2)) imag(i(vs105_n_3)) imag(i(vs105_n_4)) imag(i(vs105_n_5)) imag(i(vs105_n_6)) imag(i(vs105_n_7)) imag(i(vs105_n_8)) imag(i(vs105_n_9)) imag(i(vs105_n_10)) imag(i(vs105_n_11)) imag(i(vs105_n_12))
wrdata /repo/v2/analog/adc/results/cdac_mc_106.tsv imag(i(vs106_p_0)) imag(i(vs106_p_1)) imag(i(vs106_p_2)) imag(i(vs106_p_3)) imag(i(vs106_p_4)) imag(i(vs106_p_5)) imag(i(vs106_p_6)) imag(i(vs106_p_7)) imag(i(vs106_p_8)) imag(i(vs106_p_9)) imag(i(vs106_p_10)) imag(i(vs106_p_11)) imag(i(vs106_p_12)) imag(i(vs106_n_0)) imag(i(vs106_n_1)) imag(i(vs106_n_2)) imag(i(vs106_n_3)) imag(i(vs106_n_4)) imag(i(vs106_n_5)) imag(i(vs106_n_6)) imag(i(vs106_n_7)) imag(i(vs106_n_8)) imag(i(vs106_n_9)) imag(i(vs106_n_10)) imag(i(vs106_n_11)) imag(i(vs106_n_12))
wrdata /repo/v2/analog/adc/results/cdac_mc_107.tsv imag(i(vs107_p_0)) imag(i(vs107_p_1)) imag(i(vs107_p_2)) imag(i(vs107_p_3)) imag(i(vs107_p_4)) imag(i(vs107_p_5)) imag(i(vs107_p_6)) imag(i(vs107_p_7)) imag(i(vs107_p_8)) imag(i(vs107_p_9)) imag(i(vs107_p_10)) imag(i(vs107_p_11)) imag(i(vs107_p_12)) imag(i(vs107_n_0)) imag(i(vs107_n_1)) imag(i(vs107_n_2)) imag(i(vs107_n_3)) imag(i(vs107_n_4)) imag(i(vs107_n_5)) imag(i(vs107_n_6)) imag(i(vs107_n_7)) imag(i(vs107_n_8)) imag(i(vs107_n_9)) imag(i(vs107_n_10)) imag(i(vs107_n_11)) imag(i(vs107_n_12))
wrdata /repo/v2/analog/adc/results/cdac_mc_108.tsv imag(i(vs108_p_0)) imag(i(vs108_p_1)) imag(i(vs108_p_2)) imag(i(vs108_p_3)) imag(i(vs108_p_4)) imag(i(vs108_p_5)) imag(i(vs108_p_6)) imag(i(vs108_p_7)) imag(i(vs108_p_8)) imag(i(vs108_p_9)) imag(i(vs108_p_10)) imag(i(vs108_p_11)) imag(i(vs108_p_12)) imag(i(vs108_n_0)) imag(i(vs108_n_1)) imag(i(vs108_n_2)) imag(i(vs108_n_3)) imag(i(vs108_n_4)) imag(i(vs108_n_5)) imag(i(vs108_n_6)) imag(i(vs108_n_7)) imag(i(vs108_n_8)) imag(i(vs108_n_9)) imag(i(vs108_n_10)) imag(i(vs108_n_11)) imag(i(vs108_n_12))
wrdata /repo/v2/analog/adc/results/cdac_mc_109.tsv imag(i(vs109_p_0)) imag(i(vs109_p_1)) imag(i(vs109_p_2)) imag(i(vs109_p_3)) imag(i(vs109_p_4)) imag(i(vs109_p_5)) imag(i(vs109_p_6)) imag(i(vs109_p_7)) imag(i(vs109_p_8)) imag(i(vs109_p_9)) imag(i(vs109_p_10)) imag(i(vs109_p_11)) imag(i(vs109_p_12)) imag(i(vs109_n_0)) imag(i(vs109_n_1)) imag(i(vs109_n_2)) imag(i(vs109_n_3)) imag(i(vs109_n_4)) imag(i(vs109_n_5)) imag(i(vs109_n_6)) imag(i(vs109_n_7)) imag(i(vs109_n_8)) imag(i(vs109_n_9)) imag(i(vs109_n_10)) imag(i(vs109_n_11)) imag(i(vs109_n_12))
wrdata /repo/v2/analog/adc/results/cdac_mc_110.tsv imag(i(vs110_p_0)) imag(i(vs110_p_1)) imag(i(vs110_p_2)) imag(i(vs110_p_3)) imag(i(vs110_p_4)) imag(i(vs110_p_5)) imag(i(vs110_p_6)) imag(i(vs110_p_7)) imag(i(vs110_p_8)) imag(i(vs110_p_9)) imag(i(vs110_p_10)) imag(i(vs110_p_11)) imag(i(vs110_p_12)) imag(i(vs110_n_0)) imag(i(vs110_n_1)) imag(i(vs110_n_2)) imag(i(vs110_n_3)) imag(i(vs110_n_4)) imag(i(vs110_n_5)) imag(i(vs110_n_6)) imag(i(vs110_n_7)) imag(i(vs110_n_8)) imag(i(vs110_n_9)) imag(i(vs110_n_10)) imag(i(vs110_n_11)) imag(i(vs110_n_12))
wrdata /repo/v2/analog/adc/results/cdac_mc_111.tsv imag(i(vs111_p_0)) imag(i(vs111_p_1)) imag(i(vs111_p_2)) imag(i(vs111_p_3)) imag(i(vs111_p_4)) imag(i(vs111_p_5)) imag(i(vs111_p_6)) imag(i(vs111_p_7)) imag(i(vs111_p_8)) imag(i(vs111_p_9)) imag(i(vs111_p_10)) imag(i(vs111_p_11)) imag(i(vs111_p_12)) imag(i(vs111_n_0)) imag(i(vs111_n_1)) imag(i(vs111_n_2)) imag(i(vs111_n_3)) imag(i(vs111_n_4)) imag(i(vs111_n_5)) imag(i(vs111_n_6)) imag(i(vs111_n_7)) imag(i(vs111_n_8)) imag(i(vs111_n_9)) imag(i(vs111_n_10)) imag(i(vs111_n_11)) imag(i(vs111_n_12))
wrdata /repo/v2/analog/adc/results/cdac_mc_112.tsv imag(i(vs112_p_0)) imag(i(vs112_p_1)) imag(i(vs112_p_2)) imag(i(vs112_p_3)) imag(i(vs112_p_4)) imag(i(vs112_p_5)) imag(i(vs112_p_6)) imag(i(vs112_p_7)) imag(i(vs112_p_8)) imag(i(vs112_p_9)) imag(i(vs112_p_10)) imag(i(vs112_p_11)) imag(i(vs112_p_12)) imag(i(vs112_n_0)) imag(i(vs112_n_1)) imag(i(vs112_n_2)) imag(i(vs112_n_3)) imag(i(vs112_n_4)) imag(i(vs112_n_5)) imag(i(vs112_n_6)) imag(i(vs112_n_7)) imag(i(vs112_n_8)) imag(i(vs112_n_9)) imag(i(vs112_n_10)) imag(i(vs112_n_11)) imag(i(vs112_n_12))
wrdata /repo/v2/analog/adc/results/cdac_mc_113.tsv imag(i(vs113_p_0)) imag(i(vs113_p_1)) imag(i(vs113_p_2)) imag(i(vs113_p_3)) imag(i(vs113_p_4)) imag(i(vs113_p_5)) imag(i(vs113_p_6)) imag(i(vs113_p_7)) imag(i(vs113_p_8)) imag(i(vs113_p_9)) imag(i(vs113_p_10)) imag(i(vs113_p_11)) imag(i(vs113_p_12)) imag(i(vs113_n_0)) imag(i(vs113_n_1)) imag(i(vs113_n_2)) imag(i(vs113_n_3)) imag(i(vs113_n_4)) imag(i(vs113_n_5)) imag(i(vs113_n_6)) imag(i(vs113_n_7)) imag(i(vs113_n_8)) imag(i(vs113_n_9)) imag(i(vs113_n_10)) imag(i(vs113_n_11)) imag(i(vs113_n_12))
wrdata /repo/v2/analog/adc/results/cdac_mc_114.tsv imag(i(vs114_p_0)) imag(i(vs114_p_1)) imag(i(vs114_p_2)) imag(i(vs114_p_3)) imag(i(vs114_p_4)) imag(i(vs114_p_5)) imag(i(vs114_p_6)) imag(i(vs114_p_7)) imag(i(vs114_p_8)) imag(i(vs114_p_9)) imag(i(vs114_p_10)) imag(i(vs114_p_11)) imag(i(vs114_p_12)) imag(i(vs114_n_0)) imag(i(vs114_n_1)) imag(i(vs114_n_2)) imag(i(vs114_n_3)) imag(i(vs114_n_4)) imag(i(vs114_n_5)) imag(i(vs114_n_6)) imag(i(vs114_n_7)) imag(i(vs114_n_8)) imag(i(vs114_n_9)) imag(i(vs114_n_10)) imag(i(vs114_n_11)) imag(i(vs114_n_12))
wrdata /repo/v2/analog/adc/results/cdac_mc_115.tsv imag(i(vs115_p_0)) imag(i(vs115_p_1)) imag(i(vs115_p_2)) imag(i(vs115_p_3)) imag(i(vs115_p_4)) imag(i(vs115_p_5)) imag(i(vs115_p_6)) imag(i(vs115_p_7)) imag(i(vs115_p_8)) imag(i(vs115_p_9)) imag(i(vs115_p_10)) imag(i(vs115_p_11)) imag(i(vs115_p_12)) imag(i(vs115_n_0)) imag(i(vs115_n_1)) imag(i(vs115_n_2)) imag(i(vs115_n_3)) imag(i(vs115_n_4)) imag(i(vs115_n_5)) imag(i(vs115_n_6)) imag(i(vs115_n_7)) imag(i(vs115_n_8)) imag(i(vs115_n_9)) imag(i(vs115_n_10)) imag(i(vs115_n_11)) imag(i(vs115_n_12))
wrdata /repo/v2/analog/adc/results/cdac_mc_116.tsv imag(i(vs116_p_0)) imag(i(vs116_p_1)) imag(i(vs116_p_2)) imag(i(vs116_p_3)) imag(i(vs116_p_4)) imag(i(vs116_p_5)) imag(i(vs116_p_6)) imag(i(vs116_p_7)) imag(i(vs116_p_8)) imag(i(vs116_p_9)) imag(i(vs116_p_10)) imag(i(vs116_p_11)) imag(i(vs116_p_12)) imag(i(vs116_n_0)) imag(i(vs116_n_1)) imag(i(vs116_n_2)) imag(i(vs116_n_3)) imag(i(vs116_n_4)) imag(i(vs116_n_5)) imag(i(vs116_n_6)) imag(i(vs116_n_7)) imag(i(vs116_n_8)) imag(i(vs116_n_9)) imag(i(vs116_n_10)) imag(i(vs116_n_11)) imag(i(vs116_n_12))
wrdata /repo/v2/analog/adc/results/cdac_mc_117.tsv imag(i(vs117_p_0)) imag(i(vs117_p_1)) imag(i(vs117_p_2)) imag(i(vs117_p_3)) imag(i(vs117_p_4)) imag(i(vs117_p_5)) imag(i(vs117_p_6)) imag(i(vs117_p_7)) imag(i(vs117_p_8)) imag(i(vs117_p_9)) imag(i(vs117_p_10)) imag(i(vs117_p_11)) imag(i(vs117_p_12)) imag(i(vs117_n_0)) imag(i(vs117_n_1)) imag(i(vs117_n_2)) imag(i(vs117_n_3)) imag(i(vs117_n_4)) imag(i(vs117_n_5)) imag(i(vs117_n_6)) imag(i(vs117_n_7)) imag(i(vs117_n_8)) imag(i(vs117_n_9)) imag(i(vs117_n_10)) imag(i(vs117_n_11)) imag(i(vs117_n_12))
wrdata /repo/v2/analog/adc/results/cdac_mc_118.tsv imag(i(vs118_p_0)) imag(i(vs118_p_1)) imag(i(vs118_p_2)) imag(i(vs118_p_3)) imag(i(vs118_p_4)) imag(i(vs118_p_5)) imag(i(vs118_p_6)) imag(i(vs118_p_7)) imag(i(vs118_p_8)) imag(i(vs118_p_9)) imag(i(vs118_p_10)) imag(i(vs118_p_11)) imag(i(vs118_p_12)) imag(i(vs118_n_0)) imag(i(vs118_n_1)) imag(i(vs118_n_2)) imag(i(vs118_n_3)) imag(i(vs118_n_4)) imag(i(vs118_n_5)) imag(i(vs118_n_6)) imag(i(vs118_n_7)) imag(i(vs118_n_8)) imag(i(vs118_n_9)) imag(i(vs118_n_10)) imag(i(vs118_n_11)) imag(i(vs118_n_12))
wrdata /repo/v2/analog/adc/results/cdac_mc_119.tsv imag(i(vs119_p_0)) imag(i(vs119_p_1)) imag(i(vs119_p_2)) imag(i(vs119_p_3)) imag(i(vs119_p_4)) imag(i(vs119_p_5)) imag(i(vs119_p_6)) imag(i(vs119_p_7)) imag(i(vs119_p_8)) imag(i(vs119_p_9)) imag(i(vs119_p_10)) imag(i(vs119_p_11)) imag(i(vs119_p_12)) imag(i(vs119_n_0)) imag(i(vs119_n_1)) imag(i(vs119_n_2)) imag(i(vs119_n_3)) imag(i(vs119_n_4)) imag(i(vs119_n_5)) imag(i(vs119_n_6)) imag(i(vs119_n_7)) imag(i(vs119_n_8)) imag(i(vs119_n_9)) imag(i(vs119_n_10)) imag(i(vs119_n_11)) imag(i(vs119_n_12))
wrdata /repo/v2/analog/adc/results/cdac_mc_120.tsv imag(i(vs120_p_0)) imag(i(vs120_p_1)) imag(i(vs120_p_2)) imag(i(vs120_p_3)) imag(i(vs120_p_4)) imag(i(vs120_p_5)) imag(i(vs120_p_6)) imag(i(vs120_p_7)) imag(i(vs120_p_8)) imag(i(vs120_p_9)) imag(i(vs120_p_10)) imag(i(vs120_p_11)) imag(i(vs120_p_12)) imag(i(vs120_n_0)) imag(i(vs120_n_1)) imag(i(vs120_n_2)) imag(i(vs120_n_3)) imag(i(vs120_n_4)) imag(i(vs120_n_5)) imag(i(vs120_n_6)) imag(i(vs120_n_7)) imag(i(vs120_n_8)) imag(i(vs120_n_9)) imag(i(vs120_n_10)) imag(i(vs120_n_11)) imag(i(vs120_n_12))
wrdata /repo/v2/analog/adc/results/cdac_mc_121.tsv imag(i(vs121_p_0)) imag(i(vs121_p_1)) imag(i(vs121_p_2)) imag(i(vs121_p_3)) imag(i(vs121_p_4)) imag(i(vs121_p_5)) imag(i(vs121_p_6)) imag(i(vs121_p_7)) imag(i(vs121_p_8)) imag(i(vs121_p_9)) imag(i(vs121_p_10)) imag(i(vs121_p_11)) imag(i(vs121_p_12)) imag(i(vs121_n_0)) imag(i(vs121_n_1)) imag(i(vs121_n_2)) imag(i(vs121_n_3)) imag(i(vs121_n_4)) imag(i(vs121_n_5)) imag(i(vs121_n_6)) imag(i(vs121_n_7)) imag(i(vs121_n_8)) imag(i(vs121_n_9)) imag(i(vs121_n_10)) imag(i(vs121_n_11)) imag(i(vs121_n_12))
wrdata /repo/v2/analog/adc/results/cdac_mc_122.tsv imag(i(vs122_p_0)) imag(i(vs122_p_1)) imag(i(vs122_p_2)) imag(i(vs122_p_3)) imag(i(vs122_p_4)) imag(i(vs122_p_5)) imag(i(vs122_p_6)) imag(i(vs122_p_7)) imag(i(vs122_p_8)) imag(i(vs122_p_9)) imag(i(vs122_p_10)) imag(i(vs122_p_11)) imag(i(vs122_p_12)) imag(i(vs122_n_0)) imag(i(vs122_n_1)) imag(i(vs122_n_2)) imag(i(vs122_n_3)) imag(i(vs122_n_4)) imag(i(vs122_n_5)) imag(i(vs122_n_6)) imag(i(vs122_n_7)) imag(i(vs122_n_8)) imag(i(vs122_n_9)) imag(i(vs122_n_10)) imag(i(vs122_n_11)) imag(i(vs122_n_12))
wrdata /repo/v2/analog/adc/results/cdac_mc_123.tsv imag(i(vs123_p_0)) imag(i(vs123_p_1)) imag(i(vs123_p_2)) imag(i(vs123_p_3)) imag(i(vs123_p_4)) imag(i(vs123_p_5)) imag(i(vs123_p_6)) imag(i(vs123_p_7)) imag(i(vs123_p_8)) imag(i(vs123_p_9)) imag(i(vs123_p_10)) imag(i(vs123_p_11)) imag(i(vs123_p_12)) imag(i(vs123_n_0)) imag(i(vs123_n_1)) imag(i(vs123_n_2)) imag(i(vs123_n_3)) imag(i(vs123_n_4)) imag(i(vs123_n_5)) imag(i(vs123_n_6)) imag(i(vs123_n_7)) imag(i(vs123_n_8)) imag(i(vs123_n_9)) imag(i(vs123_n_10)) imag(i(vs123_n_11)) imag(i(vs123_n_12))
wrdata /repo/v2/analog/adc/results/cdac_mc_124.tsv imag(i(vs124_p_0)) imag(i(vs124_p_1)) imag(i(vs124_p_2)) imag(i(vs124_p_3)) imag(i(vs124_p_4)) imag(i(vs124_p_5)) imag(i(vs124_p_6)) imag(i(vs124_p_7)) imag(i(vs124_p_8)) imag(i(vs124_p_9)) imag(i(vs124_p_10)) imag(i(vs124_p_11)) imag(i(vs124_p_12)) imag(i(vs124_n_0)) imag(i(vs124_n_1)) imag(i(vs124_n_2)) imag(i(vs124_n_3)) imag(i(vs124_n_4)) imag(i(vs124_n_5)) imag(i(vs124_n_6)) imag(i(vs124_n_7)) imag(i(vs124_n_8)) imag(i(vs124_n_9)) imag(i(vs124_n_10)) imag(i(vs124_n_11)) imag(i(vs124_n_12))
wrdata /repo/v2/analog/adc/results/cdac_mc_125.tsv imag(i(vs125_p_0)) imag(i(vs125_p_1)) imag(i(vs125_p_2)) imag(i(vs125_p_3)) imag(i(vs125_p_4)) imag(i(vs125_p_5)) imag(i(vs125_p_6)) imag(i(vs125_p_7)) imag(i(vs125_p_8)) imag(i(vs125_p_9)) imag(i(vs125_p_10)) imag(i(vs125_p_11)) imag(i(vs125_p_12)) imag(i(vs125_n_0)) imag(i(vs125_n_1)) imag(i(vs125_n_2)) imag(i(vs125_n_3)) imag(i(vs125_n_4)) imag(i(vs125_n_5)) imag(i(vs125_n_6)) imag(i(vs125_n_7)) imag(i(vs125_n_8)) imag(i(vs125_n_9)) imag(i(vs125_n_10)) imag(i(vs125_n_11)) imag(i(vs125_n_12))
wrdata /repo/v2/analog/adc/results/cdac_mc_126.tsv imag(i(vs126_p_0)) imag(i(vs126_p_1)) imag(i(vs126_p_2)) imag(i(vs126_p_3)) imag(i(vs126_p_4)) imag(i(vs126_p_5)) imag(i(vs126_p_6)) imag(i(vs126_p_7)) imag(i(vs126_p_8)) imag(i(vs126_p_9)) imag(i(vs126_p_10)) imag(i(vs126_p_11)) imag(i(vs126_p_12)) imag(i(vs126_n_0)) imag(i(vs126_n_1)) imag(i(vs126_n_2)) imag(i(vs126_n_3)) imag(i(vs126_n_4)) imag(i(vs126_n_5)) imag(i(vs126_n_6)) imag(i(vs126_n_7)) imag(i(vs126_n_8)) imag(i(vs126_n_9)) imag(i(vs126_n_10)) imag(i(vs126_n_11)) imag(i(vs126_n_12))
wrdata /repo/v2/analog/adc/results/cdac_mc_127.tsv imag(i(vs127_p_0)) imag(i(vs127_p_1)) imag(i(vs127_p_2)) imag(i(vs127_p_3)) imag(i(vs127_p_4)) imag(i(vs127_p_5)) imag(i(vs127_p_6)) imag(i(vs127_p_7)) imag(i(vs127_p_8)) imag(i(vs127_p_9)) imag(i(vs127_p_10)) imag(i(vs127_p_11)) imag(i(vs127_p_12)) imag(i(vs127_n_0)) imag(i(vs127_n_1)) imag(i(vs127_n_2)) imag(i(vs127_n_3)) imag(i(vs127_n_4)) imag(i(vs127_n_5)) imag(i(vs127_n_6)) imag(i(vs127_n_7)) imag(i(vs127_n_8)) imag(i(vs127_n_9)) imag(i(vs127_n_10)) imag(i(vs127_n_11)) imag(i(vs127_n_12))
wrdata /repo/v2/analog/adc/results/cdac_mc_128.tsv imag(i(vs128_p_0)) imag(i(vs128_p_1)) imag(i(vs128_p_2)) imag(i(vs128_p_3)) imag(i(vs128_p_4)) imag(i(vs128_p_5)) imag(i(vs128_p_6)) imag(i(vs128_p_7)) imag(i(vs128_p_8)) imag(i(vs128_p_9)) imag(i(vs128_p_10)) imag(i(vs128_p_11)) imag(i(vs128_p_12)) imag(i(vs128_n_0)) imag(i(vs128_n_1)) imag(i(vs128_n_2)) imag(i(vs128_n_3)) imag(i(vs128_n_4)) imag(i(vs128_n_5)) imag(i(vs128_n_6)) imag(i(vs128_n_7)) imag(i(vs128_n_8)) imag(i(vs128_n_9)) imag(i(vs128_n_10)) imag(i(vs128_n_11)) imag(i(vs128_n_12))
wrdata /repo/v2/analog/adc/results/cdac_mc_129.tsv imag(i(vs129_p_0)) imag(i(vs129_p_1)) imag(i(vs129_p_2)) imag(i(vs129_p_3)) imag(i(vs129_p_4)) imag(i(vs129_p_5)) imag(i(vs129_p_6)) imag(i(vs129_p_7)) imag(i(vs129_p_8)) imag(i(vs129_p_9)) imag(i(vs129_p_10)) imag(i(vs129_p_11)) imag(i(vs129_p_12)) imag(i(vs129_n_0)) imag(i(vs129_n_1)) imag(i(vs129_n_2)) imag(i(vs129_n_3)) imag(i(vs129_n_4)) imag(i(vs129_n_5)) imag(i(vs129_n_6)) imag(i(vs129_n_7)) imag(i(vs129_n_8)) imag(i(vs129_n_9)) imag(i(vs129_n_10)) imag(i(vs129_n_11)) imag(i(vs129_n_12))
wrdata /repo/v2/analog/adc/results/cdac_mc_130.tsv imag(i(vs130_p_0)) imag(i(vs130_p_1)) imag(i(vs130_p_2)) imag(i(vs130_p_3)) imag(i(vs130_p_4)) imag(i(vs130_p_5)) imag(i(vs130_p_6)) imag(i(vs130_p_7)) imag(i(vs130_p_8)) imag(i(vs130_p_9)) imag(i(vs130_p_10)) imag(i(vs130_p_11)) imag(i(vs130_p_12)) imag(i(vs130_n_0)) imag(i(vs130_n_1)) imag(i(vs130_n_2)) imag(i(vs130_n_3)) imag(i(vs130_n_4)) imag(i(vs130_n_5)) imag(i(vs130_n_6)) imag(i(vs130_n_7)) imag(i(vs130_n_8)) imag(i(vs130_n_9)) imag(i(vs130_n_10)) imag(i(vs130_n_11)) imag(i(vs130_n_12))
wrdata /repo/v2/analog/adc/results/cdac_mc_131.tsv imag(i(vs131_p_0)) imag(i(vs131_p_1)) imag(i(vs131_p_2)) imag(i(vs131_p_3)) imag(i(vs131_p_4)) imag(i(vs131_p_5)) imag(i(vs131_p_6)) imag(i(vs131_p_7)) imag(i(vs131_p_8)) imag(i(vs131_p_9)) imag(i(vs131_p_10)) imag(i(vs131_p_11)) imag(i(vs131_p_12)) imag(i(vs131_n_0)) imag(i(vs131_n_1)) imag(i(vs131_n_2)) imag(i(vs131_n_3)) imag(i(vs131_n_4)) imag(i(vs131_n_5)) imag(i(vs131_n_6)) imag(i(vs131_n_7)) imag(i(vs131_n_8)) imag(i(vs131_n_9)) imag(i(vs131_n_10)) imag(i(vs131_n_11)) imag(i(vs131_n_12))
wrdata /repo/v2/analog/adc/results/cdac_mc_132.tsv imag(i(vs132_p_0)) imag(i(vs132_p_1)) imag(i(vs132_p_2)) imag(i(vs132_p_3)) imag(i(vs132_p_4)) imag(i(vs132_p_5)) imag(i(vs132_p_6)) imag(i(vs132_p_7)) imag(i(vs132_p_8)) imag(i(vs132_p_9)) imag(i(vs132_p_10)) imag(i(vs132_p_11)) imag(i(vs132_p_12)) imag(i(vs132_n_0)) imag(i(vs132_n_1)) imag(i(vs132_n_2)) imag(i(vs132_n_3)) imag(i(vs132_n_4)) imag(i(vs132_n_5)) imag(i(vs132_n_6)) imag(i(vs132_n_7)) imag(i(vs132_n_8)) imag(i(vs132_n_9)) imag(i(vs132_n_10)) imag(i(vs132_n_11)) imag(i(vs132_n_12))
wrdata /repo/v2/analog/adc/results/cdac_mc_133.tsv imag(i(vs133_p_0)) imag(i(vs133_p_1)) imag(i(vs133_p_2)) imag(i(vs133_p_3)) imag(i(vs133_p_4)) imag(i(vs133_p_5)) imag(i(vs133_p_6)) imag(i(vs133_p_7)) imag(i(vs133_p_8)) imag(i(vs133_p_9)) imag(i(vs133_p_10)) imag(i(vs133_p_11)) imag(i(vs133_p_12)) imag(i(vs133_n_0)) imag(i(vs133_n_1)) imag(i(vs133_n_2)) imag(i(vs133_n_3)) imag(i(vs133_n_4)) imag(i(vs133_n_5)) imag(i(vs133_n_6)) imag(i(vs133_n_7)) imag(i(vs133_n_8)) imag(i(vs133_n_9)) imag(i(vs133_n_10)) imag(i(vs133_n_11)) imag(i(vs133_n_12))
wrdata /repo/v2/analog/adc/results/cdac_mc_134.tsv imag(i(vs134_p_0)) imag(i(vs134_p_1)) imag(i(vs134_p_2)) imag(i(vs134_p_3)) imag(i(vs134_p_4)) imag(i(vs134_p_5)) imag(i(vs134_p_6)) imag(i(vs134_p_7)) imag(i(vs134_p_8)) imag(i(vs134_p_9)) imag(i(vs134_p_10)) imag(i(vs134_p_11)) imag(i(vs134_p_12)) imag(i(vs134_n_0)) imag(i(vs134_n_1)) imag(i(vs134_n_2)) imag(i(vs134_n_3)) imag(i(vs134_n_4)) imag(i(vs134_n_5)) imag(i(vs134_n_6)) imag(i(vs134_n_7)) imag(i(vs134_n_8)) imag(i(vs134_n_9)) imag(i(vs134_n_10)) imag(i(vs134_n_11)) imag(i(vs134_n_12))
wrdata /repo/v2/analog/adc/results/cdac_mc_135.tsv imag(i(vs135_p_0)) imag(i(vs135_p_1)) imag(i(vs135_p_2)) imag(i(vs135_p_3)) imag(i(vs135_p_4)) imag(i(vs135_p_5)) imag(i(vs135_p_6)) imag(i(vs135_p_7)) imag(i(vs135_p_8)) imag(i(vs135_p_9)) imag(i(vs135_p_10)) imag(i(vs135_p_11)) imag(i(vs135_p_12)) imag(i(vs135_n_0)) imag(i(vs135_n_1)) imag(i(vs135_n_2)) imag(i(vs135_n_3)) imag(i(vs135_n_4)) imag(i(vs135_n_5)) imag(i(vs135_n_6)) imag(i(vs135_n_7)) imag(i(vs135_n_8)) imag(i(vs135_n_9)) imag(i(vs135_n_10)) imag(i(vs135_n_11)) imag(i(vs135_n_12))
wrdata /repo/v2/analog/adc/results/cdac_mc_136.tsv imag(i(vs136_p_0)) imag(i(vs136_p_1)) imag(i(vs136_p_2)) imag(i(vs136_p_3)) imag(i(vs136_p_4)) imag(i(vs136_p_5)) imag(i(vs136_p_6)) imag(i(vs136_p_7)) imag(i(vs136_p_8)) imag(i(vs136_p_9)) imag(i(vs136_p_10)) imag(i(vs136_p_11)) imag(i(vs136_p_12)) imag(i(vs136_n_0)) imag(i(vs136_n_1)) imag(i(vs136_n_2)) imag(i(vs136_n_3)) imag(i(vs136_n_4)) imag(i(vs136_n_5)) imag(i(vs136_n_6)) imag(i(vs136_n_7)) imag(i(vs136_n_8)) imag(i(vs136_n_9)) imag(i(vs136_n_10)) imag(i(vs136_n_11)) imag(i(vs136_n_12))
wrdata /repo/v2/analog/adc/results/cdac_mc_137.tsv imag(i(vs137_p_0)) imag(i(vs137_p_1)) imag(i(vs137_p_2)) imag(i(vs137_p_3)) imag(i(vs137_p_4)) imag(i(vs137_p_5)) imag(i(vs137_p_6)) imag(i(vs137_p_7)) imag(i(vs137_p_8)) imag(i(vs137_p_9)) imag(i(vs137_p_10)) imag(i(vs137_p_11)) imag(i(vs137_p_12)) imag(i(vs137_n_0)) imag(i(vs137_n_1)) imag(i(vs137_n_2)) imag(i(vs137_n_3)) imag(i(vs137_n_4)) imag(i(vs137_n_5)) imag(i(vs137_n_6)) imag(i(vs137_n_7)) imag(i(vs137_n_8)) imag(i(vs137_n_9)) imag(i(vs137_n_10)) imag(i(vs137_n_11)) imag(i(vs137_n_12))
wrdata /repo/v2/analog/adc/results/cdac_mc_138.tsv imag(i(vs138_p_0)) imag(i(vs138_p_1)) imag(i(vs138_p_2)) imag(i(vs138_p_3)) imag(i(vs138_p_4)) imag(i(vs138_p_5)) imag(i(vs138_p_6)) imag(i(vs138_p_7)) imag(i(vs138_p_8)) imag(i(vs138_p_9)) imag(i(vs138_p_10)) imag(i(vs138_p_11)) imag(i(vs138_p_12)) imag(i(vs138_n_0)) imag(i(vs138_n_1)) imag(i(vs138_n_2)) imag(i(vs138_n_3)) imag(i(vs138_n_4)) imag(i(vs138_n_5)) imag(i(vs138_n_6)) imag(i(vs138_n_7)) imag(i(vs138_n_8)) imag(i(vs138_n_9)) imag(i(vs138_n_10)) imag(i(vs138_n_11)) imag(i(vs138_n_12))
wrdata /repo/v2/analog/adc/results/cdac_mc_139.tsv imag(i(vs139_p_0)) imag(i(vs139_p_1)) imag(i(vs139_p_2)) imag(i(vs139_p_3)) imag(i(vs139_p_4)) imag(i(vs139_p_5)) imag(i(vs139_p_6)) imag(i(vs139_p_7)) imag(i(vs139_p_8)) imag(i(vs139_p_9)) imag(i(vs139_p_10)) imag(i(vs139_p_11)) imag(i(vs139_p_12)) imag(i(vs139_n_0)) imag(i(vs139_n_1)) imag(i(vs139_n_2)) imag(i(vs139_n_3)) imag(i(vs139_n_4)) imag(i(vs139_n_5)) imag(i(vs139_n_6)) imag(i(vs139_n_7)) imag(i(vs139_n_8)) imag(i(vs139_n_9)) imag(i(vs139_n_10)) imag(i(vs139_n_11)) imag(i(vs139_n_12))
wrdata /repo/v2/analog/adc/results/cdac_mc_140.tsv imag(i(vs140_p_0)) imag(i(vs140_p_1)) imag(i(vs140_p_2)) imag(i(vs140_p_3)) imag(i(vs140_p_4)) imag(i(vs140_p_5)) imag(i(vs140_p_6)) imag(i(vs140_p_7)) imag(i(vs140_p_8)) imag(i(vs140_p_9)) imag(i(vs140_p_10)) imag(i(vs140_p_11)) imag(i(vs140_p_12)) imag(i(vs140_n_0)) imag(i(vs140_n_1)) imag(i(vs140_n_2)) imag(i(vs140_n_3)) imag(i(vs140_n_4)) imag(i(vs140_n_5)) imag(i(vs140_n_6)) imag(i(vs140_n_7)) imag(i(vs140_n_8)) imag(i(vs140_n_9)) imag(i(vs140_n_10)) imag(i(vs140_n_11)) imag(i(vs140_n_12))
wrdata /repo/v2/analog/adc/results/cdac_mc_141.tsv imag(i(vs141_p_0)) imag(i(vs141_p_1)) imag(i(vs141_p_2)) imag(i(vs141_p_3)) imag(i(vs141_p_4)) imag(i(vs141_p_5)) imag(i(vs141_p_6)) imag(i(vs141_p_7)) imag(i(vs141_p_8)) imag(i(vs141_p_9)) imag(i(vs141_p_10)) imag(i(vs141_p_11)) imag(i(vs141_p_12)) imag(i(vs141_n_0)) imag(i(vs141_n_1)) imag(i(vs141_n_2)) imag(i(vs141_n_3)) imag(i(vs141_n_4)) imag(i(vs141_n_5)) imag(i(vs141_n_6)) imag(i(vs141_n_7)) imag(i(vs141_n_8)) imag(i(vs141_n_9)) imag(i(vs141_n_10)) imag(i(vs141_n_11)) imag(i(vs141_n_12))
wrdata /repo/v2/analog/adc/results/cdac_mc_142.tsv imag(i(vs142_p_0)) imag(i(vs142_p_1)) imag(i(vs142_p_2)) imag(i(vs142_p_3)) imag(i(vs142_p_4)) imag(i(vs142_p_5)) imag(i(vs142_p_6)) imag(i(vs142_p_7)) imag(i(vs142_p_8)) imag(i(vs142_p_9)) imag(i(vs142_p_10)) imag(i(vs142_p_11)) imag(i(vs142_p_12)) imag(i(vs142_n_0)) imag(i(vs142_n_1)) imag(i(vs142_n_2)) imag(i(vs142_n_3)) imag(i(vs142_n_4)) imag(i(vs142_n_5)) imag(i(vs142_n_6)) imag(i(vs142_n_7)) imag(i(vs142_n_8)) imag(i(vs142_n_9)) imag(i(vs142_n_10)) imag(i(vs142_n_11)) imag(i(vs142_n_12))
wrdata /repo/v2/analog/adc/results/cdac_mc_143.tsv imag(i(vs143_p_0)) imag(i(vs143_p_1)) imag(i(vs143_p_2)) imag(i(vs143_p_3)) imag(i(vs143_p_4)) imag(i(vs143_p_5)) imag(i(vs143_p_6)) imag(i(vs143_p_7)) imag(i(vs143_p_8)) imag(i(vs143_p_9)) imag(i(vs143_p_10)) imag(i(vs143_p_11)) imag(i(vs143_p_12)) imag(i(vs143_n_0)) imag(i(vs143_n_1)) imag(i(vs143_n_2)) imag(i(vs143_n_3)) imag(i(vs143_n_4)) imag(i(vs143_n_5)) imag(i(vs143_n_6)) imag(i(vs143_n_7)) imag(i(vs143_n_8)) imag(i(vs143_n_9)) imag(i(vs143_n_10)) imag(i(vs143_n_11)) imag(i(vs143_n_12))
wrdata /repo/v2/analog/adc/results/cdac_mc_144.tsv imag(i(vs144_p_0)) imag(i(vs144_p_1)) imag(i(vs144_p_2)) imag(i(vs144_p_3)) imag(i(vs144_p_4)) imag(i(vs144_p_5)) imag(i(vs144_p_6)) imag(i(vs144_p_7)) imag(i(vs144_p_8)) imag(i(vs144_p_9)) imag(i(vs144_p_10)) imag(i(vs144_p_11)) imag(i(vs144_p_12)) imag(i(vs144_n_0)) imag(i(vs144_n_1)) imag(i(vs144_n_2)) imag(i(vs144_n_3)) imag(i(vs144_n_4)) imag(i(vs144_n_5)) imag(i(vs144_n_6)) imag(i(vs144_n_7)) imag(i(vs144_n_8)) imag(i(vs144_n_9)) imag(i(vs144_n_10)) imag(i(vs144_n_11)) imag(i(vs144_n_12))
wrdata /repo/v2/analog/adc/results/cdac_mc_145.tsv imag(i(vs145_p_0)) imag(i(vs145_p_1)) imag(i(vs145_p_2)) imag(i(vs145_p_3)) imag(i(vs145_p_4)) imag(i(vs145_p_5)) imag(i(vs145_p_6)) imag(i(vs145_p_7)) imag(i(vs145_p_8)) imag(i(vs145_p_9)) imag(i(vs145_p_10)) imag(i(vs145_p_11)) imag(i(vs145_p_12)) imag(i(vs145_n_0)) imag(i(vs145_n_1)) imag(i(vs145_n_2)) imag(i(vs145_n_3)) imag(i(vs145_n_4)) imag(i(vs145_n_5)) imag(i(vs145_n_6)) imag(i(vs145_n_7)) imag(i(vs145_n_8)) imag(i(vs145_n_9)) imag(i(vs145_n_10)) imag(i(vs145_n_11)) imag(i(vs145_n_12))
wrdata /repo/v2/analog/adc/results/cdac_mc_146.tsv imag(i(vs146_p_0)) imag(i(vs146_p_1)) imag(i(vs146_p_2)) imag(i(vs146_p_3)) imag(i(vs146_p_4)) imag(i(vs146_p_5)) imag(i(vs146_p_6)) imag(i(vs146_p_7)) imag(i(vs146_p_8)) imag(i(vs146_p_9)) imag(i(vs146_p_10)) imag(i(vs146_p_11)) imag(i(vs146_p_12)) imag(i(vs146_n_0)) imag(i(vs146_n_1)) imag(i(vs146_n_2)) imag(i(vs146_n_3)) imag(i(vs146_n_4)) imag(i(vs146_n_5)) imag(i(vs146_n_6)) imag(i(vs146_n_7)) imag(i(vs146_n_8)) imag(i(vs146_n_9)) imag(i(vs146_n_10)) imag(i(vs146_n_11)) imag(i(vs146_n_12))
wrdata /repo/v2/analog/adc/results/cdac_mc_147.tsv imag(i(vs147_p_0)) imag(i(vs147_p_1)) imag(i(vs147_p_2)) imag(i(vs147_p_3)) imag(i(vs147_p_4)) imag(i(vs147_p_5)) imag(i(vs147_p_6)) imag(i(vs147_p_7)) imag(i(vs147_p_8)) imag(i(vs147_p_9)) imag(i(vs147_p_10)) imag(i(vs147_p_11)) imag(i(vs147_p_12)) imag(i(vs147_n_0)) imag(i(vs147_n_1)) imag(i(vs147_n_2)) imag(i(vs147_n_3)) imag(i(vs147_n_4)) imag(i(vs147_n_5)) imag(i(vs147_n_6)) imag(i(vs147_n_7)) imag(i(vs147_n_8)) imag(i(vs147_n_9)) imag(i(vs147_n_10)) imag(i(vs147_n_11)) imag(i(vs147_n_12))
wrdata /repo/v2/analog/adc/results/cdac_mc_148.tsv imag(i(vs148_p_0)) imag(i(vs148_p_1)) imag(i(vs148_p_2)) imag(i(vs148_p_3)) imag(i(vs148_p_4)) imag(i(vs148_p_5)) imag(i(vs148_p_6)) imag(i(vs148_p_7)) imag(i(vs148_p_8)) imag(i(vs148_p_9)) imag(i(vs148_p_10)) imag(i(vs148_p_11)) imag(i(vs148_p_12)) imag(i(vs148_n_0)) imag(i(vs148_n_1)) imag(i(vs148_n_2)) imag(i(vs148_n_3)) imag(i(vs148_n_4)) imag(i(vs148_n_5)) imag(i(vs148_n_6)) imag(i(vs148_n_7)) imag(i(vs148_n_8)) imag(i(vs148_n_9)) imag(i(vs148_n_10)) imag(i(vs148_n_11)) imag(i(vs148_n_12))
wrdata /repo/v2/analog/adc/results/cdac_mc_149.tsv imag(i(vs149_p_0)) imag(i(vs149_p_1)) imag(i(vs149_p_2)) imag(i(vs149_p_3)) imag(i(vs149_p_4)) imag(i(vs149_p_5)) imag(i(vs149_p_6)) imag(i(vs149_p_7)) imag(i(vs149_p_8)) imag(i(vs149_p_9)) imag(i(vs149_p_10)) imag(i(vs149_p_11)) imag(i(vs149_p_12)) imag(i(vs149_n_0)) imag(i(vs149_n_1)) imag(i(vs149_n_2)) imag(i(vs149_n_3)) imag(i(vs149_n_4)) imag(i(vs149_n_5)) imag(i(vs149_n_6)) imag(i(vs149_n_7)) imag(i(vs149_n_8)) imag(i(vs149_n_9)) imag(i(vs149_n_10)) imag(i(vs149_n_11)) imag(i(vs149_n_12))
wrdata /repo/v2/analog/adc/results/cdac_mc_150.tsv imag(i(vs150_p_0)) imag(i(vs150_p_1)) imag(i(vs150_p_2)) imag(i(vs150_p_3)) imag(i(vs150_p_4)) imag(i(vs150_p_5)) imag(i(vs150_p_6)) imag(i(vs150_p_7)) imag(i(vs150_p_8)) imag(i(vs150_p_9)) imag(i(vs150_p_10)) imag(i(vs150_p_11)) imag(i(vs150_p_12)) imag(i(vs150_n_0)) imag(i(vs150_n_1)) imag(i(vs150_n_2)) imag(i(vs150_n_3)) imag(i(vs150_n_4)) imag(i(vs150_n_5)) imag(i(vs150_n_6)) imag(i(vs150_n_7)) imag(i(vs150_n_8)) imag(i(vs150_n_9)) imag(i(vs150_n_10)) imag(i(vs150_n_11)) imag(i(vs150_n_12))
wrdata /repo/v2/analog/adc/results/cdac_mc_151.tsv imag(i(vs151_p_0)) imag(i(vs151_p_1)) imag(i(vs151_p_2)) imag(i(vs151_p_3)) imag(i(vs151_p_4)) imag(i(vs151_p_5)) imag(i(vs151_p_6)) imag(i(vs151_p_7)) imag(i(vs151_p_8)) imag(i(vs151_p_9)) imag(i(vs151_p_10)) imag(i(vs151_p_11)) imag(i(vs151_p_12)) imag(i(vs151_n_0)) imag(i(vs151_n_1)) imag(i(vs151_n_2)) imag(i(vs151_n_3)) imag(i(vs151_n_4)) imag(i(vs151_n_5)) imag(i(vs151_n_6)) imag(i(vs151_n_7)) imag(i(vs151_n_8)) imag(i(vs151_n_9)) imag(i(vs151_n_10)) imag(i(vs151_n_11)) imag(i(vs151_n_12))
wrdata /repo/v2/analog/adc/results/cdac_mc_152.tsv imag(i(vs152_p_0)) imag(i(vs152_p_1)) imag(i(vs152_p_2)) imag(i(vs152_p_3)) imag(i(vs152_p_4)) imag(i(vs152_p_5)) imag(i(vs152_p_6)) imag(i(vs152_p_7)) imag(i(vs152_p_8)) imag(i(vs152_p_9)) imag(i(vs152_p_10)) imag(i(vs152_p_11)) imag(i(vs152_p_12)) imag(i(vs152_n_0)) imag(i(vs152_n_1)) imag(i(vs152_n_2)) imag(i(vs152_n_3)) imag(i(vs152_n_4)) imag(i(vs152_n_5)) imag(i(vs152_n_6)) imag(i(vs152_n_7)) imag(i(vs152_n_8)) imag(i(vs152_n_9)) imag(i(vs152_n_10)) imag(i(vs152_n_11)) imag(i(vs152_n_12))
wrdata /repo/v2/analog/adc/results/cdac_mc_153.tsv imag(i(vs153_p_0)) imag(i(vs153_p_1)) imag(i(vs153_p_2)) imag(i(vs153_p_3)) imag(i(vs153_p_4)) imag(i(vs153_p_5)) imag(i(vs153_p_6)) imag(i(vs153_p_7)) imag(i(vs153_p_8)) imag(i(vs153_p_9)) imag(i(vs153_p_10)) imag(i(vs153_p_11)) imag(i(vs153_p_12)) imag(i(vs153_n_0)) imag(i(vs153_n_1)) imag(i(vs153_n_2)) imag(i(vs153_n_3)) imag(i(vs153_n_4)) imag(i(vs153_n_5)) imag(i(vs153_n_6)) imag(i(vs153_n_7)) imag(i(vs153_n_8)) imag(i(vs153_n_9)) imag(i(vs153_n_10)) imag(i(vs153_n_11)) imag(i(vs153_n_12))
wrdata /repo/v2/analog/adc/results/cdac_mc_154.tsv imag(i(vs154_p_0)) imag(i(vs154_p_1)) imag(i(vs154_p_2)) imag(i(vs154_p_3)) imag(i(vs154_p_4)) imag(i(vs154_p_5)) imag(i(vs154_p_6)) imag(i(vs154_p_7)) imag(i(vs154_p_8)) imag(i(vs154_p_9)) imag(i(vs154_p_10)) imag(i(vs154_p_11)) imag(i(vs154_p_12)) imag(i(vs154_n_0)) imag(i(vs154_n_1)) imag(i(vs154_n_2)) imag(i(vs154_n_3)) imag(i(vs154_n_4)) imag(i(vs154_n_5)) imag(i(vs154_n_6)) imag(i(vs154_n_7)) imag(i(vs154_n_8)) imag(i(vs154_n_9)) imag(i(vs154_n_10)) imag(i(vs154_n_11)) imag(i(vs154_n_12))
wrdata /repo/v2/analog/adc/results/cdac_mc_155.tsv imag(i(vs155_p_0)) imag(i(vs155_p_1)) imag(i(vs155_p_2)) imag(i(vs155_p_3)) imag(i(vs155_p_4)) imag(i(vs155_p_5)) imag(i(vs155_p_6)) imag(i(vs155_p_7)) imag(i(vs155_p_8)) imag(i(vs155_p_9)) imag(i(vs155_p_10)) imag(i(vs155_p_11)) imag(i(vs155_p_12)) imag(i(vs155_n_0)) imag(i(vs155_n_1)) imag(i(vs155_n_2)) imag(i(vs155_n_3)) imag(i(vs155_n_4)) imag(i(vs155_n_5)) imag(i(vs155_n_6)) imag(i(vs155_n_7)) imag(i(vs155_n_8)) imag(i(vs155_n_9)) imag(i(vs155_n_10)) imag(i(vs155_n_11)) imag(i(vs155_n_12))
wrdata /repo/v2/analog/adc/results/cdac_mc_156.tsv imag(i(vs156_p_0)) imag(i(vs156_p_1)) imag(i(vs156_p_2)) imag(i(vs156_p_3)) imag(i(vs156_p_4)) imag(i(vs156_p_5)) imag(i(vs156_p_6)) imag(i(vs156_p_7)) imag(i(vs156_p_8)) imag(i(vs156_p_9)) imag(i(vs156_p_10)) imag(i(vs156_p_11)) imag(i(vs156_p_12)) imag(i(vs156_n_0)) imag(i(vs156_n_1)) imag(i(vs156_n_2)) imag(i(vs156_n_3)) imag(i(vs156_n_4)) imag(i(vs156_n_5)) imag(i(vs156_n_6)) imag(i(vs156_n_7)) imag(i(vs156_n_8)) imag(i(vs156_n_9)) imag(i(vs156_n_10)) imag(i(vs156_n_11)) imag(i(vs156_n_12))
wrdata /repo/v2/analog/adc/results/cdac_mc_157.tsv imag(i(vs157_p_0)) imag(i(vs157_p_1)) imag(i(vs157_p_2)) imag(i(vs157_p_3)) imag(i(vs157_p_4)) imag(i(vs157_p_5)) imag(i(vs157_p_6)) imag(i(vs157_p_7)) imag(i(vs157_p_8)) imag(i(vs157_p_9)) imag(i(vs157_p_10)) imag(i(vs157_p_11)) imag(i(vs157_p_12)) imag(i(vs157_n_0)) imag(i(vs157_n_1)) imag(i(vs157_n_2)) imag(i(vs157_n_3)) imag(i(vs157_n_4)) imag(i(vs157_n_5)) imag(i(vs157_n_6)) imag(i(vs157_n_7)) imag(i(vs157_n_8)) imag(i(vs157_n_9)) imag(i(vs157_n_10)) imag(i(vs157_n_11)) imag(i(vs157_n_12))
wrdata /repo/v2/analog/adc/results/cdac_mc_158.tsv imag(i(vs158_p_0)) imag(i(vs158_p_1)) imag(i(vs158_p_2)) imag(i(vs158_p_3)) imag(i(vs158_p_4)) imag(i(vs158_p_5)) imag(i(vs158_p_6)) imag(i(vs158_p_7)) imag(i(vs158_p_8)) imag(i(vs158_p_9)) imag(i(vs158_p_10)) imag(i(vs158_p_11)) imag(i(vs158_p_12)) imag(i(vs158_n_0)) imag(i(vs158_n_1)) imag(i(vs158_n_2)) imag(i(vs158_n_3)) imag(i(vs158_n_4)) imag(i(vs158_n_5)) imag(i(vs158_n_6)) imag(i(vs158_n_7)) imag(i(vs158_n_8)) imag(i(vs158_n_9)) imag(i(vs158_n_10)) imag(i(vs158_n_11)) imag(i(vs158_n_12))
wrdata /repo/v2/analog/adc/results/cdac_mc_159.tsv imag(i(vs159_p_0)) imag(i(vs159_p_1)) imag(i(vs159_p_2)) imag(i(vs159_p_3)) imag(i(vs159_p_4)) imag(i(vs159_p_5)) imag(i(vs159_p_6)) imag(i(vs159_p_7)) imag(i(vs159_p_8)) imag(i(vs159_p_9)) imag(i(vs159_p_10)) imag(i(vs159_p_11)) imag(i(vs159_p_12)) imag(i(vs159_n_0)) imag(i(vs159_n_1)) imag(i(vs159_n_2)) imag(i(vs159_n_3)) imag(i(vs159_n_4)) imag(i(vs159_n_5)) imag(i(vs159_n_6)) imag(i(vs159_n_7)) imag(i(vs159_n_8)) imag(i(vs159_n_9)) imag(i(vs159_n_10)) imag(i(vs159_n_11)) imag(i(vs159_n_12))
wrdata /repo/v2/analog/adc/results/cdac_mc_160.tsv imag(i(vs160_p_0)) imag(i(vs160_p_1)) imag(i(vs160_p_2)) imag(i(vs160_p_3)) imag(i(vs160_p_4)) imag(i(vs160_p_5)) imag(i(vs160_p_6)) imag(i(vs160_p_7)) imag(i(vs160_p_8)) imag(i(vs160_p_9)) imag(i(vs160_p_10)) imag(i(vs160_p_11)) imag(i(vs160_p_12)) imag(i(vs160_n_0)) imag(i(vs160_n_1)) imag(i(vs160_n_2)) imag(i(vs160_n_3)) imag(i(vs160_n_4)) imag(i(vs160_n_5)) imag(i(vs160_n_6)) imag(i(vs160_n_7)) imag(i(vs160_n_8)) imag(i(vs160_n_9)) imag(i(vs160_n_10)) imag(i(vs160_n_11)) imag(i(vs160_n_12))
wrdata /repo/v2/analog/adc/results/cdac_mc_161.tsv imag(i(vs161_p_0)) imag(i(vs161_p_1)) imag(i(vs161_p_2)) imag(i(vs161_p_3)) imag(i(vs161_p_4)) imag(i(vs161_p_5)) imag(i(vs161_p_6)) imag(i(vs161_p_7)) imag(i(vs161_p_8)) imag(i(vs161_p_9)) imag(i(vs161_p_10)) imag(i(vs161_p_11)) imag(i(vs161_p_12)) imag(i(vs161_n_0)) imag(i(vs161_n_1)) imag(i(vs161_n_2)) imag(i(vs161_n_3)) imag(i(vs161_n_4)) imag(i(vs161_n_5)) imag(i(vs161_n_6)) imag(i(vs161_n_7)) imag(i(vs161_n_8)) imag(i(vs161_n_9)) imag(i(vs161_n_10)) imag(i(vs161_n_11)) imag(i(vs161_n_12))
wrdata /repo/v2/analog/adc/results/cdac_mc_162.tsv imag(i(vs162_p_0)) imag(i(vs162_p_1)) imag(i(vs162_p_2)) imag(i(vs162_p_3)) imag(i(vs162_p_4)) imag(i(vs162_p_5)) imag(i(vs162_p_6)) imag(i(vs162_p_7)) imag(i(vs162_p_8)) imag(i(vs162_p_9)) imag(i(vs162_p_10)) imag(i(vs162_p_11)) imag(i(vs162_p_12)) imag(i(vs162_n_0)) imag(i(vs162_n_1)) imag(i(vs162_n_2)) imag(i(vs162_n_3)) imag(i(vs162_n_4)) imag(i(vs162_n_5)) imag(i(vs162_n_6)) imag(i(vs162_n_7)) imag(i(vs162_n_8)) imag(i(vs162_n_9)) imag(i(vs162_n_10)) imag(i(vs162_n_11)) imag(i(vs162_n_12))
wrdata /repo/v2/analog/adc/results/cdac_mc_163.tsv imag(i(vs163_p_0)) imag(i(vs163_p_1)) imag(i(vs163_p_2)) imag(i(vs163_p_3)) imag(i(vs163_p_4)) imag(i(vs163_p_5)) imag(i(vs163_p_6)) imag(i(vs163_p_7)) imag(i(vs163_p_8)) imag(i(vs163_p_9)) imag(i(vs163_p_10)) imag(i(vs163_p_11)) imag(i(vs163_p_12)) imag(i(vs163_n_0)) imag(i(vs163_n_1)) imag(i(vs163_n_2)) imag(i(vs163_n_3)) imag(i(vs163_n_4)) imag(i(vs163_n_5)) imag(i(vs163_n_6)) imag(i(vs163_n_7)) imag(i(vs163_n_8)) imag(i(vs163_n_9)) imag(i(vs163_n_10)) imag(i(vs163_n_11)) imag(i(vs163_n_12))
wrdata /repo/v2/analog/adc/results/cdac_mc_164.tsv imag(i(vs164_p_0)) imag(i(vs164_p_1)) imag(i(vs164_p_2)) imag(i(vs164_p_3)) imag(i(vs164_p_4)) imag(i(vs164_p_5)) imag(i(vs164_p_6)) imag(i(vs164_p_7)) imag(i(vs164_p_8)) imag(i(vs164_p_9)) imag(i(vs164_p_10)) imag(i(vs164_p_11)) imag(i(vs164_p_12)) imag(i(vs164_n_0)) imag(i(vs164_n_1)) imag(i(vs164_n_2)) imag(i(vs164_n_3)) imag(i(vs164_n_4)) imag(i(vs164_n_5)) imag(i(vs164_n_6)) imag(i(vs164_n_7)) imag(i(vs164_n_8)) imag(i(vs164_n_9)) imag(i(vs164_n_10)) imag(i(vs164_n_11)) imag(i(vs164_n_12))
wrdata /repo/v2/analog/adc/results/cdac_mc_165.tsv imag(i(vs165_p_0)) imag(i(vs165_p_1)) imag(i(vs165_p_2)) imag(i(vs165_p_3)) imag(i(vs165_p_4)) imag(i(vs165_p_5)) imag(i(vs165_p_6)) imag(i(vs165_p_7)) imag(i(vs165_p_8)) imag(i(vs165_p_9)) imag(i(vs165_p_10)) imag(i(vs165_p_11)) imag(i(vs165_p_12)) imag(i(vs165_n_0)) imag(i(vs165_n_1)) imag(i(vs165_n_2)) imag(i(vs165_n_3)) imag(i(vs165_n_4)) imag(i(vs165_n_5)) imag(i(vs165_n_6)) imag(i(vs165_n_7)) imag(i(vs165_n_8)) imag(i(vs165_n_9)) imag(i(vs165_n_10)) imag(i(vs165_n_11)) imag(i(vs165_n_12))
wrdata /repo/v2/analog/adc/results/cdac_mc_166.tsv imag(i(vs166_p_0)) imag(i(vs166_p_1)) imag(i(vs166_p_2)) imag(i(vs166_p_3)) imag(i(vs166_p_4)) imag(i(vs166_p_5)) imag(i(vs166_p_6)) imag(i(vs166_p_7)) imag(i(vs166_p_8)) imag(i(vs166_p_9)) imag(i(vs166_p_10)) imag(i(vs166_p_11)) imag(i(vs166_p_12)) imag(i(vs166_n_0)) imag(i(vs166_n_1)) imag(i(vs166_n_2)) imag(i(vs166_n_3)) imag(i(vs166_n_4)) imag(i(vs166_n_5)) imag(i(vs166_n_6)) imag(i(vs166_n_7)) imag(i(vs166_n_8)) imag(i(vs166_n_9)) imag(i(vs166_n_10)) imag(i(vs166_n_11)) imag(i(vs166_n_12))
wrdata /repo/v2/analog/adc/results/cdac_mc_167.tsv imag(i(vs167_p_0)) imag(i(vs167_p_1)) imag(i(vs167_p_2)) imag(i(vs167_p_3)) imag(i(vs167_p_4)) imag(i(vs167_p_5)) imag(i(vs167_p_6)) imag(i(vs167_p_7)) imag(i(vs167_p_8)) imag(i(vs167_p_9)) imag(i(vs167_p_10)) imag(i(vs167_p_11)) imag(i(vs167_p_12)) imag(i(vs167_n_0)) imag(i(vs167_n_1)) imag(i(vs167_n_2)) imag(i(vs167_n_3)) imag(i(vs167_n_4)) imag(i(vs167_n_5)) imag(i(vs167_n_6)) imag(i(vs167_n_7)) imag(i(vs167_n_8)) imag(i(vs167_n_9)) imag(i(vs167_n_10)) imag(i(vs167_n_11)) imag(i(vs167_n_12))
wrdata /repo/v2/analog/adc/results/cdac_mc_168.tsv imag(i(vs168_p_0)) imag(i(vs168_p_1)) imag(i(vs168_p_2)) imag(i(vs168_p_3)) imag(i(vs168_p_4)) imag(i(vs168_p_5)) imag(i(vs168_p_6)) imag(i(vs168_p_7)) imag(i(vs168_p_8)) imag(i(vs168_p_9)) imag(i(vs168_p_10)) imag(i(vs168_p_11)) imag(i(vs168_p_12)) imag(i(vs168_n_0)) imag(i(vs168_n_1)) imag(i(vs168_n_2)) imag(i(vs168_n_3)) imag(i(vs168_n_4)) imag(i(vs168_n_5)) imag(i(vs168_n_6)) imag(i(vs168_n_7)) imag(i(vs168_n_8)) imag(i(vs168_n_9)) imag(i(vs168_n_10)) imag(i(vs168_n_11)) imag(i(vs168_n_12))
wrdata /repo/v2/analog/adc/results/cdac_mc_169.tsv imag(i(vs169_p_0)) imag(i(vs169_p_1)) imag(i(vs169_p_2)) imag(i(vs169_p_3)) imag(i(vs169_p_4)) imag(i(vs169_p_5)) imag(i(vs169_p_6)) imag(i(vs169_p_7)) imag(i(vs169_p_8)) imag(i(vs169_p_9)) imag(i(vs169_p_10)) imag(i(vs169_p_11)) imag(i(vs169_p_12)) imag(i(vs169_n_0)) imag(i(vs169_n_1)) imag(i(vs169_n_2)) imag(i(vs169_n_3)) imag(i(vs169_n_4)) imag(i(vs169_n_5)) imag(i(vs169_n_6)) imag(i(vs169_n_7)) imag(i(vs169_n_8)) imag(i(vs169_n_9)) imag(i(vs169_n_10)) imag(i(vs169_n_11)) imag(i(vs169_n_12))
wrdata /repo/v2/analog/adc/results/cdac_mc_170.tsv imag(i(vs170_p_0)) imag(i(vs170_p_1)) imag(i(vs170_p_2)) imag(i(vs170_p_3)) imag(i(vs170_p_4)) imag(i(vs170_p_5)) imag(i(vs170_p_6)) imag(i(vs170_p_7)) imag(i(vs170_p_8)) imag(i(vs170_p_9)) imag(i(vs170_p_10)) imag(i(vs170_p_11)) imag(i(vs170_p_12)) imag(i(vs170_n_0)) imag(i(vs170_n_1)) imag(i(vs170_n_2)) imag(i(vs170_n_3)) imag(i(vs170_n_4)) imag(i(vs170_n_5)) imag(i(vs170_n_6)) imag(i(vs170_n_7)) imag(i(vs170_n_8)) imag(i(vs170_n_9)) imag(i(vs170_n_10)) imag(i(vs170_n_11)) imag(i(vs170_n_12))
wrdata /repo/v2/analog/adc/results/cdac_mc_171.tsv imag(i(vs171_p_0)) imag(i(vs171_p_1)) imag(i(vs171_p_2)) imag(i(vs171_p_3)) imag(i(vs171_p_4)) imag(i(vs171_p_5)) imag(i(vs171_p_6)) imag(i(vs171_p_7)) imag(i(vs171_p_8)) imag(i(vs171_p_9)) imag(i(vs171_p_10)) imag(i(vs171_p_11)) imag(i(vs171_p_12)) imag(i(vs171_n_0)) imag(i(vs171_n_1)) imag(i(vs171_n_2)) imag(i(vs171_n_3)) imag(i(vs171_n_4)) imag(i(vs171_n_5)) imag(i(vs171_n_6)) imag(i(vs171_n_7)) imag(i(vs171_n_8)) imag(i(vs171_n_9)) imag(i(vs171_n_10)) imag(i(vs171_n_11)) imag(i(vs171_n_12))
wrdata /repo/v2/analog/adc/results/cdac_mc_172.tsv imag(i(vs172_p_0)) imag(i(vs172_p_1)) imag(i(vs172_p_2)) imag(i(vs172_p_3)) imag(i(vs172_p_4)) imag(i(vs172_p_5)) imag(i(vs172_p_6)) imag(i(vs172_p_7)) imag(i(vs172_p_8)) imag(i(vs172_p_9)) imag(i(vs172_p_10)) imag(i(vs172_p_11)) imag(i(vs172_p_12)) imag(i(vs172_n_0)) imag(i(vs172_n_1)) imag(i(vs172_n_2)) imag(i(vs172_n_3)) imag(i(vs172_n_4)) imag(i(vs172_n_5)) imag(i(vs172_n_6)) imag(i(vs172_n_7)) imag(i(vs172_n_8)) imag(i(vs172_n_9)) imag(i(vs172_n_10)) imag(i(vs172_n_11)) imag(i(vs172_n_12))
wrdata /repo/v2/analog/adc/results/cdac_mc_173.tsv imag(i(vs173_p_0)) imag(i(vs173_p_1)) imag(i(vs173_p_2)) imag(i(vs173_p_3)) imag(i(vs173_p_4)) imag(i(vs173_p_5)) imag(i(vs173_p_6)) imag(i(vs173_p_7)) imag(i(vs173_p_8)) imag(i(vs173_p_9)) imag(i(vs173_p_10)) imag(i(vs173_p_11)) imag(i(vs173_p_12)) imag(i(vs173_n_0)) imag(i(vs173_n_1)) imag(i(vs173_n_2)) imag(i(vs173_n_3)) imag(i(vs173_n_4)) imag(i(vs173_n_5)) imag(i(vs173_n_6)) imag(i(vs173_n_7)) imag(i(vs173_n_8)) imag(i(vs173_n_9)) imag(i(vs173_n_10)) imag(i(vs173_n_11)) imag(i(vs173_n_12))
wrdata /repo/v2/analog/adc/results/cdac_mc_174.tsv imag(i(vs174_p_0)) imag(i(vs174_p_1)) imag(i(vs174_p_2)) imag(i(vs174_p_3)) imag(i(vs174_p_4)) imag(i(vs174_p_5)) imag(i(vs174_p_6)) imag(i(vs174_p_7)) imag(i(vs174_p_8)) imag(i(vs174_p_9)) imag(i(vs174_p_10)) imag(i(vs174_p_11)) imag(i(vs174_p_12)) imag(i(vs174_n_0)) imag(i(vs174_n_1)) imag(i(vs174_n_2)) imag(i(vs174_n_3)) imag(i(vs174_n_4)) imag(i(vs174_n_5)) imag(i(vs174_n_6)) imag(i(vs174_n_7)) imag(i(vs174_n_8)) imag(i(vs174_n_9)) imag(i(vs174_n_10)) imag(i(vs174_n_11)) imag(i(vs174_n_12))
wrdata /repo/v2/analog/adc/results/cdac_mc_175.tsv imag(i(vs175_p_0)) imag(i(vs175_p_1)) imag(i(vs175_p_2)) imag(i(vs175_p_3)) imag(i(vs175_p_4)) imag(i(vs175_p_5)) imag(i(vs175_p_6)) imag(i(vs175_p_7)) imag(i(vs175_p_8)) imag(i(vs175_p_9)) imag(i(vs175_p_10)) imag(i(vs175_p_11)) imag(i(vs175_p_12)) imag(i(vs175_n_0)) imag(i(vs175_n_1)) imag(i(vs175_n_2)) imag(i(vs175_n_3)) imag(i(vs175_n_4)) imag(i(vs175_n_5)) imag(i(vs175_n_6)) imag(i(vs175_n_7)) imag(i(vs175_n_8)) imag(i(vs175_n_9)) imag(i(vs175_n_10)) imag(i(vs175_n_11)) imag(i(vs175_n_12))
wrdata /repo/v2/analog/adc/results/cdac_mc_176.tsv imag(i(vs176_p_0)) imag(i(vs176_p_1)) imag(i(vs176_p_2)) imag(i(vs176_p_3)) imag(i(vs176_p_4)) imag(i(vs176_p_5)) imag(i(vs176_p_6)) imag(i(vs176_p_7)) imag(i(vs176_p_8)) imag(i(vs176_p_9)) imag(i(vs176_p_10)) imag(i(vs176_p_11)) imag(i(vs176_p_12)) imag(i(vs176_n_0)) imag(i(vs176_n_1)) imag(i(vs176_n_2)) imag(i(vs176_n_3)) imag(i(vs176_n_4)) imag(i(vs176_n_5)) imag(i(vs176_n_6)) imag(i(vs176_n_7)) imag(i(vs176_n_8)) imag(i(vs176_n_9)) imag(i(vs176_n_10)) imag(i(vs176_n_11)) imag(i(vs176_n_12))
wrdata /repo/v2/analog/adc/results/cdac_mc_177.tsv imag(i(vs177_p_0)) imag(i(vs177_p_1)) imag(i(vs177_p_2)) imag(i(vs177_p_3)) imag(i(vs177_p_4)) imag(i(vs177_p_5)) imag(i(vs177_p_6)) imag(i(vs177_p_7)) imag(i(vs177_p_8)) imag(i(vs177_p_9)) imag(i(vs177_p_10)) imag(i(vs177_p_11)) imag(i(vs177_p_12)) imag(i(vs177_n_0)) imag(i(vs177_n_1)) imag(i(vs177_n_2)) imag(i(vs177_n_3)) imag(i(vs177_n_4)) imag(i(vs177_n_5)) imag(i(vs177_n_6)) imag(i(vs177_n_7)) imag(i(vs177_n_8)) imag(i(vs177_n_9)) imag(i(vs177_n_10)) imag(i(vs177_n_11)) imag(i(vs177_n_12))
wrdata /repo/v2/analog/adc/results/cdac_mc_178.tsv imag(i(vs178_p_0)) imag(i(vs178_p_1)) imag(i(vs178_p_2)) imag(i(vs178_p_3)) imag(i(vs178_p_4)) imag(i(vs178_p_5)) imag(i(vs178_p_6)) imag(i(vs178_p_7)) imag(i(vs178_p_8)) imag(i(vs178_p_9)) imag(i(vs178_p_10)) imag(i(vs178_p_11)) imag(i(vs178_p_12)) imag(i(vs178_n_0)) imag(i(vs178_n_1)) imag(i(vs178_n_2)) imag(i(vs178_n_3)) imag(i(vs178_n_4)) imag(i(vs178_n_5)) imag(i(vs178_n_6)) imag(i(vs178_n_7)) imag(i(vs178_n_8)) imag(i(vs178_n_9)) imag(i(vs178_n_10)) imag(i(vs178_n_11)) imag(i(vs178_n_12))
wrdata /repo/v2/analog/adc/results/cdac_mc_179.tsv imag(i(vs179_p_0)) imag(i(vs179_p_1)) imag(i(vs179_p_2)) imag(i(vs179_p_3)) imag(i(vs179_p_4)) imag(i(vs179_p_5)) imag(i(vs179_p_6)) imag(i(vs179_p_7)) imag(i(vs179_p_8)) imag(i(vs179_p_9)) imag(i(vs179_p_10)) imag(i(vs179_p_11)) imag(i(vs179_p_12)) imag(i(vs179_n_0)) imag(i(vs179_n_1)) imag(i(vs179_n_2)) imag(i(vs179_n_3)) imag(i(vs179_n_4)) imag(i(vs179_n_5)) imag(i(vs179_n_6)) imag(i(vs179_n_7)) imag(i(vs179_n_8)) imag(i(vs179_n_9)) imag(i(vs179_n_10)) imag(i(vs179_n_11)) imag(i(vs179_n_12))
wrdata /repo/v2/analog/adc/results/cdac_mc_180.tsv imag(i(vs180_p_0)) imag(i(vs180_p_1)) imag(i(vs180_p_2)) imag(i(vs180_p_3)) imag(i(vs180_p_4)) imag(i(vs180_p_5)) imag(i(vs180_p_6)) imag(i(vs180_p_7)) imag(i(vs180_p_8)) imag(i(vs180_p_9)) imag(i(vs180_p_10)) imag(i(vs180_p_11)) imag(i(vs180_p_12)) imag(i(vs180_n_0)) imag(i(vs180_n_1)) imag(i(vs180_n_2)) imag(i(vs180_n_3)) imag(i(vs180_n_4)) imag(i(vs180_n_5)) imag(i(vs180_n_6)) imag(i(vs180_n_7)) imag(i(vs180_n_8)) imag(i(vs180_n_9)) imag(i(vs180_n_10)) imag(i(vs180_n_11)) imag(i(vs180_n_12))
wrdata /repo/v2/analog/adc/results/cdac_mc_181.tsv imag(i(vs181_p_0)) imag(i(vs181_p_1)) imag(i(vs181_p_2)) imag(i(vs181_p_3)) imag(i(vs181_p_4)) imag(i(vs181_p_5)) imag(i(vs181_p_6)) imag(i(vs181_p_7)) imag(i(vs181_p_8)) imag(i(vs181_p_9)) imag(i(vs181_p_10)) imag(i(vs181_p_11)) imag(i(vs181_p_12)) imag(i(vs181_n_0)) imag(i(vs181_n_1)) imag(i(vs181_n_2)) imag(i(vs181_n_3)) imag(i(vs181_n_4)) imag(i(vs181_n_5)) imag(i(vs181_n_6)) imag(i(vs181_n_7)) imag(i(vs181_n_8)) imag(i(vs181_n_9)) imag(i(vs181_n_10)) imag(i(vs181_n_11)) imag(i(vs181_n_12))
wrdata /repo/v2/analog/adc/results/cdac_mc_182.tsv imag(i(vs182_p_0)) imag(i(vs182_p_1)) imag(i(vs182_p_2)) imag(i(vs182_p_3)) imag(i(vs182_p_4)) imag(i(vs182_p_5)) imag(i(vs182_p_6)) imag(i(vs182_p_7)) imag(i(vs182_p_8)) imag(i(vs182_p_9)) imag(i(vs182_p_10)) imag(i(vs182_p_11)) imag(i(vs182_p_12)) imag(i(vs182_n_0)) imag(i(vs182_n_1)) imag(i(vs182_n_2)) imag(i(vs182_n_3)) imag(i(vs182_n_4)) imag(i(vs182_n_5)) imag(i(vs182_n_6)) imag(i(vs182_n_7)) imag(i(vs182_n_8)) imag(i(vs182_n_9)) imag(i(vs182_n_10)) imag(i(vs182_n_11)) imag(i(vs182_n_12))
wrdata /repo/v2/analog/adc/results/cdac_mc_183.tsv imag(i(vs183_p_0)) imag(i(vs183_p_1)) imag(i(vs183_p_2)) imag(i(vs183_p_3)) imag(i(vs183_p_4)) imag(i(vs183_p_5)) imag(i(vs183_p_6)) imag(i(vs183_p_7)) imag(i(vs183_p_8)) imag(i(vs183_p_9)) imag(i(vs183_p_10)) imag(i(vs183_p_11)) imag(i(vs183_p_12)) imag(i(vs183_n_0)) imag(i(vs183_n_1)) imag(i(vs183_n_2)) imag(i(vs183_n_3)) imag(i(vs183_n_4)) imag(i(vs183_n_5)) imag(i(vs183_n_6)) imag(i(vs183_n_7)) imag(i(vs183_n_8)) imag(i(vs183_n_9)) imag(i(vs183_n_10)) imag(i(vs183_n_11)) imag(i(vs183_n_12))
wrdata /repo/v2/analog/adc/results/cdac_mc_184.tsv imag(i(vs184_p_0)) imag(i(vs184_p_1)) imag(i(vs184_p_2)) imag(i(vs184_p_3)) imag(i(vs184_p_4)) imag(i(vs184_p_5)) imag(i(vs184_p_6)) imag(i(vs184_p_7)) imag(i(vs184_p_8)) imag(i(vs184_p_9)) imag(i(vs184_p_10)) imag(i(vs184_p_11)) imag(i(vs184_p_12)) imag(i(vs184_n_0)) imag(i(vs184_n_1)) imag(i(vs184_n_2)) imag(i(vs184_n_3)) imag(i(vs184_n_4)) imag(i(vs184_n_5)) imag(i(vs184_n_6)) imag(i(vs184_n_7)) imag(i(vs184_n_8)) imag(i(vs184_n_9)) imag(i(vs184_n_10)) imag(i(vs184_n_11)) imag(i(vs184_n_12))
wrdata /repo/v2/analog/adc/results/cdac_mc_185.tsv imag(i(vs185_p_0)) imag(i(vs185_p_1)) imag(i(vs185_p_2)) imag(i(vs185_p_3)) imag(i(vs185_p_4)) imag(i(vs185_p_5)) imag(i(vs185_p_6)) imag(i(vs185_p_7)) imag(i(vs185_p_8)) imag(i(vs185_p_9)) imag(i(vs185_p_10)) imag(i(vs185_p_11)) imag(i(vs185_p_12)) imag(i(vs185_n_0)) imag(i(vs185_n_1)) imag(i(vs185_n_2)) imag(i(vs185_n_3)) imag(i(vs185_n_4)) imag(i(vs185_n_5)) imag(i(vs185_n_6)) imag(i(vs185_n_7)) imag(i(vs185_n_8)) imag(i(vs185_n_9)) imag(i(vs185_n_10)) imag(i(vs185_n_11)) imag(i(vs185_n_12))
wrdata /repo/v2/analog/adc/results/cdac_mc_186.tsv imag(i(vs186_p_0)) imag(i(vs186_p_1)) imag(i(vs186_p_2)) imag(i(vs186_p_3)) imag(i(vs186_p_4)) imag(i(vs186_p_5)) imag(i(vs186_p_6)) imag(i(vs186_p_7)) imag(i(vs186_p_8)) imag(i(vs186_p_9)) imag(i(vs186_p_10)) imag(i(vs186_p_11)) imag(i(vs186_p_12)) imag(i(vs186_n_0)) imag(i(vs186_n_1)) imag(i(vs186_n_2)) imag(i(vs186_n_3)) imag(i(vs186_n_4)) imag(i(vs186_n_5)) imag(i(vs186_n_6)) imag(i(vs186_n_7)) imag(i(vs186_n_8)) imag(i(vs186_n_9)) imag(i(vs186_n_10)) imag(i(vs186_n_11)) imag(i(vs186_n_12))
wrdata /repo/v2/analog/adc/results/cdac_mc_187.tsv imag(i(vs187_p_0)) imag(i(vs187_p_1)) imag(i(vs187_p_2)) imag(i(vs187_p_3)) imag(i(vs187_p_4)) imag(i(vs187_p_5)) imag(i(vs187_p_6)) imag(i(vs187_p_7)) imag(i(vs187_p_8)) imag(i(vs187_p_9)) imag(i(vs187_p_10)) imag(i(vs187_p_11)) imag(i(vs187_p_12)) imag(i(vs187_n_0)) imag(i(vs187_n_1)) imag(i(vs187_n_2)) imag(i(vs187_n_3)) imag(i(vs187_n_4)) imag(i(vs187_n_5)) imag(i(vs187_n_6)) imag(i(vs187_n_7)) imag(i(vs187_n_8)) imag(i(vs187_n_9)) imag(i(vs187_n_10)) imag(i(vs187_n_11)) imag(i(vs187_n_12))
wrdata /repo/v2/analog/adc/results/cdac_mc_188.tsv imag(i(vs188_p_0)) imag(i(vs188_p_1)) imag(i(vs188_p_2)) imag(i(vs188_p_3)) imag(i(vs188_p_4)) imag(i(vs188_p_5)) imag(i(vs188_p_6)) imag(i(vs188_p_7)) imag(i(vs188_p_8)) imag(i(vs188_p_9)) imag(i(vs188_p_10)) imag(i(vs188_p_11)) imag(i(vs188_p_12)) imag(i(vs188_n_0)) imag(i(vs188_n_1)) imag(i(vs188_n_2)) imag(i(vs188_n_3)) imag(i(vs188_n_4)) imag(i(vs188_n_5)) imag(i(vs188_n_6)) imag(i(vs188_n_7)) imag(i(vs188_n_8)) imag(i(vs188_n_9)) imag(i(vs188_n_10)) imag(i(vs188_n_11)) imag(i(vs188_n_12))
wrdata /repo/v2/analog/adc/results/cdac_mc_189.tsv imag(i(vs189_p_0)) imag(i(vs189_p_1)) imag(i(vs189_p_2)) imag(i(vs189_p_3)) imag(i(vs189_p_4)) imag(i(vs189_p_5)) imag(i(vs189_p_6)) imag(i(vs189_p_7)) imag(i(vs189_p_8)) imag(i(vs189_p_9)) imag(i(vs189_p_10)) imag(i(vs189_p_11)) imag(i(vs189_p_12)) imag(i(vs189_n_0)) imag(i(vs189_n_1)) imag(i(vs189_n_2)) imag(i(vs189_n_3)) imag(i(vs189_n_4)) imag(i(vs189_n_5)) imag(i(vs189_n_6)) imag(i(vs189_n_7)) imag(i(vs189_n_8)) imag(i(vs189_n_9)) imag(i(vs189_n_10)) imag(i(vs189_n_11)) imag(i(vs189_n_12))
wrdata /repo/v2/analog/adc/results/cdac_mc_190.tsv imag(i(vs190_p_0)) imag(i(vs190_p_1)) imag(i(vs190_p_2)) imag(i(vs190_p_3)) imag(i(vs190_p_4)) imag(i(vs190_p_5)) imag(i(vs190_p_6)) imag(i(vs190_p_7)) imag(i(vs190_p_8)) imag(i(vs190_p_9)) imag(i(vs190_p_10)) imag(i(vs190_p_11)) imag(i(vs190_p_12)) imag(i(vs190_n_0)) imag(i(vs190_n_1)) imag(i(vs190_n_2)) imag(i(vs190_n_3)) imag(i(vs190_n_4)) imag(i(vs190_n_5)) imag(i(vs190_n_6)) imag(i(vs190_n_7)) imag(i(vs190_n_8)) imag(i(vs190_n_9)) imag(i(vs190_n_10)) imag(i(vs190_n_11)) imag(i(vs190_n_12))
wrdata /repo/v2/analog/adc/results/cdac_mc_191.tsv imag(i(vs191_p_0)) imag(i(vs191_p_1)) imag(i(vs191_p_2)) imag(i(vs191_p_3)) imag(i(vs191_p_4)) imag(i(vs191_p_5)) imag(i(vs191_p_6)) imag(i(vs191_p_7)) imag(i(vs191_p_8)) imag(i(vs191_p_9)) imag(i(vs191_p_10)) imag(i(vs191_p_11)) imag(i(vs191_p_12)) imag(i(vs191_n_0)) imag(i(vs191_n_1)) imag(i(vs191_n_2)) imag(i(vs191_n_3)) imag(i(vs191_n_4)) imag(i(vs191_n_5)) imag(i(vs191_n_6)) imag(i(vs191_n_7)) imag(i(vs191_n_8)) imag(i(vs191_n_9)) imag(i(vs191_n_10)) imag(i(vs191_n_11)) imag(i(vs191_n_12))
wrdata /repo/v2/analog/adc/results/cdac_mc_192.tsv imag(i(vs192_p_0)) imag(i(vs192_p_1)) imag(i(vs192_p_2)) imag(i(vs192_p_3)) imag(i(vs192_p_4)) imag(i(vs192_p_5)) imag(i(vs192_p_6)) imag(i(vs192_p_7)) imag(i(vs192_p_8)) imag(i(vs192_p_9)) imag(i(vs192_p_10)) imag(i(vs192_p_11)) imag(i(vs192_p_12)) imag(i(vs192_n_0)) imag(i(vs192_n_1)) imag(i(vs192_n_2)) imag(i(vs192_n_3)) imag(i(vs192_n_4)) imag(i(vs192_n_5)) imag(i(vs192_n_6)) imag(i(vs192_n_7)) imag(i(vs192_n_8)) imag(i(vs192_n_9)) imag(i(vs192_n_10)) imag(i(vs192_n_11)) imag(i(vs192_n_12))
wrdata /repo/v2/analog/adc/results/cdac_mc_193.tsv imag(i(vs193_p_0)) imag(i(vs193_p_1)) imag(i(vs193_p_2)) imag(i(vs193_p_3)) imag(i(vs193_p_4)) imag(i(vs193_p_5)) imag(i(vs193_p_6)) imag(i(vs193_p_7)) imag(i(vs193_p_8)) imag(i(vs193_p_9)) imag(i(vs193_p_10)) imag(i(vs193_p_11)) imag(i(vs193_p_12)) imag(i(vs193_n_0)) imag(i(vs193_n_1)) imag(i(vs193_n_2)) imag(i(vs193_n_3)) imag(i(vs193_n_4)) imag(i(vs193_n_5)) imag(i(vs193_n_6)) imag(i(vs193_n_7)) imag(i(vs193_n_8)) imag(i(vs193_n_9)) imag(i(vs193_n_10)) imag(i(vs193_n_11)) imag(i(vs193_n_12))
wrdata /repo/v2/analog/adc/results/cdac_mc_194.tsv imag(i(vs194_p_0)) imag(i(vs194_p_1)) imag(i(vs194_p_2)) imag(i(vs194_p_3)) imag(i(vs194_p_4)) imag(i(vs194_p_5)) imag(i(vs194_p_6)) imag(i(vs194_p_7)) imag(i(vs194_p_8)) imag(i(vs194_p_9)) imag(i(vs194_p_10)) imag(i(vs194_p_11)) imag(i(vs194_p_12)) imag(i(vs194_n_0)) imag(i(vs194_n_1)) imag(i(vs194_n_2)) imag(i(vs194_n_3)) imag(i(vs194_n_4)) imag(i(vs194_n_5)) imag(i(vs194_n_6)) imag(i(vs194_n_7)) imag(i(vs194_n_8)) imag(i(vs194_n_9)) imag(i(vs194_n_10)) imag(i(vs194_n_11)) imag(i(vs194_n_12))
wrdata /repo/v2/analog/adc/results/cdac_mc_195.tsv imag(i(vs195_p_0)) imag(i(vs195_p_1)) imag(i(vs195_p_2)) imag(i(vs195_p_3)) imag(i(vs195_p_4)) imag(i(vs195_p_5)) imag(i(vs195_p_6)) imag(i(vs195_p_7)) imag(i(vs195_p_8)) imag(i(vs195_p_9)) imag(i(vs195_p_10)) imag(i(vs195_p_11)) imag(i(vs195_p_12)) imag(i(vs195_n_0)) imag(i(vs195_n_1)) imag(i(vs195_n_2)) imag(i(vs195_n_3)) imag(i(vs195_n_4)) imag(i(vs195_n_5)) imag(i(vs195_n_6)) imag(i(vs195_n_7)) imag(i(vs195_n_8)) imag(i(vs195_n_9)) imag(i(vs195_n_10)) imag(i(vs195_n_11)) imag(i(vs195_n_12))
wrdata /repo/v2/analog/adc/results/cdac_mc_196.tsv imag(i(vs196_p_0)) imag(i(vs196_p_1)) imag(i(vs196_p_2)) imag(i(vs196_p_3)) imag(i(vs196_p_4)) imag(i(vs196_p_5)) imag(i(vs196_p_6)) imag(i(vs196_p_7)) imag(i(vs196_p_8)) imag(i(vs196_p_9)) imag(i(vs196_p_10)) imag(i(vs196_p_11)) imag(i(vs196_p_12)) imag(i(vs196_n_0)) imag(i(vs196_n_1)) imag(i(vs196_n_2)) imag(i(vs196_n_3)) imag(i(vs196_n_4)) imag(i(vs196_n_5)) imag(i(vs196_n_6)) imag(i(vs196_n_7)) imag(i(vs196_n_8)) imag(i(vs196_n_9)) imag(i(vs196_n_10)) imag(i(vs196_n_11)) imag(i(vs196_n_12))
wrdata /repo/v2/analog/adc/results/cdac_mc_197.tsv imag(i(vs197_p_0)) imag(i(vs197_p_1)) imag(i(vs197_p_2)) imag(i(vs197_p_3)) imag(i(vs197_p_4)) imag(i(vs197_p_5)) imag(i(vs197_p_6)) imag(i(vs197_p_7)) imag(i(vs197_p_8)) imag(i(vs197_p_9)) imag(i(vs197_p_10)) imag(i(vs197_p_11)) imag(i(vs197_p_12)) imag(i(vs197_n_0)) imag(i(vs197_n_1)) imag(i(vs197_n_2)) imag(i(vs197_n_3)) imag(i(vs197_n_4)) imag(i(vs197_n_5)) imag(i(vs197_n_6)) imag(i(vs197_n_7)) imag(i(vs197_n_8)) imag(i(vs197_n_9)) imag(i(vs197_n_10)) imag(i(vs197_n_11)) imag(i(vs197_n_12))
wrdata /repo/v2/analog/adc/results/cdac_mc_198.tsv imag(i(vs198_p_0)) imag(i(vs198_p_1)) imag(i(vs198_p_2)) imag(i(vs198_p_3)) imag(i(vs198_p_4)) imag(i(vs198_p_5)) imag(i(vs198_p_6)) imag(i(vs198_p_7)) imag(i(vs198_p_8)) imag(i(vs198_p_9)) imag(i(vs198_p_10)) imag(i(vs198_p_11)) imag(i(vs198_p_12)) imag(i(vs198_n_0)) imag(i(vs198_n_1)) imag(i(vs198_n_2)) imag(i(vs198_n_3)) imag(i(vs198_n_4)) imag(i(vs198_n_5)) imag(i(vs198_n_6)) imag(i(vs198_n_7)) imag(i(vs198_n_8)) imag(i(vs198_n_9)) imag(i(vs198_n_10)) imag(i(vs198_n_11)) imag(i(vs198_n_12))
wrdata /repo/v2/analog/adc/results/cdac_mc_199.tsv imag(i(vs199_p_0)) imag(i(vs199_p_1)) imag(i(vs199_p_2)) imag(i(vs199_p_3)) imag(i(vs199_p_4)) imag(i(vs199_p_5)) imag(i(vs199_p_6)) imag(i(vs199_p_7)) imag(i(vs199_p_8)) imag(i(vs199_p_9)) imag(i(vs199_p_10)) imag(i(vs199_p_11)) imag(i(vs199_p_12)) imag(i(vs199_n_0)) imag(i(vs199_n_1)) imag(i(vs199_n_2)) imag(i(vs199_n_3)) imag(i(vs199_n_4)) imag(i(vs199_n_5)) imag(i(vs199_n_6)) imag(i(vs199_n_7)) imag(i(vs199_n_8)) imag(i(vs199_n_9)) imag(i(vs199_n_10)) imag(i(vs199_n_11)) imag(i(vs199_n_12))
quit
.endc
.end
