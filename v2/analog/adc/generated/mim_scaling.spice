* MIM multiplier qualification: AC current independently checks count
.lib /foss/pdks/sky130A/libs.tech/combined/sky130.lib.spice tt
.include /repo/v2/analog/adc/adc_blocks.spice
.temp 27
.options reltol=1e-5 abstol=1e-14 vntol=1e-8 method=gear

VONE one 0 DC 0 AC 1
VBANK bank 0 DC 0 AC 1
XONE one 0 adc_mim_bank COUNT=1
XBANK bank 0 adc_mim_bank COUNT=4096

.control
set num_threads=1
set wr_singlescale
set wr_vecnames
set numdgt=12
ac lin 1 1k 1k
wrdata /repo/v2/analog/adc/results/mim_scaling.tsv imag(i(vone)) imag(i(vbank))
quit
.endc
.end
