* cmp_refine_stable_r3_batch_0
.lib /foss/pdks/sky130A/libs.tech/combined/sky130.lib.spice tt_mm
.include /repo/v2/analog/adc/adc_blocks.spice
.temp 27
.options reltol=1e-5 abstol=1e-14 vntol=1e-8 method=gear klu
VDD vdd 0 1.8
VCLK clk 0 PULSE(0 1.8 200n 1n 1n 250n 625n)
VIP0 sp0 0 PWL(0 0.90048053240741 5.25e-07 0.90048053240741 5.26e-07 0.90048053240741 1.15e-06 0.90048053240741 1.151e-06 0.90048189429012 1.775e-06 0.90048189429012 1.776e-06 0.90048189429012 2.4e-06 0.90048189429012 2.401e-06 0.90048325617284 3.025e-06 0.90048325617284 3.026e-06 0.90048325617284 3.65e-06 0.90048325617284 3.651e-06 0.90048461805556 4.275e-06 0.90048461805556 4.276e-06 0.90048461805556 4.9e-06 0.90048461805556 4.901e-06 0.90048597993827 5.525e-06 0.90048597993827 5.526e-06 0.90048597993827 6.15e-06 0.90048597993827 6.151e-06 0.90048734182099 6.775e-06 0.90048734182099 6.776e-06 0.90048734182099 7.4e-06 0.90048734182099 7.401e-06 0.9004887037037 8.025e-06 0.9004887037037 8.026e-06 0.9004887037037)
VIN0 sn0 0 PWL(0 0.89951946759259 5.25e-07 0.89951946759259 5.26e-07 0.89951946759259 1.15e-06 0.89951946759259 1.151e-06 0.89951810570988 1.775e-06 0.89951810570988 1.776e-06 0.89951810570988 2.4e-06 0.89951810570988 2.401e-06 0.89951674382716 3.025e-06 0.89951674382716 3.026e-06 0.89951674382716 3.65e-06 0.89951674382716 3.651e-06 0.89951538194444 4.275e-06 0.89951538194444 4.276e-06 0.89951538194444 4.9e-06 0.89951538194444 4.901e-06 0.89951402006173 5.525e-06 0.89951402006173 5.526e-06 0.89951402006173 6.15e-06 0.89951402006173 6.151e-06 0.89951265817901 6.775e-06 0.89951265817901 6.776e-06 0.89951265817901 7.4e-06 0.89951265817901 7.401e-06 0.8995112962963 8.025e-06 0.8995112962963 8.026e-06 0.8995112962963)
RP0 sp0 ip0 350
RN0 sn0 inn0 350
XCP0 ip0 0 adc_mim_bank COUNT=4096
XCN0 inn0 0 adc_mim_bank COUNT=4096
XCMP0 ip0 inn0 q0 qb0 clk vdd 0 adc_latched_comparator
CQ0 q0 0 5f
CQB0 qb0 0 5f
.ic V(q0)=0 V(qb0)=1.8
VIP1 sp1 0 PWL(0 0.89873819444444 5.25e-07 0.89873819444444 5.26e-07 0.89873819444444 1.15e-06 0.89873819444444 1.151e-06 0.89874003858025 1.775e-06 0.89874003858025 1.776e-06 0.89874003858025 2.4e-06 0.89874003858025 2.401e-06 0.89874188271605 3.025e-06 0.89874188271605 3.026e-06 0.89874188271605 3.65e-06 0.89874188271605 3.651e-06 0.89874372685185 4.275e-06 0.89874372685185 4.276e-06 0.89874372685185 4.9e-06 0.89874372685185 4.901e-06 0.89874557098765 5.525e-06 0.89874557098765 5.526e-06 0.89874557098765 6.15e-06 0.89874557098765 6.151e-06 0.89874741512346 6.775e-06 0.89874741512346 6.776e-06 0.89874741512346 7.4e-06 0.89874741512346 7.401e-06 0.89874925925926 8.025e-06 0.89874925925926 8.026e-06 0.89874925925926)
VIN1 sn1 0 PWL(0 0.90126180555556 5.25e-07 0.90126180555556 5.26e-07 0.90126180555556 1.15e-06 0.90126180555556 1.151e-06 0.90125996141975 1.775e-06 0.90125996141975 1.776e-06 0.90125996141975 2.4e-06 0.90125996141975 2.401e-06 0.90125811728395 3.025e-06 0.90125811728395 3.026e-06 0.90125811728395 3.65e-06 0.90125811728395 3.651e-06 0.90125627314815 4.275e-06 0.90125627314815 4.276e-06 0.90125627314815 4.9e-06 0.90125627314815 4.901e-06 0.90125442901235 5.525e-06 0.90125442901235 5.526e-06 0.90125442901235 6.15e-06 0.90125442901235 6.151e-06 0.90125258487654 6.775e-06 0.90125258487654 6.776e-06 0.90125258487654 7.4e-06 0.90125258487654 7.401e-06 0.90125074074074 8.025e-06 0.90125074074074 8.026e-06 0.90125074074074)
RP1 sp1 ip1 350
RN1 sn1 inn1 350
XCP1 ip1 0 adc_mim_bank COUNT=4096
XCN1 inn1 0 adc_mim_bank COUNT=4096
XCMP1 ip1 inn1 q1 qb1 clk vdd 0 adc_latched_comparator
CQ1 q1 0 5f
CQB1 qb1 0 5f
.ic V(q1)=0 V(qb1)=1.8
VIP2 sp2 0 PWL(0 0.90143407407407 5.25e-07 0.90143407407407 5.26e-07 0.90143407407407 1.15e-06 0.90143407407407 1.151e-06 0.90143591820988 1.775e-06 0.90143591820988 1.776e-06 0.90143591820988 2.4e-06 0.90143591820988 2.401e-06 0.90143776234568 3.025e-06 0.90143776234568 3.026e-06 0.90143776234568 3.65e-06 0.90143776234568 3.651e-06 0.90143960648148 4.275e-06 0.90143960648148 4.276e-06 0.90143960648148 4.9e-06 0.90143960648148 4.901e-06 0.90144145061728 5.525e-06 0.90144145061728 5.526e-06 0.90144145061728 6.15e-06 0.90144145061728 6.151e-06 0.90144329475309 6.775e-06 0.90144329475309 6.776e-06 0.90144329475309 7.4e-06 0.90144329475309 7.401e-06 0.90144513888889 8.025e-06 0.90144513888889 8.026e-06 0.90144513888889)
VIN2 sn2 0 PWL(0 0.89856592592593 5.25e-07 0.89856592592593 5.26e-07 0.89856592592593 1.15e-06 0.89856592592593 1.151e-06 0.89856408179012 1.775e-06 0.89856408179012 1.776e-06 0.89856408179012 2.4e-06 0.89856408179012 2.401e-06 0.89856223765432 3.025e-06 0.89856223765432 3.026e-06 0.89856223765432 3.65e-06 0.89856223765432 3.651e-06 0.89856039351852 4.275e-06 0.89856039351852 4.276e-06 0.89856039351852 4.9e-06 0.89856039351852 4.901e-06 0.89855854938272 5.525e-06 0.89855854938272 5.526e-06 0.89855854938272 6.15e-06 0.89855854938272 6.151e-06 0.89855670524691 6.775e-06 0.89855670524691 6.776e-06 0.89855670524691 7.4e-06 0.89855670524691 7.401e-06 0.89855486111111 8.025e-06 0.89855486111111 8.026e-06 0.89855486111111)
RP2 sp2 ip2 350
RN2 sn2 inn2 350
XCP2 ip2 0 adc_mim_bank COUNT=4096
XCN2 inn2 0 adc_mim_bank COUNT=4096
XCMP2 ip2 inn2 q2 qb2 clk vdd 0 adc_latched_comparator
CQ2 q2 0 5f
CQB2 qb2 0 5f
.ic V(q2)=0 V(qb2)=1.8
VIP3 sp3 0 PWL(0 0.89872606481481 5.25e-07 0.89872606481481 5.26e-07 0.89872606481481 1.15e-06 0.89872606481481 1.151e-06 0.89872790895062 1.775e-06 0.89872790895062 1.776e-06 0.89872790895062 2.4e-06 0.89872790895062 2.401e-06 0.89872975308642 3.025e-06 0.89872975308642 3.026e-06 0.89872975308642 3.65e-06 0.89872975308642 3.651e-06 0.89873159722222 4.275e-06 0.89873159722222 4.276e-06 0.89873159722222 4.9e-06 0.89873159722222 4.901e-06 0.89873344135802 5.525e-06 0.89873344135802 5.526e-06 0.89873344135802 6.15e-06 0.89873344135802 6.151e-06 0.89873528549383 6.775e-06 0.89873528549383 6.776e-06 0.89873528549383 7.4e-06 0.89873528549383 7.401e-06 0.89873712962963 8.025e-06 0.89873712962963 8.026e-06 0.89873712962963)
VIN3 sn3 0 PWL(0 0.90127393518519 5.25e-07 0.90127393518519 5.26e-07 0.90127393518519 1.15e-06 0.90127393518519 1.151e-06 0.90127209104938 1.775e-06 0.90127209104938 1.776e-06 0.90127209104938 2.4e-06 0.90127209104938 2.401e-06 0.90127024691358 3.025e-06 0.90127024691358 3.026e-06 0.90127024691358 3.65e-06 0.90127024691358 3.651e-06 0.90126840277778 4.275e-06 0.90126840277778 4.276e-06 0.90126840277778 4.9e-06 0.90126840277778 4.901e-06 0.90126655864198 5.525e-06 0.90126655864198 5.526e-06 0.90126655864198 6.15e-06 0.90126655864198 6.151e-06 0.90126471450617 6.775e-06 0.90126471450617 6.776e-06 0.90126471450617 7.4e-06 0.90126471450617 7.401e-06 0.90126287037037 8.025e-06 0.90126287037037 8.026e-06 0.90126287037037)
RP3 sp3 ip3 350
RN3 sn3 inn3 350
XCP3 ip3 0 adc_mim_bank COUNT=4096
XCN3 inn3 0 adc_mim_bank COUNT=4096
XCMP3 ip3 inn3 q3 qb3 clk vdd 0 adc_latched_comparator
CQ3 q3 0 5f
CQB3 qb3 0 5f
.ic V(q3)=0 V(qb3)=1.8
VIP4 sp4 0 PWL(0 0.89937736111111 5.25e-07 0.89937736111111 5.26e-07 0.89937736111111 1.15e-06 0.89937736111111 1.151e-06 0.89937920524691 1.775e-06 0.89937920524691 1.776e-06 0.89937920524691 2.4e-06 0.89937920524691 2.401e-06 0.89938104938272 3.025e-06 0.89938104938272 3.026e-06 0.89938104938272 3.65e-06 0.89938104938272 3.651e-06 0.89938289351852 4.275e-06 0.89938289351852 4.276e-06 0.89938289351852 4.9e-06 0.89938289351852 4.901e-06 0.89938473765432 5.525e-06 0.89938473765432 5.526e-06 0.89938473765432 6.15e-06 0.89938473765432 6.151e-06 0.89938658179012 6.775e-06 0.89938658179012 6.776e-06 0.89938658179012 7.4e-06 0.89938658179012 7.401e-06 0.89938842592593 8.025e-06 0.89938842592593 8.026e-06 0.89938842592593)
VIN4 sn4 0 PWL(0 0.90062263888889 5.25e-07 0.90062263888889 5.26e-07 0.90062263888889 1.15e-06 0.90062263888889 1.151e-06 0.90062079475309 1.775e-06 0.90062079475309 1.776e-06 0.90062079475309 2.4e-06 0.90062079475309 2.401e-06 0.90061895061728 3.025e-06 0.90061895061728 3.026e-06 0.90061895061728 3.65e-06 0.90061895061728 3.651e-06 0.90061710648148 4.275e-06 0.90061710648148 4.276e-06 0.90061710648148 4.9e-06 0.90061710648148 4.901e-06 0.90061526234568 5.525e-06 0.90061526234568 5.526e-06 0.90061526234568 6.15e-06 0.90061526234568 6.151e-06 0.90061341820988 6.775e-06 0.90061341820988 6.776e-06 0.90061341820988 7.4e-06 0.90061341820988 7.401e-06 0.90061157407407 8.025e-06 0.90061157407407 8.026e-06 0.90061157407407)
RP4 sp4 ip4 350
RN4 sn4 inn4 350
XCP4 ip4 0 adc_mim_bank COUNT=4096
XCN4 inn4 0 adc_mim_bank COUNT=4096
XCMP4 ip4 inn4 q4 qb4 clk vdd 0 adc_latched_comparator
CQ4 q4 0 5f
CQB4 qb4 0 5f
.ic V(q4)=0 V(qb4)=1.8
VIP5 sp5 0 PWL(0 0.90247472222222 5.25e-07 0.90247472222222 5.26e-07 0.90247472222222 1.15e-06 0.90247472222222 1.151e-06 0.90248428240741 1.775e-06 0.90248428240741 1.776e-06 0.90248428240741 2.4e-06 0.90248428240741 2.401e-06 0.90249384259259 3.025e-06 0.90249384259259 3.026e-06 0.90249384259259 3.65e-06 0.90249384259259 3.651e-06 0.90250340277778 4.275e-06 0.90250340277778 4.276e-06 0.90250340277778 4.9e-06 0.90250340277778 4.901e-06 0.90251296296296 5.525e-06 0.90251296296296 5.526e-06 0.90251296296296 6.15e-06 0.90251296296296 6.151e-06 0.90252252314815 6.775e-06 0.90252252314815 6.776e-06 0.90252252314815 7.4e-06 0.90252252314815 7.401e-06 0.90253208333333 8.025e-06 0.90253208333333 8.026e-06 0.90253208333333)
VIN5 sn5 0 PWL(0 0.89752527777778 5.25e-07 0.89752527777778 5.26e-07 0.89752527777778 1.15e-06 0.89752527777778 1.151e-06 0.89751571759259 1.775e-06 0.89751571759259 1.776e-06 0.89751571759259 2.4e-06 0.89751571759259 2.401e-06 0.89750615740741 3.025e-06 0.89750615740741 3.026e-06 0.89750615740741 3.65e-06 0.89750615740741 3.651e-06 0.89749659722222 4.275e-06 0.89749659722222 4.276e-06 0.89749659722222 4.9e-06 0.89749659722222 4.901e-06 0.89748703703704 5.525e-06 0.89748703703704 5.526e-06 0.89748703703704 6.15e-06 0.89748703703704 6.151e-06 0.89747747685185 6.775e-06 0.89747747685185 6.776e-06 0.89747747685185 7.4e-06 0.89747747685185 7.401e-06 0.89746791666667 8.025e-06 0.89746791666667 8.026e-06 0.89746791666667)
RP5 sp5 ip5 350
RN5 sn5 inn5 350
XCP5 ip5 0 adc_mim_bank COUNT=4096
XCN5 inn5 0 adc_mim_bank COUNT=4096
XCMP5 ip5 inn5 q5 qb5 clk vdd 0 adc_latched_comparator
CQ5 q5 0 5f
CQB5 qb5 0 5f
.ic V(q5)=0 V(qb5)=1.8
VIP6 sp6 0 PWL(0 0.89913625 5.25e-07 0.89913625 5.26e-07 0.89913625 1.15e-06 0.89913625 1.151e-06 0.8991380941358 1.775e-06 0.8991380941358 1.776e-06 0.8991380941358 2.4e-06 0.8991380941358 2.401e-06 0.8991399382716 3.025e-06 0.8991399382716 3.026e-06 0.8991399382716 3.65e-06 0.8991399382716 3.651e-06 0.89914178240741 4.275e-06 0.89914178240741 4.276e-06 0.89914178240741 4.9e-06 0.89914178240741 4.901e-06 0.89914362654321 5.525e-06 0.89914362654321 5.526e-06 0.89914362654321 6.15e-06 0.89914362654321 6.151e-06 0.89914547067901 6.775e-06 0.89914547067901 6.776e-06 0.89914547067901 7.4e-06 0.89914547067901 7.401e-06 0.89914731481481 8.025e-06 0.89914731481481 8.026e-06 0.89914731481481)
VIN6 sn6 0 PWL(0 0.90086375 5.25e-07 0.90086375 5.26e-07 0.90086375 1.15e-06 0.90086375 1.151e-06 0.9008619058642 1.775e-06 0.9008619058642 1.776e-06 0.9008619058642 2.4e-06 0.9008619058642 2.401e-06 0.9008600617284 3.025e-06 0.9008600617284 3.026e-06 0.9008600617284 3.65e-06 0.9008600617284 3.651e-06 0.90085821759259 4.275e-06 0.90085821759259 4.276e-06 0.90085821759259 4.9e-06 0.90085821759259 4.901e-06 0.90085637345679 5.525e-06 0.90085637345679 5.526e-06 0.90085637345679 6.15e-06 0.90085637345679 6.151e-06 0.90085452932099 6.775e-06 0.90085452932099 6.776e-06 0.90085452932099 7.4e-06 0.90085452932099 7.401e-06 0.90085268518519 8.025e-06 0.90085268518519 8.026e-06 0.90085268518519)
RP6 sp6 ip6 350
RN6 sn6 inn6 350
XCP6 ip6 0 adc_mim_bank COUNT=4096
XCN6 inn6 0 adc_mim_bank COUNT=4096
XCMP6 ip6 inn6 q6 qb6 clk vdd 0 adc_latched_comparator
CQ6 q6 0 5f
CQB6 qb6 0 5f
.ic V(q6)=0 V(qb6)=1.8
VIP7 sp7 0 PWL(0 0.89757263888889 5.25e-07 0.89757263888889 5.26e-07 0.89757263888889 1.15e-06 0.89757263888889 1.151e-06 0.89758219907407 1.775e-06 0.89758219907407 1.776e-06 0.89758219907407 2.4e-06 0.89758219907407 2.401e-06 0.89759175925926 3.025e-06 0.89759175925926 3.026e-06 0.89759175925926 3.65e-06 0.89759175925926 3.651e-06 0.89760131944444 4.275e-06 0.89760131944444 4.276e-06 0.89760131944444 4.9e-06 0.89760131944444 4.901e-06 0.89761087962963 5.525e-06 0.89761087962963 5.526e-06 0.89761087962963 6.15e-06 0.89761087962963 6.151e-06 0.89762043981481 6.775e-06 0.89762043981481 6.776e-06 0.89762043981481 7.4e-06 0.89762043981481 7.401e-06 0.89763 8.025e-06 0.89763 8.026e-06 0.89763)
VIN7 sn7 0 PWL(0 0.90242736111111 5.25e-07 0.90242736111111 5.26e-07 0.90242736111111 1.15e-06 0.90242736111111 1.151e-06 0.90241780092593 1.775e-06 0.90241780092593 1.776e-06 0.90241780092593 2.4e-06 0.90241780092593 2.401e-06 0.90240824074074 3.025e-06 0.90240824074074 3.026e-06 0.90240824074074 3.65e-06 0.90240824074074 3.651e-06 0.90239868055556 4.275e-06 0.90239868055556 4.276e-06 0.90239868055556 4.9e-06 0.90239868055556 4.901e-06 0.90238912037037 5.525e-06 0.90238912037037 5.526e-06 0.90238912037037 6.15e-06 0.90238912037037 6.151e-06 0.90237956018519 6.775e-06 0.90237956018519 6.776e-06 0.90237956018519 7.4e-06 0.90237956018519 7.401e-06 0.90237 8.025e-06 0.90237 8.026e-06 0.90237)
RP7 sp7 ip7 350
RN7 sn7 inn7 350
XCP7 ip7 0 adc_mim_bank COUNT=4096
XCN7 inn7 0 adc_mim_bank COUNT=4096
XCMP7 ip7 inn7 q7 qb7 clk vdd 0 adc_latched_comparator
CQ7 q7 0 5f
CQB7 qb7 0 5f
.ic V(q7)=0 V(qb7)=1.8
VIP8 sp8 0 PWL(0 0.90026657407407 5.25e-07 0.90026657407407 5.26e-07 0.90026657407407 1.15e-06 0.90026657407407 1.151e-06 0.90026793595679 1.775e-06 0.90026793595679 1.776e-06 0.90026793595679 2.4e-06 0.90026793595679 2.401e-06 0.90026929783951 3.025e-06 0.90026929783951 3.026e-06 0.90026929783951 3.65e-06 0.90026929783951 3.651e-06 0.90027065972222 4.275e-06 0.90027065972222 4.276e-06 0.90027065972222 4.9e-06 0.90027065972222 4.901e-06 0.90027202160494 5.525e-06 0.90027202160494 5.526e-06 0.90027202160494 6.15e-06 0.90027202160494 6.151e-06 0.90027338348765 6.775e-06 0.90027338348765 6.776e-06 0.90027338348765 7.4e-06 0.90027338348765 7.401e-06 0.90027474537037 8.025e-06 0.90027474537037 8.026e-06 0.90027474537037)
VIN8 sn8 0 PWL(0 0.89973342592593 5.25e-07 0.89973342592593 5.26e-07 0.89973342592593 1.15e-06 0.89973342592593 1.151e-06 0.89973206404321 1.775e-06 0.89973206404321 1.776e-06 0.89973206404321 2.4e-06 0.89973206404321 2.401e-06 0.89973070216049 3.025e-06 0.89973070216049 3.026e-06 0.89973070216049 3.65e-06 0.89973070216049 3.651e-06 0.89972934027778 4.275e-06 0.89972934027778 4.276e-06 0.89972934027778 4.9e-06 0.89972934027778 4.901e-06 0.89972797839506 5.525e-06 0.89972797839506 5.526e-06 0.89972797839506 6.15e-06 0.89972797839506 6.151e-06 0.89972661651235 6.775e-06 0.89972661651235 6.776e-06 0.89972661651235 7.4e-06 0.89972661651235 7.401e-06 0.89972525462963 8.025e-06 0.89972525462963 8.026e-06 0.89972525462963)
RP8 sp8 ip8 350
RN8 sn8 inn8 350
XCP8 ip8 0 adc_mim_bank COUNT=4096
XCN8 inn8 0 adc_mim_bank COUNT=4096
XCMP8 ip8 inn8 q8 qb8 clk vdd 0 adc_latched_comparator
CQ8 q8 0 5f
CQB8 qb8 0 5f
.ic V(q8)=0 V(qb8)=1.8
VIP9 sp9 0 PWL(0 0.89864402777778 5.25e-07 0.89864402777778 5.26e-07 0.89864402777778 1.15e-06 0.89864402777778 1.151e-06 0.89864587191358 1.775e-06 0.89864587191358 1.776e-06 0.89864587191358 2.4e-06 0.89864587191358 2.401e-06 0.89864771604938 3.025e-06 0.89864771604938 3.026e-06 0.89864771604938 3.65e-06 0.89864771604938 3.651e-06 0.89864956018519 4.275e-06 0.89864956018519 4.276e-06 0.89864956018519 4.9e-06 0.89864956018519 4.901e-06 0.89865140432099 5.525e-06 0.89865140432099 5.526e-06 0.89865140432099 6.15e-06 0.89865140432099 6.151e-06 0.89865324845679 6.775e-06 0.89865324845679 6.776e-06 0.89865324845679 7.4e-06 0.89865324845679 7.401e-06 0.89865509259259 8.025e-06 0.89865509259259 8.026e-06 0.89865509259259)
VIN9 sn9 0 PWL(0 0.90135597222222 5.25e-07 0.90135597222222 5.26e-07 0.90135597222222 1.15e-06 0.90135597222222 1.151e-06 0.90135412808642 1.775e-06 0.90135412808642 1.776e-06 0.90135412808642 2.4e-06 0.90135412808642 2.401e-06 0.90135228395062 3.025e-06 0.90135228395062 3.026e-06 0.90135228395062 3.65e-06 0.90135228395062 3.651e-06 0.90135043981481 4.275e-06 0.90135043981481 4.276e-06 0.90135043981481 4.9e-06 0.90135043981481 4.901e-06 0.90134859567901 5.525e-06 0.90134859567901 5.526e-06 0.90134859567901 6.15e-06 0.90134859567901 6.151e-06 0.90134675154321 6.775e-06 0.90134675154321 6.776e-06 0.90134675154321 7.4e-06 0.90134675154321 7.401e-06 0.90134490740741 8.025e-06 0.90134490740741 8.026e-06 0.90134490740741)
RP9 sp9 ip9 350
RN9 sn9 inn9 350
XCP9 ip9 0 adc_mim_bank COUNT=4096
XCN9 inn9 0 adc_mim_bank COUNT=4096
XCMP9 ip9 inn9 q9 qb9 clk vdd 0 adc_latched_comparator
CQ9 q9 0 5f
CQB9 qb9 0 5f
.ic V(q9)=0 V(qb9)=1.8
VIP10 sp10 0 PWL(0 0.89907953703704 5.25e-07 0.89907953703704 5.26e-07 0.89907953703704 1.15e-06 0.89907953703704 1.151e-06 0.89908138117284 1.775e-06 0.89908138117284 1.776e-06 0.89908138117284 2.4e-06 0.89908138117284 2.401e-06 0.89908322530864 3.025e-06 0.89908322530864 3.026e-06 0.89908322530864 3.65e-06 0.89908322530864 3.651e-06 0.89908506944444 4.275e-06 0.89908506944444 4.276e-06 0.89908506944444 4.9e-06 0.89908506944444 4.901e-06 0.89908691358025 5.525e-06 0.89908691358025 5.526e-06 0.89908691358025 6.15e-06 0.89908691358025 6.151e-06 0.89908875771605 6.775e-06 0.89908875771605 6.776e-06 0.89908875771605 7.4e-06 0.89908875771605 7.401e-06 0.89909060185185 8.025e-06 0.89909060185185 8.026e-06 0.89909060185185)
VIN10 sn10 0 PWL(0 0.90092046296296 5.25e-07 0.90092046296296 5.26e-07 0.90092046296296 1.15e-06 0.90092046296296 1.151e-06 0.90091861882716 1.775e-06 0.90091861882716 1.776e-06 0.90091861882716 2.4e-06 0.90091861882716 2.401e-06 0.90091677469136 3.025e-06 0.90091677469136 3.026e-06 0.90091677469136 3.65e-06 0.90091677469136 3.651e-06 0.90091493055556 4.275e-06 0.90091493055556 4.276e-06 0.90091493055556 4.9e-06 0.90091493055556 4.901e-06 0.90091308641975 5.525e-06 0.90091308641975 5.526e-06 0.90091308641975 6.15e-06 0.90091308641975 6.151e-06 0.90091124228395 6.775e-06 0.90091124228395 6.776e-06 0.90091124228395 7.4e-06 0.90091124228395 7.401e-06 0.90090939814815 8.025e-06 0.90090939814815 8.026e-06 0.90090939814815)
RP10 sp10 ip10 350
RN10 sn10 inn10 350
XCP10 ip10 0 adc_mim_bank COUNT=4096
XCN10 inn10 0 adc_mim_bank COUNT=4096
XCMP10 ip10 inn10 q10 qb10 clk vdd 0 adc_latched_comparator
CQ10 q10 0 5f
CQB10 qb10 0 5f
.ic V(q10)=0 V(qb10)=1.8
VIP11 sp11 0 PWL(0 0.89959497685185 5.25e-07 0.89959497685185 5.26e-07 0.89959497685185 1.15e-06 0.89959497685185 1.151e-06 0.89959633873457 1.775e-06 0.89959633873457 1.776e-06 0.89959633873457 2.4e-06 0.89959633873457 2.401e-06 0.89959770061728 3.025e-06 0.89959770061728 3.026e-06 0.89959770061728 3.65e-06 0.89959770061728 3.651e-06 0.8995990625 4.275e-06 0.8995990625 4.276e-06 0.8995990625 4.9e-06 0.8995990625 4.901e-06 0.89960042438272 5.525e-06 0.89960042438272 5.526e-06 0.89960042438272 6.15e-06 0.89960042438272 6.151e-06 0.89960178626543 6.775e-06 0.89960178626543 6.776e-06 0.89960178626543 7.4e-06 0.89960178626543 7.401e-06 0.89960314814815 8.025e-06 0.89960314814815 8.026e-06 0.89960314814815)
VIN11 sn11 0 PWL(0 0.90040502314815 5.25e-07 0.90040502314815 5.26e-07 0.90040502314815 1.15e-06 0.90040502314815 1.151e-06 0.90040366126543 1.775e-06 0.90040366126543 1.776e-06 0.90040366126543 2.4e-06 0.90040366126543 2.401e-06 0.90040229938272 3.025e-06 0.90040229938272 3.026e-06 0.90040229938272 3.65e-06 0.90040229938272 3.651e-06 0.9004009375 4.275e-06 0.9004009375 4.276e-06 0.9004009375 4.9e-06 0.9004009375 4.901e-06 0.90039957561728 5.525e-06 0.90039957561728 5.526e-06 0.90039957561728 6.15e-06 0.90039957561728 6.151e-06 0.90039821373457 6.775e-06 0.90039821373457 6.776e-06 0.90039821373457 7.4e-06 0.90039821373457 7.401e-06 0.90039685185185 8.025e-06 0.90039685185185 8.026e-06 0.90039685185185)
RP11 sp11 ip11 350
RN11 sn11 inn11 350
XCP11 ip11 0 adc_mim_bank COUNT=4096
XCN11 inn11 0 adc_mim_bank COUNT=4096
XCMP11 ip11 inn11 q11 qb11 clk vdd 0 adc_latched_comparator
CQ11 q11 0 5f
CQB11 qb11 0 5f
.ic V(q11)=0 V(qb11)=1.8
VIP12 sp12 0 PWL(0 0.89941481481481 5.25e-07 0.89941481481481 5.26e-07 0.89941481481481 1.15e-06 0.89941481481481 1.151e-06 0.89941665895062 1.775e-06 0.89941665895062 1.776e-06 0.89941665895062 2.4e-06 0.89941665895062 2.401e-06 0.89941850308642 3.025e-06 0.89941850308642 3.026e-06 0.89941850308642 3.65e-06 0.89941850308642 3.651e-06 0.89942034722222 4.275e-06 0.89942034722222 4.276e-06 0.89942034722222 4.9e-06 0.89942034722222 4.901e-06 0.89942219135802 5.525e-06 0.89942219135802 5.526e-06 0.89942219135802 6.15e-06 0.89942219135802 6.151e-06 0.89942403549383 6.775e-06 0.89942403549383 6.776e-06 0.89942403549383 7.4e-06 0.89942403549383 7.401e-06 0.89942587962963 8.025e-06 0.89942587962963 8.026e-06 0.89942587962963)
VIN12 sn12 0 PWL(0 0.90058518518519 5.25e-07 0.90058518518519 5.26e-07 0.90058518518519 1.15e-06 0.90058518518519 1.151e-06 0.90058334104938 1.775e-06 0.90058334104938 1.776e-06 0.90058334104938 2.4e-06 0.90058334104938 2.401e-06 0.90058149691358 3.025e-06 0.90058149691358 3.026e-06 0.90058149691358 3.65e-06 0.90058149691358 3.651e-06 0.90057965277778 4.275e-06 0.90057965277778 4.276e-06 0.90057965277778 4.9e-06 0.90057965277778 4.901e-06 0.90057780864198 5.525e-06 0.90057780864198 5.526e-06 0.90057780864198 6.15e-06 0.90057780864198 6.151e-06 0.90057596450617 6.775e-06 0.90057596450617 6.776e-06 0.90057596450617 7.4e-06 0.90057596450617 7.401e-06 0.90057412037037 8.025e-06 0.90057412037037 8.026e-06 0.90057412037037)
RP12 sp12 ip12 350
RN12 sn12 inn12 350
XCP12 ip12 0 adc_mim_bank COUNT=4096
XCN12 inn12 0 adc_mim_bank COUNT=4096
XCMP12 ip12 inn12 q12 qb12 clk vdd 0 adc_latched_comparator
CQ12 q12 0 5f
CQB12 qb12 0 5f
.ic V(q12)=0 V(qb12)=1.8
VIP13 sp13 0 PWL(0 0.90147152777778 5.25e-07 0.90147152777778 5.26e-07 0.90147152777778 1.15e-06 0.90147152777778 1.151e-06 0.90147337191358 1.775e-06 0.90147337191358 1.776e-06 0.90147337191358 2.4e-06 0.90147337191358 2.401e-06 0.90147521604938 3.025e-06 0.90147521604938 3.026e-06 0.90147521604938 3.65e-06 0.90147521604938 3.651e-06 0.90147706018519 4.275e-06 0.90147706018519 4.276e-06 0.90147706018519 4.9e-06 0.90147706018519 4.901e-06 0.90147890432099 5.525e-06 0.90147890432099 5.526e-06 0.90147890432099 6.15e-06 0.90147890432099 6.151e-06 0.90148074845679 6.775e-06 0.90148074845679 6.776e-06 0.90148074845679 7.4e-06 0.90148074845679 7.401e-06 0.90148259259259 8.025e-06 0.90148259259259 8.026e-06 0.90148259259259)
VIN13 sn13 0 PWL(0 0.89852847222222 5.25e-07 0.89852847222222 5.26e-07 0.89852847222222 1.15e-06 0.89852847222222 1.151e-06 0.89852662808642 1.775e-06 0.89852662808642 1.776e-06 0.89852662808642 2.4e-06 0.89852662808642 2.401e-06 0.89852478395062 3.025e-06 0.89852478395062 3.026e-06 0.89852478395062 3.65e-06 0.89852478395062 3.651e-06 0.89852293981481 4.275e-06 0.89852293981481 4.276e-06 0.89852293981481 4.9e-06 0.89852293981481 4.901e-06 0.89852109567901 5.525e-06 0.89852109567901 5.526e-06 0.89852109567901 6.15e-06 0.89852109567901 6.151e-06 0.89851925154321 6.775e-06 0.89851925154321 6.776e-06 0.89851925154321 7.4e-06 0.89851925154321 7.401e-06 0.89851740740741 8.025e-06 0.89851740740741 8.026e-06 0.89851740740741)
RP13 sp13 ip13 350
RN13 sn13 inn13 350
XCP13 ip13 0 adc_mim_bank COUNT=4096
XCN13 inn13 0 adc_mim_bank COUNT=4096
XCMP13 ip13 inn13 q13 qb13 clk vdd 0 adc_latched_comparator
CQ13 q13 0 5f
CQB13 qb13 0 5f
.ic V(q13)=0 V(qb13)=1.8
VIP14 sp14 0 PWL(0 0.90149486111111 5.25e-07 0.90149486111111 5.26e-07 0.90149486111111 1.15e-06 0.90149486111111 1.151e-06 0.9015044212963 1.775e-06 0.9015044212963 1.776e-06 0.9015044212963 2.4e-06 0.9015044212963 2.401e-06 0.90151398148148 3.025e-06 0.90151398148148 3.026e-06 0.90151398148148 3.65e-06 0.90151398148148 3.651e-06 0.90152354166667 4.275e-06 0.90152354166667 4.276e-06 0.90152354166667 4.9e-06 0.90152354166667 4.901e-06 0.90153310185185 5.525e-06 0.90153310185185 5.526e-06 0.90153310185185 6.15e-06 0.90153310185185 6.151e-06 0.90154266203704 6.775e-06 0.90154266203704 6.776e-06 0.90154266203704 7.4e-06 0.90154266203704 7.401e-06 0.90155222222222 8.025e-06 0.90155222222222 8.026e-06 0.90155222222222)
VIN14 sn14 0 PWL(0 0.89850513888889 5.25e-07 0.89850513888889 5.26e-07 0.89850513888889 1.15e-06 0.89850513888889 1.151e-06 0.8984955787037 1.775e-06 0.8984955787037 1.776e-06 0.8984955787037 2.4e-06 0.8984955787037 2.401e-06 0.89848601851852 3.025e-06 0.89848601851852 3.026e-06 0.89848601851852 3.65e-06 0.89848601851852 3.651e-06 0.89847645833333 4.275e-06 0.89847645833333 4.276e-06 0.89847645833333 4.9e-06 0.89847645833333 4.901e-06 0.89846689814815 5.525e-06 0.89846689814815 5.526e-06 0.89846689814815 6.15e-06 0.89846689814815 6.151e-06 0.89845733796296 6.775e-06 0.89845733796296 6.776e-06 0.89845733796296 7.4e-06 0.89845733796296 7.401e-06 0.89844777777778 8.025e-06 0.89844777777778 8.026e-06 0.89844777777778)
RP14 sp14 ip14 350
RN14 sn14 inn14 350
XCP14 ip14 0 adc_mim_bank COUNT=4096
XCN14 inn14 0 adc_mim_bank COUNT=4096
XCMP14 ip14 inn14 q14 qb14 clk vdd 0 adc_latched_comparator
CQ14 q14 0 5f
CQB14 qb14 0 5f
.ic V(q14)=0 V(qb14)=1.8
VIP15 sp15 0 PWL(0 0.89970037037037 5.25e-07 0.89970037037037 5.26e-07 0.89970037037037 1.15e-06 0.89970037037037 1.151e-06 0.89970173225309 1.775e-06 0.89970173225309 1.776e-06 0.89970173225309 2.4e-06 0.89970173225309 2.401e-06 0.8997030941358 3.025e-06 0.8997030941358 3.026e-06 0.8997030941358 3.65e-06 0.8997030941358 3.651e-06 0.89970445601852 4.275e-06 0.89970445601852 4.276e-06 0.89970445601852 4.9e-06 0.89970445601852 4.901e-06 0.89970581790123 5.525e-06 0.89970581790123 5.526e-06 0.89970581790123 6.15e-06 0.89970581790123 6.151e-06 0.89970717978395 6.775e-06 0.89970717978395 6.776e-06 0.89970717978395 7.4e-06 0.89970717978395 7.401e-06 0.89970854166667 8.025e-06 0.89970854166667 8.026e-06 0.89970854166667)
VIN15 sn15 0 PWL(0 0.90029962962963 5.25e-07 0.90029962962963 5.26e-07 0.90029962962963 1.15e-06 0.90029962962963 1.151e-06 0.90029826774691 1.775e-06 0.90029826774691 1.776e-06 0.90029826774691 2.4e-06 0.90029826774691 2.401e-06 0.9002969058642 3.025e-06 0.9002969058642 3.026e-06 0.9002969058642 3.65e-06 0.9002969058642 3.651e-06 0.90029554398148 4.275e-06 0.90029554398148 4.276e-06 0.90029554398148 4.9e-06 0.90029554398148 4.901e-06 0.90029418209877 5.525e-06 0.90029418209877 5.526e-06 0.90029418209877 6.15e-06 0.90029418209877 6.151e-06 0.90029282021605 6.775e-06 0.90029282021605 6.776e-06 0.90029282021605 7.4e-06 0.90029282021605 7.401e-06 0.90029145833333 8.025e-06 0.90029145833333 8.026e-06 0.90029145833333)
RP15 sp15 ip15 350
RN15 sn15 inn15 350
XCP15 ip15 0 adc_mim_bank COUNT=4096
XCN15 inn15 0 adc_mim_bank COUNT=4096
XCMP15 ip15 inn15 q15 qb15 clk vdd 0 adc_latched_comparator
CQ15 q15 0 5f
CQB15 qb15 0 5f
.ic V(q15)=0 V(qb15)=1.8
VIP16 sp16 0 PWL(0 0.89951581018519 5.25e-07 0.89951581018519 5.26e-07 0.89951581018519 1.15e-06 0.89951581018519 1.151e-06 0.8995171720679 1.775e-06 0.8995171720679 1.776e-06 0.8995171720679 2.4e-06 0.8995171720679 2.401e-06 0.89951853395062 3.025e-06 0.89951853395062 3.026e-06 0.89951853395062 3.65e-06 0.89951853395062 3.651e-06 0.89951989583333 4.275e-06 0.89951989583333 4.276e-06 0.89951989583333 4.9e-06 0.89951989583333 4.901e-06 0.89952125771605 5.525e-06 0.89952125771605 5.526e-06 0.89952125771605 6.15e-06 0.89952125771605 6.151e-06 0.89952261959877 6.775e-06 0.89952261959877 6.776e-06 0.89952261959877 7.4e-06 0.89952261959877 7.401e-06 0.89952398148148 8.025e-06 0.89952398148148 8.026e-06 0.89952398148148)
VIN16 sn16 0 PWL(0 0.90048418981481 5.25e-07 0.90048418981481 5.26e-07 0.90048418981481 1.15e-06 0.90048418981481 1.151e-06 0.9004828279321 1.775e-06 0.9004828279321 1.776e-06 0.9004828279321 2.4e-06 0.9004828279321 2.401e-06 0.90048146604938 3.025e-06 0.90048146604938 3.026e-06 0.90048146604938 3.65e-06 0.90048146604938 3.651e-06 0.90048010416667 4.275e-06 0.90048010416667 4.276e-06 0.90048010416667 4.9e-06 0.90048010416667 4.901e-06 0.90047874228395 5.525e-06 0.90047874228395 5.526e-06 0.90047874228395 6.15e-06 0.90047874228395 6.151e-06 0.90047738040123 6.775e-06 0.90047738040123 6.776e-06 0.90047738040123 7.4e-06 0.90047738040123 7.401e-06 0.90047601851852 8.025e-06 0.90047601851852 8.026e-06 0.90047601851852)
RP16 sp16 ip16 350
RN16 sn16 inn16 350
XCP16 ip16 0 adc_mim_bank COUNT=4096
XCN16 inn16 0 adc_mim_bank COUNT=4096
XCMP16 ip16 inn16 q16 qb16 clk vdd 0 adc_latched_comparator
CQ16 q16 0 5f
CQB16 qb16 0 5f
.ic V(q16)=0 V(qb16)=1.8
VIP17 sp17 0 PWL(0 0.89925680555556 5.25e-07 0.89925680555556 5.26e-07 0.89925680555556 1.15e-06 0.89925680555556 1.151e-06 0.89925864969136 1.775e-06 0.89925864969136 1.776e-06 0.89925864969136 2.4e-06 0.89925864969136 2.401e-06 0.89926049382716 3.025e-06 0.89926049382716 3.026e-06 0.89926049382716 3.65e-06 0.89926049382716 3.651e-06 0.89926233796296 4.275e-06 0.89926233796296 4.276e-06 0.89926233796296 4.9e-06 0.89926233796296 4.901e-06 0.89926418209877 5.525e-06 0.89926418209877 5.526e-06 0.89926418209877 6.15e-06 0.89926418209877 6.151e-06 0.89926602623457 6.775e-06 0.89926602623457 6.776e-06 0.89926602623457 7.4e-06 0.89926602623457 7.401e-06 0.89926787037037 8.025e-06 0.89926787037037 8.026e-06 0.89926787037037)
VIN17 sn17 0 PWL(0 0.90074319444444 5.25e-07 0.90074319444444 5.26e-07 0.90074319444444 1.15e-06 0.90074319444444 1.151e-06 0.90074135030864 1.775e-06 0.90074135030864 1.776e-06 0.90074135030864 2.4e-06 0.90074135030864 2.401e-06 0.90073950617284 3.025e-06 0.90073950617284 3.026e-06 0.90073950617284 3.65e-06 0.90073950617284 3.651e-06 0.90073766203704 4.275e-06 0.90073766203704 4.276e-06 0.90073766203704 4.9e-06 0.90073766203704 4.901e-06 0.90073581790123 5.525e-06 0.90073581790123 5.526e-06 0.90073581790123 6.15e-06 0.90073581790123 6.151e-06 0.90073397376543 6.775e-06 0.90073397376543 6.776e-06 0.90073397376543 7.4e-06 0.90073397376543 7.401e-06 0.90073212962963 8.025e-06 0.90073212962963 8.026e-06 0.90073212962963)
RP17 sp17 ip17 350
RN17 sn17 inn17 350
XCP17 ip17 0 adc_mim_bank COUNT=4096
XCN17 inn17 0 adc_mim_bank COUNT=4096
XCMP17 ip17 inn17 q17 qb17 clk vdd 0 adc_latched_comparator
CQ17 q17 0 5f
CQB17 qb17 0 5f
.ic V(q17)=0 V(qb17)=1.8
VIP18 sp18 0 PWL(0 0.90365402777778 5.25e-07 0.90365402777778 5.26e-07 0.90365402777778 1.15e-06 0.90365402777778 1.151e-06 0.90366358796296 1.775e-06 0.90366358796296 1.776e-06 0.90366358796296 2.4e-06 0.90366358796296 2.401e-06 0.90367314814815 3.025e-06 0.90367314814815 3.026e-06 0.90367314814815 3.65e-06 0.90367314814815 3.651e-06 0.90368270833333 4.275e-06 0.90368270833333 4.276e-06 0.90368270833333 4.9e-06 0.90368270833333 4.901e-06 0.90369226851852 5.525e-06 0.90369226851852 5.526e-06 0.90369226851852 6.15e-06 0.90369226851852 6.151e-06 0.9037018287037 6.775e-06 0.9037018287037 6.776e-06 0.9037018287037 7.4e-06 0.9037018287037 7.401e-06 0.90371138888889 8.025e-06 0.90371138888889 8.026e-06 0.90371138888889)
VIN18 sn18 0 PWL(0 0.89634597222222 5.25e-07 0.89634597222222 5.26e-07 0.89634597222222 1.15e-06 0.89634597222222 1.151e-06 0.89633641203704 1.775e-06 0.89633641203704 1.776e-06 0.89633641203704 2.4e-06 0.89633641203704 2.401e-06 0.89632685185185 3.025e-06 0.89632685185185 3.026e-06 0.89632685185185 3.65e-06 0.89632685185185 3.651e-06 0.89631729166667 4.275e-06 0.89631729166667 4.276e-06 0.89631729166667 4.9e-06 0.89631729166667 4.901e-06 0.89630773148148 5.525e-06 0.89630773148148 5.526e-06 0.89630773148148 6.15e-06 0.89630773148148 6.151e-06 0.8962981712963 6.775e-06 0.8962981712963 6.776e-06 0.8962981712963 7.4e-06 0.8962981712963 7.401e-06 0.89628861111111 8.025e-06 0.89628861111111 8.026e-06 0.89628861111111)
RP18 sp18 ip18 350
RN18 sn18 inn18 350
XCP18 ip18 0 adc_mim_bank COUNT=4096
XCN18 inn18 0 adc_mim_bank COUNT=4096
XCMP18 ip18 inn18 q18 qb18 clk vdd 0 adc_latched_comparator
CQ18 q18 0 5f
CQB18 qb18 0 5f
.ic V(q18)=0 V(qb18)=1.8
VIP19 sp19 0 PWL(0 0.90079490740741 5.25e-07 0.90079490740741 5.26e-07 0.90079490740741 1.15e-06 0.90079490740741 1.151e-06 0.90079675154321 1.775e-06 0.90079675154321 1.776e-06 0.90079675154321 2.4e-06 0.90079675154321 2.401e-06 0.90079859567901 3.025e-06 0.90079859567901 3.026e-06 0.90079859567901 3.65e-06 0.90079859567901 3.651e-06 0.90080043981481 4.275e-06 0.90080043981481 4.276e-06 0.90080043981481 4.9e-06 0.90080043981481 4.901e-06 0.90080228395062 5.525e-06 0.90080228395062 5.526e-06 0.90080228395062 6.15e-06 0.90080228395062 6.151e-06 0.90080412808642 6.775e-06 0.90080412808642 6.776e-06 0.90080412808642 7.4e-06 0.90080412808642 7.401e-06 0.90080597222222 8.025e-06 0.90080597222222 8.026e-06 0.90080597222222)
VIN19 sn19 0 PWL(0 0.89920509259259 5.25e-07 0.89920509259259 5.26e-07 0.89920509259259 1.15e-06 0.89920509259259 1.151e-06 0.89920324845679 1.775e-06 0.89920324845679 1.776e-06 0.89920324845679 2.4e-06 0.89920324845679 2.401e-06 0.89920140432099 3.025e-06 0.89920140432099 3.026e-06 0.89920140432099 3.65e-06 0.89920140432099 3.651e-06 0.89919956018519 4.275e-06 0.89919956018519 4.276e-06 0.89919956018519 4.9e-06 0.89919956018519 4.901e-06 0.89919771604938 5.525e-06 0.89919771604938 5.526e-06 0.89919771604938 6.15e-06 0.89919771604938 6.151e-06 0.89919587191358 6.775e-06 0.89919587191358 6.776e-06 0.89919587191358 7.4e-06 0.89919587191358 7.401e-06 0.89919402777778 8.025e-06 0.89919402777778 8.026e-06 0.89919402777778)
RP19 sp19 ip19 350
RN19 sn19 inn19 350
XCP19 ip19 0 adc_mim_bank COUNT=4096
XCN19 inn19 0 adc_mim_bank COUNT=4096
XCMP19 ip19 inn19 q19 qb19 clk vdd 0 adc_latched_comparator
CQ19 q19 0 5f
CQB19 qb19 0 5f
.ic V(q19)=0 V(qb19)=1.8
VIP20 sp20 0 PWL(0 0.90063189814815 5.25e-07 0.90063189814815 5.26e-07 0.90063189814815 1.15e-06 0.90063189814815 1.151e-06 0.90063374228395 1.775e-06 0.90063374228395 1.776e-06 0.90063374228395 2.4e-06 0.90063374228395 2.401e-06 0.90063558641975 3.025e-06 0.90063558641975 3.026e-06 0.90063558641975 3.65e-06 0.90063558641975 3.651e-06 0.90063743055556 4.275e-06 0.90063743055556 4.276e-06 0.90063743055556 4.9e-06 0.90063743055556 4.901e-06 0.90063927469136 5.525e-06 0.90063927469136 5.526e-06 0.90063927469136 6.15e-06 0.90063927469136 6.151e-06 0.90064111882716 6.775e-06 0.90064111882716 6.776e-06 0.90064111882716 7.4e-06 0.90064111882716 7.401e-06 0.90064296296296 8.025e-06 0.90064296296296 8.026e-06 0.90064296296296)
VIN20 sn20 0 PWL(0 0.89936810185185 5.25e-07 0.89936810185185 5.26e-07 0.89936810185185 1.15e-06 0.89936810185185 1.151e-06 0.89936625771605 1.775e-06 0.89936625771605 1.776e-06 0.89936625771605 2.4e-06 0.89936625771605 2.401e-06 0.89936441358025 3.025e-06 0.89936441358025 3.026e-06 0.89936441358025 3.65e-06 0.89936441358025 3.651e-06 0.89936256944444 4.275e-06 0.89936256944444 4.276e-06 0.89936256944444 4.9e-06 0.89936256944444 4.901e-06 0.89936072530864 5.525e-06 0.89936072530864 5.526e-06 0.89936072530864 6.15e-06 0.89936072530864 6.151e-06 0.89935888117284 6.775e-06 0.89935888117284 6.776e-06 0.89935888117284 7.4e-06 0.89935888117284 7.401e-06 0.89935703703704 8.025e-06 0.89935703703704 8.026e-06 0.89935703703704)
RP20 sp20 ip20 350
RN20 sn20 inn20 350
XCP20 ip20 0 adc_mim_bank COUNT=4096
XCN20 inn20 0 adc_mim_bank COUNT=4096
XCMP20 ip20 inn20 q20 qb20 clk vdd 0 adc_latched_comparator
CQ20 q20 0 5f
CQB20 qb20 0 5f
.ic V(q20)=0 V(qb20)=1.8
VIP21 sp21 0 PWL(0 0.89870074074074 5.25e-07 0.89870074074074 5.26e-07 0.89870074074074 1.15e-06 0.89870074074074 1.151e-06 0.89870258487654 1.775e-06 0.89870258487654 1.776e-06 0.89870258487654 2.4e-06 0.89870258487654 2.401e-06 0.89870442901235 3.025e-06 0.89870442901235 3.026e-06 0.89870442901235 3.65e-06 0.89870442901235 3.651e-06 0.89870627314815 4.275e-06 0.89870627314815 4.276e-06 0.89870627314815 4.9e-06 0.89870627314815 4.901e-06 0.89870811728395 5.525e-06 0.89870811728395 5.526e-06 0.89870811728395 6.15e-06 0.89870811728395 6.151e-06 0.89870996141975 6.775e-06 0.89870996141975 6.776e-06 0.89870996141975 7.4e-06 0.89870996141975 7.401e-06 0.89871180555556 8.025e-06 0.89871180555556 8.026e-06 0.89871180555556)
VIN21 sn21 0 PWL(0 0.90129925925926 5.25e-07 0.90129925925926 5.26e-07 0.90129925925926 1.15e-06 0.90129925925926 1.151e-06 0.90129741512346 1.775e-06 0.90129741512346 1.776e-06 0.90129741512346 2.4e-06 0.90129741512346 2.401e-06 0.90129557098765 3.025e-06 0.90129557098765 3.026e-06 0.90129557098765 3.65e-06 0.90129557098765 3.651e-06 0.90129372685185 4.275e-06 0.90129372685185 4.276e-06 0.90129372685185 4.9e-06 0.90129372685185 4.901e-06 0.90129188271605 5.525e-06 0.90129188271605 5.526e-06 0.90129188271605 6.15e-06 0.90129188271605 6.151e-06 0.90129003858025 6.775e-06 0.90129003858025 6.776e-06 0.90129003858025 7.4e-06 0.90129003858025 7.401e-06 0.90128819444444 8.025e-06 0.90128819444444 8.026e-06 0.90128819444444)
RP21 sp21 ip21 350
RN21 sn21 inn21 350
XCP21 ip21 0 adc_mim_bank COUNT=4096
XCN21 inn21 0 adc_mim_bank COUNT=4096
XCMP21 ip21 inn21 q21 qb21 clk vdd 0 adc_latched_comparator
CQ21 q21 0 5f
CQB21 qb21 0 5f
.ic V(q21)=0 V(qb21)=1.8
VIP22 sp22 0 PWL(0 0.90091546296296 5.25e-07 0.90091546296296 5.26e-07 0.90091546296296 1.15e-06 0.90091546296296 1.151e-06 0.90091730709877 1.775e-06 0.90091730709877 1.776e-06 0.90091730709877 2.4e-06 0.90091730709877 2.401e-06 0.90091915123457 3.025e-06 0.90091915123457 3.026e-06 0.90091915123457 3.65e-06 0.90091915123457 3.651e-06 0.90092099537037 4.275e-06 0.90092099537037 4.276e-06 0.90092099537037 4.9e-06 0.90092099537037 4.901e-06 0.90092283950617 5.525e-06 0.90092283950617 5.526e-06 0.90092283950617 6.15e-06 0.90092283950617 6.151e-06 0.90092468364198 6.775e-06 0.90092468364198 6.776e-06 0.90092468364198 7.4e-06 0.90092468364198 7.401e-06 0.90092652777778 8.025e-06 0.90092652777778 8.026e-06 0.90092652777778)
VIN22 sn22 0 PWL(0 0.89908453703704 5.25e-07 0.89908453703704 5.26e-07 0.89908453703704 1.15e-06 0.89908453703704 1.151e-06 0.89908269290123 1.775e-06 0.89908269290123 1.776e-06 0.89908269290123 2.4e-06 0.89908269290123 2.401e-06 0.89908084876543 3.025e-06 0.89908084876543 3.026e-06 0.89908084876543 3.65e-06 0.89908084876543 3.651e-06 0.89907900462963 4.275e-06 0.89907900462963 4.276e-06 0.89907900462963 4.9e-06 0.89907900462963 4.901e-06 0.89907716049383 5.525e-06 0.89907716049383 5.526e-06 0.89907716049383 6.15e-06 0.89907716049383 6.151e-06 0.89907531635802 6.775e-06 0.89907531635802 6.776e-06 0.89907531635802 7.4e-06 0.89907531635802 7.401e-06 0.89907347222222 8.025e-06 0.89907347222222 8.026e-06 0.89907347222222)
RP22 sp22 ip22 350
RN22 sn22 inn22 350
XCP22 ip22 0 adc_mim_bank COUNT=4096
XCN22 inn22 0 adc_mim_bank COUNT=4096
XCMP22 ip22 inn22 q22 qb22 clk vdd 0 adc_latched_comparator
CQ22 q22 0 5f
CQB22 qb22 0 5f
.ic V(q22)=0 V(qb22)=1.8
VIP23 sp23 0 PWL(0 0.89752027777778 5.25e-07 0.89752027777778 5.26e-07 0.89752027777778 1.15e-06 0.89752027777778 1.151e-06 0.89752983796296 1.775e-06 0.89752983796296 1.776e-06 0.89752983796296 2.4e-06 0.89752983796296 2.401e-06 0.89753939814815 3.025e-06 0.89753939814815 3.026e-06 0.89753939814815 3.65e-06 0.89753939814815 3.651e-06 0.89754895833333 4.275e-06 0.89754895833333 4.276e-06 0.89754895833333 4.9e-06 0.89754895833333 4.901e-06 0.89755851851852 5.525e-06 0.89755851851852 5.526e-06 0.89755851851852 6.15e-06 0.89755851851852 6.151e-06 0.8975680787037 6.775e-06 0.8975680787037 6.776e-06 0.8975680787037 7.4e-06 0.8975680787037 7.401e-06 0.89757763888889 8.025e-06 0.89757763888889 8.026e-06 0.89757763888889)
VIN23 sn23 0 PWL(0 0.90247972222222 5.25e-07 0.90247972222222 5.26e-07 0.90247972222222 1.15e-06 0.90247972222222 1.151e-06 0.90247016203704 1.775e-06 0.90247016203704 1.776e-06 0.90247016203704 2.4e-06 0.90247016203704 2.401e-06 0.90246060185185 3.025e-06 0.90246060185185 3.026e-06 0.90246060185185 3.65e-06 0.90246060185185 3.651e-06 0.90245104166667 4.275e-06 0.90245104166667 4.276e-06 0.90245104166667 4.9e-06 0.90245104166667 4.901e-06 0.90244148148148 5.525e-06 0.90244148148148 5.526e-06 0.90244148148148 6.15e-06 0.90244148148148 6.151e-06 0.9024319212963 6.775e-06 0.9024319212963 6.776e-06 0.9024319212963 7.4e-06 0.9024319212963 7.401e-06 0.90242236111111 8.025e-06 0.90242236111111 8.026e-06 0.90242236111111)
RP23 sp23 ip23 350
RN23 sn23 inn23 350
XCP23 ip23 0 adc_mim_bank COUNT=4096
XCN23 inn23 0 adc_mim_bank COUNT=4096
XCMP23 ip23 inn23 q23 qb23 clk vdd 0 adc_latched_comparator
CQ23 q23 0 5f
CQB23 qb23 0 5f
.ic V(q23)=0 V(qb23)=1.8
VIP24 sp24 0 PWL(0 0.8995112962963 5.25e-07 0.8995112962963 5.26e-07 0.8995112962963 1.15e-06 0.8995112962963 1.151e-06 0.89951265817901 1.775e-06 0.89951265817901 1.776e-06 0.89951265817901 2.4e-06 0.89951265817901 2.401e-06 0.89951402006173 3.025e-06 0.89951402006173 3.026e-06 0.89951402006173 3.65e-06 0.89951402006173 3.651e-06 0.89951538194444 4.275e-06 0.89951538194444 4.276e-06 0.89951538194444 4.9e-06 0.89951538194444 4.901e-06 0.89951674382716 5.525e-06 0.89951674382716 5.526e-06 0.89951674382716 6.15e-06 0.89951674382716 6.151e-06 0.89951810570988 6.775e-06 0.89951810570988 6.776e-06 0.89951810570988 7.4e-06 0.89951810570988 7.401e-06 0.89951946759259 8.025e-06 0.89951946759259 8.026e-06 0.89951946759259)
VIN24 sn24 0 PWL(0 0.9004887037037 5.25e-07 0.9004887037037 5.26e-07 0.9004887037037 1.15e-06 0.9004887037037 1.151e-06 0.90048734182099 1.775e-06 0.90048734182099 1.776e-06 0.90048734182099 2.4e-06 0.90048734182099 2.401e-06 0.90048597993827 3.025e-06 0.90048597993827 3.026e-06 0.90048597993827 3.65e-06 0.90048597993827 3.651e-06 0.90048461805556 4.275e-06 0.90048461805556 4.276e-06 0.90048461805556 4.9e-06 0.90048461805556 4.901e-06 0.90048325617284 5.525e-06 0.90048325617284 5.526e-06 0.90048325617284 6.15e-06 0.90048325617284 6.151e-06 0.90048189429012 6.775e-06 0.90048189429012 6.776e-06 0.90048189429012 7.4e-06 0.90048189429012 7.401e-06 0.90048053240741 8.025e-06 0.90048053240741 8.026e-06 0.90048053240741)
RP24 sp24 ip24 350
RN24 sn24 inn24 350
XCP24 ip24 0 adc_mim_bank COUNT=4096
XCN24 inn24 0 adc_mim_bank COUNT=4096
XCMP24 ip24 inn24 q24 qb24 clk vdd 0 adc_latched_comparator
CQ24 q24 0 5f
CQB24 qb24 0 5f
.ic V(q24)=0 V(qb24)=1.8
.control
set num_threads=1
set wr_singlescale
set wr_vecnames
set numdgt=12
setseed 1309200
reset
tran 1n 8.675e-06
meas tran s0_k0_q find v(q0) at=1.05e-06
meas tran s0_k0_qb find v(qb0) at=1.05e-06
meas tran s0_k1_q find v(q0) at=2.3e-06
meas tran s0_k1_qb find v(qb0) at=2.3e-06
meas tran s0_k2_q find v(q0) at=3.55e-06
meas tran s0_k2_qb find v(qb0) at=3.55e-06
meas tran s0_k3_q find v(q0) at=4.8e-06
meas tran s0_k3_qb find v(qb0) at=4.8e-06
meas tran s0_k4_q find v(q0) at=6.05e-06
meas tran s0_k4_qb find v(qb0) at=6.05e-06
meas tran s0_k5_q find v(q0) at=7.3e-06
meas tran s0_k5_qb find v(qb0) at=7.3e-06
meas tran s0_k6_q find v(q0) at=8.55e-06
meas tran s0_k6_qb find v(qb0) at=8.55e-06
meas tran s1_k0_q find v(q1) at=1.05e-06
meas tran s1_k0_qb find v(qb1) at=1.05e-06
meas tran s1_k1_q find v(q1) at=2.3e-06
meas tran s1_k1_qb find v(qb1) at=2.3e-06
meas tran s1_k2_q find v(q1) at=3.55e-06
meas tran s1_k2_qb find v(qb1) at=3.55e-06
meas tran s1_k3_q find v(q1) at=4.8e-06
meas tran s1_k3_qb find v(qb1) at=4.8e-06
meas tran s1_k4_q find v(q1) at=6.05e-06
meas tran s1_k4_qb find v(qb1) at=6.05e-06
meas tran s1_k5_q find v(q1) at=7.3e-06
meas tran s1_k5_qb find v(qb1) at=7.3e-06
meas tran s1_k6_q find v(q1) at=8.55e-06
meas tran s1_k6_qb find v(qb1) at=8.55e-06
meas tran s2_k0_q find v(q2) at=1.05e-06
meas tran s2_k0_qb find v(qb2) at=1.05e-06
meas tran s2_k1_q find v(q2) at=2.3e-06
meas tran s2_k1_qb find v(qb2) at=2.3e-06
meas tran s2_k2_q find v(q2) at=3.55e-06
meas tran s2_k2_qb find v(qb2) at=3.55e-06
meas tran s2_k3_q find v(q2) at=4.8e-06
meas tran s2_k3_qb find v(qb2) at=4.8e-06
meas tran s2_k4_q find v(q2) at=6.05e-06
meas tran s2_k4_qb find v(qb2) at=6.05e-06
meas tran s2_k5_q find v(q2) at=7.3e-06
meas tran s2_k5_qb find v(qb2) at=7.3e-06
meas tran s2_k6_q find v(q2) at=8.55e-06
meas tran s2_k6_qb find v(qb2) at=8.55e-06
meas tran s3_k0_q find v(q3) at=1.05e-06
meas tran s3_k0_qb find v(qb3) at=1.05e-06
meas tran s3_k1_q find v(q3) at=2.3e-06
meas tran s3_k1_qb find v(qb3) at=2.3e-06
meas tran s3_k2_q find v(q3) at=3.55e-06
meas tran s3_k2_qb find v(qb3) at=3.55e-06
meas tran s3_k3_q find v(q3) at=4.8e-06
meas tran s3_k3_qb find v(qb3) at=4.8e-06
meas tran s3_k4_q find v(q3) at=6.05e-06
meas tran s3_k4_qb find v(qb3) at=6.05e-06
meas tran s3_k5_q find v(q3) at=7.3e-06
meas tran s3_k5_qb find v(qb3) at=7.3e-06
meas tran s3_k6_q find v(q3) at=8.55e-06
meas tran s3_k6_qb find v(qb3) at=8.55e-06
meas tran s4_k0_q find v(q4) at=1.05e-06
meas tran s4_k0_qb find v(qb4) at=1.05e-06
meas tran s4_k1_q find v(q4) at=2.3e-06
meas tran s4_k1_qb find v(qb4) at=2.3e-06
meas tran s4_k2_q find v(q4) at=3.55e-06
meas tran s4_k2_qb find v(qb4) at=3.55e-06
meas tran s4_k3_q find v(q4) at=4.8e-06
meas tran s4_k3_qb find v(qb4) at=4.8e-06
meas tran s4_k4_q find v(q4) at=6.05e-06
meas tran s4_k4_qb find v(qb4) at=6.05e-06
meas tran s4_k5_q find v(q4) at=7.3e-06
meas tran s4_k5_qb find v(qb4) at=7.3e-06
meas tran s4_k6_q find v(q4) at=8.55e-06
meas tran s4_k6_qb find v(qb4) at=8.55e-06
meas tran s5_k0_q find v(q5) at=1.05e-06
meas tran s5_k0_qb find v(qb5) at=1.05e-06
meas tran s5_k1_q find v(q5) at=2.3e-06
meas tran s5_k1_qb find v(qb5) at=2.3e-06
meas tran s5_k2_q find v(q5) at=3.55e-06
meas tran s5_k2_qb find v(qb5) at=3.55e-06
meas tran s5_k3_q find v(q5) at=4.8e-06
meas tran s5_k3_qb find v(qb5) at=4.8e-06
meas tran s5_k4_q find v(q5) at=6.05e-06
meas tran s5_k4_qb find v(qb5) at=6.05e-06
meas tran s5_k5_q find v(q5) at=7.3e-06
meas tran s5_k5_qb find v(qb5) at=7.3e-06
meas tran s5_k6_q find v(q5) at=8.55e-06
meas tran s5_k6_qb find v(qb5) at=8.55e-06
meas tran s6_k0_q find v(q6) at=1.05e-06
meas tran s6_k0_qb find v(qb6) at=1.05e-06
meas tran s6_k1_q find v(q6) at=2.3e-06
meas tran s6_k1_qb find v(qb6) at=2.3e-06
meas tran s6_k2_q find v(q6) at=3.55e-06
meas tran s6_k2_qb find v(qb6) at=3.55e-06
meas tran s6_k3_q find v(q6) at=4.8e-06
meas tran s6_k3_qb find v(qb6) at=4.8e-06
meas tran s6_k4_q find v(q6) at=6.05e-06
meas tran s6_k4_qb find v(qb6) at=6.05e-06
meas tran s6_k5_q find v(q6) at=7.3e-06
meas tran s6_k5_qb find v(qb6) at=7.3e-06
meas tran s6_k6_q find v(q6) at=8.55e-06
meas tran s6_k6_qb find v(qb6) at=8.55e-06
meas tran s7_k0_q find v(q7) at=1.05e-06
meas tran s7_k0_qb find v(qb7) at=1.05e-06
meas tran s7_k1_q find v(q7) at=2.3e-06
meas tran s7_k1_qb find v(qb7) at=2.3e-06
meas tran s7_k2_q find v(q7) at=3.55e-06
meas tran s7_k2_qb find v(qb7) at=3.55e-06
meas tran s7_k3_q find v(q7) at=4.8e-06
meas tran s7_k3_qb find v(qb7) at=4.8e-06
meas tran s7_k4_q find v(q7) at=6.05e-06
meas tran s7_k4_qb find v(qb7) at=6.05e-06
meas tran s7_k5_q find v(q7) at=7.3e-06
meas tran s7_k5_qb find v(qb7) at=7.3e-06
meas tran s7_k6_q find v(q7) at=8.55e-06
meas tran s7_k6_qb find v(qb7) at=8.55e-06
meas tran s8_k0_q find v(q8) at=1.05e-06
meas tran s8_k0_qb find v(qb8) at=1.05e-06
meas tran s8_k1_q find v(q8) at=2.3e-06
meas tran s8_k1_qb find v(qb8) at=2.3e-06
meas tran s8_k2_q find v(q8) at=3.55e-06
meas tran s8_k2_qb find v(qb8) at=3.55e-06
meas tran s8_k3_q find v(q8) at=4.8e-06
meas tran s8_k3_qb find v(qb8) at=4.8e-06
meas tran s8_k4_q find v(q8) at=6.05e-06
meas tran s8_k4_qb find v(qb8) at=6.05e-06
meas tran s8_k5_q find v(q8) at=7.3e-06
meas tran s8_k5_qb find v(qb8) at=7.3e-06
meas tran s8_k6_q find v(q8) at=8.55e-06
meas tran s8_k6_qb find v(qb8) at=8.55e-06
meas tran s9_k0_q find v(q9) at=1.05e-06
meas tran s9_k0_qb find v(qb9) at=1.05e-06
meas tran s9_k1_q find v(q9) at=2.3e-06
meas tran s9_k1_qb find v(qb9) at=2.3e-06
meas tran s9_k2_q find v(q9) at=3.55e-06
meas tran s9_k2_qb find v(qb9) at=3.55e-06
meas tran s9_k3_q find v(q9) at=4.8e-06
meas tran s9_k3_qb find v(qb9) at=4.8e-06
meas tran s9_k4_q find v(q9) at=6.05e-06
meas tran s9_k4_qb find v(qb9) at=6.05e-06
meas tran s9_k5_q find v(q9) at=7.3e-06
meas tran s9_k5_qb find v(qb9) at=7.3e-06
meas tran s9_k6_q find v(q9) at=8.55e-06
meas tran s9_k6_qb find v(qb9) at=8.55e-06
meas tran s10_k0_q find v(q10) at=1.05e-06
meas tran s10_k0_qb find v(qb10) at=1.05e-06
meas tran s10_k1_q find v(q10) at=2.3e-06
meas tran s10_k1_qb find v(qb10) at=2.3e-06
meas tran s10_k2_q find v(q10) at=3.55e-06
meas tran s10_k2_qb find v(qb10) at=3.55e-06
meas tran s10_k3_q find v(q10) at=4.8e-06
meas tran s10_k3_qb find v(qb10) at=4.8e-06
meas tran s10_k4_q find v(q10) at=6.05e-06
meas tran s10_k4_qb find v(qb10) at=6.05e-06
meas tran s10_k5_q find v(q10) at=7.3e-06
meas tran s10_k5_qb find v(qb10) at=7.3e-06
meas tran s10_k6_q find v(q10) at=8.55e-06
meas tran s10_k6_qb find v(qb10) at=8.55e-06
meas tran s11_k0_q find v(q11) at=1.05e-06
meas tran s11_k0_qb find v(qb11) at=1.05e-06
meas tran s11_k1_q find v(q11) at=2.3e-06
meas tran s11_k1_qb find v(qb11) at=2.3e-06
meas tran s11_k2_q find v(q11) at=3.55e-06
meas tran s11_k2_qb find v(qb11) at=3.55e-06
meas tran s11_k3_q find v(q11) at=4.8e-06
meas tran s11_k3_qb find v(qb11) at=4.8e-06
meas tran s11_k4_q find v(q11) at=6.05e-06
meas tran s11_k4_qb find v(qb11) at=6.05e-06
meas tran s11_k5_q find v(q11) at=7.3e-06
meas tran s11_k5_qb find v(qb11) at=7.3e-06
meas tran s11_k6_q find v(q11) at=8.55e-06
meas tran s11_k6_qb find v(qb11) at=8.55e-06
meas tran s12_k0_q find v(q12) at=1.05e-06
meas tran s12_k0_qb find v(qb12) at=1.05e-06
meas tran s12_k1_q find v(q12) at=2.3e-06
meas tran s12_k1_qb find v(qb12) at=2.3e-06
meas tran s12_k2_q find v(q12) at=3.55e-06
meas tran s12_k2_qb find v(qb12) at=3.55e-06
meas tran s12_k3_q find v(q12) at=4.8e-06
meas tran s12_k3_qb find v(qb12) at=4.8e-06
meas tran s12_k4_q find v(q12) at=6.05e-06
meas tran s12_k4_qb find v(qb12) at=6.05e-06
meas tran s12_k5_q find v(q12) at=7.3e-06
meas tran s12_k5_qb find v(qb12) at=7.3e-06
meas tran s12_k6_q find v(q12) at=8.55e-06
meas tran s12_k6_qb find v(qb12) at=8.55e-06
meas tran s13_k0_q find v(q13) at=1.05e-06
meas tran s13_k0_qb find v(qb13) at=1.05e-06
meas tran s13_k1_q find v(q13) at=2.3e-06
meas tran s13_k1_qb find v(qb13) at=2.3e-06
meas tran s13_k2_q find v(q13) at=3.55e-06
meas tran s13_k2_qb find v(qb13) at=3.55e-06
meas tran s13_k3_q find v(q13) at=4.8e-06
meas tran s13_k3_qb find v(qb13) at=4.8e-06
meas tran s13_k4_q find v(q13) at=6.05e-06
meas tran s13_k4_qb find v(qb13) at=6.05e-06
meas tran s13_k5_q find v(q13) at=7.3e-06
meas tran s13_k5_qb find v(qb13) at=7.3e-06
meas tran s13_k6_q find v(q13) at=8.55e-06
meas tran s13_k6_qb find v(qb13) at=8.55e-06
meas tran s14_k0_q find v(q14) at=1.05e-06
meas tran s14_k0_qb find v(qb14) at=1.05e-06
meas tran s14_k1_q find v(q14) at=2.3e-06
meas tran s14_k1_qb find v(qb14) at=2.3e-06
meas tran s14_k2_q find v(q14) at=3.55e-06
meas tran s14_k2_qb find v(qb14) at=3.55e-06
meas tran s14_k3_q find v(q14) at=4.8e-06
meas tran s14_k3_qb find v(qb14) at=4.8e-06
meas tran s14_k4_q find v(q14) at=6.05e-06
meas tran s14_k4_qb find v(qb14) at=6.05e-06
meas tran s14_k5_q find v(q14) at=7.3e-06
meas tran s14_k5_qb find v(qb14) at=7.3e-06
meas tran s14_k6_q find v(q14) at=8.55e-06
meas tran s14_k6_qb find v(qb14) at=8.55e-06
meas tran s15_k0_q find v(q15) at=1.05e-06
meas tran s15_k0_qb find v(qb15) at=1.05e-06
meas tran s15_k1_q find v(q15) at=2.3e-06
meas tran s15_k1_qb find v(qb15) at=2.3e-06
meas tran s15_k2_q find v(q15) at=3.55e-06
meas tran s15_k2_qb find v(qb15) at=3.55e-06
meas tran s15_k3_q find v(q15) at=4.8e-06
meas tran s15_k3_qb find v(qb15) at=4.8e-06
meas tran s15_k4_q find v(q15) at=6.05e-06
meas tran s15_k4_qb find v(qb15) at=6.05e-06
meas tran s15_k5_q find v(q15) at=7.3e-06
meas tran s15_k5_qb find v(qb15) at=7.3e-06
meas tran s15_k6_q find v(q15) at=8.55e-06
meas tran s15_k6_qb find v(qb15) at=8.55e-06
meas tran s16_k0_q find v(q16) at=1.05e-06
meas tran s16_k0_qb find v(qb16) at=1.05e-06
meas tran s16_k1_q find v(q16) at=2.3e-06
meas tran s16_k1_qb find v(qb16) at=2.3e-06
meas tran s16_k2_q find v(q16) at=3.55e-06
meas tran s16_k2_qb find v(qb16) at=3.55e-06
meas tran s16_k3_q find v(q16) at=4.8e-06
meas tran s16_k3_qb find v(qb16) at=4.8e-06
meas tran s16_k4_q find v(q16) at=6.05e-06
meas tran s16_k4_qb find v(qb16) at=6.05e-06
meas tran s16_k5_q find v(q16) at=7.3e-06
meas tran s16_k5_qb find v(qb16) at=7.3e-06
meas tran s16_k6_q find v(q16) at=8.55e-06
meas tran s16_k6_qb find v(qb16) at=8.55e-06
meas tran s17_k0_q find v(q17) at=1.05e-06
meas tran s17_k0_qb find v(qb17) at=1.05e-06
meas tran s17_k1_q find v(q17) at=2.3e-06
meas tran s17_k1_qb find v(qb17) at=2.3e-06
meas tran s17_k2_q find v(q17) at=3.55e-06
meas tran s17_k2_qb find v(qb17) at=3.55e-06
meas tran s17_k3_q find v(q17) at=4.8e-06
meas tran s17_k3_qb find v(qb17) at=4.8e-06
meas tran s17_k4_q find v(q17) at=6.05e-06
meas tran s17_k4_qb find v(qb17) at=6.05e-06
meas tran s17_k5_q find v(q17) at=7.3e-06
meas tran s17_k5_qb find v(qb17) at=7.3e-06
meas tran s17_k6_q find v(q17) at=8.55e-06
meas tran s17_k6_qb find v(qb17) at=8.55e-06
meas tran s18_k0_q find v(q18) at=1.05e-06
meas tran s18_k0_qb find v(qb18) at=1.05e-06
meas tran s18_k1_q find v(q18) at=2.3e-06
meas tran s18_k1_qb find v(qb18) at=2.3e-06
meas tran s18_k2_q find v(q18) at=3.55e-06
meas tran s18_k2_qb find v(qb18) at=3.55e-06
meas tran s18_k3_q find v(q18) at=4.8e-06
meas tran s18_k3_qb find v(qb18) at=4.8e-06
meas tran s18_k4_q find v(q18) at=6.05e-06
meas tran s18_k4_qb find v(qb18) at=6.05e-06
meas tran s18_k5_q find v(q18) at=7.3e-06
meas tran s18_k5_qb find v(qb18) at=7.3e-06
meas tran s18_k6_q find v(q18) at=8.55e-06
meas tran s18_k6_qb find v(qb18) at=8.55e-06
meas tran s19_k0_q find v(q19) at=1.05e-06
meas tran s19_k0_qb find v(qb19) at=1.05e-06
meas tran s19_k1_q find v(q19) at=2.3e-06
meas tran s19_k1_qb find v(qb19) at=2.3e-06
meas tran s19_k2_q find v(q19) at=3.55e-06
meas tran s19_k2_qb find v(qb19) at=3.55e-06
meas tran s19_k3_q find v(q19) at=4.8e-06
meas tran s19_k3_qb find v(qb19) at=4.8e-06
meas tran s19_k4_q find v(q19) at=6.05e-06
meas tran s19_k4_qb find v(qb19) at=6.05e-06
meas tran s19_k5_q find v(q19) at=7.3e-06
meas tran s19_k5_qb find v(qb19) at=7.3e-06
meas tran s19_k6_q find v(q19) at=8.55e-06
meas tran s19_k6_qb find v(qb19) at=8.55e-06
meas tran s20_k0_q find v(q20) at=1.05e-06
meas tran s20_k0_qb find v(qb20) at=1.05e-06
meas tran s20_k1_q find v(q20) at=2.3e-06
meas tran s20_k1_qb find v(qb20) at=2.3e-06
meas tran s20_k2_q find v(q20) at=3.55e-06
meas tran s20_k2_qb find v(qb20) at=3.55e-06
meas tran s20_k3_q find v(q20) at=4.8e-06
meas tran s20_k3_qb find v(qb20) at=4.8e-06
meas tran s20_k4_q find v(q20) at=6.05e-06
meas tran s20_k4_qb find v(qb20) at=6.05e-06
meas tran s20_k5_q find v(q20) at=7.3e-06
meas tran s20_k5_qb find v(qb20) at=7.3e-06
meas tran s20_k6_q find v(q20) at=8.55e-06
meas tran s20_k6_qb find v(qb20) at=8.55e-06
meas tran s21_k0_q find v(q21) at=1.05e-06
meas tran s21_k0_qb find v(qb21) at=1.05e-06
meas tran s21_k1_q find v(q21) at=2.3e-06
meas tran s21_k1_qb find v(qb21) at=2.3e-06
meas tran s21_k2_q find v(q21) at=3.55e-06
meas tran s21_k2_qb find v(qb21) at=3.55e-06
meas tran s21_k3_q find v(q21) at=4.8e-06
meas tran s21_k3_qb find v(qb21) at=4.8e-06
meas tran s21_k4_q find v(q21) at=6.05e-06
meas tran s21_k4_qb find v(qb21) at=6.05e-06
meas tran s21_k5_q find v(q21) at=7.3e-06
meas tran s21_k5_qb find v(qb21) at=7.3e-06
meas tran s21_k6_q find v(q21) at=8.55e-06
meas tran s21_k6_qb find v(qb21) at=8.55e-06
meas tran s22_k0_q find v(q22) at=1.05e-06
meas tran s22_k0_qb find v(qb22) at=1.05e-06
meas tran s22_k1_q find v(q22) at=2.3e-06
meas tran s22_k1_qb find v(qb22) at=2.3e-06
meas tran s22_k2_q find v(q22) at=3.55e-06
meas tran s22_k2_qb find v(qb22) at=3.55e-06
meas tran s22_k3_q find v(q22) at=4.8e-06
meas tran s22_k3_qb find v(qb22) at=4.8e-06
meas tran s22_k4_q find v(q22) at=6.05e-06
meas tran s22_k4_qb find v(qb22) at=6.05e-06
meas tran s22_k5_q find v(q22) at=7.3e-06
meas tran s22_k5_qb find v(qb22) at=7.3e-06
meas tran s22_k6_q find v(q22) at=8.55e-06
meas tran s22_k6_qb find v(qb22) at=8.55e-06
meas tran s23_k0_q find v(q23) at=1.05e-06
meas tran s23_k0_qb find v(qb23) at=1.05e-06
meas tran s23_k1_q find v(q23) at=2.3e-06
meas tran s23_k1_qb find v(qb23) at=2.3e-06
meas tran s23_k2_q find v(q23) at=3.55e-06
meas tran s23_k2_qb find v(qb23) at=3.55e-06
meas tran s23_k3_q find v(q23) at=4.8e-06
meas tran s23_k3_qb find v(qb23) at=4.8e-06
meas tran s23_k4_q find v(q23) at=6.05e-06
meas tran s23_k4_qb find v(qb23) at=6.05e-06
meas tran s23_k5_q find v(q23) at=7.3e-06
meas tran s23_k5_qb find v(qb23) at=7.3e-06
meas tran s23_k6_q find v(q23) at=8.55e-06
meas tran s23_k6_qb find v(qb23) at=8.55e-06
meas tran s24_k0_q find v(q24) at=1.05e-06
meas tran s24_k0_qb find v(qb24) at=1.05e-06
meas tran s24_k1_q find v(q24) at=2.3e-06
meas tran s24_k1_qb find v(qb24) at=2.3e-06
meas tran s24_k2_q find v(q24) at=3.55e-06
meas tran s24_k2_qb find v(qb24) at=3.55e-06
meas tran s24_k3_q find v(q24) at=4.8e-06
meas tran s24_k3_qb find v(qb24) at=4.8e-06
meas tran s24_k4_q find v(q24) at=6.05e-06
meas tran s24_k4_qb find v(qb24) at=6.05e-06
meas tran s24_k5_q find v(q24) at=7.3e-06
meas tran s24_k5_qb find v(qb24) at=7.3e-06
meas tran s24_k6_q find v(q24) at=8.55e-06
meas tran s24_k6_qb find v(qb24) at=8.55e-06
quit
.endc
.end
