* preamp_reset_strongarm_noise
.lib /foss/pdks/sky130A/libs.tech/combined/sky130.lib.spice tt
.include /repo/v2/analog/adc/adc_blocks.spice
.temp 27
.options reltol=1e-5 abstol=1e-14 vntol=1e-8 method=gear klu
.include /repo/v2/analog/adc/adc_preamp.spice
.options sparse
VDD vdd 0 1.8
VCMP cmpdd 0 1.8
VCM cm 0 .9
VDIFF diff 0 DC 0 AC 1
EIP ip cm diff 0 .5
EIN inn cm diff 0 -.5
XPRE ip inn op on vdd 0 adc_preamp
XSA op on dp dn 0 cmpdd 0 adc_strongarm
XDP dp 0 adc_mim_bank COUNT=16
XDN dn 0 adc_mim_bank COUNT=16

.control
set num_threads=1
set wr_singlescale
set wr_vecnames
set numdgt=12
op
wrdata /repo/v2/analog/adc/results/preamp_reset_strongarm_noise_op.tsv v(op) v(on) i(vdd) i(vcmp)
ac lin 1 1 1
let dg=v(op)-v(on)
wrdata /repo/v2/analog/adc/results/preamp_reset_strongarm_noise_ac.tsv real(dg) imag(dg)
noise v(op,on) VDIFF dec 40 1 100meg
setplot noise1
wrdata /repo/v2/analog/adc/results/preamp_reset_strongarm_noise_noise.tsv onoise_spectrum inoise_spectrum

quit
.endc
.end
