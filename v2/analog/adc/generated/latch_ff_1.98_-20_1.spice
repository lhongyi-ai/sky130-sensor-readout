* latch_ff_1.98_-20_1
.lib /foss/pdks/sky130A/libs.tech/combined/sky130.lib.spice ff
.include /repo/v2/analog/adc/adc_blocks.spice
.temp -20
.options reltol=1e-5 abstol=1e-14 vntol=1e-8 method=gear klu

VDD vdd 0 1.98
VIP sp 0 PWL(0 0.990024414062 600n 0.990024414062 601n 0.989975585938)
VIN sn 0 PWL(0 0.989975585938 600n 0.989975585938 601n 0.990024414062)
RP sp ip 350
RN sn inn 350
XCP ip 0 adc_mim_bank COUNT=4096
XCN inn 0 adc_mim_bank COUNT=4096
VCLK clk 0 PULSE(0 1.98 200n 1n 1n 250n 625n)
XCMP ip inn q qb clk vdd 0 adc_latched_comparator
CP q 0 5f
CN qb 0 5f
.ic V(q)=0 V(qb)=1.98

.control
set num_threads=1
set wr_singlescale
set wr_vecnames
set numdgt=12
tran 250p 1.4u
wrdata /repo/v2/analog/adc/results/latch_ff_1.98_-20_1.tsv v(q) v(qb) v(xcmp.dpos) v(xcmp.dneg) v(clk) i(vclk) v(ip) v(inn)
quit
.endc
.end
