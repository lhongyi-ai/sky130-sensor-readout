Frozen composite SKY130 ADC / live unchanged SAR RTL / static campaign
.lib /foss/pdks/sky130A/libs.tech/combined/sky130.lib.spice tt
.include /repo/v2/analog/adc/verification_20260910/campaigns/continuous_three_point/frozen/adc_blocks.spice
.include /repo/v2/analog/adc/verification_20260910/campaigns/continuous_three_point/frozen/sensor_adc_candidate.spice
.include /repo/v2/analog/adc/verification_20260910/campaigns/continuous_three_point/frozen/adc_preamp.spice
.include /repo/v2/analog/adc/verification_20260910/campaigns/continuous_three_point/frozen/adc_reference_candidate.spice
.include /repo/v2/analog/adc/verification_20260910/campaigns/continuous_three_point/frozen/adc_tgate_dual_lvt_dummy.spice
.include /repo/v2/analog/adc/verification_20260910/campaigns/continuous_three_point/frozen/sensor_phases.spice
.temp 27
.options sparse method=gear reltol=1e-5 abstol=1e-13 vntol=1e-8 trtol=1
VDD vdd 0 1.8
VVCM cv 0 0.9
VRP pr 0 1.1
VRN nr 0 0.7
RRP pr rp 1
RRN nr rn 1
RCM cv vcm 1
CRP rp 0 10n
CRN rn 0 10n
CCM vcm 0 10n
VIP sp 0 PWL(0 0.99301757812500002 1.1014e-05 0.99301757812500002 1.1015e-05 0.85639648437500004 2.1013999999999999e-05 0.85639648437500004 2.1014999999999998e-05 0.88627929687499996 3.1013999999999998e-05 0.88627929687499996 3.1015e-05 0.91518554687500009 4.1014000000000004e-05 0.91518554687500009 4.1015000000000006e-05 0.94975585937499996 5.1014000000000003e-05 0.94975585937499996 5.1015000000000005e-05 1.023388671875)
VIN sn 0 PWL(0 0.80698242187500002 1.1014e-05 0.80698242187500002 1.1015e-05 0.943603515625 2.1013999999999999e-05 0.943603515625 2.1014999999999998e-05 0.91372070312500009 3.1013999999999998e-05 0.91372070312500009 3.1015e-05 0.88481445312499996 4.1014000000000004e-05 0.88481445312499996 4.1015000000000006e-05 0.85024414062500009 5.1014000000000003e-05 0.85024414062500009 5.1015000000000005e-05 0.776611328125)
RSP sp inp 350
RSN sn inn 350
Vclk clk 0 PULSE(0 1.8 1u 1n 1n 311.5n 625n)
Vrst rst 0 PWL(0 0 200n 0 201n 1.8)
Vstart start 0 PWL(0 0 800n 0 801n 1.8)
VG1 gain_sel1 0 0
VG0 gain_sel0 0 0
Rbridge_ready ready 0 1g
Rbridge_busy busy 0 1g
Rbridge_valid valid 0 1g
Rbridge_data11 data11 0 1g
Rbridge_data10 data10 0 1g
Rbridge_data9 data9 0 1g
Rbridge_data8 data8 0 1g
Rbridge_data7 data7 0 1g
Rbridge_data6 data6 0 1g
Rbridge_data5 data5 0 1g
Rbridge_data4 data4 0 1g
Rbridge_data3 data3 0 1g
Rbridge_data2 data2 0 1g
Rbridge_data1 data1 0 1g
Rbridge_data0 data0 0 1g
Rbridge_dgain1 dgain1 0 1g
Rbridge_dgain0 dgain0 0 1g
Rbridge_gain1 gain1 0 1g
Rbridge_gain0 gain0 0 1g
Rbridge_sample sample 0 1g
Rbridge_trial11 trial11 0 1g
Rbridge_trial10 trial10 0 1g
Rbridge_trial9 trial9 0 1g
Rbridge_trial8 trial8 0 1g
Rbridge_trial7 trial7 0 1g
Rbridge_trial6 trial6 0 1g
Rbridge_trial5 trial5 0 1g
Rbridge_trial4 trial4 0 1g
Rbridge_trial3 trial3 0 1g
Rbridge_trial2 trial2 0 1g
Rbridge_trial1 trial1 0 1g
Rbridge_trial0 trial0 0 1g
Rbridge_evaluate evaluate 0 1g
XPHASE sample top_sample top_sample_b acq conv vdd 0 sensor_phases
XADC inp inn decision decision_b top_sample top_sample_b acq conv evaluate trial11 trial10 trial9 trial8 trial7 trial6 trial5 trial4 trial3 trial2 trial1 trial0 rp rn vcm vdd 0 sensor_adc_candidate
CQ decision 0 5f
CQB decision_b 0 5f
.save v(valid) v(inp) v(inn) v(data11) v(data10) v(data9) v(data8) v(data7) v(data6) v(data5) v(data4) v(data3) v(data2) v(data1) v(data0) v(clk) v(evaluate) v(top_sample) v(acq) v(conv) v(xadc.tp) v(xadc.tn) v(rp) v(rn) v(vcm) v(xadc.prep) v(xadc.pren) v(decision) v(decision_b) v(ready) v(busy) v(dgain1) v(dgain0) v(gain1) v(gain0) v(sample) v(trial11) v(trial10) v(trial9) v(trial8) v(trial7) v(trial6) v(trial5) v(trial4) v(trial3) v(trial2) v(trial1) v(trial0)
VTRACE_ready ready 0 PWL(0 0 2.0299999999999998e-07 0 2.0399999999999997e-07 1.8 1.0029999999999453e-06 1.8 1.0039999999999454e-06 0 1.0378000000001326e-05 0 1.0379000000001327e-05 1.8 1.1002999999998951e-05 1.8 1.1003999999998951e-05 0 2.0378000000002968e-05 0 2.0379000000002967e-05 1.8 2.1002999999999341e-05 1.8 2.100399999999934e-05 0 3.0378000000002195e-05 0 3.0379000000002194e-05 1.8 3.1003000000000625e-05 1.8 3.1004000000000627e-05 0 4.037799999999926e-05 0 4.0378999999999262e-05 1.8 4.1003000000002047e-05 1.8 4.1004000000002049e-05 0 5.0378000000000323e-05 0 5.0379000000000325e-05 1.8 5.1002999999997973e-05 1.8 5.1003999999997975e-05 0 6.0377999999995619e-05 0 6.0378999999995622e-05 1.8 6.1003000000000358e-05 1.8 6.100400000000036e-05 0 6.2000000000000003e-05 0)
VTRACE_busy busy 0 PWL(0 0 9.9999999999999986e-10 0 1.9999999999999997e-09 1.8 2.0299999999999998e-07 1.8 2.0399999999999997e-07 0 1.0029999999999453e-06 0 1.0039999999999454e-06 1.8 1.0378000000001326e-05 1.8 1.0379000000001327e-05 0 1.1002999999998951e-05 0 1.1003999999998951e-05 1.8 2.0378000000002968e-05 1.8 2.0379000000002967e-05 0 2.1002999999999341e-05 0 2.100399999999934e-05 1.8 3.0378000000002195e-05 1.8 3.0379000000002194e-05 0 3.1003000000000625e-05 0 3.1004000000000627e-05 1.8 4.037799999999926e-05 1.8 4.0378999999999262e-05 0 4.1003000000002047e-05 0 4.1004000000002049e-05 1.8 5.0378000000000323e-05 1.8 5.0379000000000325e-05 0 5.1002999999997973e-05 0 5.1003999999997975e-05 1.8 6.0377999999995619e-05 1.8 6.0378999999995622e-05 0 6.1003000000000358e-05 0 6.100400000000036e-05 1.8 6.2000000000000003e-05 1.8)
VTRACE_valid valid 0 PWL(0 0 1.1002999999998951e-05 0 1.1003999999998951e-05 1.8 1.1628000000000001e-05 1.8 1.1629000000000002e-05 0 2.1002999999999341e-05 0 2.100399999999934e-05 1.8 2.1628e-05 1.8 2.1628999999999999e-05 0 3.1003000000000625e-05 0 3.1004000000000627e-05 1.8 3.1628000000000003e-05 1.8 3.1629000000000005e-05 0 4.1003000000002047e-05 0 4.1004000000002049e-05 1.8 4.1628000000000002e-05 1.8 4.1629000000000004e-05 0 5.1002999999997973e-05 0 5.1003999999997975e-05 1.8 5.1628000000000001e-05 1.8 5.1629000000000003e-05 0 6.1003000000000358e-05 0 6.100400000000036e-05 1.8 6.1628e-05 1.8 6.1629000000000002e-05 0 6.2000000000000003e-05 0)
VTRACE_data11 data11 0 PWL(0 0 1.1003e-05 0 1.1004e-05 1.8 2.1003000000000002e-05 1.8 2.1004000000000001e-05 0 4.1003e-05 0 4.1004000000000002e-05 1.8 6.2000000000000003e-05 1.8)
VTRACE_data10 data10 0 PWL(0 0 2.1003000000000002e-05 0 2.1004000000000001e-05 1.8 4.1003e-05 1.8 4.1004000000000002e-05 0 6.1002999999999999e-05 0 6.1004000000000001e-05 1.8 6.2000000000000003e-05 1.8)
VTRACE_data9 data9 0 PWL(0 0 1.1003e-05 0 1.1004e-05 1.8 4.1003e-05 1.8 4.1004000000000002e-05 0 6.2000000000000003e-05 0)
VTRACE_data8 data8 0 PWL(0 0 1.1003e-05 0 1.1004e-05 1.8 2.1003000000000002e-05 1.8 2.1004000000000001e-05 0 3.1003000000000001e-05 0 3.1004000000000003e-05 1.8 4.1003e-05 1.8 4.1004000000000002e-05 0 5.1002999999999999e-05 0 5.1004000000000002e-05 1.8 6.1002999999999999e-05 1.8 6.1004000000000001e-05 0 6.2000000000000003e-05 0)
VTRACE_data7 data7 0 PWL(0 0 1.1003e-05 0 1.1004e-05 1.8 2.1003000000000002e-05 1.8 2.1004000000000001e-05 0 4.1003e-05 0 4.1004000000000002e-05 1.8 6.2000000000000003e-05 1.8)
VTRACE_data6 data6 0 PWL(0 0 2.1003000000000002e-05 0 2.1004000000000001e-05 1.8 4.1003e-05 1.8 4.1004000000000002e-05 0 5.1002999999999999e-05 0 5.1004000000000002e-05 1.8 6.2000000000000003e-05 1.8)
VTRACE_data5 data5 0 PWL(0 0 1.1003e-05 0 1.1004e-05 1.8 2.1003000000000002e-05 1.8 2.1004000000000001e-05 0 3.1003000000000001e-05 0 3.1004000000000003e-05 1.8 4.1003e-05 1.8 4.1004000000000002e-05 0 5.1002999999999999e-05 0 5.1004000000000002e-05 1.8 6.2000000000000003e-05 1.8)
VTRACE_data4 data4 0 PWL(0 0 1.1003e-05 0 1.1004e-05 1.8 2.1003000000000002e-05 1.8 2.1004000000000001e-05 0 3.1003000000000001e-05 0 3.1004000000000003e-05 1.8 6.1002999999999999e-05 1.8 6.1004000000000001e-05 0 6.2000000000000003e-05 0)
VTRACE_data3 data3 0 PWL(0 0 1.1003e-05 0 1.1004e-05 1.8 2.1003000000000002e-05 1.8 2.1004000000000001e-05 0 4.1003e-05 0 4.1004000000000002e-05 1.8 6.2000000000000003e-05 1.8)
VTRACE_data2 data2 0 PWL(0 0 5.1002999999999999e-05 0 5.1004000000000002e-05 1.8 6.2000000000000003e-05 1.8)
VTRACE_data1 data1 0 PWL(0 0 3.1003000000000001e-05 0 3.1004000000000003e-05 1.8 5.1002999999999999e-05 1.8 5.1004000000000002e-05 0 6.1002999999999999e-05 0 6.1004000000000001e-05 1.8 6.2000000000000003e-05 1.8)
VTRACE_data0 data0 0 PWL(0 0 2.1003000000000002e-05 0 2.1004000000000001e-05 1.8 6.2000000000000003e-05 1.8)
VTRACE_dgain1 dgain1 0 PWL(0 0 6.2000000000000003e-05 0)
VTRACE_dgain0 dgain0 0 PWL(0 0 6.2000000000000003e-05 0)
VTRACE_gain1 gain1 0 PWL(0 0 6.2000000000000003e-05 0)
VTRACE_gain0 gain0 0 PWL(0 0 6.2000000000000003e-05 0)
VTRACE_sample sample 0 PWL(0 0 1.0029999999999453e-06 0 1.0039999999999454e-06 1.8 3.5029999999997486e-06 1.8 3.5039999999997487e-06 0 1.1002999999998951e-05 0 1.1003999999998951e-05 1.8 1.3503000000002981e-05 1.8 1.3504000000002981e-05 0 2.1002999999999341e-05 0 2.100399999999934e-05 1.8 2.3502999999997837e-05 1.8 2.3503999999997836e-05 0 3.1003000000000625e-05 0 3.1004000000000627e-05 1.8 3.3502999999998937e-05 1.8 3.3503999999998939e-05 0 4.1003000000002047e-05 0 4.1004000000002049e-05 1.8 4.3502999999998936e-05 1.8 4.3503999999998938e-05 0 5.1002999999997973e-05 0 5.1003999999997975e-05 1.8 5.3502999999998359e-05 1.8 5.3503999999998362e-05 0 6.1003000000000358e-05 0 6.100400000000036e-05 1.8 6.2000000000000003e-05 1.8)
VTRACE_trial11 trial11 0 PWL(0 0 3.5030000000000002e-06 0 3.5040000000000002e-06 1.8 1.1003e-05 1.8 1.1004e-05 0 1.3503000000000001e-05 0 1.3504000000000001e-05 1.8 1.4128000000000001e-05 1.8 1.4129000000000001e-05 0 2.3503000000000002e-05 0 2.3504000000000001e-05 1.8 2.4128000000000003e-05 1.8 2.4129000000000002e-05 0 3.3503000000000008e-05 0 3.350400000000001e-05 1.8 4.1003e-05 1.8 4.1004000000000002e-05 0 4.3503000000000007e-05 0 4.3504000000000009e-05 1.8 5.1002999999999999e-05 1.8 5.1004000000000002e-05 0 5.3503000000000006e-05 0 5.3504000000000008e-05 1.8 6.1002999999999999e-05 1.8 6.1004000000000001e-05 0 6.2000000000000003e-05 0)
VTRACE_trial10 trial10 0 PWL(0 0 4.1280000000000001e-06 0 4.1289999999999998e-06 1.8 4.7530000000000001e-06 1.8 4.7539999999999997e-06 0 1.4128000000000001e-05 0 1.4129000000000001e-05 1.8 2.1003000000000002e-05 1.8 2.1004000000000001e-05 0 2.4128000000000003e-05 0 2.4129000000000002e-05 1.8 3.1003000000000001e-05 1.8 3.1004000000000003e-05 0 3.4128000000000009e-05 0 3.4129000000000012e-05 1.8 3.4753000000000011e-05 1.8 3.4754000000000013e-05 0 4.4128000000000008e-05 0 4.4129000000000011e-05 1.8 4.475300000000001e-05 1.8 4.4754000000000012e-05 0 5.4128000000000008e-05 0 5.412900000000001e-05 1.8 6.1002999999999999e-05 1.8 6.1004000000000001e-05 0 6.2000000000000003e-05 0)
VTRACE_trial9 trial9 0 PWL(0 0 4.7530000000000001e-06 0 4.7539999999999997e-06 1.8 1.1003e-05 1.8 1.1004e-05 0 1.4753000000000001e-05 0 1.4754000000000001e-05 1.8 2.1003000000000002e-05 1.8 2.1004000000000001e-05 0 2.4753000000000002e-05 0 2.4754000000000001e-05 1.8 3.1003000000000001e-05 1.8 3.1004000000000003e-05 0 3.4753000000000011e-05 0 3.4754000000000013e-05 1.8 3.5378000000000006e-05 1.8 3.5379000000000008e-05 0 4.475300000000001e-05 0 4.4754000000000012e-05 1.8 4.5378000000000005e-05 1.8 4.5379000000000007e-05 0 5.4753000000000009e-05 0 5.4754000000000011e-05 1.8 5.5378000000000004e-05 1.8 5.5379000000000006e-05 0 6.2000000000000003e-05 0)
VTRACE_trial8 trial8 0 PWL(0 0 5.378e-06 0 5.3789999999999997e-06 1.8 1.1003e-05 1.8 1.1004e-05 0 1.5378000000000001e-05 0 1.5379e-05 1.8 1.6003000000000002e-05 1.8 1.6004000000000001e-05 0 2.5378000000000003e-05 0 2.5379000000000002e-05 1.8 3.1003000000000001e-05 1.8 3.1004000000000003e-05 0 3.5378000000000006e-05 0 3.5379000000000008e-05 1.8 3.6003000000000007e-05 1.8 3.600400000000001e-05 0 4.5378000000000005e-05 0 4.5379000000000007e-05 1.8 5.1002999999999999e-05 1.8 5.1004000000000002e-05 0 5.5378000000000004e-05 0 5.5379000000000006e-05 1.8 5.6003000000000006e-05 1.8 5.6004000000000008e-05 0 6.2000000000000003e-05 0)
VTRACE_trial7 trial7 0 PWL(0 0 6.003e-06 0 6.0039999999999996e-06 1.8 1.1003e-05 1.8 1.1004e-05 0 1.6003000000000002e-05 0 1.6004000000000001e-05 1.8 1.6628000000000001e-05 1.8 1.6629e-05 0 2.6003000000000002e-05 0 2.6004e-05 1.8 2.6628000000000003e-05 1.8 2.6629000000000002e-05 0 3.6003000000000007e-05 0 3.600400000000001e-05 1.8 4.1003e-05 1.8 4.1004000000000002e-05 0 4.6003000000000007e-05 0 4.6004000000000009e-05 1.8 5.1002999999999999e-05 1.8 5.1004000000000002e-05 0 5.6003000000000006e-05 0 5.6004000000000008e-05 1.8 6.1002999999999999e-05 1.8 6.1004000000000001e-05 0 6.2000000000000003e-05 0)
VTRACE_trial6 trial6 0 PWL(0 0 6.6279999999999999e-06 0 6.6289999999999996e-06 1.8 7.2530000000000007e-06 1.8 7.2540000000000003e-06 0 1.6628000000000001e-05 0 1.6629e-05 1.8 2.1003000000000002e-05 1.8 2.1004000000000001e-05 0 2.6628000000000003e-05 0 2.6629000000000002e-05 1.8 3.1003000000000001e-05 1.8 3.1004000000000003e-05 0 3.6628000000000009e-05 0 3.6629000000000011e-05 1.8 3.7253000000000011e-05 1.8 3.7254000000000013e-05 0 4.6628000000000008e-05 0 4.662900000000001e-05 1.8 5.1002999999999999e-05 1.8 5.1004000000000002e-05 0 5.6628000000000007e-05 0 5.662900000000001e-05 1.8 6.1002999999999999e-05 1.8 6.1004000000000001e-05 0 6.2000000000000003e-05 0)
VTRACE_trial5 trial5 0 PWL(0 0 7.2530000000000007e-06 0 7.2540000000000003e-06 1.8 1.1003e-05 1.8 1.1004e-05 0 1.7253000000000002e-05 0 1.7254000000000001e-05 1.8 1.7878000000000001e-05 1.8 1.7878999999999999e-05 0 2.7253000000000001e-05 0 2.7254e-05 1.8 3.1003000000000001e-05 1.8 3.1004000000000003e-05 0 3.7253000000000011e-05 0 3.7254000000000013e-05 1.8 3.7878000000000006e-05 1.8 3.7879000000000008e-05 0 4.725300000000001e-05 0 4.7254000000000012e-05 1.8 5.1002999999999999e-05 1.8 5.1004000000000002e-05 0 5.7253000000000009e-05 0 5.7254000000000011e-05 1.8 6.1002999999999999e-05 1.8 6.1004000000000001e-05 0 6.2000000000000003e-05 0)
VTRACE_trial4 trial4 0 PWL(0 0 7.8780000000000015e-06 0 7.879000000000002e-06 1.8 1.1003e-05 1.8 1.1004e-05 0 1.7878000000000001e-05 0 1.7878999999999999e-05 1.8 1.8503000000000002e-05 1.8 1.8504000000000001e-05 0 2.7878000000000003e-05 0 2.7879000000000002e-05 1.8 3.1003000000000001e-05 1.8 3.1004000000000003e-05 0 3.7878000000000006e-05 0 3.7879000000000008e-05 1.8 4.1003e-05 1.8 4.1004000000000002e-05 0 4.7878000000000005e-05 0 4.7879000000000007e-05 1.8 5.1002999999999999e-05 1.8 5.1004000000000002e-05 0 5.7878000000000004e-05 0 5.7879000000000006e-05 1.8 5.8503000000000006e-05 1.8 5.8504000000000008e-05 0 6.2000000000000003e-05 0)
VTRACE_trial3 trial3 0 PWL(0 0 8.5029999999999997e-06 0 8.5040000000000002e-06 1.8 1.1003e-05 1.8 1.1004e-05 0 1.8503000000000002e-05 0 1.8504000000000001e-05 1.8 1.9128e-05 1.8 1.9128999999999999e-05 0 2.8503000000000001e-05 0 2.8504e-05 1.8 2.9128000000000003e-05 1.8 2.9129000000000002e-05 0 3.8503000000000007e-05 0 3.8504000000000009e-05 1.8 4.1003e-05 1.8 4.1004000000000002e-05 0 4.8503000000000006e-05 0 4.8504000000000009e-05 1.8 5.1002999999999999e-05 1.8 5.1004000000000002e-05 0 5.8503000000000006e-05 0 5.8504000000000008e-05 1.8 6.1002999999999999e-05 1.8 6.1004000000000001e-05 0 6.2000000000000003e-05 0)
VTRACE_trial2 trial2 0 PWL(0 0 9.1280000000000014e-06 0 9.1290000000000019e-06 1.8 9.7529999999999996e-06 1.8 9.7540000000000001e-06 0 1.9128e-05 0 1.9128999999999999e-05 1.8 1.9753000000000002e-05 1.8 1.9754000000000001e-05 0 2.9128000000000003e-05 0 2.9129000000000002e-05 1.8 2.9753000000000001e-05 1.8 2.9754e-05 0 3.9128000000000009e-05 0 3.9129000000000011e-05 1.8 3.9753000000000011e-05 1.8 3.9754000000000013e-05 0 4.9128000000000008e-05 0 4.912900000000001e-05 1.8 5.1002999999999999e-05 1.8 5.1004000000000002e-05 0 5.9128000000000007e-05 0 5.9129000000000009e-05 1.8 6.1002999999999999e-05 1.8 6.1004000000000001e-05 0 6.2000000000000003e-05 0)
VTRACE_trial1 trial1 0 PWL(0 0 9.7529999999999996e-06 0 9.7540000000000001e-06 1.8 1.0378000000000001e-05 1.8 1.0379000000000002e-05 0 1.9753000000000002e-05 0 1.9754000000000001e-05 1.8 2.0378e-05 1.8 2.0378999999999999e-05 0 2.9753000000000001e-05 0 2.9754e-05 1.8 3.1003000000000001e-05 1.8 3.1004000000000003e-05 0 3.9753000000000011e-05 0 3.9754000000000013e-05 1.8 4.1003e-05 1.8 4.1004000000000002e-05 0 4.975300000000001e-05 0 4.9754000000000012e-05 1.8 5.0378000000000005e-05 1.8 5.0379000000000007e-05 0 5.9753000000000009e-05 0 5.9754000000000011e-05 1.8 6.1002999999999999e-05 1.8 6.1004000000000001e-05 0 6.2000000000000003e-05 0)
VTRACE_trial0 trial0 0 PWL(0 0 1.0378000000000001e-05 0 1.0379000000000002e-05 1.8 1.1003e-05 1.8 1.1004e-05 0 2.0378e-05 0 2.0378999999999999e-05 1.8 2.1003000000000002e-05 1.8 2.1004000000000001e-05 0 3.0378000000000003e-05 0 3.0379000000000002e-05 1.8 3.1003000000000001e-05 1.8 3.1004000000000003e-05 0 4.0378000000000005e-05 0 4.0379000000000008e-05 1.8 4.1003e-05 1.8 4.1004000000000002e-05 0 5.0378000000000005e-05 0 5.0379000000000007e-05 1.8 5.1002999999999999e-05 1.8 5.1004000000000002e-05 0 6.0378000000000004e-05 0 6.0379000000000006e-05 1.8 6.1002999999999999e-05 1.8 6.1004000000000001e-05 0 6.2000000000000003e-05 0)
VTRACE_evaluate evaluate 0 PWL(0 0 3.8155000000004296e-06 0 3.8165000000004292e-06 1.8 4.1280000000002695e-06 1.8 4.1290000000002691e-06 0 4.4405000000003762e-06 0 4.4415000000003758e-06 1.8 4.7529999999996494e-06 1.8 4.753999999999649e-06 0 5.0655000000003837e-06 0 5.0665000000003834e-06 1.8 5.3779999999999678e-06 1.8 5.3789999999999675e-06 0 5.6904999999999602e-06 0 5.6914999999999598e-06 1.8 6.0029999999999009e-06 1.8 6.0039999999999005e-06 0 6.3154999999999898e-06 0 6.3164999999999894e-06 1.8 6.6280000000002608e-06 1.8 6.6290000000002604e-06 0 6.9405000000000414e-06 0 6.941500000000041e-06 1.8 7.2529999999996144e-06 1.8 7.2539999999996141e-06 0 7.5654999999997161e-06 0 7.5664999999997157e-06 1.8 7.8779999999998948e-06 1.8 7.8789999999998953e-06 0 8.1904999999999278e-06 0 8.1914999999999283e-06 1.8 8.5029999999997405e-06 1.8 8.503999999999741e-06 0 8.815500000000192e-06 0 8.8165000000001925e-06 1.8 9.1279999999996829e-06 1.8 9.1289999999996834e-06 0 9.4405000000004511e-06 0 9.4415000000004516e-06 1.8 9.7530000000001097e-06 1.8 9.7540000000001102e-06 0 1.0065499999998488e-05 0 1.0066499999998488e-05 1.8 1.0378000000001326e-05 1.8 1.0379000000001327e-05 0 1.0690500000001178e-05 0 1.0691500000001178e-05 1.8 1.1002999999998951e-05 1.8 1.1003999999998951e-05 0 1.3815500000000385e-05 0 1.3816500000000385e-05 1.8 1.4128000000001878e-05 1.8 1.4129000000001878e-05 0 1.4440500000001286e-05 0 1.4441500000001286e-05 1.8 1.4752999999996276e-05 1.8 1.4753999999996276e-05 0 1.506550000000152e-05 0 1.506650000000152e-05 1.8 1.5377999999995813e-05 1.8 1.5378999999995812e-05 0 1.5690500000000764e-05 0 1.5691500000000763e-05 1.8 1.6003000000002466e-05 1.8 1.6004000000002464e-05 0 1.6315500000000864e-05 0 1.6316500000000863e-05 1.8 1.6627999999995877e-05 1.8 1.6628999999995876e-05 0 1.6940499999999775e-05 0 1.6941499999999773e-05 1.8 1.7253000000001171e-05 1.8 1.725400000000117e-05 0 1.7565499999999793e-05 0 1.7566499999999792e-05 1.8 1.7877999999999154e-05 1.8 1.7878999999999152e-05 0 1.8190500000003725e-05 0 1.8191500000003724e-05 1.8 1.8503000000003993e-05 1.8 1.8504000000003992e-05 0 1.8815500000002741e-05 0 1.8816500000002739e-05 1.8 1.9128000000003636e-05 1.8 1.9129000000003635e-05 0 1.944050000000138e-05 0 1.9441500000001379e-05 1.8 1.9752999999999169e-05 1.8 1.9753999999999167e-05 0 2.0065500000001043e-05 0 2.0066500000001042e-05 1.8 2.0378000000002968e-05 1.8 2.0379000000002967e-05 0 2.0690500000001583e-05 0 2.0691500000001582e-05 1.8 2.1002999999999341e-05 1.8 2.100399999999934e-05 0 2.3815499999997692e-05 0 2.3816499999997691e-05 1.8 2.4127999999999444e-05 1.8 2.4128999999999443e-05 0 2.4440499999997372e-05 0 2.444149999999737e-05 1.8 2.4752999999999636e-05 1.8 2.4753999999999635e-05 0 2.5065499999998776e-05 0 2.5066499999998775e-05 1.8 2.5377999999999285e-05 1.8 2.5378999999999284e-05 0 2.5690500000004693e-05 0 2.5691500000004692e-05 1.8 2.6003000000002976e-05 1.8 2.6004000000002975e-05 0 2.6315500000001571e-05 0 2.631650000000157e-05 1.8 2.6628000000002951e-05 1.8 2.662900000000295e-05 0 2.6940500000004043e-05 0 2.6941500000004042e-05 1.8 2.7253000000000774e-05 1.8 2.7254000000000773e-05 0 2.7565499999995621e-05 0 2.756649999999562e-05 1.8 2.7877999999996537e-05 1.8 2.7878999999996536e-05 0 2.8190499999997419e-05 0 2.8191499999997418e-05 1.8 2.8502999999996003e-05 1.8 2.8503999999996002e-05 0 2.8815499999999108e-05 0 2.8816499999999107e-05 1.8 2.9128000000003154e-05 1.8 2.9129000000003153e-05 0 2.9440499999995958e-05 0 2.9441499999995957e-05 1.8 2.9753000000004067e-05 1.8 2.9754000000004066e-05 0 3.0065499999999158e-05 0 3.0066499999999157e-05 1.8 3.0378000000002195e-05 1.8 3.0379000000002194e-05 0 3.0690499999998313e-05 0 3.0691499999998315e-05 1.8 3.1003000000000625e-05 1.8 3.1004000000000627e-05 0 3.3815499999999338e-05 0 3.381649999999934e-05 1.8 3.4127999999999305e-05 1.8 3.4128999999999307e-05 0 3.4440499999998045e-05 0 3.4441499999998047e-05 1.8 3.4753000000002871e-05 1.8 3.4754000000002873e-05 0 3.5065499999997979e-05 0 3.5066499999997981e-05 1.8 3.5377999999998224e-05 1.8 3.5378999999998226e-05 0 3.5690500000003971e-05 0 3.5691500000003973e-05 1.8 3.6002999999998246e-05 1.8 3.6003999999998248e-05 0 3.6315499999996952e-05 0 3.6316499999996954e-05 1.8 3.6627999999998606e-05 1.8 3.6628999999998609e-05 0 3.6940500000000322e-05 0 3.6941500000000324e-05 1.8 3.7252999999997592e-05 1.8 3.7253999999997594e-05 0 3.75655000000034e-05 0 3.7566500000003402e-05 1.8 3.7877999999996638e-05 1.8 3.787899999999664e-05 0 3.8190499999998211e-05 0 3.8191499999998213e-05 1.8 3.8502999999997026e-05 1.8 3.8503999999997028e-05 0 3.8815500000002387e-05 0 3.8816500000002389e-05 1.8 3.9128000000003018e-05 1.8 3.912900000000302e-05 0 3.9440499999995531e-05 0 3.9441499999995533e-05 1.8 3.9752999999999225e-05 1.8 3.9753999999999227e-05 0 4.0065500000003393e-05 0 4.0066500000003395e-05 1.8 4.037799999999926e-05 1.8 4.0378999999999262e-05 0 4.0690499999998122e-05 0 4.0691499999998125e-05 1.8 4.1003000000002047e-05 1.8 4.1004000000002049e-05 0 4.3815500000001553e-05 0 4.3816500000001555e-05 1.8 4.4127999999998857e-05 1.8 4.4128999999998859e-05 0 4.4440499999998207e-05 0 4.4441499999998209e-05 1.8 4.4753000000000234e-05 1.8 4.4754000000000236e-05 0 4.5065499999998283e-05 0 4.5066499999998285e-05 1.8 4.5377999999998047e-05 1.8 4.5378999999998049e-05 0 4.5690500000002987e-05 0 4.569150000000299e-05 1.8 4.600299999999941e-05 1.8 4.6003999999999412e-05 0 4.6315499999997378e-05 0 4.631649999999738e-05 1.8 4.6628000000002515e-05 1.8 4.6629000000002518e-05 0 4.6940500000002028e-05 0 4.6941500000002031e-05 1.8 4.7252999999997848e-05 1.8 4.725399999999785e-05 0 4.7565500000000966e-05 0 4.7566500000000968e-05 1.8 4.7877999999999774e-05 1.8 4.7878999999999777e-05 0 4.8190500000001151e-05 0 4.8191500000001153e-05 1.8 4.8502999999996069e-05 1.8 4.8503999999996072e-05 0 4.8815499999997622e-05 0 4.8816499999997624e-05 1.8 4.9127999999998395e-05 1.8 4.9128999999998397e-05 0 4.9440499999995496e-05 0 4.9441499999995498e-05 1.8 4.9753000000001534e-05 1.8 4.9754000000001537e-05 0 5.0065500000000492e-05 0 5.0066500000000494e-05 1.8 5.0378000000000323e-05 1.8 5.0379000000000325e-05 0 5.0690499999999524e-05 0 5.0691499999999526e-05 1.8 5.1002999999997973e-05 1.8 5.1003999999997975e-05 0 5.3815499999997574e-05 0 5.3816499999997576e-05 1.8 5.4128000000002684e-05 1.8 5.4129000000002686e-05 0 5.4440500000003051e-05 0 5.4441500000003053e-05 1.8 5.4753000000002164e-05 1.8 5.4754000000002166e-05 0 5.5065499999996561e-05 0 5.5066499999996563e-05 1.8 5.5377999999999543e-05 1.8 5.5378999999999546e-05 0 5.5690500000001089e-05 0 5.5691500000001091e-05 1.8 5.6003000000002554e-05 1.8 5.6004000000002556e-05 0 5.6315500000002988e-05 0 5.631650000000299e-05 1.8 5.6627999999997995e-05 1.8 5.6628999999997997e-05 0 5.6940499999995875e-05 0 5.6941499999995877e-05 1.8 5.7253000000004617e-05 1.8 5.7254000000004619e-05 0 5.7565500000000233e-05 0 5.7566500000000236e-05 1.8 5.7877999999996162e-05 1.8 5.7878999999996164e-05 0 5.8190499999996942e-05 0 5.8191499999996944e-05 1.8 5.8503000000003529e-05 1.8 5.8504000000003531e-05 0 5.8815500000001538e-05 0 5.881650000000154e-05 1.8 5.9128000000001749e-05 1.8 5.9129000000001751e-05 0 5.9440500000004385e-05 0 5.9441500000004388e-05 1.8 5.9753000000000924e-05 1.8 5.9754000000000926e-05 0 6.0065500000002991e-05 0 6.0066500000002993e-05 1.8 6.0377999999995619e-05 1.8 6.0378999999995622e-05 0 6.0690499999999232e-05 0 6.0691499999999234e-05 1.8 6.1003000000000358e-05 1.8 6.100400000000036e-05 0 6.2000000000000003e-05 0)
.control
set num_threads=1
set wr_singlescale
set wr_vecnames
set numdgt=12
tran 2n 62u 0 2n
wrdata waveform.dat v(valid) v(inp) v(inn) v(data11) v(data10) v(data9) v(data8) v(data7) v(data6) v(data5) v(data4) v(data3) v(data2) v(data1) v(data0) v(clk) v(evaluate) v(top_sample) v(acq) v(conv) v(xadc.tp) v(xadc.tn) v(rp) v(rn) v(vcm) v(xadc.prep) v(xadc.pren) v(decision) v(decision_b) v(ready) v(busy) v(dgain1) v(dgain0) v(gain1) v(gain0) v(sample) v(trial11) v(trial10) v(trial9) v(trial8) v(trial7) v(trial6) v(trial5) v(trial4) v(trial3) v(trial2) v(trial1) v(trial0)
rusage all
quit
.endc
.end
