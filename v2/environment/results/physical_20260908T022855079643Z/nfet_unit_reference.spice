* Independent intended primitive connectivity
.subckt nfet_unit B D S G
XM D G S B sky130_fd_pr__nfet_01v8 w=2 l=1
.ends
