* Independent intended primitive connectivity
.subckt mim_unit C2 C1
XC C1 C2 sky130_fd_pr__cap_mim_m3_1 w=3 l=3
.ends
