* NGSPICE file created from mim_unit.ext - technology: sky130A

.subckt mim_unit C2 C1
X0 C1 C2 sky130_fd_pr__cap_mim_m3_1 l=3 w=3
C0 C2 C1 0.97772f
C1 C2 VSUBS 1.32632f
.ends
