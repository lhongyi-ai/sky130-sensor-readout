* NGSPICE file created from cdac_side_n_routed_flat.ext - technology: sky130A

.subckt cdac_side_n_routed_flat TOP B11 B10 B9 B8 B7 B6 B5 B4 B3 B2 B1 B0 DUMMY EDGE_BIAS
X0 B11 TOP sky130_fd_pr__cap_mim_m3_1 l=3 w=3
X1 B11 TOP sky130_fd_pr__cap_mim_m3_1 l=3 w=3
X2 B11 TOP sky130_fd_pr__cap_mim_m3_1 l=3 w=3
X3 B10 TOP sky130_fd_pr__cap_mim_m3_1 l=3 w=3
X4 B10 TOP sky130_fd_pr__cap_mim_m3_1 l=3 w=3
X5 B8 TOP sky130_fd_pr__cap_mim_m3_1 l=3 w=3
X6 B11 TOP sky130_fd_pr__cap_mim_m3_1 l=3 w=3
X7 B5 TOP sky130_fd_pr__cap_mim_m3_1 l=3 w=3
X8 B11 TOP sky130_fd_pr__cap_mim_m3_1 l=3 w=3
X9 B11 TOP sky130_fd_pr__cap_mim_m3_1 l=3 w=3
X10 B10 TOP sky130_fd_pr__cap_mim_m3_1 l=3 w=3
X11 B11 TOP sky130_fd_pr__cap_mim_m3_1 l=3 w=3
X12 B9 TOP sky130_fd_pr__cap_mim_m3_1 l=3 w=3
X13 EDGE_BIAS EDGE_BIAS sky130_fd_pr__cap_mim_m3_1 l=3 w=3
X14 B4 TOP sky130_fd_pr__cap_mim_m3_1 l=3 w=3
X15 B11 TOP sky130_fd_pr__cap_mim_m3_1 l=3 w=3
X16 B10 TOP sky130_fd_pr__cap_mim_m3_1 l=3 w=3
X17 B8 TOP sky130_fd_pr__cap_mim_m3_1 l=3 w=3
X18 EDGE_BIAS EDGE_BIAS sky130_fd_pr__cap_mim_m3_1 l=3 w=3
X19 B11 TOP sky130_fd_pr__cap_mim_m3_1 l=3 w=3
X20 EDGE_BIAS EDGE_BIAS sky130_fd_pr__cap_mim_m3_1 l=3 w=3
X21 B11 TOP sky130_fd_pr__cap_mim_m3_1 l=3 w=3
X22 B11 TOP sky130_fd_pr__cap_mim_m3_1 l=3 w=3
X23 B11 TOP sky130_fd_pr__cap_mim_m3_1 l=3 w=3
X24 B11 TOP sky130_fd_pr__cap_mim_m3_1 l=3 w=3
X25 B10 TOP sky130_fd_pr__cap_mim_m3_1 l=3 w=3
X26 B8 TOP sky130_fd_pr__cap_mim_m3_1 l=3 w=3
X27 B11 TOP sky130_fd_pr__cap_mim_m3_1 l=3 w=3
X28 B8 TOP sky130_fd_pr__cap_mim_m3_1 l=3 w=3
X29 B8 TOP sky130_fd_pr__cap_mim_m3_1 l=3 w=3
X30 B11 TOP sky130_fd_pr__cap_mim_m3_1 l=3 w=3
X31 B10 TOP sky130_fd_pr__cap_mim_m3_1 l=3 w=3
X32 B10 TOP sky130_fd_pr__cap_mim_m3_1 l=3 w=3
X33 B11 TOP sky130_fd_pr__cap_mim_m3_1 l=3 w=3
X34 B11 TOP sky130_fd_pr__cap_mim_m3_1 l=3 w=3
X35 EDGE_BIAS EDGE_BIAS sky130_fd_pr__cap_mim_m3_1 l=3 w=3
X36 B11 TOP sky130_fd_pr__cap_mim_m3_1 l=3 w=3
X37 B11 TOP sky130_fd_pr__cap_mim_m3_1 l=3 w=3
X38 B7 TOP sky130_fd_pr__cap_mim_m3_1 l=3 w=3
X39 EDGE_BIAS EDGE_BIAS sky130_fd_pr__cap_mim_m3_1 l=3 w=3
X40 B9 TOP sky130_fd_pr__cap_mim_m3_1 l=3 w=3
X41 B10 TOP sky130_fd_pr__cap_mim_m3_1 l=3 w=3
X42 B11 TOP sky130_fd_pr__cap_mim_m3_1 l=3 w=3
X43 B10 TOP sky130_fd_pr__cap_mim_m3_1 l=3 w=3
X44 B11 TOP sky130_fd_pr__cap_mim_m3_1 l=3 w=3
X45 B9 TOP sky130_fd_pr__cap_mim_m3_1 l=3 w=3
X46 B11 TOP sky130_fd_pr__cap_mim_m3_1 l=3 w=3
X47 B11 TOP sky130_fd_pr__cap_mim_m3_1 l=3 w=3
X48 B10 TOP sky130_fd_pr__cap_mim_m3_1 l=3 w=3
X49 EDGE_BIAS EDGE_BIAS sky130_fd_pr__cap_mim_m3_1 l=3 w=3
X50 B11 TOP sky130_fd_pr__cap_mim_m3_1 l=3 w=3
X51 B11 TOP sky130_fd_pr__cap_mim_m3_1 l=3 w=3
X52 B11 TOP sky130_fd_pr__cap_mim_m3_1 l=3 w=3
X53 B11 TOP sky130_fd_pr__cap_mim_m3_1 l=3 w=3
X54 B11 TOP sky130_fd_pr__cap_mim_m3_1 l=3 w=3
X55 B11 TOP sky130_fd_pr__cap_mim_m3_1 l=3 w=3
X56 B10 TOP sky130_fd_pr__cap_mim_m3_1 l=3 w=3
X57 B9 TOP sky130_fd_pr__cap_mim_m3_1 l=3 w=3
X58 B10 TOP sky130_fd_pr__cap_mim_m3_1 l=3 w=3
X59 B10 TOP sky130_fd_pr__cap_mim_m3_1 l=3 w=3
X60 B9 TOP sky130_fd_pr__cap_mim_m3_1 l=3 w=3
X61 B10 TOP sky130_fd_pr__cap_mim_m3_1 l=3 w=3
X62 B11 TOP sky130_fd_pr__cap_mim_m3_1 l=3 w=3
X63 B8 TOP sky130_fd_pr__cap_mim_m3_1 l=3 w=3
X64 B10 TOP sky130_fd_pr__cap_mim_m3_1 l=3 w=3
X65 B11 TOP sky130_fd_pr__cap_mim_m3_1 l=3 w=3
X66 B10 TOP sky130_fd_pr__cap_mim_m3_1 l=3 w=3
X67 B9 TOP sky130_fd_pr__cap_mim_m3_1 l=3 w=3
X68 B11 TOP sky130_fd_pr__cap_mim_m3_1 l=3 w=3
X69 EDGE_BIAS EDGE_BIAS sky130_fd_pr__cap_mim_m3_1 l=3 w=3
X70 B8 TOP sky130_fd_pr__cap_mim_m3_1 l=3 w=3
X71 B11 TOP sky130_fd_pr__cap_mim_m3_1 l=3 w=3
X72 B11 TOP sky130_fd_pr__cap_mim_m3_1 l=3 w=3
X73 B3 TOP sky130_fd_pr__cap_mim_m3_1 l=3 w=3
X74 B11 TOP sky130_fd_pr__cap_mim_m3_1 l=3 w=3
X75 B11 TOP sky130_fd_pr__cap_mim_m3_1 l=3 w=3
X76 B11 TOP sky130_fd_pr__cap_mim_m3_1 l=3 w=3
X77 B9 TOP sky130_fd_pr__cap_mim_m3_1 l=3 w=3
X78 B9 TOP sky130_fd_pr__cap_mim_m3_1 l=3 w=3
X79 B11 TOP sky130_fd_pr__cap_mim_m3_1 l=3 w=3
X80 EDGE_BIAS EDGE_BIAS sky130_fd_pr__cap_mim_m3_1 l=3 w=3
X81 B5 TOP sky130_fd_pr__cap_mim_m3_1 l=3 w=3
X82 B11 TOP sky130_fd_pr__cap_mim_m3_1 l=3 w=3
X83 EDGE_BIAS EDGE_BIAS sky130_fd_pr__cap_mim_m3_1 l=3 w=3
X84 B11 TOP sky130_fd_pr__cap_mim_m3_1 l=3 w=3
X85 B11 TOP sky130_fd_pr__cap_mim_m3_1 l=3 w=3
X86 B11 TOP sky130_fd_pr__cap_mim_m3_1 l=3 w=3
X87 B10 TOP sky130_fd_pr__cap_mim_m3_1 l=3 w=3
X88 B10 TOP sky130_fd_pr__cap_mim_m3_1 l=3 w=3
X89 B11 TOP sky130_fd_pr__cap_mim_m3_1 l=3 w=3
X90 B11 TOP sky130_fd_pr__cap_mim_m3_1 l=3 w=3
X91 B8 TOP sky130_fd_pr__cap_mim_m3_1 l=3 w=3
X92 B11 TOP sky130_fd_pr__cap_mim_m3_1 l=3 w=3
X93 B11 TOP sky130_fd_pr__cap_mim_m3_1 l=3 w=3
X94 B9 TOP sky130_fd_pr__cap_mim_m3_1 l=3 w=3
X95 EDGE_BIAS EDGE_BIAS sky130_fd_pr__cap_mim_m3_1 l=3 w=3
X96 B10 TOP sky130_fd_pr__cap_mim_m3_1 l=3 w=3
X97 B11 TOP sky130_fd_pr__cap_mim_m3_1 l=3 w=3
X98 B11 TOP sky130_fd_pr__cap_mim_m3_1 l=3 w=3
X99 B11 TOP sky130_fd_pr__cap_mim_m3_1 l=3 w=3
X100 B7 TOP sky130_fd_pr__cap_mim_m3_1 l=3 w=3
X101 B7 TOP sky130_fd_pr__cap_mim_m3_1 l=3 w=3
X102 B11 TOP sky130_fd_pr__cap_mim_m3_1 l=3 w=3
X103 B9 TOP sky130_fd_pr__cap_mim_m3_1 l=3 w=3
X104 B10 TOP sky130_fd_pr__cap_mim_m3_1 l=3 w=3
X105 B10 TOP sky130_fd_pr__cap_mim_m3_1 l=3 w=3
X106 B10 TOP sky130_fd_pr__cap_mim_m3_1 l=3 w=3
X107 B10 TOP sky130_fd_pr__cap_mim_m3_1 l=3 w=3
X108 B11 TOP sky130_fd_pr__cap_mim_m3_1 l=3 w=3
X109 B11 TOP sky130_fd_pr__cap_mim_m3_1 l=3 w=3
X110 B11 TOP sky130_fd_pr__cap_mim_m3_1 l=3 w=3
X111 B11 TOP sky130_fd_pr__cap_mim_m3_1 l=3 w=3
X112 B10 TOP sky130_fd_pr__cap_mim_m3_1 l=3 w=3
X113 B11 TOP sky130_fd_pr__cap_mim_m3_1 l=3 w=3
X114 B10 TOP sky130_fd_pr__cap_mim_m3_1 l=3 w=3
X115 EDGE_BIAS EDGE_BIAS sky130_fd_pr__cap_mim_m3_1 l=3 w=3
X116 B11 TOP sky130_fd_pr__cap_mim_m3_1 l=3 w=3
X117 B11 TOP sky130_fd_pr__cap_mim_m3_1 l=3 w=3
X118 B11 TOP sky130_fd_pr__cap_mim_m3_1 l=3 w=3
X119 B10 TOP sky130_fd_pr__cap_mim_m3_1 l=3 w=3
X120 B10 TOP sky130_fd_pr__cap_mim_m3_1 l=3 w=3
X121 B9 TOP sky130_fd_pr__cap_mim_m3_1 l=3 w=3
X122 B10 TOP sky130_fd_pr__cap_mim_m3_1 l=3 w=3
X123 B8 TOP sky130_fd_pr__cap_mim_m3_1 l=3 w=3
X124 B11 TOP sky130_fd_pr__cap_mim_m3_1 l=3 w=3
X125 B11 TOP sky130_fd_pr__cap_mim_m3_1 l=3 w=3
X126 EDGE_BIAS EDGE_BIAS sky130_fd_pr__cap_mim_m3_1 l=3 w=3
X127 B8 TOP sky130_fd_pr__cap_mim_m3_1 l=3 w=3
X128 B11 TOP sky130_fd_pr__cap_mim_m3_1 l=3 w=3
X129 B10 TOP sky130_fd_pr__cap_mim_m3_1 l=3 w=3
X130 B9 TOP sky130_fd_pr__cap_mim_m3_1 l=3 w=3
X131 B11 TOP sky130_fd_pr__cap_mim_m3_1 l=3 w=3
X132 B10 TOP sky130_fd_pr__cap_mim_m3_1 l=3 w=3
X133 B8 TOP sky130_fd_pr__cap_mim_m3_1 l=3 w=3
X134 B11 TOP sky130_fd_pr__cap_mim_m3_1 l=3 w=3
X135 B11 TOP sky130_fd_pr__cap_mim_m3_1 l=3 w=3
X136 B9 TOP sky130_fd_pr__cap_mim_m3_1 l=3 w=3
X137 B11 TOP sky130_fd_pr__cap_mim_m3_1 l=3 w=3
X138 B11 TOP sky130_fd_pr__cap_mim_m3_1 l=3 w=3
X139 B11 TOP sky130_fd_pr__cap_mim_m3_1 l=3 w=3
X140 B11 TOP sky130_fd_pr__cap_mim_m3_1 l=3 w=3
X141 B11 TOP sky130_fd_pr__cap_mim_m3_1 l=3 w=3
X142 B11 TOP sky130_fd_pr__cap_mim_m3_1 l=3 w=3
X143 B10 TOP sky130_fd_pr__cap_mim_m3_1 l=3 w=3
X144 B8 TOP sky130_fd_pr__cap_mim_m3_1 l=3 w=3
X145 B11 TOP sky130_fd_pr__cap_mim_m3_1 l=3 w=3
X146 B11 TOP sky130_fd_pr__cap_mim_m3_1 l=3 w=3
X147 B10 TOP sky130_fd_pr__cap_mim_m3_1 l=3 w=3
X148 B11 TOP sky130_fd_pr__cap_mim_m3_1 l=3 w=3
X149 B11 TOP sky130_fd_pr__cap_mim_m3_1 l=3 w=3
X150 B11 TOP sky130_fd_pr__cap_mim_m3_1 l=3 w=3
X151 B8 TOP sky130_fd_pr__cap_mim_m3_1 l=3 w=3
X152 B10 TOP sky130_fd_pr__cap_mim_m3_1 l=3 w=3
X153 B11 TOP sky130_fd_pr__cap_mim_m3_1 l=3 w=3
X154 EDGE_BIAS EDGE_BIAS sky130_fd_pr__cap_mim_m3_1 l=3 w=3
X155 B11 TOP sky130_fd_pr__cap_mim_m3_1 l=3 w=3
X156 B11 TOP sky130_fd_pr__cap_mim_m3_1 l=3 w=3
X157 B11 TOP sky130_fd_pr__cap_mim_m3_1 l=3 w=3
X158 B7 TOP sky130_fd_pr__cap_mim_m3_1 l=3 w=3
X159 B7 TOP sky130_fd_pr__cap_mim_m3_1 l=3 w=3
X160 B11 TOP sky130_fd_pr__cap_mim_m3_1 l=3 w=3
X161 EDGE_BIAS EDGE_BIAS sky130_fd_pr__cap_mim_m3_1 l=3 w=3
X162 B9 TOP sky130_fd_pr__cap_mim_m3_1 l=3 w=3
X163 B10 TOP sky130_fd_pr__cap_mim_m3_1 l=3 w=3
X164 B10 TOP sky130_fd_pr__cap_mim_m3_1 l=3 w=3
X165 B8 TOP sky130_fd_pr__cap_mim_m3_1 l=3 w=3
X166 B11 TOP sky130_fd_pr__cap_mim_m3_1 l=3 w=3
X167 B11 TOP sky130_fd_pr__cap_mim_m3_1 l=3 w=3
X168 B10 TOP sky130_fd_pr__cap_mim_m3_1 l=3 w=3
X169 B9 TOP sky130_fd_pr__cap_mim_m3_1 l=3 w=3
X170 EDGE_BIAS EDGE_BIAS sky130_fd_pr__cap_mim_m3_1 l=3 w=3
X171 B11 TOP sky130_fd_pr__cap_mim_m3_1 l=3 w=3
X172 B7 TOP sky130_fd_pr__cap_mim_m3_1 l=3 w=3
X173 B11 TOP sky130_fd_pr__cap_mim_m3_1 l=3 w=3
X174 B11 TOP sky130_fd_pr__cap_mim_m3_1 l=3 w=3
X175 B10 TOP sky130_fd_pr__cap_mim_m3_1 l=3 w=3
X176 B9 TOP sky130_fd_pr__cap_mim_m3_1 l=3 w=3
X177 B11 TOP sky130_fd_pr__cap_mim_m3_1 l=3 w=3
X178 B11 TOP sky130_fd_pr__cap_mim_m3_1 l=3 w=3
X179 B11 TOP sky130_fd_pr__cap_mim_m3_1 l=3 w=3
X180 EDGE_BIAS EDGE_BIAS sky130_fd_pr__cap_mim_m3_1 l=3 w=3
X181 B11 TOP sky130_fd_pr__cap_mim_m3_1 l=3 w=3
X182 B10 TOP sky130_fd_pr__cap_mim_m3_1 l=3 w=3
X183 B9 TOP sky130_fd_pr__cap_mim_m3_1 l=3 w=3
X184 B9 TOP sky130_fd_pr__cap_mim_m3_1 l=3 w=3
X185 B11 TOP sky130_fd_pr__cap_mim_m3_1 l=3 w=3
X186 B11 TOP sky130_fd_pr__cap_mim_m3_1 l=3 w=3
X187 B10 TOP sky130_fd_pr__cap_mim_m3_1 l=3 w=3
X188 B8 TOP sky130_fd_pr__cap_mim_m3_1 l=3 w=3
X189 B11 TOP sky130_fd_pr__cap_mim_m3_1 l=3 w=3
X190 B10 TOP sky130_fd_pr__cap_mim_m3_1 l=3 w=3
X191 B11 TOP sky130_fd_pr__cap_mim_m3_1 l=3 w=3
X192 B9 TOP sky130_fd_pr__cap_mim_m3_1 l=3 w=3
X193 B10 TOP sky130_fd_pr__cap_mim_m3_1 l=3 w=3
X194 B11 TOP sky130_fd_pr__cap_mim_m3_1 l=3 w=3
X195 B9 TOP sky130_fd_pr__cap_mim_m3_1 l=3 w=3
X196 B9 TOP sky130_fd_pr__cap_mim_m3_1 l=3 w=3
X197 B11 TOP sky130_fd_pr__cap_mim_m3_1 l=3 w=3
X198 EDGE_BIAS EDGE_BIAS sky130_fd_pr__cap_mim_m3_1 l=3 w=3
X199 B11 TOP sky130_fd_pr__cap_mim_m3_1 l=3 w=3
X200 B11 TOP sky130_fd_pr__cap_mim_m3_1 l=3 w=3
X201 B11 TOP sky130_fd_pr__cap_mim_m3_1 l=3 w=3
X202 B11 TOP sky130_fd_pr__cap_mim_m3_1 l=3 w=3
X203 B11 TOP sky130_fd_pr__cap_mim_m3_1 l=3 w=3
X204 B11 TOP sky130_fd_pr__cap_mim_m3_1 l=3 w=3
X205 B10 TOP sky130_fd_pr__cap_mim_m3_1 l=3 w=3
X206 B11 TOP sky130_fd_pr__cap_mim_m3_1 l=3 w=3
X207 B11 TOP sky130_fd_pr__cap_mim_m3_1 l=3 w=3
X208 B11 TOP sky130_fd_pr__cap_mim_m3_1 l=3 w=3
X209 B11 TOP sky130_fd_pr__cap_mim_m3_1 l=3 w=3
X210 B11 TOP sky130_fd_pr__cap_mim_m3_1 l=3 w=3
X211 B10 TOP sky130_fd_pr__cap_mim_m3_1 l=3 w=3
X212 B11 TOP sky130_fd_pr__cap_mim_m3_1 l=3 w=3
X213 B11 TOP sky130_fd_pr__cap_mim_m3_1 l=3 w=3
X214 B7 TOP sky130_fd_pr__cap_mim_m3_1 l=3 w=3
X215 B7 TOP sky130_fd_pr__cap_mim_m3_1 l=3 w=3
X216 EDGE_BIAS EDGE_BIAS sky130_fd_pr__cap_mim_m3_1 l=3 w=3
X217 B11 TOP sky130_fd_pr__cap_mim_m3_1 l=3 w=3
X218 B7 TOP sky130_fd_pr__cap_mim_m3_1 l=3 w=3
X219 B11 TOP sky130_fd_pr__cap_mim_m3_1 l=3 w=3
X220 B9 TOP sky130_fd_pr__cap_mim_m3_1 l=3 w=3
X221 B10 TOP sky130_fd_pr__cap_mim_m3_1 l=3 w=3
X222 B11 TOP sky130_fd_pr__cap_mim_m3_1 l=3 w=3
X223 B8 TOP sky130_fd_pr__cap_mim_m3_1 l=3 w=3
X224 B10 TOP sky130_fd_pr__cap_mim_m3_1 l=3 w=3
X225 B9 TOP sky130_fd_pr__cap_mim_m3_1 l=3 w=3
X226 B11 TOP sky130_fd_pr__cap_mim_m3_1 l=3 w=3
X227 B11 TOP sky130_fd_pr__cap_mim_m3_1 l=3 w=3
X228 B11 TOP sky130_fd_pr__cap_mim_m3_1 l=3 w=3
X229 B11 TOP sky130_fd_pr__cap_mim_m3_1 l=3 w=3
X230 B11 TOP sky130_fd_pr__cap_mim_m3_1 l=3 w=3
X231 B11 TOP sky130_fd_pr__cap_mim_m3_1 l=3 w=3
X232 B6 TOP sky130_fd_pr__cap_mim_m3_1 l=3 w=3
X233 B11 TOP sky130_fd_pr__cap_mim_m3_1 l=3 w=3
X234 B11 TOP sky130_fd_pr__cap_mim_m3_1 l=3 w=3
X235 B11 TOP sky130_fd_pr__cap_mim_m3_1 l=3 w=3
X236 B10 TOP sky130_fd_pr__cap_mim_m3_1 l=3 w=3
X237 EDGE_BIAS EDGE_BIAS sky130_fd_pr__cap_mim_m3_1 l=3 w=3
X238 EDGE_BIAS EDGE_BIAS sky130_fd_pr__cap_mim_m3_1 l=3 w=3
X239 B10 TOP sky130_fd_pr__cap_mim_m3_1 l=3 w=3
X240 EDGE_BIAS EDGE_BIAS sky130_fd_pr__cap_mim_m3_1 l=3 w=3
X241 B11 TOP sky130_fd_pr__cap_mim_m3_1 l=3 w=3
X242 B8 TOP sky130_fd_pr__cap_mim_m3_1 l=3 w=3
X243 B11 TOP sky130_fd_pr__cap_mim_m3_1 l=3 w=3
X244 B11 TOP sky130_fd_pr__cap_mim_m3_1 l=3 w=3
X245 B10 TOP sky130_fd_pr__cap_mim_m3_1 l=3 w=3
X246 B9 TOP sky130_fd_pr__cap_mim_m3_1 l=3 w=3
X247 B11 TOP sky130_fd_pr__cap_mim_m3_1 l=3 w=3
X248 B11 TOP sky130_fd_pr__cap_mim_m3_1 l=3 w=3
X249 B11 TOP sky130_fd_pr__cap_mim_m3_1 l=3 w=3
X250 B8 TOP sky130_fd_pr__cap_mim_m3_1 l=3 w=3
X251 B11 TOP sky130_fd_pr__cap_mim_m3_1 l=3 w=3
X252 B9 TOP sky130_fd_pr__cap_mim_m3_1 l=3 w=3
X253 B11 TOP sky130_fd_pr__cap_mim_m3_1 l=3 w=3
X254 B10 TOP sky130_fd_pr__cap_mim_m3_1 l=3 w=3
X255 B11 TOP sky130_fd_pr__cap_mim_m3_1 l=3 w=3
X256 B9 TOP sky130_fd_pr__cap_mim_m3_1 l=3 w=3
X257 B11 TOP sky130_fd_pr__cap_mim_m3_1 l=3 w=3
X258 EDGE_BIAS EDGE_BIAS sky130_fd_pr__cap_mim_m3_1 l=3 w=3
X259 B11 TOP sky130_fd_pr__cap_mim_m3_1 l=3 w=3
X260 B6 TOP sky130_fd_pr__cap_mim_m3_1 l=3 w=3
X261 B11 TOP sky130_fd_pr__cap_mim_m3_1 l=3 w=3
X262 B10 TOP sky130_fd_pr__cap_mim_m3_1 l=3 w=3
X263 B11 TOP sky130_fd_pr__cap_mim_m3_1 l=3 w=3
X264 B10 TOP sky130_fd_pr__cap_mim_m3_1 l=3 w=3
X265 B10 TOP sky130_fd_pr__cap_mim_m3_1 l=3 w=3
X266 B9 TOP sky130_fd_pr__cap_mim_m3_1 l=3 w=3
X267 B11 TOP sky130_fd_pr__cap_mim_m3_1 l=3 w=3
X268 B8 TOP sky130_fd_pr__cap_mim_m3_1 l=3 w=3
X269 B10 TOP sky130_fd_pr__cap_mim_m3_1 l=3 w=3
X270 B11 TOP sky130_fd_pr__cap_mim_m3_1 l=3 w=3
X271 B11 TOP sky130_fd_pr__cap_mim_m3_1 l=3 w=3
X272 EDGE_BIAS EDGE_BIAS sky130_fd_pr__cap_mim_m3_1 l=3 w=3
X273 B11 TOP sky130_fd_pr__cap_mim_m3_1 l=3 w=3
X274 B11 TOP sky130_fd_pr__cap_mim_m3_1 l=3 w=3
X275 B10 TOP sky130_fd_pr__cap_mim_m3_1 l=3 w=3
X276 B11 TOP sky130_fd_pr__cap_mim_m3_1 l=3 w=3
X277 B11 TOP sky130_fd_pr__cap_mim_m3_1 l=3 w=3
X278 B11 TOP sky130_fd_pr__cap_mim_m3_1 l=3 w=3
X279 B11 TOP sky130_fd_pr__cap_mim_m3_1 l=3 w=3
X280 B7 TOP sky130_fd_pr__cap_mim_m3_1 l=3 w=3
X281 B7 TOP sky130_fd_pr__cap_mim_m3_1 l=3 w=3
X282 B10 TOP sky130_fd_pr__cap_mim_m3_1 l=3 w=3
X283 B11 TOP sky130_fd_pr__cap_mim_m3_1 l=3 w=3
X284 B10 TOP sky130_fd_pr__cap_mim_m3_1 l=3 w=3
X285 B11 TOP sky130_fd_pr__cap_mim_m3_1 l=3 w=3
X286 B10 TOP sky130_fd_pr__cap_mim_m3_1 l=3 w=3
X287 B10 TOP sky130_fd_pr__cap_mim_m3_1 l=3 w=3
X288 B11 TOP sky130_fd_pr__cap_mim_m3_1 l=3 w=3
X289 B11 TOP sky130_fd_pr__cap_mim_m3_1 l=3 w=3
X290 B10 TOP sky130_fd_pr__cap_mim_m3_1 l=3 w=3
X291 B10 TOP sky130_fd_pr__cap_mim_m3_1 l=3 w=3
X292 B11 TOP sky130_fd_pr__cap_mim_m3_1 l=3 w=3
X293 B11 TOP sky130_fd_pr__cap_mim_m3_1 l=3 w=3
X294 B11 TOP sky130_fd_pr__cap_mim_m3_1 l=3 w=3
X295 B11 TOP sky130_fd_pr__cap_mim_m3_1 l=3 w=3
X296 B10 TOP sky130_fd_pr__cap_mim_m3_1 l=3 w=3
X297 B11 TOP sky130_fd_pr__cap_mim_m3_1 l=3 w=3
X298 B7 TOP sky130_fd_pr__cap_mim_m3_1 l=3 w=3
X299 B10 TOP sky130_fd_pr__cap_mim_m3_1 l=3 w=3
X300 B9 TOP sky130_fd_pr__cap_mim_m3_1 l=3 w=3
X301 B11 TOP sky130_fd_pr__cap_mim_m3_1 l=3 w=3
X302 EDGE_BIAS EDGE_BIAS sky130_fd_pr__cap_mim_m3_1 l=3 w=3
X303 B11 TOP sky130_fd_pr__cap_mim_m3_1 l=3 w=3
X304 B8 TOP sky130_fd_pr__cap_mim_m3_1 l=3 w=3
X305 B11 TOP sky130_fd_pr__cap_mim_m3_1 l=3 w=3
X306 B11 TOP sky130_fd_pr__cap_mim_m3_1 l=3 w=3
X307 B10 TOP sky130_fd_pr__cap_mim_m3_1 l=3 w=3
X308 B9 TOP sky130_fd_pr__cap_mim_m3_1 l=3 w=3
X309 B11 TOP sky130_fd_pr__cap_mim_m3_1 l=3 w=3
X310 B10 TOP sky130_fd_pr__cap_mim_m3_1 l=3 w=3
X311 B11 TOP sky130_fd_pr__cap_mim_m3_1 l=3 w=3
X312 B10 TOP sky130_fd_pr__cap_mim_m3_1 l=3 w=3
X313 B8 TOP sky130_fd_pr__cap_mim_m3_1 l=3 w=3
X314 B11 TOP sky130_fd_pr__cap_mim_m3_1 l=3 w=3
X315 B11 TOP sky130_fd_pr__cap_mim_m3_1 l=3 w=3
X316 B11 TOP sky130_fd_pr__cap_mim_m3_1 l=3 w=3
X317 B9 TOP sky130_fd_pr__cap_mim_m3_1 l=3 w=3
X318 B11 TOP sky130_fd_pr__cap_mim_m3_1 l=3 w=3
X319 B9 TOP sky130_fd_pr__cap_mim_m3_1 l=3 w=3
X320 B11 TOP sky130_fd_pr__cap_mim_m3_1 l=3 w=3
X321 B9 TOP sky130_fd_pr__cap_mim_m3_1 l=3 w=3
X322 B11 TOP sky130_fd_pr__cap_mim_m3_1 l=3 w=3
X323 B11 TOP sky130_fd_pr__cap_mim_m3_1 l=3 w=3
X324 B11 TOP sky130_fd_pr__cap_mim_m3_1 l=3 w=3
X325 B10 TOP sky130_fd_pr__cap_mim_m3_1 l=3 w=3
X326 B11 TOP sky130_fd_pr__cap_mim_m3_1 l=3 w=3
X327 B11 TOP sky130_fd_pr__cap_mim_m3_1 l=3 w=3
X328 B11 TOP sky130_fd_pr__cap_mim_m3_1 l=3 w=3
X329 B11 TOP sky130_fd_pr__cap_mim_m3_1 l=3 w=3
X330 EDGE_BIAS EDGE_BIAS sky130_fd_pr__cap_mim_m3_1 l=3 w=3
X331 B11 TOP sky130_fd_pr__cap_mim_m3_1 l=3 w=3
X332 B10 TOP sky130_fd_pr__cap_mim_m3_1 l=3 w=3
X333 B11 TOP sky130_fd_pr__cap_mim_m3_1 l=3 w=3
X334 B11 TOP sky130_fd_pr__cap_mim_m3_1 l=3 w=3
X335 B11 TOP sky130_fd_pr__cap_mim_m3_1 l=3 w=3
X336 B10 TOP sky130_fd_pr__cap_mim_m3_1 l=3 w=3
X337 B7 TOP sky130_fd_pr__cap_mim_m3_1 l=3 w=3
X338 EDGE_BIAS EDGE_BIAS sky130_fd_pr__cap_mim_m3_1 l=3 w=3
X339 B11 TOP sky130_fd_pr__cap_mim_m3_1 l=3 w=3
X340 B7 TOP sky130_fd_pr__cap_mim_m3_1 l=3 w=3
X341 B9 TOP sky130_fd_pr__cap_mim_m3_1 l=3 w=3
X342 B10 TOP sky130_fd_pr__cap_mim_m3_1 l=3 w=3
X343 B11 TOP sky130_fd_pr__cap_mim_m3_1 l=3 w=3
X344 B10 TOP sky130_fd_pr__cap_mim_m3_1 l=3 w=3
X345 B8 TOP sky130_fd_pr__cap_mim_m3_1 l=3 w=3
X346 B11 TOP sky130_fd_pr__cap_mim_m3_1 l=3 w=3
X347 B11 TOP sky130_fd_pr__cap_mim_m3_1 l=3 w=3
X348 B10 TOP sky130_fd_pr__cap_mim_m3_1 l=3 w=3
X349 B11 TOP sky130_fd_pr__cap_mim_m3_1 l=3 w=3
X350 B11 TOP sky130_fd_pr__cap_mim_m3_1 l=3 w=3
X351 B11 TOP sky130_fd_pr__cap_mim_m3_1 l=3 w=3
X352 B11 TOP sky130_fd_pr__cap_mim_m3_1 l=3 w=3
X353 B10 TOP sky130_fd_pr__cap_mim_m3_1 l=3 w=3
X354 EDGE_BIAS EDGE_BIAS sky130_fd_pr__cap_mim_m3_1 l=3 w=3
X355 B11 TOP sky130_fd_pr__cap_mim_m3_1 l=3 w=3
X356 B8 TOP sky130_fd_pr__cap_mim_m3_1 l=3 w=3
X357 B11 TOP sky130_fd_pr__cap_mim_m3_1 l=3 w=3
X358 B11 TOP sky130_fd_pr__cap_mim_m3_1 l=3 w=3
X359 B11 TOP sky130_fd_pr__cap_mim_m3_1 l=3 w=3
X360 B10 TOP sky130_fd_pr__cap_mim_m3_1 l=3 w=3
X361 B9 TOP sky130_fd_pr__cap_mim_m3_1 l=3 w=3
X362 B8 TOP sky130_fd_pr__cap_mim_m3_1 l=3 w=3
X363 B9 TOP sky130_fd_pr__cap_mim_m3_1 l=3 w=3
X364 B8 TOP sky130_fd_pr__cap_mim_m3_1 l=3 w=3
X365 B10 TOP sky130_fd_pr__cap_mim_m3_1 l=3 w=3
X366 B11 TOP sky130_fd_pr__cap_mim_m3_1 l=3 w=3
X367 B11 TOP sky130_fd_pr__cap_mim_m3_1 l=3 w=3
X368 B10 TOP sky130_fd_pr__cap_mim_m3_1 l=3 w=3
X369 B9 TOP sky130_fd_pr__cap_mim_m3_1 l=3 w=3
X370 B11 TOP sky130_fd_pr__cap_mim_m3_1 l=3 w=3
X371 B10 TOP sky130_fd_pr__cap_mim_m3_1 l=3 w=3
X372 B11 TOP sky130_fd_pr__cap_mim_m3_1 l=3 w=3
X373 B9 TOP sky130_fd_pr__cap_mim_m3_1 l=3 w=3
X374 EDGE_BIAS EDGE_BIAS sky130_fd_pr__cap_mim_m3_1 l=3 w=3
X375 B11 TOP sky130_fd_pr__cap_mim_m3_1 l=3 w=3
X376 B9 TOP sky130_fd_pr__cap_mim_m3_1 l=3 w=3
X377 B11 TOP sky130_fd_pr__cap_mim_m3_1 l=3 w=3
X378 B11 TOP sky130_fd_pr__cap_mim_m3_1 l=3 w=3
X379 B11 TOP sky130_fd_pr__cap_mim_m3_1 l=3 w=3
X380 B10 TOP sky130_fd_pr__cap_mim_m3_1 l=3 w=3
X381 EDGE_BIAS EDGE_BIAS sky130_fd_pr__cap_mim_m3_1 l=3 w=3
X382 B11 TOP sky130_fd_pr__cap_mim_m3_1 l=3 w=3
X383 EDGE_BIAS EDGE_BIAS sky130_fd_pr__cap_mim_m3_1 l=3 w=3
X384 B11 TOP sky130_fd_pr__cap_mim_m3_1 l=3 w=3
X385 B10 TOP sky130_fd_pr__cap_mim_m3_1 l=3 w=3
X386 B11 TOP sky130_fd_pr__cap_mim_m3_1 l=3 w=3
X387 B11 TOP sky130_fd_pr__cap_mim_m3_1 l=3 w=3
X388 B7 TOP sky130_fd_pr__cap_mim_m3_1 l=3 w=3
X389 B7 TOP sky130_fd_pr__cap_mim_m3_1 l=3 w=3
X390 B7 TOP sky130_fd_pr__cap_mim_m3_1 l=3 w=3
X391 B9 TOP sky130_fd_pr__cap_mim_m3_1 l=3 w=3
X392 B11 TOP sky130_fd_pr__cap_mim_m3_1 l=3 w=3
X393 B10 TOP sky130_fd_pr__cap_mim_m3_1 l=3 w=3
X394 B9 TOP sky130_fd_pr__cap_mim_m3_1 l=3 w=3
X395 B10 TOP sky130_fd_pr__cap_mim_m3_1 l=3 w=3
X396 B11 TOP sky130_fd_pr__cap_mim_m3_1 l=3 w=3
X397 B11 TOP sky130_fd_pr__cap_mim_m3_1 l=3 w=3
X398 B9 TOP sky130_fd_pr__cap_mim_m3_1 l=3 w=3
X399 B8 TOP sky130_fd_pr__cap_mim_m3_1 l=3 w=3
X400 B11 TOP sky130_fd_pr__cap_mim_m3_1 l=3 w=3
X401 B11 TOP sky130_fd_pr__cap_mim_m3_1 l=3 w=3
X402 B11 TOP sky130_fd_pr__cap_mim_m3_1 l=3 w=3
X403 B11 TOP sky130_fd_pr__cap_mim_m3_1 l=3 w=3
X404 B8 TOP sky130_fd_pr__cap_mim_m3_1 l=3 w=3
X405 B11 TOP sky130_fd_pr__cap_mim_m3_1 l=3 w=3
X406 B11 TOP sky130_fd_pr__cap_mim_m3_1 l=3 w=3
X407 B11 TOP sky130_fd_pr__cap_mim_m3_1 l=3 w=3
X408 B11 TOP sky130_fd_pr__cap_mim_m3_1 l=3 w=3
X409 B10 TOP sky130_fd_pr__cap_mim_m3_1 l=3 w=3
X410 B6 TOP sky130_fd_pr__cap_mim_m3_1 l=3 w=3
X411 B11 TOP sky130_fd_pr__cap_mim_m3_1 l=3 w=3
X412 EDGE_BIAS EDGE_BIAS sky130_fd_pr__cap_mim_m3_1 l=3 w=3
X413 EDGE_BIAS EDGE_BIAS sky130_fd_pr__cap_mim_m3_1 l=3 w=3
X414 B11 TOP sky130_fd_pr__cap_mim_m3_1 l=3 w=3
X415 B8 TOP sky130_fd_pr__cap_mim_m3_1 l=3 w=3
X416 B11 TOP sky130_fd_pr__cap_mim_m3_1 l=3 w=3
X417 B11 TOP sky130_fd_pr__cap_mim_m3_1 l=3 w=3
X418 B9 TOP sky130_fd_pr__cap_mim_m3_1 l=3 w=3
X419 B11 TOP sky130_fd_pr__cap_mim_m3_1 l=3 w=3
X420 B11 TOP sky130_fd_pr__cap_mim_m3_1 l=3 w=3
X421 B11 TOP sky130_fd_pr__cap_mim_m3_1 l=3 w=3
X422 B11 TOP sky130_fd_pr__cap_mim_m3_1 l=3 w=3
X423 B9 TOP sky130_fd_pr__cap_mim_m3_1 l=3 w=3
X424 B10 TOP sky130_fd_pr__cap_mim_m3_1 l=3 w=3
X425 B8 TOP sky130_fd_pr__cap_mim_m3_1 l=3 w=3
X426 B11 TOP sky130_fd_pr__cap_mim_m3_1 l=3 w=3
X427 B9 TOP sky130_fd_pr__cap_mim_m3_1 l=3 w=3
X428 B9 TOP sky130_fd_pr__cap_mim_m3_1 l=3 w=3
X429 B10 TOP sky130_fd_pr__cap_mim_m3_1 l=3 w=3
X430 B11 TOP sky130_fd_pr__cap_mim_m3_1 l=3 w=3
X431 B9 TOP sky130_fd_pr__cap_mim_m3_1 l=3 w=3
X432 B11 TOP sky130_fd_pr__cap_mim_m3_1 l=3 w=3
X433 B11 TOP sky130_fd_pr__cap_mim_m3_1 l=3 w=3
X434 B10 TOP sky130_fd_pr__cap_mim_m3_1 l=3 w=3
X435 B8 TOP sky130_fd_pr__cap_mim_m3_1 l=3 w=3
X436 B10 TOP sky130_fd_pr__cap_mim_m3_1 l=3 w=3
X437 B11 TOP sky130_fd_pr__cap_mim_m3_1 l=3 w=3
X438 EDGE_BIAS EDGE_BIAS sky130_fd_pr__cap_mim_m3_1 l=3 w=3
X439 B11 TOP sky130_fd_pr__cap_mim_m3_1 l=3 w=3
X440 B11 TOP sky130_fd_pr__cap_mim_m3_1 l=3 w=3
X441 B11 TOP sky130_fd_pr__cap_mim_m3_1 l=3 w=3
X442 B11 TOP sky130_fd_pr__cap_mim_m3_1 l=3 w=3
X443 B11 TOP sky130_fd_pr__cap_mim_m3_1 l=3 w=3
X444 B11 TOP sky130_fd_pr__cap_mim_m3_1 l=3 w=3
X445 B11 TOP sky130_fd_pr__cap_mim_m3_1 l=3 w=3
X446 B10 TOP sky130_fd_pr__cap_mim_m3_1 l=3 w=3
X447 B11 TOP sky130_fd_pr__cap_mim_m3_1 l=3 w=3
X448 B7 TOP sky130_fd_pr__cap_mim_m3_1 l=3 w=3
X449 B11 TOP sky130_fd_pr__cap_mim_m3_1 l=3 w=3
X450 B10 TOP sky130_fd_pr__cap_mim_m3_1 l=3 w=3
X451 B10 TOP sky130_fd_pr__cap_mim_m3_1 l=3 w=3
X452 EDGE_BIAS EDGE_BIAS sky130_fd_pr__cap_mim_m3_1 l=3 w=3
X453 B10 TOP sky130_fd_pr__cap_mim_m3_1 l=3 w=3
X454 B8 TOP sky130_fd_pr__cap_mim_m3_1 l=3 w=3
X455 B10 TOP sky130_fd_pr__cap_mim_m3_1 l=3 w=3
X456 B10 TOP sky130_fd_pr__cap_mim_m3_1 l=3 w=3
X457 B11 TOP sky130_fd_pr__cap_mim_m3_1 l=3 w=3
X458 B11 TOP sky130_fd_pr__cap_mim_m3_1 l=3 w=3
X459 B11 TOP sky130_fd_pr__cap_mim_m3_1 l=3 w=3
X460 B11 TOP sky130_fd_pr__cap_mim_m3_1 l=3 w=3
X461 B10 TOP sky130_fd_pr__cap_mim_m3_1 l=3 w=3
X462 B11 TOP sky130_fd_pr__cap_mim_m3_1 l=3 w=3
X463 EDGE_BIAS EDGE_BIAS sky130_fd_pr__cap_mim_m3_1 l=3 w=3
X464 B11 TOP sky130_fd_pr__cap_mim_m3_1 l=3 w=3
X465 B10 TOP sky130_fd_pr__cap_mim_m3_1 l=3 w=3
X466 B11 TOP sky130_fd_pr__cap_mim_m3_1 l=3 w=3
X467 B11 TOP sky130_fd_pr__cap_mim_m3_1 l=3 w=3
X468 B10 TOP sky130_fd_pr__cap_mim_m3_1 l=3 w=3
X469 B8 TOP sky130_fd_pr__cap_mim_m3_1 l=3 w=3
X470 B11 TOP sky130_fd_pr__cap_mim_m3_1 l=3 w=3
X471 B9 TOP sky130_fd_pr__cap_mim_m3_1 l=3 w=3
X472 B8 TOP sky130_fd_pr__cap_mim_m3_1 l=3 w=3
X473 B11 TOP sky130_fd_pr__cap_mim_m3_1 l=3 w=3
X474 B10 TOP sky130_fd_pr__cap_mim_m3_1 l=3 w=3
X475 B11 TOP sky130_fd_pr__cap_mim_m3_1 l=3 w=3
X476 B11 TOP sky130_fd_pr__cap_mim_m3_1 l=3 w=3
X477 B9 TOP sky130_fd_pr__cap_mim_m3_1 l=3 w=3
X478 B11 TOP sky130_fd_pr__cap_mim_m3_1 l=3 w=3
X479 B10 TOP sky130_fd_pr__cap_mim_m3_1 l=3 w=3
X480 B11 TOP sky130_fd_pr__cap_mim_m3_1 l=3 w=3
X481 B8 TOP sky130_fd_pr__cap_mim_m3_1 l=3 w=3
X482 B9 TOP sky130_fd_pr__cap_mim_m3_1 l=3 w=3
X483 B11 TOP sky130_fd_pr__cap_mim_m3_1 l=3 w=3
X484 B11 TOP sky130_fd_pr__cap_mim_m3_1 l=3 w=3
X485 B11 TOP sky130_fd_pr__cap_mim_m3_1 l=3 w=3
X486 B11 TOP sky130_fd_pr__cap_mim_m3_1 l=3 w=3
X487 EDGE_BIAS EDGE_BIAS sky130_fd_pr__cap_mim_m3_1 l=3 w=3
X488 B10 TOP sky130_fd_pr__cap_mim_m3_1 l=3 w=3
X489 B11 TOP sky130_fd_pr__cap_mim_m3_1 l=3 w=3
X490 B11 TOP sky130_fd_pr__cap_mim_m3_1 l=3 w=3
X491 B11 TOP sky130_fd_pr__cap_mim_m3_1 l=3 w=3
X492 B10 TOP sky130_fd_pr__cap_mim_m3_1 l=3 w=3
X493 B9 TOP sky130_fd_pr__cap_mim_m3_1 l=3 w=3
X494 B10 TOP sky130_fd_pr__cap_mim_m3_1 l=3 w=3
X495 B11 TOP sky130_fd_pr__cap_mim_m3_1 l=3 w=3
X496 B7 TOP sky130_fd_pr__cap_mim_m3_1 l=3 w=3
X497 B11 TOP sky130_fd_pr__cap_mim_m3_1 l=3 w=3
X498 B11 TOP sky130_fd_pr__cap_mim_m3_1 l=3 w=3
X499 B10 TOP sky130_fd_pr__cap_mim_m3_1 l=3 w=3
X500 B9 TOP sky130_fd_pr__cap_mim_m3_1 l=3 w=3
X501 B11 TOP sky130_fd_pr__cap_mim_m3_1 l=3 w=3
X502 B11 TOP sky130_fd_pr__cap_mim_m3_1 l=3 w=3
X503 B10 TOP sky130_fd_pr__cap_mim_m3_1 l=3 w=3
X504 B8 TOP sky130_fd_pr__cap_mim_m3_1 l=3 w=3
X505 B10 TOP sky130_fd_pr__cap_mim_m3_1 l=3 w=3
X506 B11 TOP sky130_fd_pr__cap_mim_m3_1 l=3 w=3
X507 B11 TOP sky130_fd_pr__cap_mim_m3_1 l=3 w=3
X508 B10 TOP sky130_fd_pr__cap_mim_m3_1 l=3 w=3
X509 B11 TOP sky130_fd_pr__cap_mim_m3_1 l=3 w=3
X510 B6 TOP sky130_fd_pr__cap_mim_m3_1 l=3 w=3
X511 B11 TOP sky130_fd_pr__cap_mim_m3_1 l=3 w=3
X512 EDGE_BIAS EDGE_BIAS sky130_fd_pr__cap_mim_m3_1 l=3 w=3
X513 B11 TOP sky130_fd_pr__cap_mim_m3_1 l=3 w=3
X514 B11 TOP sky130_fd_pr__cap_mim_m3_1 l=3 w=3
X515 B11 TOP sky130_fd_pr__cap_mim_m3_1 l=3 w=3
X516 EDGE_BIAS EDGE_BIAS sky130_fd_pr__cap_mim_m3_1 l=3 w=3
X517 EDGE_BIAS EDGE_BIAS sky130_fd_pr__cap_mim_m3_1 l=3 w=3
X518 B11 TOP sky130_fd_pr__cap_mim_m3_1 l=3 w=3
X519 B8 TOP sky130_fd_pr__cap_mim_m3_1 l=3 w=3
X520 B8 TOP sky130_fd_pr__cap_mim_m3_1 l=3 w=3
X521 B8 TOP sky130_fd_pr__cap_mim_m3_1 l=3 w=3
X522 B11 TOP sky130_fd_pr__cap_mim_m3_1 l=3 w=3
X523 B11 TOP sky130_fd_pr__cap_mim_m3_1 l=3 w=3
X524 B10 TOP sky130_fd_pr__cap_mim_m3_1 l=3 w=3
X525 B11 TOP sky130_fd_pr__cap_mim_m3_1 l=3 w=3
X526 B11 TOP sky130_fd_pr__cap_mim_m3_1 l=3 w=3
X527 B8 TOP sky130_fd_pr__cap_mim_m3_1 l=3 w=3
X528 B11 TOP sky130_fd_pr__cap_mim_m3_1 l=3 w=3
X529 B10 TOP sky130_fd_pr__cap_mim_m3_1 l=3 w=3
X530 B10 TOP sky130_fd_pr__cap_mim_m3_1 l=3 w=3
X531 B11 TOP sky130_fd_pr__cap_mim_m3_1 l=3 w=3
X532 B9 TOP sky130_fd_pr__cap_mim_m3_1 l=3 w=3
X533 B7 TOP sky130_fd_pr__cap_mim_m3_1 l=3 w=3
X534 B9 TOP sky130_fd_pr__cap_mim_m3_1 l=3 w=3
X535 B9 TOP sky130_fd_pr__cap_mim_m3_1 l=3 w=3
X536 B11 TOP sky130_fd_pr__cap_mim_m3_1 l=3 w=3
X537 B10 TOP sky130_fd_pr__cap_mim_m3_1 l=3 w=3
X538 EDGE_BIAS EDGE_BIAS sky130_fd_pr__cap_mim_m3_1 l=3 w=3
X539 B11 TOP sky130_fd_pr__cap_mim_m3_1 l=3 w=3
X540 B11 TOP sky130_fd_pr__cap_mim_m3_1 l=3 w=3
X541 B11 TOP sky130_fd_pr__cap_mim_m3_1 l=3 w=3
X542 B11 TOP sky130_fd_pr__cap_mim_m3_1 l=3 w=3
X543 B11 TOP sky130_fd_pr__cap_mim_m3_1 l=3 w=3
X544 B11 TOP sky130_fd_pr__cap_mim_m3_1 l=3 w=3
X545 B10 TOP sky130_fd_pr__cap_mim_m3_1 l=3 w=3
X546 B10 TOP sky130_fd_pr__cap_mim_m3_1 l=3 w=3
X547 B11 TOP sky130_fd_pr__cap_mim_m3_1 l=3 w=3
X548 B11 TOP sky130_fd_pr__cap_mim_m3_1 l=3 w=3
X549 B10 TOP sky130_fd_pr__cap_mim_m3_1 l=3 w=3
X550 B11 TOP sky130_fd_pr__cap_mim_m3_1 l=3 w=3
X551 B10 TOP sky130_fd_pr__cap_mim_m3_1 l=3 w=3
X552 B9 TOP sky130_fd_pr__cap_mim_m3_1 l=3 w=3
X553 B11 TOP sky130_fd_pr__cap_mim_m3_1 l=3 w=3
X554 B10 TOP sky130_fd_pr__cap_mim_m3_1 l=3 w=3
X555 B8 TOP sky130_fd_pr__cap_mim_m3_1 l=3 w=3
X556 B11 TOP sky130_fd_pr__cap_mim_m3_1 l=3 w=3
X557 B11 TOP sky130_fd_pr__cap_mim_m3_1 l=3 w=3
X558 B11 TOP sky130_fd_pr__cap_mim_m3_1 l=3 w=3
X559 B8 TOP sky130_fd_pr__cap_mim_m3_1 l=3 w=3
X560 B11 TOP sky130_fd_pr__cap_mim_m3_1 l=3 w=3
X561 DUMMY TOP sky130_fd_pr__cap_mim_m3_1 l=3 w=3
X562 B11 TOP sky130_fd_pr__cap_mim_m3_1 l=3 w=3
X563 B11 TOP sky130_fd_pr__cap_mim_m3_1 l=3 w=3
X564 B11 TOP sky130_fd_pr__cap_mim_m3_1 l=3 w=3
X565 EDGE_BIAS EDGE_BIAS sky130_fd_pr__cap_mim_m3_1 l=3 w=3
X566 B11 TOP sky130_fd_pr__cap_mim_m3_1 l=3 w=3
X567 B11 TOP sky130_fd_pr__cap_mim_m3_1 l=3 w=3
X568 B11 TOP sky130_fd_pr__cap_mim_m3_1 l=3 w=3
X569 B8 TOP sky130_fd_pr__cap_mim_m3_1 l=3 w=3
X570 B11 TOP sky130_fd_pr__cap_mim_m3_1 l=3 w=3
X571 B9 TOP sky130_fd_pr__cap_mim_m3_1 l=3 w=3
X572 B10 TOP sky130_fd_pr__cap_mim_m3_1 l=3 w=3
X573 EDGE_BIAS EDGE_BIAS sky130_fd_pr__cap_mim_m3_1 l=3 w=3
X574 B11 TOP sky130_fd_pr__cap_mim_m3_1 l=3 w=3
X575 B10 TOP sky130_fd_pr__cap_mim_m3_1 l=3 w=3
X576 B8 TOP sky130_fd_pr__cap_mim_m3_1 l=3 w=3
X577 B11 TOP sky130_fd_pr__cap_mim_m3_1 l=3 w=3
X578 B11 TOP sky130_fd_pr__cap_mim_m3_1 l=3 w=3
X579 B11 TOP sky130_fd_pr__cap_mim_m3_1 l=3 w=3
X580 B11 TOP sky130_fd_pr__cap_mim_m3_1 l=3 w=3
X581 B9 TOP sky130_fd_pr__cap_mim_m3_1 l=3 w=3
X582 B11 TOP sky130_fd_pr__cap_mim_m3_1 l=3 w=3
X583 B10 TOP sky130_fd_pr__cap_mim_m3_1 l=3 w=3
X584 B11 TOP sky130_fd_pr__cap_mim_m3_1 l=3 w=3
X585 B9 TOP sky130_fd_pr__cap_mim_m3_1 l=3 w=3
X586 EDGE_BIAS EDGE_BIAS sky130_fd_pr__cap_mim_m3_1 l=3 w=3
X587 B10 TOP sky130_fd_pr__cap_mim_m3_1 l=3 w=3
X588 B11 TOP sky130_fd_pr__cap_mim_m3_1 l=3 w=3
X589 B10 TOP sky130_fd_pr__cap_mim_m3_1 l=3 w=3
X590 B11 TOP sky130_fd_pr__cap_mim_m3_1 l=3 w=3
X591 B11 TOP sky130_fd_pr__cap_mim_m3_1 l=3 w=3
X592 B11 TOP sky130_fd_pr__cap_mim_m3_1 l=3 w=3
X593 B11 TOP sky130_fd_pr__cap_mim_m3_1 l=3 w=3
X594 B10 TOP sky130_fd_pr__cap_mim_m3_1 l=3 w=3
X595 B11 TOP sky130_fd_pr__cap_mim_m3_1 l=3 w=3
X596 B10 TOP sky130_fd_pr__cap_mim_m3_1 l=3 w=3
X597 B7 TOP sky130_fd_pr__cap_mim_m3_1 l=3 w=3
X598 B11 TOP sky130_fd_pr__cap_mim_m3_1 l=3 w=3
X599 B11 TOP sky130_fd_pr__cap_mim_m3_1 l=3 w=3
X600 EDGE_BIAS EDGE_BIAS sky130_fd_pr__cap_mim_m3_1 l=3 w=3
X601 B10 TOP sky130_fd_pr__cap_mim_m3_1 l=3 w=3
X602 B9 TOP sky130_fd_pr__cap_mim_m3_1 l=3 w=3
X603 B10 TOP sky130_fd_pr__cap_mim_m3_1 l=3 w=3
X604 B8 TOP sky130_fd_pr__cap_mim_m3_1 l=3 w=3
X605 B10 TOP sky130_fd_pr__cap_mim_m3_1 l=3 w=3
X606 B11 TOP sky130_fd_pr__cap_mim_m3_1 l=3 w=3
X607 B10 TOP sky130_fd_pr__cap_mim_m3_1 l=3 w=3
X608 B11 TOP sky130_fd_pr__cap_mim_m3_1 l=3 w=3
X609 B10 TOP sky130_fd_pr__cap_mim_m3_1 l=3 w=3
X610 B9 TOP sky130_fd_pr__cap_mim_m3_1 l=3 w=3
X611 B11 TOP sky130_fd_pr__cap_mim_m3_1 l=3 w=3
X612 B11 TOP sky130_fd_pr__cap_mim_m3_1 l=3 w=3
X613 B11 TOP sky130_fd_pr__cap_mim_m3_1 l=3 w=3
X614 B11 TOP sky130_fd_pr__cap_mim_m3_1 l=3 w=3
X615 B11 TOP sky130_fd_pr__cap_mim_m3_1 l=3 w=3
X616 B11 TOP sky130_fd_pr__cap_mim_m3_1 l=3 w=3
X617 B11 TOP sky130_fd_pr__cap_mim_m3_1 l=3 w=3
X618 EDGE_BIAS EDGE_BIAS sky130_fd_pr__cap_mim_m3_1 l=3 w=3
X619 B10 TOP sky130_fd_pr__cap_mim_m3_1 l=3 w=3
X620 B8 TOP sky130_fd_pr__cap_mim_m3_1 l=3 w=3
X621 B11 TOP sky130_fd_pr__cap_mim_m3_1 l=3 w=3
X622 B11 TOP sky130_fd_pr__cap_mim_m3_1 l=3 w=3
X623 B11 TOP sky130_fd_pr__cap_mim_m3_1 l=3 w=3
X624 EDGE_BIAS EDGE_BIAS sky130_fd_pr__cap_mim_m3_1 l=3 w=3
X625 B11 TOP sky130_fd_pr__cap_mim_m3_1 l=3 w=3
X626 B11 TOP sky130_fd_pr__cap_mim_m3_1 l=3 w=3
X627 EDGE_BIAS EDGE_BIAS sky130_fd_pr__cap_mim_m3_1 l=3 w=3
X628 B8 TOP sky130_fd_pr__cap_mim_m3_1 l=3 w=3
X629 B11 TOP sky130_fd_pr__cap_mim_m3_1 l=3 w=3
X630 B10 TOP sky130_fd_pr__cap_mim_m3_1 l=3 w=3
X631 B11 TOP sky130_fd_pr__cap_mim_m3_1 l=3 w=3
X632 B9 TOP sky130_fd_pr__cap_mim_m3_1 l=3 w=3
X633 B10 TOP sky130_fd_pr__cap_mim_m3_1 l=3 w=3
X634 B11 TOP sky130_fd_pr__cap_mim_m3_1 l=3 w=3
X635 B11 TOP sky130_fd_pr__cap_mim_m3_1 l=3 w=3
X636 B11 TOP sky130_fd_pr__cap_mim_m3_1 l=3 w=3
X637 B11 TOP sky130_fd_pr__cap_mim_m3_1 l=3 w=3
X638 B9 TOP sky130_fd_pr__cap_mim_m3_1 l=3 w=3
X639 B7 TOP sky130_fd_pr__cap_mim_m3_1 l=3 w=3
X640 EDGE_BIAS EDGE_BIAS sky130_fd_pr__cap_mim_m3_1 l=3 w=3
X641 B11 TOP sky130_fd_pr__cap_mim_m3_1 l=3 w=3
X642 B11 TOP sky130_fd_pr__cap_mim_m3_1 l=3 w=3
X643 B11 TOP sky130_fd_pr__cap_mim_m3_1 l=3 w=3
X644 B11 TOP sky130_fd_pr__cap_mim_m3_1 l=3 w=3
X645 B8 TOP sky130_fd_pr__cap_mim_m3_1 l=3 w=3
X646 B11 TOP sky130_fd_pr__cap_mim_m3_1 l=3 w=3
X647 B7 TOP sky130_fd_pr__cap_mim_m3_1 l=3 w=3
X648 B11 TOP sky130_fd_pr__cap_mim_m3_1 l=3 w=3
X649 B11 TOP sky130_fd_pr__cap_mim_m3_1 l=3 w=3
X650 EDGE_BIAS EDGE_BIAS sky130_fd_pr__cap_mim_m3_1 l=3 w=3
X651 B11 TOP sky130_fd_pr__cap_mim_m3_1 l=3 w=3
X652 B11 TOP sky130_fd_pr__cap_mim_m3_1 l=3 w=3
X653 B10 TOP sky130_fd_pr__cap_mim_m3_1 l=3 w=3
X654 B10 TOP sky130_fd_pr__cap_mim_m3_1 l=3 w=3
X655 B9 TOP sky130_fd_pr__cap_mim_m3_1 l=3 w=3
X656 B11 TOP sky130_fd_pr__cap_mim_m3_1 l=3 w=3
X657 B10 TOP sky130_fd_pr__cap_mim_m3_1 l=3 w=3
X658 B10 TOP sky130_fd_pr__cap_mim_m3_1 l=3 w=3
X659 B8 TOP sky130_fd_pr__cap_mim_m3_1 l=3 w=3
X660 B10 TOP sky130_fd_pr__cap_mim_m3_1 l=3 w=3
X661 B11 TOP sky130_fd_pr__cap_mim_m3_1 l=3 w=3
X662 B10 TOP sky130_fd_pr__cap_mim_m3_1 l=3 w=3
X663 B10 TOP sky130_fd_pr__cap_mim_m3_1 l=3 w=3
X664 B9 TOP sky130_fd_pr__cap_mim_m3_1 l=3 w=3
X665 B8 TOP sky130_fd_pr__cap_mim_m3_1 l=3 w=3
X666 B11 TOP sky130_fd_pr__cap_mim_m3_1 l=3 w=3
X667 EDGE_BIAS EDGE_BIAS sky130_fd_pr__cap_mim_m3_1 l=3 w=3
X668 B11 TOP sky130_fd_pr__cap_mim_m3_1 l=3 w=3
X669 EDGE_BIAS EDGE_BIAS sky130_fd_pr__cap_mim_m3_1 l=3 w=3
X670 B11 TOP sky130_fd_pr__cap_mim_m3_1 l=3 w=3
X671 B11 TOP sky130_fd_pr__cap_mim_m3_1 l=3 w=3
X672 EDGE_BIAS EDGE_BIAS sky130_fd_pr__cap_mim_m3_1 l=3 w=3
X673 B9 TOP sky130_fd_pr__cap_mim_m3_1 l=3 w=3
X674 B11 TOP sky130_fd_pr__cap_mim_m3_1 l=3 w=3
X675 B11 TOP sky130_fd_pr__cap_mim_m3_1 l=3 w=3
X676 B11 TOP sky130_fd_pr__cap_mim_m3_1 l=3 w=3
X677 B11 TOP sky130_fd_pr__cap_mim_m3_1 l=3 w=3
X678 B10 TOP sky130_fd_pr__cap_mim_m3_1 l=3 w=3
X679 B11 TOP sky130_fd_pr__cap_mim_m3_1 l=3 w=3
X680 B8 TOP sky130_fd_pr__cap_mim_m3_1 l=3 w=3
X681 B9 TOP sky130_fd_pr__cap_mim_m3_1 l=3 w=3
X682 B10 TOP sky130_fd_pr__cap_mim_m3_1 l=3 w=3
X683 B11 TOP sky130_fd_pr__cap_mim_m3_1 l=3 w=3
X684 B7 TOP sky130_fd_pr__cap_mim_m3_1 l=3 w=3
X685 B7 TOP sky130_fd_pr__cap_mim_m3_1 l=3 w=3
X686 B11 TOP sky130_fd_pr__cap_mim_m3_1 l=3 w=3
X687 B11 TOP sky130_fd_pr__cap_mim_m3_1 l=3 w=3
X688 B9 TOP sky130_fd_pr__cap_mim_m3_1 l=3 w=3
X689 B11 TOP sky130_fd_pr__cap_mim_m3_1 l=3 w=3
X690 B10 TOP sky130_fd_pr__cap_mim_m3_1 l=3 w=3
X691 B11 TOP sky130_fd_pr__cap_mim_m3_1 l=3 w=3
X692 B11 TOP sky130_fd_pr__cap_mim_m3_1 l=3 w=3
X693 B11 TOP sky130_fd_pr__cap_mim_m3_1 l=3 w=3
X694 B11 TOP sky130_fd_pr__cap_mim_m3_1 l=3 w=3
X695 B11 TOP sky130_fd_pr__cap_mim_m3_1 l=3 w=3
X696 B11 TOP sky130_fd_pr__cap_mim_m3_1 l=3 w=3
X697 B11 TOP sky130_fd_pr__cap_mim_m3_1 l=3 w=3
X698 B10 TOP sky130_fd_pr__cap_mim_m3_1 l=3 w=3
X699 EDGE_BIAS EDGE_BIAS sky130_fd_pr__cap_mim_m3_1 l=3 w=3
X700 B11 TOP sky130_fd_pr__cap_mim_m3_1 l=3 w=3
X701 B9 TOP sky130_fd_pr__cap_mim_m3_1 l=3 w=3
X702 B11 TOP sky130_fd_pr__cap_mim_m3_1 l=3 w=3
X703 B11 TOP sky130_fd_pr__cap_mim_m3_1 l=3 w=3
X704 B10 TOP sky130_fd_pr__cap_mim_m3_1 l=3 w=3
X705 B11 TOP sky130_fd_pr__cap_mim_m3_1 l=3 w=3
X706 B10 TOP sky130_fd_pr__cap_mim_m3_1 l=3 w=3
X707 B9 TOP sky130_fd_pr__cap_mim_m3_1 l=3 w=3
X708 EDGE_BIAS EDGE_BIAS sky130_fd_pr__cap_mim_m3_1 l=3 w=3
X709 B8 TOP sky130_fd_pr__cap_mim_m3_1 l=3 w=3
X710 B11 TOP sky130_fd_pr__cap_mim_m3_1 l=3 w=3
X711 B11 TOP sky130_fd_pr__cap_mim_m3_1 l=3 w=3
X712 B8 TOP sky130_fd_pr__cap_mim_m3_1 l=3 w=3
X713 B11 TOP sky130_fd_pr__cap_mim_m3_1 l=3 w=3
X714 B5 TOP sky130_fd_pr__cap_mim_m3_1 l=3 w=3
X715 B11 TOP sky130_fd_pr__cap_mim_m3_1 l=3 w=3
X716 B11 TOP sky130_fd_pr__cap_mim_m3_1 l=3 w=3
X717 B9 TOP sky130_fd_pr__cap_mim_m3_1 l=3 w=3
X718 EDGE_BIAS EDGE_BIAS sky130_fd_pr__cap_mim_m3_1 l=3 w=3
X719 B5 TOP sky130_fd_pr__cap_mim_m3_1 l=3 w=3
X720 B10 TOP sky130_fd_pr__cap_mim_m3_1 l=3 w=3
X721 B8 TOP sky130_fd_pr__cap_mim_m3_1 l=3 w=3
X722 EDGE_BIAS EDGE_BIAS sky130_fd_pr__cap_mim_m3_1 l=3 w=3
X723 B11 TOP sky130_fd_pr__cap_mim_m3_1 l=3 w=3
X724 B10 TOP sky130_fd_pr__cap_mim_m3_1 l=3 w=3
X725 B11 TOP sky130_fd_pr__cap_mim_m3_1 l=3 w=3
X726 B11 TOP sky130_fd_pr__cap_mim_m3_1 l=3 w=3
X727 B11 TOP sky130_fd_pr__cap_mim_m3_1 l=3 w=3
X728 B10 TOP sky130_fd_pr__cap_mim_m3_1 l=3 w=3
X729 B8 TOP sky130_fd_pr__cap_mim_m3_1 l=3 w=3
X730 B11 TOP sky130_fd_pr__cap_mim_m3_1 l=3 w=3
X731 B11 TOP sky130_fd_pr__cap_mim_m3_1 l=3 w=3
X732 B10 TOP sky130_fd_pr__cap_mim_m3_1 l=3 w=3
X733 B9 TOP sky130_fd_pr__cap_mim_m3_1 l=3 w=3
X734 B10 TOP sky130_fd_pr__cap_mim_m3_1 l=3 w=3
X735 B11 TOP sky130_fd_pr__cap_mim_m3_1 l=3 w=3
X736 B11 TOP sky130_fd_pr__cap_mim_m3_1 l=3 w=3
X737 EDGE_BIAS EDGE_BIAS sky130_fd_pr__cap_mim_m3_1 l=3 w=3
X738 B11 TOP sky130_fd_pr__cap_mim_m3_1 l=3 w=3
X739 B11 TOP sky130_fd_pr__cap_mim_m3_1 l=3 w=3
X740 B10 TOP sky130_fd_pr__cap_mim_m3_1 l=3 w=3
X741 B11 TOP sky130_fd_pr__cap_mim_m3_1 l=3 w=3
X742 B10 TOP sky130_fd_pr__cap_mim_m3_1 l=3 w=3
X743 B11 TOP sky130_fd_pr__cap_mim_m3_1 l=3 w=3
X744 B11 TOP sky130_fd_pr__cap_mim_m3_1 l=3 w=3
X745 B10 TOP sky130_fd_pr__cap_mim_m3_1 l=3 w=3
X746 B11 TOP sky130_fd_pr__cap_mim_m3_1 l=3 w=3
X747 EDGE_BIAS EDGE_BIAS sky130_fd_pr__cap_mim_m3_1 l=3 w=3
X748 B11 TOP sky130_fd_pr__cap_mim_m3_1 l=3 w=3
X749 B11 TOP sky130_fd_pr__cap_mim_m3_1 l=3 w=3
X750 B11 TOP sky130_fd_pr__cap_mim_m3_1 l=3 w=3
X751 B10 TOP sky130_fd_pr__cap_mim_m3_1 l=3 w=3
X752 B9 TOP sky130_fd_pr__cap_mim_m3_1 l=3 w=3
X753 B10 TOP sky130_fd_pr__cap_mim_m3_1 l=3 w=3
X754 B11 TOP sky130_fd_pr__cap_mim_m3_1 l=3 w=3
X755 B8 TOP sky130_fd_pr__cap_mim_m3_1 l=3 w=3
X756 B11 TOP sky130_fd_pr__cap_mim_m3_1 l=3 w=3
X757 B10 TOP sky130_fd_pr__cap_mim_m3_1 l=3 w=3
X758 B10 TOP sky130_fd_pr__cap_mim_m3_1 l=3 w=3
X759 B11 TOP sky130_fd_pr__cap_mim_m3_1 l=3 w=3
X760 B10 TOP sky130_fd_pr__cap_mim_m3_1 l=3 w=3
X761 B11 TOP sky130_fd_pr__cap_mim_m3_1 l=3 w=3
X762 B9 TOP sky130_fd_pr__cap_mim_m3_1 l=3 w=3
X763 B11 TOP sky130_fd_pr__cap_mim_m3_1 l=3 w=3
X764 B10 TOP sky130_fd_pr__cap_mim_m3_1 l=3 w=3
X765 B11 TOP sky130_fd_pr__cap_mim_m3_1 l=3 w=3
X766 B11 TOP sky130_fd_pr__cap_mim_m3_1 l=3 w=3
X767 B10 TOP sky130_fd_pr__cap_mim_m3_1 l=3 w=3
X768 B11 TOP sky130_fd_pr__cap_mim_m3_1 l=3 w=3
X769 B11 TOP sky130_fd_pr__cap_mim_m3_1 l=3 w=3
X770 B11 TOP sky130_fd_pr__cap_mim_m3_1 l=3 w=3
X771 EDGE_BIAS EDGE_BIAS sky130_fd_pr__cap_mim_m3_1 l=3 w=3
X772 B11 TOP sky130_fd_pr__cap_mim_m3_1 l=3 w=3
X773 B11 TOP sky130_fd_pr__cap_mim_m3_1 l=3 w=3
X774 EDGE_BIAS EDGE_BIAS sky130_fd_pr__cap_mim_m3_1 l=3 w=3
X775 B11 TOP sky130_fd_pr__cap_mim_m3_1 l=3 w=3
X776 B10 TOP sky130_fd_pr__cap_mim_m3_1 l=3 w=3
X777 B10 TOP sky130_fd_pr__cap_mim_m3_1 l=3 w=3
X778 B11 TOP sky130_fd_pr__cap_mim_m3_1 l=3 w=3
X779 B11 TOP sky130_fd_pr__cap_mim_m3_1 l=3 w=3
X780 B8 TOP sky130_fd_pr__cap_mim_m3_1 l=3 w=3
X781 B11 TOP sky130_fd_pr__cap_mim_m3_1 l=3 w=3
X782 B10 TOP sky130_fd_pr__cap_mim_m3_1 l=3 w=3
X783 B9 TOP sky130_fd_pr__cap_mim_m3_1 l=3 w=3
X784 B11 TOP sky130_fd_pr__cap_mim_m3_1 l=3 w=3
X785 B11 TOP sky130_fd_pr__cap_mim_m3_1 l=3 w=3
X786 B11 TOP sky130_fd_pr__cap_mim_m3_1 l=3 w=3
X787 B7 TOP sky130_fd_pr__cap_mim_m3_1 l=3 w=3
X788 B7 TOP sky130_fd_pr__cap_mim_m3_1 l=3 w=3
X789 B11 TOP sky130_fd_pr__cap_mim_m3_1 l=3 w=3
X790 B11 TOP sky130_fd_pr__cap_mim_m3_1 l=3 w=3
X791 B10 TOP sky130_fd_pr__cap_mim_m3_1 l=3 w=3
X792 B11 TOP sky130_fd_pr__cap_mim_m3_1 l=3 w=3
X793 B11 TOP sky130_fd_pr__cap_mim_m3_1 l=3 w=3
X794 B11 TOP sky130_fd_pr__cap_mim_m3_1 l=3 w=3
X795 B11 TOP sky130_fd_pr__cap_mim_m3_1 l=3 w=3
X796 B11 TOP sky130_fd_pr__cap_mim_m3_1 l=3 w=3
X797 B11 TOP sky130_fd_pr__cap_mim_m3_1 l=3 w=3
X798 B11 TOP sky130_fd_pr__cap_mim_m3_1 l=3 w=3
X799 B11 TOP sky130_fd_pr__cap_mim_m3_1 l=3 w=3
X800 B11 TOP sky130_fd_pr__cap_mim_m3_1 l=3 w=3
X801 B10 TOP sky130_fd_pr__cap_mim_m3_1 l=3 w=3
X802 B10 TOP sky130_fd_pr__cap_mim_m3_1 l=3 w=3
X803 B9 TOP sky130_fd_pr__cap_mim_m3_1 l=3 w=3
X804 B10 TOP sky130_fd_pr__cap_mim_m3_1 l=3 w=3
X805 B11 TOP sky130_fd_pr__cap_mim_m3_1 l=3 w=3
X806 B8 TOP sky130_fd_pr__cap_mim_m3_1 l=3 w=3
X807 B10 TOP sky130_fd_pr__cap_mim_m3_1 l=3 w=3
X808 B11 TOP sky130_fd_pr__cap_mim_m3_1 l=3 w=3
X809 B10 TOP sky130_fd_pr__cap_mim_m3_1 l=3 w=3
X810 B9 TOP sky130_fd_pr__cap_mim_m3_1 l=3 w=3
X811 B10 TOP sky130_fd_pr__cap_mim_m3_1 l=3 w=3
X812 B11 TOP sky130_fd_pr__cap_mim_m3_1 l=3 w=3
X813 B10 TOP sky130_fd_pr__cap_mim_m3_1 l=3 w=3
X814 B9 TOP sky130_fd_pr__cap_mim_m3_1 l=3 w=3
X815 B11 TOP sky130_fd_pr__cap_mim_m3_1 l=3 w=3
X816 B11 TOP sky130_fd_pr__cap_mim_m3_1 l=3 w=3
X817 EDGE_BIAS EDGE_BIAS sky130_fd_pr__cap_mim_m3_1 l=3 w=3
X818 B11 TOP sky130_fd_pr__cap_mim_m3_1 l=3 w=3
X819 B11 TOP sky130_fd_pr__cap_mim_m3_1 l=3 w=3
X820 B11 TOP sky130_fd_pr__cap_mim_m3_1 l=3 w=3
X821 B10 TOP sky130_fd_pr__cap_mim_m3_1 l=3 w=3
X822 B11 TOP sky130_fd_pr__cap_mim_m3_1 l=3 w=3
X823 B11 TOP sky130_fd_pr__cap_mim_m3_1 l=3 w=3
X824 B11 TOP sky130_fd_pr__cap_mim_m3_1 l=3 w=3
X825 B8 TOP sky130_fd_pr__cap_mim_m3_1 l=3 w=3
X826 EDGE_BIAS EDGE_BIAS sky130_fd_pr__cap_mim_m3_1 l=3 w=3
X827 B11 TOP sky130_fd_pr__cap_mim_m3_1 l=3 w=3
X828 B11 TOP sky130_fd_pr__cap_mim_m3_1 l=3 w=3
X829 B7 TOP sky130_fd_pr__cap_mim_m3_1 l=3 w=3
X830 B11 TOP sky130_fd_pr__cap_mim_m3_1 l=3 w=3
X831 B7 TOP sky130_fd_pr__cap_mim_m3_1 l=3 w=3
X832 B11 TOP sky130_fd_pr__cap_mim_m3_1 l=3 w=3
X833 B11 TOP sky130_fd_pr__cap_mim_m3_1 l=3 w=3
X834 B9 TOP sky130_fd_pr__cap_mim_m3_1 l=3 w=3
X835 B11 TOP sky130_fd_pr__cap_mim_m3_1 l=3 w=3
X836 B8 TOP sky130_fd_pr__cap_mim_m3_1 l=3 w=3
X837 B11 TOP sky130_fd_pr__cap_mim_m3_1 l=3 w=3
X838 B11 TOP sky130_fd_pr__cap_mim_m3_1 l=3 w=3
X839 B10 TOP sky130_fd_pr__cap_mim_m3_1 l=3 w=3
X840 B9 TOP sky130_fd_pr__cap_mim_m3_1 l=3 w=3
X841 B11 TOP sky130_fd_pr__cap_mim_m3_1 l=3 w=3
X842 B11 TOP sky130_fd_pr__cap_mim_m3_1 l=3 w=3
X843 EDGE_BIAS EDGE_BIAS sky130_fd_pr__cap_mim_m3_1 l=3 w=3
X844 B11 TOP sky130_fd_pr__cap_mim_m3_1 l=3 w=3
X845 B11 TOP sky130_fd_pr__cap_mim_m3_1 l=3 w=3
X846 B11 TOP sky130_fd_pr__cap_mim_m3_1 l=3 w=3
X847 B10 TOP sky130_fd_pr__cap_mim_m3_1 l=3 w=3
X848 B9 TOP sky130_fd_pr__cap_mim_m3_1 l=3 w=3
X849 B11 TOP sky130_fd_pr__cap_mim_m3_1 l=3 w=3
X850 B9 TOP sky130_fd_pr__cap_mim_m3_1 l=3 w=3
X851 B11 TOP sky130_fd_pr__cap_mim_m3_1 l=3 w=3
X852 B11 TOP sky130_fd_pr__cap_mim_m3_1 l=3 w=3
X853 B11 TOP sky130_fd_pr__cap_mim_m3_1 l=3 w=3
X854 B8 TOP sky130_fd_pr__cap_mim_m3_1 l=3 w=3
X855 B11 TOP sky130_fd_pr__cap_mim_m3_1 l=3 w=3
X856 B9 TOP sky130_fd_pr__cap_mim_m3_1 l=3 w=3
X857 B11 TOP sky130_fd_pr__cap_mim_m3_1 l=3 w=3
X858 B10 TOP sky130_fd_pr__cap_mim_m3_1 l=3 w=3
X859 B11 TOP sky130_fd_pr__cap_mim_m3_1 l=3 w=3
X860 B9 TOP sky130_fd_pr__cap_mim_m3_1 l=3 w=3
X861 EDGE_BIAS EDGE_BIAS sky130_fd_pr__cap_mim_m3_1 l=3 w=3
X862 B11 TOP sky130_fd_pr__cap_mim_m3_1 l=3 w=3
X863 B11 TOP sky130_fd_pr__cap_mim_m3_1 l=3 w=3
X864 B11 TOP sky130_fd_pr__cap_mim_m3_1 l=3 w=3
X865 B11 TOP sky130_fd_pr__cap_mim_m3_1 l=3 w=3
X866 B11 TOP sky130_fd_pr__cap_mim_m3_1 l=3 w=3
X867 B10 TOP sky130_fd_pr__cap_mim_m3_1 l=3 w=3
X868 B11 TOP sky130_fd_pr__cap_mim_m3_1 l=3 w=3
X869 B11 TOP sky130_fd_pr__cap_mim_m3_1 l=3 w=3
X870 B11 TOP sky130_fd_pr__cap_mim_m3_1 l=3 w=3
X871 B11 TOP sky130_fd_pr__cap_mim_m3_1 l=3 w=3
X872 B10 TOP sky130_fd_pr__cap_mim_m3_1 l=3 w=3
X873 B9 TOP sky130_fd_pr__cap_mim_m3_1 l=3 w=3
X874 B11 TOP sky130_fd_pr__cap_mim_m3_1 l=3 w=3
X875 B7 TOP sky130_fd_pr__cap_mim_m3_1 l=3 w=3
X876 B10 TOP sky130_fd_pr__cap_mim_m3_1 l=3 w=3
X877 B11 TOP sky130_fd_pr__cap_mim_m3_1 l=3 w=3
X878 B11 TOP sky130_fd_pr__cap_mim_m3_1 l=3 w=3
X879 B10 TOP sky130_fd_pr__cap_mim_m3_1 l=3 w=3
X880 B11 TOP sky130_fd_pr__cap_mim_m3_1 l=3 w=3
X881 B10 TOP sky130_fd_pr__cap_mim_m3_1 l=3 w=3
X882 B11 TOP sky130_fd_pr__cap_mim_m3_1 l=3 w=3
X883 B11 TOP sky130_fd_pr__cap_mim_m3_1 l=3 w=3
X884 B11 TOP sky130_fd_pr__cap_mim_m3_1 l=3 w=3
X885 B11 TOP sky130_fd_pr__cap_mim_m3_1 l=3 w=3
X886 B11 TOP sky130_fd_pr__cap_mim_m3_1 l=3 w=3
X887 B11 TOP sky130_fd_pr__cap_mim_m3_1 l=3 w=3
X888 B11 TOP sky130_fd_pr__cap_mim_m3_1 l=3 w=3
X889 B11 TOP sky130_fd_pr__cap_mim_m3_1 l=3 w=3
X890 EDGE_BIAS EDGE_BIAS sky130_fd_pr__cap_mim_m3_1 l=3 w=3
X891 B10 TOP sky130_fd_pr__cap_mim_m3_1 l=3 w=3
X892 EDGE_BIAS EDGE_BIAS sky130_fd_pr__cap_mim_m3_1 l=3 w=3
X893 B10 TOP sky130_fd_pr__cap_mim_m3_1 l=3 w=3
X894 B11 TOP sky130_fd_pr__cap_mim_m3_1 l=3 w=3
X895 B8 TOP sky130_fd_pr__cap_mim_m3_1 l=3 w=3
X896 B11 TOP sky130_fd_pr__cap_mim_m3_1 l=3 w=3
X897 B11 TOP sky130_fd_pr__cap_mim_m3_1 l=3 w=3
X898 B9 TOP sky130_fd_pr__cap_mim_m3_1 l=3 w=3
X899 B10 TOP sky130_fd_pr__cap_mim_m3_1 l=3 w=3
X900 B11 TOP sky130_fd_pr__cap_mim_m3_1 l=3 w=3
X901 B10 TOP sky130_fd_pr__cap_mim_m3_1 l=3 w=3
X902 B11 TOP sky130_fd_pr__cap_mim_m3_1 l=3 w=3
X903 B11 TOP sky130_fd_pr__cap_mim_m3_1 l=3 w=3
X904 B11 TOP sky130_fd_pr__cap_mim_m3_1 l=3 w=3
X905 B11 TOP sky130_fd_pr__cap_mim_m3_1 l=3 w=3
X906 EDGE_BIAS EDGE_BIAS sky130_fd_pr__cap_mim_m3_1 l=3 w=3
X907 EDGE_BIAS EDGE_BIAS sky130_fd_pr__cap_mim_m3_1 l=3 w=3
X908 B11 TOP sky130_fd_pr__cap_mim_m3_1 l=3 w=3
X909 B10 TOP sky130_fd_pr__cap_mim_m3_1 l=3 w=3
X910 B11 TOP sky130_fd_pr__cap_mim_m3_1 l=3 w=3
X911 B10 TOP sky130_fd_pr__cap_mim_m3_1 l=3 w=3
X912 B9 TOP sky130_fd_pr__cap_mim_m3_1 l=3 w=3
X913 B9 TOP sky130_fd_pr__cap_mim_m3_1 l=3 w=3
X914 B10 TOP sky130_fd_pr__cap_mim_m3_1 l=3 w=3
X915 B11 TOP sky130_fd_pr__cap_mim_m3_1 l=3 w=3
X916 B11 TOP sky130_fd_pr__cap_mim_m3_1 l=3 w=3
X917 B11 TOP sky130_fd_pr__cap_mim_m3_1 l=3 w=3
X918 B11 TOP sky130_fd_pr__cap_mim_m3_1 l=3 w=3
X919 B10 TOP sky130_fd_pr__cap_mim_m3_1 l=3 w=3
X920 B11 TOP sky130_fd_pr__cap_mim_m3_1 l=3 w=3
X921 B11 TOP sky130_fd_pr__cap_mim_m3_1 l=3 w=3
X922 B11 TOP sky130_fd_pr__cap_mim_m3_1 l=3 w=3
X923 B11 TOP sky130_fd_pr__cap_mim_m3_1 l=3 w=3
X924 B7 TOP sky130_fd_pr__cap_mim_m3_1 l=3 w=3
X925 B11 TOP sky130_fd_pr__cap_mim_m3_1 l=3 w=3
X926 B10 TOP sky130_fd_pr__cap_mim_m3_1 l=3 w=3
X927 B11 TOP sky130_fd_pr__cap_mim_m3_1 l=3 w=3
X928 B11 TOP sky130_fd_pr__cap_mim_m3_1 l=3 w=3
X929 B10 TOP sky130_fd_pr__cap_mim_m3_1 l=3 w=3
X930 EDGE_BIAS EDGE_BIAS sky130_fd_pr__cap_mim_m3_1 l=3 w=3
X931 B11 TOP sky130_fd_pr__cap_mim_m3_1 l=3 w=3
X932 B11 TOP sky130_fd_pr__cap_mim_m3_1 l=3 w=3
X933 B11 TOP sky130_fd_pr__cap_mim_m3_1 l=3 w=3
X934 B11 TOP sky130_fd_pr__cap_mim_m3_1 l=3 w=3
X935 B7 TOP sky130_fd_pr__cap_mim_m3_1 l=3 w=3
X936 EDGE_BIAS EDGE_BIAS sky130_fd_pr__cap_mim_m3_1 l=3 w=3
X937 B11 TOP sky130_fd_pr__cap_mim_m3_1 l=3 w=3
X938 B10 TOP sky130_fd_pr__cap_mim_m3_1 l=3 w=3
X939 B8 TOP sky130_fd_pr__cap_mim_m3_1 l=3 w=3
X940 B11 TOP sky130_fd_pr__cap_mim_m3_1 l=3 w=3
X941 B9 TOP sky130_fd_pr__cap_mim_m3_1 l=3 w=3
X942 B10 TOP sky130_fd_pr__cap_mim_m3_1 l=3 w=3
X943 B10 TOP sky130_fd_pr__cap_mim_m3_1 l=3 w=3
X944 B8 TOP sky130_fd_pr__cap_mim_m3_1 l=3 w=3
X945 B11 TOP sky130_fd_pr__cap_mim_m3_1 l=3 w=3
X946 B11 TOP sky130_fd_pr__cap_mim_m3_1 l=3 w=3
X947 B9 TOP sky130_fd_pr__cap_mim_m3_1 l=3 w=3
X948 B11 TOP sky130_fd_pr__cap_mim_m3_1 l=3 w=3
X949 B11 TOP sky130_fd_pr__cap_mim_m3_1 l=3 w=3
X950 B9 TOP sky130_fd_pr__cap_mim_m3_1 l=3 w=3
X951 EDGE_BIAS EDGE_BIAS sky130_fd_pr__cap_mim_m3_1 l=3 w=3
X952 B11 TOP sky130_fd_pr__cap_mim_m3_1 l=3 w=3
X953 B11 TOP sky130_fd_pr__cap_mim_m3_1 l=3 w=3
X954 B11 TOP sky130_fd_pr__cap_mim_m3_1 l=3 w=3
X955 B10 TOP sky130_fd_pr__cap_mim_m3_1 l=3 w=3
X956 B11 TOP sky130_fd_pr__cap_mim_m3_1 l=3 w=3
X957 B11 TOP sky130_fd_pr__cap_mim_m3_1 l=3 w=3
X958 B2 TOP sky130_fd_pr__cap_mim_m3_1 l=3 w=3
X959 B11 TOP sky130_fd_pr__cap_mim_m3_1 l=3 w=3
X960 B11 TOP sky130_fd_pr__cap_mim_m3_1 l=3 w=3
X961 B10 TOP sky130_fd_pr__cap_mim_m3_1 l=3 w=3
X962 B11 TOP sky130_fd_pr__cap_mim_m3_1 l=3 w=3
X963 B11 TOP sky130_fd_pr__cap_mim_m3_1 l=3 w=3
X964 B7 TOP sky130_fd_pr__cap_mim_m3_1 l=3 w=3
X965 B11 TOP sky130_fd_pr__cap_mim_m3_1 l=3 w=3
X966 EDGE_BIAS EDGE_BIAS sky130_fd_pr__cap_mim_m3_1 l=3 w=3
X967 B7 TOP sky130_fd_pr__cap_mim_m3_1 l=3 w=3
X968 B9 TOP sky130_fd_pr__cap_mim_m3_1 l=3 w=3
X969 B11 TOP sky130_fd_pr__cap_mim_m3_1 l=3 w=3
X970 B11 TOP sky130_fd_pr__cap_mim_m3_1 l=3 w=3
X971 B8 TOP sky130_fd_pr__cap_mim_m3_1 l=3 w=3
X972 B11 TOP sky130_fd_pr__cap_mim_m3_1 l=3 w=3
X973 B11 TOP sky130_fd_pr__cap_mim_m3_1 l=3 w=3
X974 B11 TOP sky130_fd_pr__cap_mim_m3_1 l=3 w=3
X975 B11 TOP sky130_fd_pr__cap_mim_m3_1 l=3 w=3
X976 B11 TOP sky130_fd_pr__cap_mim_m3_1 l=3 w=3
X977 B10 TOP sky130_fd_pr__cap_mim_m3_1 l=3 w=3
X978 B10 TOP sky130_fd_pr__cap_mim_m3_1 l=3 w=3
X979 B11 TOP sky130_fd_pr__cap_mim_m3_1 l=3 w=3
X980 B8 TOP sky130_fd_pr__cap_mim_m3_1 l=3 w=3
X981 B11 TOP sky130_fd_pr__cap_mim_m3_1 l=3 w=3
X982 B11 TOP sky130_fd_pr__cap_mim_m3_1 l=3 w=3
X983 B11 TOP sky130_fd_pr__cap_mim_m3_1 l=3 w=3
X984 B9 TOP sky130_fd_pr__cap_mim_m3_1 l=3 w=3
X985 B11 TOP sky130_fd_pr__cap_mim_m3_1 l=3 w=3
X986 B11 TOP sky130_fd_pr__cap_mim_m3_1 l=3 w=3
X987 B6 TOP sky130_fd_pr__cap_mim_m3_1 l=3 w=3
X988 B11 TOP sky130_fd_pr__cap_mim_m3_1 l=3 w=3
X989 B10 TOP sky130_fd_pr__cap_mim_m3_1 l=3 w=3
X990 B11 TOP sky130_fd_pr__cap_mim_m3_1 l=3 w=3
X991 B11 TOP sky130_fd_pr__cap_mim_m3_1 l=3 w=3
X992 B10 TOP sky130_fd_pr__cap_mim_m3_1 l=3 w=3
X993 B9 TOP sky130_fd_pr__cap_mim_m3_1 l=3 w=3
X994 B11 TOP sky130_fd_pr__cap_mim_m3_1 l=3 w=3
X995 B11 TOP sky130_fd_pr__cap_mim_m3_1 l=3 w=3
X996 B11 TOP sky130_fd_pr__cap_mim_m3_1 l=3 w=3
X997 B11 TOP sky130_fd_pr__cap_mim_m3_1 l=3 w=3
X998 B10 TOP sky130_fd_pr__cap_mim_m3_1 l=3 w=3
X999 B11 TOP sky130_fd_pr__cap_mim_m3_1 l=3 w=3
X1000 EDGE_BIAS EDGE_BIAS sky130_fd_pr__cap_mim_m3_1 l=3 w=3
X1001 B9 TOP sky130_fd_pr__cap_mim_m3_1 l=3 w=3
X1002 B11 TOP sky130_fd_pr__cap_mim_m3_1 l=3 w=3
X1003 B11 TOP sky130_fd_pr__cap_mim_m3_1 l=3 w=3
X1004 B10 TOP sky130_fd_pr__cap_mim_m3_1 l=3 w=3
X1005 B11 TOP sky130_fd_pr__cap_mim_m3_1 l=3 w=3
X1006 B7 TOP sky130_fd_pr__cap_mim_m3_1 l=3 w=3
X1007 B11 TOP sky130_fd_pr__cap_mim_m3_1 l=3 w=3
X1008 B10 TOP sky130_fd_pr__cap_mim_m3_1 l=3 w=3
X1009 B10 TOP sky130_fd_pr__cap_mim_m3_1 l=3 w=3
X1010 B11 TOP sky130_fd_pr__cap_mim_m3_1 l=3 w=3
X1011 B10 TOP sky130_fd_pr__cap_mim_m3_1 l=3 w=3
X1012 B11 TOP sky130_fd_pr__cap_mim_m3_1 l=3 w=3
X1013 B11 TOP sky130_fd_pr__cap_mim_m3_1 l=3 w=3
X1014 B11 TOP sky130_fd_pr__cap_mim_m3_1 l=3 w=3
X1015 B11 TOP sky130_fd_pr__cap_mim_m3_1 l=3 w=3
X1016 B10 TOP sky130_fd_pr__cap_mim_m3_1 l=3 w=3
X1017 B11 TOP sky130_fd_pr__cap_mim_m3_1 l=3 w=3
X1018 B11 TOP sky130_fd_pr__cap_mim_m3_1 l=3 w=3
X1019 B11 TOP sky130_fd_pr__cap_mim_m3_1 l=3 w=3
X1020 B10 TOP sky130_fd_pr__cap_mim_m3_1 l=3 w=3
X1021 B11 TOP sky130_fd_pr__cap_mim_m3_1 l=3 w=3
X1022 B11 TOP sky130_fd_pr__cap_mim_m3_1 l=3 w=3
X1023 EDGE_BIAS EDGE_BIAS sky130_fd_pr__cap_mim_m3_1 l=3 w=3
X1024 EDGE_BIAS EDGE_BIAS sky130_fd_pr__cap_mim_m3_1 l=3 w=3
X1025 B11 TOP sky130_fd_pr__cap_mim_m3_1 l=3 w=3
X1026 B10 TOP sky130_fd_pr__cap_mim_m3_1 l=3 w=3
X1027 B11 TOP sky130_fd_pr__cap_mim_m3_1 l=3 w=3
X1028 B8 TOP sky130_fd_pr__cap_mim_m3_1 l=3 w=3
X1029 B11 TOP sky130_fd_pr__cap_mim_m3_1 l=3 w=3
X1030 B11 TOP sky130_fd_pr__cap_mim_m3_1 l=3 w=3
X1031 B9 TOP sky130_fd_pr__cap_mim_m3_1 l=3 w=3
X1032 B10 TOP sky130_fd_pr__cap_mim_m3_1 l=3 w=3
X1033 B11 TOP sky130_fd_pr__cap_mim_m3_1 l=3 w=3
X1034 B11 TOP sky130_fd_pr__cap_mim_m3_1 l=3 w=3
X1035 B6 TOP sky130_fd_pr__cap_mim_m3_1 l=3 w=3
X1036 B11 TOP sky130_fd_pr__cap_mim_m3_1 l=3 w=3
X1037 B11 TOP sky130_fd_pr__cap_mim_m3_1 l=3 w=3
X1038 B9 TOP sky130_fd_pr__cap_mim_m3_1 l=3 w=3
X1039 B11 TOP sky130_fd_pr__cap_mim_m3_1 l=3 w=3
X1040 EDGE_BIAS EDGE_BIAS sky130_fd_pr__cap_mim_m3_1 l=3 w=3
X1041 B11 TOP sky130_fd_pr__cap_mim_m3_1 l=3 w=3
X1042 B11 TOP sky130_fd_pr__cap_mim_m3_1 l=3 w=3
X1043 B8 TOP sky130_fd_pr__cap_mim_m3_1 l=3 w=3
X1044 B11 TOP sky130_fd_pr__cap_mim_m3_1 l=3 w=3
X1045 B8 TOP sky130_fd_pr__cap_mim_m3_1 l=3 w=3
X1046 B11 TOP sky130_fd_pr__cap_mim_m3_1 l=3 w=3
X1047 B11 TOP sky130_fd_pr__cap_mim_m3_1 l=3 w=3
X1048 EDGE_BIAS EDGE_BIAS sky130_fd_pr__cap_mim_m3_1 l=3 w=3
X1049 B11 TOP sky130_fd_pr__cap_mim_m3_1 l=3 w=3
X1050 B11 TOP sky130_fd_pr__cap_mim_m3_1 l=3 w=3
X1051 B11 TOP sky130_fd_pr__cap_mim_m3_1 l=3 w=3
X1052 B10 TOP sky130_fd_pr__cap_mim_m3_1 l=3 w=3
X1053 B11 TOP sky130_fd_pr__cap_mim_m3_1 l=3 w=3
X1054 B7 TOP sky130_fd_pr__cap_mim_m3_1 l=3 w=3
X1055 B10 TOP sky130_fd_pr__cap_mim_m3_1 l=3 w=3
X1056 B10 TOP sky130_fd_pr__cap_mim_m3_1 l=3 w=3
X1057 EDGE_BIAS EDGE_BIAS sky130_fd_pr__cap_mim_m3_1 l=3 w=3
X1058 B11 TOP sky130_fd_pr__cap_mim_m3_1 l=3 w=3
X1059 B10 TOP sky130_fd_pr__cap_mim_m3_1 l=3 w=3
X1060 B10 TOP sky130_fd_pr__cap_mim_m3_1 l=3 w=3
X1061 B8 TOP sky130_fd_pr__cap_mim_m3_1 l=3 w=3
X1062 B11 TOP sky130_fd_pr__cap_mim_m3_1 l=3 w=3
X1063 B10 TOP sky130_fd_pr__cap_mim_m3_1 l=3 w=3
X1064 B11 TOP sky130_fd_pr__cap_mim_m3_1 l=3 w=3
X1065 B11 TOP sky130_fd_pr__cap_mim_m3_1 l=3 w=3
X1066 B11 TOP sky130_fd_pr__cap_mim_m3_1 l=3 w=3
X1067 B9 TOP sky130_fd_pr__cap_mim_m3_1 l=3 w=3
X1068 EDGE_BIAS EDGE_BIAS sky130_fd_pr__cap_mim_m3_1 l=3 w=3
X1069 B11 TOP sky130_fd_pr__cap_mim_m3_1 l=3 w=3
X1070 B8 TOP sky130_fd_pr__cap_mim_m3_1 l=3 w=3
X1071 B11 TOP sky130_fd_pr__cap_mim_m3_1 l=3 w=3
X1072 B9 TOP sky130_fd_pr__cap_mim_m3_1 l=3 w=3
X1073 B8 TOP sky130_fd_pr__cap_mim_m3_1 l=3 w=3
X1074 B11 TOP sky130_fd_pr__cap_mim_m3_1 l=3 w=3
X1075 B10 TOP sky130_fd_pr__cap_mim_m3_1 l=3 w=3
X1076 B11 TOP sky130_fd_pr__cap_mim_m3_1 l=3 w=3
X1077 B10 TOP sky130_fd_pr__cap_mim_m3_1 l=3 w=3
X1078 B9 TOP sky130_fd_pr__cap_mim_m3_1 l=3 w=3
X1079 B11 TOP sky130_fd_pr__cap_mim_m3_1 l=3 w=3
X1080 B11 TOP sky130_fd_pr__cap_mim_m3_1 l=3 w=3
X1081 B11 TOP sky130_fd_pr__cap_mim_m3_1 l=3 w=3
X1082 B11 TOP sky130_fd_pr__cap_mim_m3_1 l=3 w=3
X1083 EDGE_BIAS EDGE_BIAS sky130_fd_pr__cap_mim_m3_1 l=3 w=3
X1084 B11 TOP sky130_fd_pr__cap_mim_m3_1 l=3 w=3
X1085 B11 TOP sky130_fd_pr__cap_mim_m3_1 l=3 w=3
X1086 B11 TOP sky130_fd_pr__cap_mim_m3_1 l=3 w=3
X1087 B10 TOP sky130_fd_pr__cap_mim_m3_1 l=3 w=3
X1088 B9 TOP sky130_fd_pr__cap_mim_m3_1 l=3 w=3
X1089 EDGE_BIAS EDGE_BIAS sky130_fd_pr__cap_mim_m3_1 l=3 w=3
X1090 B11 TOP sky130_fd_pr__cap_mim_m3_1 l=3 w=3
X1091 B11 TOP sky130_fd_pr__cap_mim_m3_1 l=3 w=3
X1092 B11 TOP sky130_fd_pr__cap_mim_m3_1 l=3 w=3
X1093 B10 TOP sky130_fd_pr__cap_mim_m3_1 l=3 w=3
X1094 B11 TOP sky130_fd_pr__cap_mim_m3_1 l=3 w=3
X1095 B11 TOP sky130_fd_pr__cap_mim_m3_1 l=3 w=3
X1096 B9 TOP sky130_fd_pr__cap_mim_m3_1 l=3 w=3
X1097 B7 TOP sky130_fd_pr__cap_mim_m3_1 l=3 w=3
X1098 B11 TOP sky130_fd_pr__cap_mim_m3_1 l=3 w=3
X1099 B11 TOP sky130_fd_pr__cap_mim_m3_1 l=3 w=3
X1100 B9 TOP sky130_fd_pr__cap_mim_m3_1 l=3 w=3
X1101 B8 TOP sky130_fd_pr__cap_mim_m3_1 l=3 w=3
X1102 B11 TOP sky130_fd_pr__cap_mim_m3_1 l=3 w=3
X1103 B11 TOP sky130_fd_pr__cap_mim_m3_1 l=3 w=3
X1104 B11 TOP sky130_fd_pr__cap_mim_m3_1 l=3 w=3
X1105 B11 TOP sky130_fd_pr__cap_mim_m3_1 l=3 w=3
X1106 B11 TOP sky130_fd_pr__cap_mim_m3_1 l=3 w=3
X1107 B6 TOP sky130_fd_pr__cap_mim_m3_1 l=3 w=3
X1108 B10 TOP sky130_fd_pr__cap_mim_m3_1 l=3 w=3
X1109 EDGE_BIAS EDGE_BIAS sky130_fd_pr__cap_mim_m3_1 l=3 w=3
X1110 B11 TOP sky130_fd_pr__cap_mim_m3_1 l=3 w=3
X1111 EDGE_BIAS EDGE_BIAS sky130_fd_pr__cap_mim_m3_1 l=3 w=3
X1112 EDGE_BIAS EDGE_BIAS sky130_fd_pr__cap_mim_m3_1 l=3 w=3
X1113 B11 TOP sky130_fd_pr__cap_mim_m3_1 l=3 w=3
X1114 B8 TOP sky130_fd_pr__cap_mim_m3_1 l=3 w=3
X1115 B11 TOP sky130_fd_pr__cap_mim_m3_1 l=3 w=3
X1116 B9 TOP sky130_fd_pr__cap_mim_m3_1 l=3 w=3
X1117 B11 TOP sky130_fd_pr__cap_mim_m3_1 l=3 w=3
X1118 B10 TOP sky130_fd_pr__cap_mim_m3_1 l=3 w=3
X1119 B11 TOP sky130_fd_pr__cap_mim_m3_1 l=3 w=3
X1120 B11 TOP sky130_fd_pr__cap_mim_m3_1 l=3 w=3
X1121 B6 TOP sky130_fd_pr__cap_mim_m3_1 l=3 w=3
X1122 B9 TOP sky130_fd_pr__cap_mim_m3_1 l=3 w=3
X1123 B10 TOP sky130_fd_pr__cap_mim_m3_1 l=3 w=3
X1124 B9 TOP sky130_fd_pr__cap_mim_m3_1 l=3 w=3
X1125 B10 TOP sky130_fd_pr__cap_mim_m3_1 l=3 w=3
X1126 B11 TOP sky130_fd_pr__cap_mim_m3_1 l=3 w=3
X1127 B11 TOP sky130_fd_pr__cap_mim_m3_1 l=3 w=3
X1128 B11 TOP sky130_fd_pr__cap_mim_m3_1 l=3 w=3
X1129 EDGE_BIAS EDGE_BIAS sky130_fd_pr__cap_mim_m3_1 l=3 w=3
X1130 B10 TOP sky130_fd_pr__cap_mim_m3_1 l=3 w=3
X1131 B11 TOP sky130_fd_pr__cap_mim_m3_1 l=3 w=3
X1132 B11 TOP sky130_fd_pr__cap_mim_m3_1 l=3 w=3
X1133 B10 TOP sky130_fd_pr__cap_mim_m3_1 l=3 w=3
X1134 B9 TOP sky130_fd_pr__cap_mim_m3_1 l=3 w=3
X1135 B10 TOP sky130_fd_pr__cap_mim_m3_1 l=3 w=3
X1136 B11 TOP sky130_fd_pr__cap_mim_m3_1 l=3 w=3
X1137 B10 TOP sky130_fd_pr__cap_mim_m3_1 l=3 w=3
X1138 B11 TOP sky130_fd_pr__cap_mim_m3_1 l=3 w=3
X1139 B11 TOP sky130_fd_pr__cap_mim_m3_1 l=3 w=3
X1140 B10 TOP sky130_fd_pr__cap_mim_m3_1 l=3 w=3
X1141 B11 TOP sky130_fd_pr__cap_mim_m3_1 l=3 w=3
X1142 B10 TOP sky130_fd_pr__cap_mim_m3_1 l=3 w=3
X1143 B11 TOP sky130_fd_pr__cap_mim_m3_1 l=3 w=3
X1144 B10 TOP sky130_fd_pr__cap_mim_m3_1 l=3 w=3
X1145 B11 TOP sky130_fd_pr__cap_mim_m3_1 l=3 w=3
X1146 B10 TOP sky130_fd_pr__cap_mim_m3_1 l=3 w=3
X1147 B11 TOP sky130_fd_pr__cap_mim_m3_1 l=3 w=3
X1148 B11 TOP sky130_fd_pr__cap_mim_m3_1 l=3 w=3
X1149 B11 TOP sky130_fd_pr__cap_mim_m3_1 l=3 w=3
X1150 B11 TOP sky130_fd_pr__cap_mim_m3_1 l=3 w=3
X1151 EDGE_BIAS EDGE_BIAS sky130_fd_pr__cap_mim_m3_1 l=3 w=3
X1152 B8 TOP sky130_fd_pr__cap_mim_m3_1 l=3 w=3
X1153 B11 TOP sky130_fd_pr__cap_mim_m3_1 l=3 w=3
X1154 B9 TOP sky130_fd_pr__cap_mim_m3_1 l=3 w=3
X1155 B11 TOP sky130_fd_pr__cap_mim_m3_1 l=3 w=3
X1156 B10 TOP sky130_fd_pr__cap_mim_m3_1 l=3 w=3
X1157 B11 TOP sky130_fd_pr__cap_mim_m3_1 l=3 w=3
X1158 B10 TOP sky130_fd_pr__cap_mim_m3_1 l=3 w=3
X1159 B8 TOP sky130_fd_pr__cap_mim_m3_1 l=3 w=3
X1160 EDGE_BIAS EDGE_BIAS sky130_fd_pr__cap_mim_m3_1 l=3 w=3
X1161 B11 TOP sky130_fd_pr__cap_mim_m3_1 l=3 w=3
X1162 B11 TOP sky130_fd_pr__cap_mim_m3_1 l=3 w=3
X1163 B10 TOP sky130_fd_pr__cap_mim_m3_1 l=3 w=3
X1164 B11 TOP sky130_fd_pr__cap_mim_m3_1 l=3 w=3
X1165 B11 TOP sky130_fd_pr__cap_mim_m3_1 l=3 w=3
X1166 B9 TOP sky130_fd_pr__cap_mim_m3_1 l=3 w=3
X1167 B11 TOP sky130_fd_pr__cap_mim_m3_1 l=3 w=3
X1168 B11 TOP sky130_fd_pr__cap_mim_m3_1 l=3 w=3
X1169 B11 TOP sky130_fd_pr__cap_mim_m3_1 l=3 w=3
X1170 B11 TOP sky130_fd_pr__cap_mim_m3_1 l=3 w=3
X1171 EDGE_BIAS EDGE_BIAS sky130_fd_pr__cap_mim_m3_1 l=3 w=3
X1172 B11 TOP sky130_fd_pr__cap_mim_m3_1 l=3 w=3
X1173 B10 TOP sky130_fd_pr__cap_mim_m3_1 l=3 w=3
X1174 B11 TOP sky130_fd_pr__cap_mim_m3_1 l=3 w=3
X1175 B11 TOP sky130_fd_pr__cap_mim_m3_1 l=3 w=3
X1176 B11 TOP sky130_fd_pr__cap_mim_m3_1 l=3 w=3
X1177 B11 TOP sky130_fd_pr__cap_mim_m3_1 l=3 w=3
X1178 B10 TOP sky130_fd_pr__cap_mim_m3_1 l=3 w=3
X1179 B11 TOP sky130_fd_pr__cap_mim_m3_1 l=3 w=3
X1180 B10 TOP sky130_fd_pr__cap_mim_m3_1 l=3 w=3
X1181 B10 TOP sky130_fd_pr__cap_mim_m3_1 l=3 w=3
X1182 B9 TOP sky130_fd_pr__cap_mim_m3_1 l=3 w=3
X1183 B10 TOP sky130_fd_pr__cap_mim_m3_1 l=3 w=3
X1184 B11 TOP sky130_fd_pr__cap_mim_m3_1 l=3 w=3
X1185 B11 TOP sky130_fd_pr__cap_mim_m3_1 l=3 w=3
X1186 B10 TOP sky130_fd_pr__cap_mim_m3_1 l=3 w=3
X1187 B10 TOP sky130_fd_pr__cap_mim_m3_1 l=3 w=3
X1188 B10 TOP sky130_fd_pr__cap_mim_m3_1 l=3 w=3
X1189 B10 TOP sky130_fd_pr__cap_mim_m3_1 l=3 w=3
X1190 B9 TOP sky130_fd_pr__cap_mim_m3_1 l=3 w=3
X1191 B11 TOP sky130_fd_pr__cap_mim_m3_1 l=3 w=3
X1192 B11 TOP sky130_fd_pr__cap_mim_m3_1 l=3 w=3
X1193 B10 TOP sky130_fd_pr__cap_mim_m3_1 l=3 w=3
X1194 B11 TOP sky130_fd_pr__cap_mim_m3_1 l=3 w=3
X1195 B11 TOP sky130_fd_pr__cap_mim_m3_1 l=3 w=3
X1196 EDGE_BIAS EDGE_BIAS sky130_fd_pr__cap_mim_m3_1 l=3 w=3
X1197 B10 TOP sky130_fd_pr__cap_mim_m3_1 l=3 w=3
X1198 B8 TOP sky130_fd_pr__cap_mim_m3_1 l=3 w=3
X1199 B11 TOP sky130_fd_pr__cap_mim_m3_1 l=3 w=3
X1200 B11 TOP sky130_fd_pr__cap_mim_m3_1 l=3 w=3
X1201 B11 TOP sky130_fd_pr__cap_mim_m3_1 l=3 w=3
X1202 EDGE_BIAS EDGE_BIAS sky130_fd_pr__cap_mim_m3_1 l=3 w=3
X1203 B11 TOP sky130_fd_pr__cap_mim_m3_1 l=3 w=3
X1204 B11 TOP sky130_fd_pr__cap_mim_m3_1 l=3 w=3
X1205 B8 TOP sky130_fd_pr__cap_mim_m3_1 l=3 w=3
X1206 B11 TOP sky130_fd_pr__cap_mim_m3_1 l=3 w=3
X1207 B10 TOP sky130_fd_pr__cap_mim_m3_1 l=3 w=3
X1208 EDGE_BIAS EDGE_BIAS sky130_fd_pr__cap_mim_m3_1 l=3 w=3
X1209 B9 TOP sky130_fd_pr__cap_mim_m3_1 l=3 w=3
X1210 B11 TOP sky130_fd_pr__cap_mim_m3_1 l=3 w=3
X1211 B11 TOP sky130_fd_pr__cap_mim_m3_1 l=3 w=3
X1212 B9 TOP sky130_fd_pr__cap_mim_m3_1 l=3 w=3
X1213 B7 TOP sky130_fd_pr__cap_mim_m3_1 l=3 w=3
X1214 EDGE_BIAS EDGE_BIAS sky130_fd_pr__cap_mim_m3_1 l=3 w=3
X1215 EDGE_BIAS EDGE_BIAS sky130_fd_pr__cap_mim_m3_1 l=3 w=3
X1216 B11 TOP sky130_fd_pr__cap_mim_m3_1 l=3 w=3
X1217 B11 TOP sky130_fd_pr__cap_mim_m3_1 l=3 w=3
X1218 B11 TOP sky130_fd_pr__cap_mim_m3_1 l=3 w=3
X1219 B11 TOP sky130_fd_pr__cap_mim_m3_1 l=3 w=3
X1220 B9 TOP sky130_fd_pr__cap_mim_m3_1 l=3 w=3
X1221 B11 TOP sky130_fd_pr__cap_mim_m3_1 l=3 w=3
X1222 B10 TOP sky130_fd_pr__cap_mim_m3_1 l=3 w=3
X1223 B9 TOP sky130_fd_pr__cap_mim_m3_1 l=3 w=3
X1224 B11 TOP sky130_fd_pr__cap_mim_m3_1 l=3 w=3
X1225 B11 TOP sky130_fd_pr__cap_mim_m3_1 l=3 w=3
X1226 B8 TOP sky130_fd_pr__cap_mim_m3_1 l=3 w=3
X1227 B10 TOP sky130_fd_pr__cap_mim_m3_1 l=3 w=3
X1228 B8 TOP sky130_fd_pr__cap_mim_m3_1 l=3 w=3
X1229 B11 TOP sky130_fd_pr__cap_mim_m3_1 l=3 w=3
X1230 EDGE_BIAS EDGE_BIAS sky130_fd_pr__cap_mim_m3_1 l=3 w=3
X1231 B11 TOP sky130_fd_pr__cap_mim_m3_1 l=3 w=3
X1232 EDGE_BIAS EDGE_BIAS sky130_fd_pr__cap_mim_m3_1 l=3 w=3
X1233 B11 TOP sky130_fd_pr__cap_mim_m3_1 l=3 w=3
X1234 B11 TOP sky130_fd_pr__cap_mim_m3_1 l=3 w=3
X1235 EDGE_BIAS EDGE_BIAS sky130_fd_pr__cap_mim_m3_1 l=3 w=3
X1236 B11 TOP sky130_fd_pr__cap_mim_m3_1 l=3 w=3
X1237 B10 TOP sky130_fd_pr__cap_mim_m3_1 l=3 w=3
X1238 B9 TOP sky130_fd_pr__cap_mim_m3_1 l=3 w=3
X1239 B11 TOP sky130_fd_pr__cap_mim_m3_1 l=3 w=3
X1240 B10 TOP sky130_fd_pr__cap_mim_m3_1 l=3 w=3
X1241 B11 TOP sky130_fd_pr__cap_mim_m3_1 l=3 w=3
X1242 B6 TOP sky130_fd_pr__cap_mim_m3_1 l=3 w=3
X1243 B9 TOP sky130_fd_pr__cap_mim_m3_1 l=3 w=3
X1244 B10 TOP sky130_fd_pr__cap_mim_m3_1 l=3 w=3
X1245 B11 TOP sky130_fd_pr__cap_mim_m3_1 l=3 w=3
X1246 B11 TOP sky130_fd_pr__cap_mim_m3_1 l=3 w=3
X1247 B11 TOP sky130_fd_pr__cap_mim_m3_1 l=3 w=3
X1248 B11 TOP sky130_fd_pr__cap_mim_m3_1 l=3 w=3
X1249 B11 TOP sky130_fd_pr__cap_mim_m3_1 l=3 w=3
X1250 B10 TOP sky130_fd_pr__cap_mim_m3_1 l=3 w=3
X1251 B11 TOP sky130_fd_pr__cap_mim_m3_1 l=3 w=3
X1252 B11 TOP sky130_fd_pr__cap_mim_m3_1 l=3 w=3
X1253 B11 TOP sky130_fd_pr__cap_mim_m3_1 l=3 w=3
X1254 B11 TOP sky130_fd_pr__cap_mim_m3_1 l=3 w=3
X1255 B11 TOP sky130_fd_pr__cap_mim_m3_1 l=3 w=3
X1256 B11 TOP sky130_fd_pr__cap_mim_m3_1 l=3 w=3
X1257 B11 TOP sky130_fd_pr__cap_mim_m3_1 l=3 w=3
X1258 B9 TOP sky130_fd_pr__cap_mim_m3_1 l=3 w=3
X1259 B11 TOP sky130_fd_pr__cap_mim_m3_1 l=3 w=3
X1260 B11 TOP sky130_fd_pr__cap_mim_m3_1 l=3 w=3
X1261 B10 TOP sky130_fd_pr__cap_mim_m3_1 l=3 w=3
X1262 B11 TOP sky130_fd_pr__cap_mim_m3_1 l=3 w=3
X1263 B11 TOP sky130_fd_pr__cap_mim_m3_1 l=3 w=3
X1264 B10 TOP sky130_fd_pr__cap_mim_m3_1 l=3 w=3
X1265 B10 TOP sky130_fd_pr__cap_mim_m3_1 l=3 w=3
X1266 B11 TOP sky130_fd_pr__cap_mim_m3_1 l=3 w=3
X1267 B10 TOP sky130_fd_pr__cap_mim_m3_1 l=3 w=3
X1268 B10 TOP sky130_fd_pr__cap_mim_m3_1 l=3 w=3
X1269 B11 TOP sky130_fd_pr__cap_mim_m3_1 l=3 w=3
X1270 B11 TOP sky130_fd_pr__cap_mim_m3_1 l=3 w=3
X1271 B11 TOP sky130_fd_pr__cap_mim_m3_1 l=3 w=3
X1272 EDGE_BIAS EDGE_BIAS sky130_fd_pr__cap_mim_m3_1 l=3 w=3
X1273 B10 TOP sky130_fd_pr__cap_mim_m3_1 l=3 w=3
X1274 B9 TOP sky130_fd_pr__cap_mim_m3_1 l=3 w=3
X1275 B11 TOP sky130_fd_pr__cap_mim_m3_1 l=3 w=3
X1276 B10 TOP sky130_fd_pr__cap_mim_m3_1 l=3 w=3
X1277 B11 TOP sky130_fd_pr__cap_mim_m3_1 l=3 w=3
X1278 B11 TOP sky130_fd_pr__cap_mim_m3_1 l=3 w=3
X1279 B11 TOP sky130_fd_pr__cap_mim_m3_1 l=3 w=3
X1280 B10 TOP sky130_fd_pr__cap_mim_m3_1 l=3 w=3
X1281 B11 TOP sky130_fd_pr__cap_mim_m3_1 l=3 w=3
X1282 B11 TOP sky130_fd_pr__cap_mim_m3_1 l=3 w=3
X1283 B10 TOP sky130_fd_pr__cap_mim_m3_1 l=3 w=3
X1284 B11 TOP sky130_fd_pr__cap_mim_m3_1 l=3 w=3
X1285 B10 TOP sky130_fd_pr__cap_mim_m3_1 l=3 w=3
X1286 B9 TOP sky130_fd_pr__cap_mim_m3_1 l=3 w=3
X1287 B11 TOP sky130_fd_pr__cap_mim_m3_1 l=3 w=3
X1288 B11 TOP sky130_fd_pr__cap_mim_m3_1 l=3 w=3
X1289 EDGE_BIAS EDGE_BIAS sky130_fd_pr__cap_mim_m3_1 l=3 w=3
X1290 EDGE_BIAS EDGE_BIAS sky130_fd_pr__cap_mim_m3_1 l=3 w=3
X1291 B11 TOP sky130_fd_pr__cap_mim_m3_1 l=3 w=3
X1292 B11 TOP sky130_fd_pr__cap_mim_m3_1 l=3 w=3
X1293 B11 TOP sky130_fd_pr__cap_mim_m3_1 l=3 w=3
X1294 B11 TOP sky130_fd_pr__cap_mim_m3_1 l=3 w=3
X1295 B11 TOP sky130_fd_pr__cap_mim_m3_1 l=3 w=3
X1296 B11 TOP sky130_fd_pr__cap_mim_m3_1 l=3 w=3
X1297 B11 TOP sky130_fd_pr__cap_mim_m3_1 l=3 w=3
X1298 B11 TOP sky130_fd_pr__cap_mim_m3_1 l=3 w=3
X1299 B10 TOP sky130_fd_pr__cap_mim_m3_1 l=3 w=3
X1300 B10 TOP sky130_fd_pr__cap_mim_m3_1 l=3 w=3
X1301 B8 TOP sky130_fd_pr__cap_mim_m3_1 l=3 w=3
X1302 B11 TOP sky130_fd_pr__cap_mim_m3_1 l=3 w=3
X1303 B11 TOP sky130_fd_pr__cap_mim_m3_1 l=3 w=3
X1304 B10 TOP sky130_fd_pr__cap_mim_m3_1 l=3 w=3
X1305 B10 TOP sky130_fd_pr__cap_mim_m3_1 l=3 w=3
X1306 B9 TOP sky130_fd_pr__cap_mim_m3_1 l=3 w=3
X1307 B11 TOP sky130_fd_pr__cap_mim_m3_1 l=3 w=3
X1308 B10 TOP sky130_fd_pr__cap_mim_m3_1 l=3 w=3
X1309 B11 TOP sky130_fd_pr__cap_mim_m3_1 l=3 w=3
X1310 B10 TOP sky130_fd_pr__cap_mim_m3_1 l=3 w=3
X1311 B11 TOP sky130_fd_pr__cap_mim_m3_1 l=3 w=3
X1312 B11 TOP sky130_fd_pr__cap_mim_m3_1 l=3 w=3
X1313 EDGE_BIAS EDGE_BIAS sky130_fd_pr__cap_mim_m3_1 l=3 w=3
X1314 B11 TOP sky130_fd_pr__cap_mim_m3_1 l=3 w=3
X1315 B10 TOP sky130_fd_pr__cap_mim_m3_1 l=3 w=3
X1316 B6 TOP sky130_fd_pr__cap_mim_m3_1 l=3 w=3
X1317 B11 TOP sky130_fd_pr__cap_mim_m3_1 l=3 w=3
X1318 B10 TOP sky130_fd_pr__cap_mim_m3_1 l=3 w=3
X1319 B11 TOP sky130_fd_pr__cap_mim_m3_1 l=3 w=3
X1320 B11 TOP sky130_fd_pr__cap_mim_m3_1 l=3 w=3
X1321 B11 TOP sky130_fd_pr__cap_mim_m3_1 l=3 w=3
X1322 B8 TOP sky130_fd_pr__cap_mim_m3_1 l=3 w=3
X1323 B11 TOP sky130_fd_pr__cap_mim_m3_1 l=3 w=3
X1324 B11 TOP sky130_fd_pr__cap_mim_m3_1 l=3 w=3
X1325 B9 TOP sky130_fd_pr__cap_mim_m3_1 l=3 w=3
X1326 B11 TOP sky130_fd_pr__cap_mim_m3_1 l=3 w=3
X1327 B7 TOP sky130_fd_pr__cap_mim_m3_1 l=3 w=3
X1328 B7 TOP sky130_fd_pr__cap_mim_m3_1 l=3 w=3
X1329 B11 TOP sky130_fd_pr__cap_mim_m3_1 l=3 w=3
X1330 B11 TOP sky130_fd_pr__cap_mim_m3_1 l=3 w=3
X1331 B11 TOP sky130_fd_pr__cap_mim_m3_1 l=3 w=3
X1332 B11 TOP sky130_fd_pr__cap_mim_m3_1 l=3 w=3
X1333 B11 TOP sky130_fd_pr__cap_mim_m3_1 l=3 w=3
X1334 B11 TOP sky130_fd_pr__cap_mim_m3_1 l=3 w=3
X1335 B10 TOP sky130_fd_pr__cap_mim_m3_1 l=3 w=3
X1336 B9 TOP sky130_fd_pr__cap_mim_m3_1 l=3 w=3
X1337 B11 TOP sky130_fd_pr__cap_mim_m3_1 l=3 w=3
X1338 B11 TOP sky130_fd_pr__cap_mim_m3_1 l=3 w=3
X1339 B10 TOP sky130_fd_pr__cap_mim_m3_1 l=3 w=3
X1340 B9 TOP sky130_fd_pr__cap_mim_m3_1 l=3 w=3
X1341 B11 TOP sky130_fd_pr__cap_mim_m3_1 l=3 w=3
X1342 B11 TOP sky130_fd_pr__cap_mim_m3_1 l=3 w=3
X1343 B10 TOP sky130_fd_pr__cap_mim_m3_1 l=3 w=3
X1344 B5 TOP sky130_fd_pr__cap_mim_m3_1 l=3 w=3
X1345 B11 TOP sky130_fd_pr__cap_mim_m3_1 l=3 w=3
X1346 EDGE_BIAS EDGE_BIAS sky130_fd_pr__cap_mim_m3_1 l=3 w=3
X1347 B5 TOP sky130_fd_pr__cap_mim_m3_1 l=3 w=3
X1348 B10 TOP sky130_fd_pr__cap_mim_m3_1 l=3 w=3
X1349 B11 TOP sky130_fd_pr__cap_mim_m3_1 l=3 w=3
X1350 B11 TOP sky130_fd_pr__cap_mim_m3_1 l=3 w=3
X1351 B11 TOP sky130_fd_pr__cap_mim_m3_1 l=3 w=3
X1352 B11 TOP sky130_fd_pr__cap_mim_m3_1 l=3 w=3
X1353 B11 TOP sky130_fd_pr__cap_mim_m3_1 l=3 w=3
X1354 B11 TOP sky130_fd_pr__cap_mim_m3_1 l=3 w=3
X1355 B10 TOP sky130_fd_pr__cap_mim_m3_1 l=3 w=3
X1356 B9 TOP sky130_fd_pr__cap_mim_m3_1 l=3 w=3
X1357 B10 TOP sky130_fd_pr__cap_mim_m3_1 l=3 w=3
X1358 B11 TOP sky130_fd_pr__cap_mim_m3_1 l=3 w=3
X1359 B11 TOP sky130_fd_pr__cap_mim_m3_1 l=3 w=3
X1360 B11 TOP sky130_fd_pr__cap_mim_m3_1 l=3 w=3
X1361 B11 TOP sky130_fd_pr__cap_mim_m3_1 l=3 w=3
X1362 B9 TOP sky130_fd_pr__cap_mim_m3_1 l=3 w=3
X1363 B10 TOP sky130_fd_pr__cap_mim_m3_1 l=3 w=3
X1364 B11 TOP sky130_fd_pr__cap_mim_m3_1 l=3 w=3
X1365 B11 TOP sky130_fd_pr__cap_mim_m3_1 l=3 w=3
X1366 B11 TOP sky130_fd_pr__cap_mim_m3_1 l=3 w=3
X1367 B11 TOP sky130_fd_pr__cap_mim_m3_1 l=3 w=3
X1368 B10 TOP sky130_fd_pr__cap_mim_m3_1 l=3 w=3
X1369 B11 TOP sky130_fd_pr__cap_mim_m3_1 l=3 w=3
X1370 B11 TOP sky130_fd_pr__cap_mim_m3_1 l=3 w=3
X1371 B11 TOP sky130_fd_pr__cap_mim_m3_1 l=3 w=3
X1372 B10 TOP sky130_fd_pr__cap_mim_m3_1 l=3 w=3
X1373 EDGE_BIAS EDGE_BIAS sky130_fd_pr__cap_mim_m3_1 l=3 w=3
X1374 B11 TOP sky130_fd_pr__cap_mim_m3_1 l=3 w=3
X1375 B11 TOP sky130_fd_pr__cap_mim_m3_1 l=3 w=3
X1376 B11 TOP sky130_fd_pr__cap_mim_m3_1 l=3 w=3
X1377 B11 TOP sky130_fd_pr__cap_mim_m3_1 l=3 w=3
X1378 B11 TOP sky130_fd_pr__cap_mim_m3_1 l=3 w=3
X1379 B10 TOP sky130_fd_pr__cap_mim_m3_1 l=3 w=3
X1380 B10 TOP sky130_fd_pr__cap_mim_m3_1 l=3 w=3
X1381 B11 TOP sky130_fd_pr__cap_mim_m3_1 l=3 w=3
X1382 B3 TOP sky130_fd_pr__cap_mim_m3_1 l=3 w=3
X1383 B11 TOP sky130_fd_pr__cap_mim_m3_1 l=3 w=3
X1384 B10 TOP sky130_fd_pr__cap_mim_m3_1 l=3 w=3
X1385 B9 TOP sky130_fd_pr__cap_mim_m3_1 l=3 w=3
X1386 B10 TOP sky130_fd_pr__cap_mim_m3_1 l=3 w=3
X1387 B11 TOP sky130_fd_pr__cap_mim_m3_1 l=3 w=3
X1388 EDGE_BIAS EDGE_BIAS sky130_fd_pr__cap_mim_m3_1 l=3 w=3
X1389 B10 TOP sky130_fd_pr__cap_mim_m3_1 l=3 w=3
X1390 B6 TOP sky130_fd_pr__cap_mim_m3_1 l=3 w=3
X1391 B11 TOP sky130_fd_pr__cap_mim_m3_1 l=3 w=3
X1392 B10 TOP sky130_fd_pr__cap_mim_m3_1 l=3 w=3
X1393 B11 TOP sky130_fd_pr__cap_mim_m3_1 l=3 w=3
X1394 B11 TOP sky130_fd_pr__cap_mim_m3_1 l=3 w=3
X1395 EDGE_BIAS EDGE_BIAS sky130_fd_pr__cap_mim_m3_1 l=3 w=3
X1396 B10 TOP sky130_fd_pr__cap_mim_m3_1 l=3 w=3
X1397 B8 TOP sky130_fd_pr__cap_mim_m3_1 l=3 w=3
X1398 B11 TOP sky130_fd_pr__cap_mim_m3_1 l=3 w=3
X1399 B11 TOP sky130_fd_pr__cap_mim_m3_1 l=3 w=3
X1400 B11 TOP sky130_fd_pr__cap_mim_m3_1 l=3 w=3
X1401 B10 TOP sky130_fd_pr__cap_mim_m3_1 l=3 w=3
X1402 B11 TOP sky130_fd_pr__cap_mim_m3_1 l=3 w=3
X1403 B11 TOP sky130_fd_pr__cap_mim_m3_1 l=3 w=3
X1404 B11 TOP sky130_fd_pr__cap_mim_m3_1 l=3 w=3
X1405 B10 TOP sky130_fd_pr__cap_mim_m3_1 l=3 w=3
X1406 B9 TOP sky130_fd_pr__cap_mim_m3_1 l=3 w=3
X1407 B10 TOP sky130_fd_pr__cap_mim_m3_1 l=3 w=3
X1408 B11 TOP sky130_fd_pr__cap_mim_m3_1 l=3 w=3
X1409 B7 TOP sky130_fd_pr__cap_mim_m3_1 l=3 w=3
X1410 B11 TOP sky130_fd_pr__cap_mim_m3_1 l=3 w=3
X1411 B11 TOP sky130_fd_pr__cap_mim_m3_1 l=3 w=3
X1412 B10 TOP sky130_fd_pr__cap_mim_m3_1 l=3 w=3
X1413 B11 TOP sky130_fd_pr__cap_mim_m3_1 l=3 w=3
X1414 B11 TOP sky130_fd_pr__cap_mim_m3_1 l=3 w=3
X1415 B10 TOP sky130_fd_pr__cap_mim_m3_1 l=3 w=3
X1416 B11 TOP sky130_fd_pr__cap_mim_m3_1 l=3 w=3
X1417 B9 TOP sky130_fd_pr__cap_mim_m3_1 l=3 w=3
X1418 B11 TOP sky130_fd_pr__cap_mim_m3_1 l=3 w=3
X1419 B11 TOP sky130_fd_pr__cap_mim_m3_1 l=3 w=3
X1420 B11 TOP sky130_fd_pr__cap_mim_m3_1 l=3 w=3
X1421 B10 TOP sky130_fd_pr__cap_mim_m3_1 l=3 w=3
X1422 B10 TOP sky130_fd_pr__cap_mim_m3_1 l=3 w=3
X1423 EDGE_BIAS EDGE_BIAS sky130_fd_pr__cap_mim_m3_1 l=3 w=3
X1424 EDGE_BIAS EDGE_BIAS sky130_fd_pr__cap_mim_m3_1 l=3 w=3
X1425 B10 TOP sky130_fd_pr__cap_mim_m3_1 l=3 w=3
X1426 B8 TOP sky130_fd_pr__cap_mim_m3_1 l=3 w=3
X1427 B11 TOP sky130_fd_pr__cap_mim_m3_1 l=3 w=3
X1428 B11 TOP sky130_fd_pr__cap_mim_m3_1 l=3 w=3
X1429 B9 TOP sky130_fd_pr__cap_mim_m3_1 l=3 w=3
X1430 B10 TOP sky130_fd_pr__cap_mim_m3_1 l=3 w=3
X1431 B10 TOP sky130_fd_pr__cap_mim_m3_1 l=3 w=3
X1432 B11 TOP sky130_fd_pr__cap_mim_m3_1 l=3 w=3
X1433 B11 TOP sky130_fd_pr__cap_mim_m3_1 l=3 w=3
X1434 B11 TOP sky130_fd_pr__cap_mim_m3_1 l=3 w=3
X1435 B8 TOP sky130_fd_pr__cap_mim_m3_1 l=3 w=3
X1436 EDGE_BIAS EDGE_BIAS sky130_fd_pr__cap_mim_m3_1 l=3 w=3
X1437 B11 TOP sky130_fd_pr__cap_mim_m3_1 l=3 w=3
X1438 B10 TOP sky130_fd_pr__cap_mim_m3_1 l=3 w=3
X1439 B10 TOP sky130_fd_pr__cap_mim_m3_1 l=3 w=3
X1440 B11 TOP sky130_fd_pr__cap_mim_m3_1 l=3 w=3
X1441 B9 TOP sky130_fd_pr__cap_mim_m3_1 l=3 w=3
X1442 B10 TOP sky130_fd_pr__cap_mim_m3_1 l=3 w=3
X1443 B11 TOP sky130_fd_pr__cap_mim_m3_1 l=3 w=3
X1444 B11 TOP sky130_fd_pr__cap_mim_m3_1 l=3 w=3
X1445 B11 TOP sky130_fd_pr__cap_mim_m3_1 l=3 w=3
X1446 B11 TOP sky130_fd_pr__cap_mim_m3_1 l=3 w=3
X1447 B9 TOP sky130_fd_pr__cap_mim_m3_1 l=3 w=3
X1448 B7 TOP sky130_fd_pr__cap_mim_m3_1 l=3 w=3
X1449 B11 TOP sky130_fd_pr__cap_mim_m3_1 l=3 w=3
X1450 B11 TOP sky130_fd_pr__cap_mim_m3_1 l=3 w=3
X1451 B11 TOP sky130_fd_pr__cap_mim_m3_1 l=3 w=3
X1452 B11 TOP sky130_fd_pr__cap_mim_m3_1 l=3 w=3
X1453 B11 TOP sky130_fd_pr__cap_mim_m3_1 l=3 w=3
X1454 B11 TOP sky130_fd_pr__cap_mim_m3_1 l=3 w=3
X1455 EDGE_BIAS EDGE_BIAS sky130_fd_pr__cap_mim_m3_1 l=3 w=3
X1456 B9 TOP sky130_fd_pr__cap_mim_m3_1 l=3 w=3
X1457 B11 TOP sky130_fd_pr__cap_mim_m3_1 l=3 w=3
X1458 B10 TOP sky130_fd_pr__cap_mim_m3_1 l=3 w=3
X1459 B11 TOP sky130_fd_pr__cap_mim_m3_1 l=3 w=3
X1460 B11 TOP sky130_fd_pr__cap_mim_m3_1 l=3 w=3
X1461 B11 TOP sky130_fd_pr__cap_mim_m3_1 l=3 w=3
X1462 B10 TOP sky130_fd_pr__cap_mim_m3_1 l=3 w=3
X1463 B8 TOP sky130_fd_pr__cap_mim_m3_1 l=3 w=3
X1464 EDGE_BIAS EDGE_BIAS sky130_fd_pr__cap_mim_m3_1 l=3 w=3
X1465 B11 TOP sky130_fd_pr__cap_mim_m3_1 l=3 w=3
X1466 B4 TOP sky130_fd_pr__cap_mim_m3_1 l=3 w=3
X1467 B9 TOP sky130_fd_pr__cap_mim_m3_1 l=3 w=3
X1468 B5 TOP sky130_fd_pr__cap_mim_m3_1 l=3 w=3
X1469 B10 TOP sky130_fd_pr__cap_mim_m3_1 l=3 w=3
X1470 B11 TOP sky130_fd_pr__cap_mim_m3_1 l=3 w=3
X1471 B11 TOP sky130_fd_pr__cap_mim_m3_1 l=3 w=3
X1472 B9 TOP sky130_fd_pr__cap_mim_m3_1 l=3 w=3
X1473 B11 TOP sky130_fd_pr__cap_mim_m3_1 l=3 w=3
X1474 B10 TOP sky130_fd_pr__cap_mim_m3_1 l=3 w=3
X1475 B11 TOP sky130_fd_pr__cap_mim_m3_1 l=3 w=3
X1476 B11 TOP sky130_fd_pr__cap_mim_m3_1 l=3 w=3
X1477 B10 TOP sky130_fd_pr__cap_mim_m3_1 l=3 w=3
X1478 B11 TOP sky130_fd_pr__cap_mim_m3_1 l=3 w=3
X1479 B11 TOP sky130_fd_pr__cap_mim_m3_1 l=3 w=3
X1480 B11 TOP sky130_fd_pr__cap_mim_m3_1 l=3 w=3
X1481 B9 TOP sky130_fd_pr__cap_mim_m3_1 l=3 w=3
X1482 B2 TOP sky130_fd_pr__cap_mim_m3_1 l=3 w=3
X1483 B11 TOP sky130_fd_pr__cap_mim_m3_1 l=3 w=3
X1484 B10 TOP sky130_fd_pr__cap_mim_m3_1 l=3 w=3
X1485 B11 TOP sky130_fd_pr__cap_mim_m3_1 l=3 w=3
X1486 B10 TOP sky130_fd_pr__cap_mim_m3_1 l=3 w=3
X1487 B9 TOP sky130_fd_pr__cap_mim_m3_1 l=3 w=3
X1488 B10 TOP sky130_fd_pr__cap_mim_m3_1 l=3 w=3
X1489 EDGE_BIAS EDGE_BIAS sky130_fd_pr__cap_mim_m3_1 l=3 w=3
X1490 B11 TOP sky130_fd_pr__cap_mim_m3_1 l=3 w=3
X1491 B9 TOP sky130_fd_pr__cap_mim_m3_1 l=3 w=3
X1492 B10 TOP sky130_fd_pr__cap_mim_m3_1 l=3 w=3
X1493 B10 TOP sky130_fd_pr__cap_mim_m3_1 l=3 w=3
X1494 B11 TOP sky130_fd_pr__cap_mim_m3_1 l=3 w=3
X1495 B11 TOP sky130_fd_pr__cap_mim_m3_1 l=3 w=3
X1496 B11 TOP sky130_fd_pr__cap_mim_m3_1 l=3 w=3
X1497 B11 TOP sky130_fd_pr__cap_mim_m3_1 l=3 w=3
X1498 B11 TOP sky130_fd_pr__cap_mim_m3_1 l=3 w=3
X1499 B11 TOP sky130_fd_pr__cap_mim_m3_1 l=3 w=3
X1500 B8 TOP sky130_fd_pr__cap_mim_m3_1 l=3 w=3
X1501 B10 TOP sky130_fd_pr__cap_mim_m3_1 l=3 w=3
X1502 B11 TOP sky130_fd_pr__cap_mim_m3_1 l=3 w=3
X1503 B10 TOP sky130_fd_pr__cap_mim_m3_1 l=3 w=3
X1504 B11 TOP sky130_fd_pr__cap_mim_m3_1 l=3 w=3
X1505 B8 TOP sky130_fd_pr__cap_mim_m3_1 l=3 w=3
X1506 EDGE_BIAS EDGE_BIAS sky130_fd_pr__cap_mim_m3_1 l=3 w=3
X1507 B11 TOP sky130_fd_pr__cap_mim_m3_1 l=3 w=3
X1508 B11 TOP sky130_fd_pr__cap_mim_m3_1 l=3 w=3
X1509 B11 TOP sky130_fd_pr__cap_mim_m3_1 l=3 w=3
X1510 B11 TOP sky130_fd_pr__cap_mim_m3_1 l=3 w=3
X1511 B10 TOP sky130_fd_pr__cap_mim_m3_1 l=3 w=3
X1512 B9 TOP sky130_fd_pr__cap_mim_m3_1 l=3 w=3
X1513 B10 TOP sky130_fd_pr__cap_mim_m3_1 l=3 w=3
X1514 B11 TOP sky130_fd_pr__cap_mim_m3_1 l=3 w=3
X1515 B6 TOP sky130_fd_pr__cap_mim_m3_1 l=3 w=3
X1516 EDGE_BIAS EDGE_BIAS sky130_fd_pr__cap_mim_m3_1 l=3 w=3
X1517 B11 TOP sky130_fd_pr__cap_mim_m3_1 l=3 w=3
X1518 B10 TOP sky130_fd_pr__cap_mim_m3_1 l=3 w=3
X1519 B11 TOP sky130_fd_pr__cap_mim_m3_1 l=3 w=3
X1520 B9 TOP sky130_fd_pr__cap_mim_m3_1 l=3 w=3
X1521 B11 TOP sky130_fd_pr__cap_mim_m3_1 l=3 w=3
X1522 B10 TOP sky130_fd_pr__cap_mim_m3_1 l=3 w=3
X1523 B11 TOP sky130_fd_pr__cap_mim_m3_1 l=3 w=3
X1524 EDGE_BIAS EDGE_BIAS sky130_fd_pr__cap_mim_m3_1 l=3 w=3
X1525 B11 TOP sky130_fd_pr__cap_mim_m3_1 l=3 w=3
X1526 B11 TOP sky130_fd_pr__cap_mim_m3_1 l=3 w=3
X1527 B10 TOP sky130_fd_pr__cap_mim_m3_1 l=3 w=3
X1528 B9 TOP sky130_fd_pr__cap_mim_m3_1 l=3 w=3
X1529 B11 TOP sky130_fd_pr__cap_mim_m3_1 l=3 w=3
X1530 B11 TOP sky130_fd_pr__cap_mim_m3_1 l=3 w=3
X1531 B10 TOP sky130_fd_pr__cap_mim_m3_1 l=3 w=3
X1532 B10 TOP sky130_fd_pr__cap_mim_m3_1 l=3 w=3
X1533 B11 TOP sky130_fd_pr__cap_mim_m3_1 l=3 w=3
X1534 B11 TOP sky130_fd_pr__cap_mim_m3_1 l=3 w=3
X1535 B10 TOP sky130_fd_pr__cap_mim_m3_1 l=3 w=3
X1536 B10 TOP sky130_fd_pr__cap_mim_m3_1 l=3 w=3
X1537 B10 TOP sky130_fd_pr__cap_mim_m3_1 l=3 w=3
X1538 B11 TOP sky130_fd_pr__cap_mim_m3_1 l=3 w=3
X1539 B11 TOP sky130_fd_pr__cap_mim_m3_1 l=3 w=3
X1540 B10 TOP sky130_fd_pr__cap_mim_m3_1 l=3 w=3
X1541 B11 TOP sky130_fd_pr__cap_mim_m3_1 l=3 w=3
X1542 B11 TOP sky130_fd_pr__cap_mim_m3_1 l=3 w=3
X1543 B10 TOP sky130_fd_pr__cap_mim_m3_1 l=3 w=3
X1544 B11 TOP sky130_fd_pr__cap_mim_m3_1 l=3 w=3
X1545 B7 TOP sky130_fd_pr__cap_mim_m3_1 l=3 w=3
X1546 B10 TOP sky130_fd_pr__cap_mim_m3_1 l=3 w=3
X1547 B11 TOP sky130_fd_pr__cap_mim_m3_1 l=3 w=3
X1548 B11 TOP sky130_fd_pr__cap_mim_m3_1 l=3 w=3
X1549 B11 TOP sky130_fd_pr__cap_mim_m3_1 l=3 w=3
X1550 B11 TOP sky130_fd_pr__cap_mim_m3_1 l=3 w=3
X1551 B10 TOP sky130_fd_pr__cap_mim_m3_1 l=3 w=3
X1552 B10 TOP sky130_fd_pr__cap_mim_m3_1 l=3 w=3
X1553 EDGE_BIAS EDGE_BIAS sky130_fd_pr__cap_mim_m3_1 l=3 w=3
X1554 B11 TOP sky130_fd_pr__cap_mim_m3_1 l=3 w=3
X1555 B10 TOP sky130_fd_pr__cap_mim_m3_1 l=3 w=3
X1556 B10 TOP sky130_fd_pr__cap_mim_m3_1 l=3 w=3
X1557 B8 TOP sky130_fd_pr__cap_mim_m3_1 l=3 w=3
X1558 B11 TOP sky130_fd_pr__cap_mim_m3_1 l=3 w=3
X1559 B9 TOP sky130_fd_pr__cap_mim_m3_1 l=3 w=3
X1560 B11 TOP sky130_fd_pr__cap_mim_m3_1 l=3 w=3
X1561 B10 TOP sky130_fd_pr__cap_mim_m3_1 l=3 w=3
X1562 B6 TOP sky130_fd_pr__cap_mim_m3_1 l=3 w=3
X1563 B11 TOP sky130_fd_pr__cap_mim_m3_1 l=3 w=3
X1564 B9 TOP sky130_fd_pr__cap_mim_m3_1 l=3 w=3
X1565 B11 TOP sky130_fd_pr__cap_mim_m3_1 l=3 w=3
X1566 B11 TOP sky130_fd_pr__cap_mim_m3_1 l=3 w=3
X1567 EDGE_BIAS EDGE_BIAS sky130_fd_pr__cap_mim_m3_1 l=3 w=3
X1568 B11 TOP sky130_fd_pr__cap_mim_m3_1 l=3 w=3
X1569 B11 TOP sky130_fd_pr__cap_mim_m3_1 l=3 w=3
X1570 B7 TOP sky130_fd_pr__cap_mim_m3_1 l=3 w=3
X1571 B11 TOP sky130_fd_pr__cap_mim_m3_1 l=3 w=3
X1572 B11 TOP sky130_fd_pr__cap_mim_m3_1 l=3 w=3
X1573 B9 TOP sky130_fd_pr__cap_mim_m3_1 l=3 w=3
X1574 B11 TOP sky130_fd_pr__cap_mim_m3_1 l=3 w=3
X1575 B11 TOP sky130_fd_pr__cap_mim_m3_1 l=3 w=3
X1576 B9 TOP sky130_fd_pr__cap_mim_m3_1 l=3 w=3
X1577 B7 TOP sky130_fd_pr__cap_mim_m3_1 l=3 w=3
X1578 B11 TOP sky130_fd_pr__cap_mim_m3_1 l=3 w=3
X1579 B11 TOP sky130_fd_pr__cap_mim_m3_1 l=3 w=3
X1580 EDGE_BIAS EDGE_BIAS sky130_fd_pr__cap_mim_m3_1 l=3 w=3
X1581 B11 TOP sky130_fd_pr__cap_mim_m3_1 l=3 w=3
X1582 B10 TOP sky130_fd_pr__cap_mim_m3_1 l=3 w=3
X1583 B8 TOP sky130_fd_pr__cap_mim_m3_1 l=3 w=3
X1584 B10 TOP sky130_fd_pr__cap_mim_m3_1 l=3 w=3
X1585 B11 TOP sky130_fd_pr__cap_mim_m3_1 l=3 w=3
X1586 B11 TOP sky130_fd_pr__cap_mim_m3_1 l=3 w=3
X1587 B10 TOP sky130_fd_pr__cap_mim_m3_1 l=3 w=3
X1588 B9 TOP sky130_fd_pr__cap_mim_m3_1 l=3 w=3
X1589 B11 TOP sky130_fd_pr__cap_mim_m3_1 l=3 w=3
X1590 EDGE_BIAS EDGE_BIAS sky130_fd_pr__cap_mim_m3_1 l=3 w=3
X1591 B8 TOP sky130_fd_pr__cap_mim_m3_1 l=3 w=3
X1592 B10 TOP sky130_fd_pr__cap_mim_m3_1 l=3 w=3
X1593 B1 TOP sky130_fd_pr__cap_mim_m3_1 l=3 w=3
X1594 B11 TOP sky130_fd_pr__cap_mim_m3_1 l=3 w=3
X1595 B9 TOP sky130_fd_pr__cap_mim_m3_1 l=3 w=3
X1596 B6 TOP sky130_fd_pr__cap_mim_m3_1 l=3 w=3
X1597 B11 TOP sky130_fd_pr__cap_mim_m3_1 l=3 w=3
X1598 B11 TOP sky130_fd_pr__cap_mim_m3_1 l=3 w=3
X1599 B10 TOP sky130_fd_pr__cap_mim_m3_1 l=3 w=3
X1600 B11 TOP sky130_fd_pr__cap_mim_m3_1 l=3 w=3
X1601 B10 TOP sky130_fd_pr__cap_mim_m3_1 l=3 w=3
X1602 B11 TOP sky130_fd_pr__cap_mim_m3_1 l=3 w=3
X1603 B11 TOP sky130_fd_pr__cap_mim_m3_1 l=3 w=3
X1604 B11 TOP sky130_fd_pr__cap_mim_m3_1 l=3 w=3
X1605 B11 TOP sky130_fd_pr__cap_mim_m3_1 l=3 w=3
X1606 EDGE_BIAS EDGE_BIAS sky130_fd_pr__cap_mim_m3_1 l=3 w=3
X1607 B11 TOP sky130_fd_pr__cap_mim_m3_1 l=3 w=3
X1608 B7 TOP sky130_fd_pr__cap_mim_m3_1 l=3 w=3
X1609 B9 TOP sky130_fd_pr__cap_mim_m3_1 l=3 w=3
X1610 B11 TOP sky130_fd_pr__cap_mim_m3_1 l=3 w=3
X1611 B11 TOP sky130_fd_pr__cap_mim_m3_1 l=3 w=3
X1612 B9 TOP sky130_fd_pr__cap_mim_m3_1 l=3 w=3
X1613 B11 TOP sky130_fd_pr__cap_mim_m3_1 l=3 w=3
X1614 B10 TOP sky130_fd_pr__cap_mim_m3_1 l=3 w=3
X1615 B11 TOP sky130_fd_pr__cap_mim_m3_1 l=3 w=3
X1616 B10 TOP sky130_fd_pr__cap_mim_m3_1 l=3 w=3
X1617 B10 TOP sky130_fd_pr__cap_mim_m3_1 l=3 w=3
X1618 B11 TOP sky130_fd_pr__cap_mim_m3_1 l=3 w=3
X1619 B9 TOP sky130_fd_pr__cap_mim_m3_1 l=3 w=3
X1620 B11 TOP sky130_fd_pr__cap_mim_m3_1 l=3 w=3
X1621 B10 TOP sky130_fd_pr__cap_mim_m3_1 l=3 w=3
X1622 EDGE_BIAS EDGE_BIAS sky130_fd_pr__cap_mim_m3_1 l=3 w=3
X1623 B10 TOP sky130_fd_pr__cap_mim_m3_1 l=3 w=3
X1624 B10 TOP sky130_fd_pr__cap_mim_m3_1 l=3 w=3
X1625 B11 TOP sky130_fd_pr__cap_mim_m3_1 l=3 w=3
X1626 B11 TOP sky130_fd_pr__cap_mim_m3_1 l=3 w=3
X1627 B11 TOP sky130_fd_pr__cap_mim_m3_1 l=3 w=3
X1628 B10 TOP sky130_fd_pr__cap_mim_m3_1 l=3 w=3
X1629 B11 TOP sky130_fd_pr__cap_mim_m3_1 l=3 w=3
X1630 B11 TOP sky130_fd_pr__cap_mim_m3_1 l=3 w=3
X1631 EDGE_BIAS EDGE_BIAS sky130_fd_pr__cap_mim_m3_1 l=3 w=3
X1632 B10 TOP sky130_fd_pr__cap_mim_m3_1 l=3 w=3
X1633 B11 TOP sky130_fd_pr__cap_mim_m3_1 l=3 w=3
X1634 B11 TOP sky130_fd_pr__cap_mim_m3_1 l=3 w=3
X1635 B11 TOP sky130_fd_pr__cap_mim_m3_1 l=3 w=3
X1636 B9 TOP sky130_fd_pr__cap_mim_m3_1 l=3 w=3
X1637 B11 TOP sky130_fd_pr__cap_mim_m3_1 l=3 w=3
X1638 B10 TOP sky130_fd_pr__cap_mim_m3_1 l=3 w=3
X1639 B10 TOP sky130_fd_pr__cap_mim_m3_1 l=3 w=3
X1640 B11 TOP sky130_fd_pr__cap_mim_m3_1 l=3 w=3
X1641 B11 TOP sky130_fd_pr__cap_mim_m3_1 l=3 w=3
X1642 B6 TOP sky130_fd_pr__cap_mim_m3_1 l=3 w=3
X1643 B11 TOP sky130_fd_pr__cap_mim_m3_1 l=3 w=3
X1644 B9 TOP sky130_fd_pr__cap_mim_m3_1 l=3 w=3
X1645 B11 TOP sky130_fd_pr__cap_mim_m3_1 l=3 w=3
X1646 B11 TOP sky130_fd_pr__cap_mim_m3_1 l=3 w=3
X1647 B11 TOP sky130_fd_pr__cap_mim_m3_1 l=3 w=3
X1648 B11 TOP sky130_fd_pr__cap_mim_m3_1 l=3 w=3
X1649 B11 TOP sky130_fd_pr__cap_mim_m3_1 l=3 w=3
X1650 B11 TOP sky130_fd_pr__cap_mim_m3_1 l=3 w=3
X1651 B11 TOP sky130_fd_pr__cap_mim_m3_1 l=3 w=3
X1652 B11 TOP sky130_fd_pr__cap_mim_m3_1 l=3 w=3
X1653 B10 TOP sky130_fd_pr__cap_mim_m3_1 l=3 w=3
X1654 B9 TOP sky130_fd_pr__cap_mim_m3_1 l=3 w=3
X1655 B10 TOP sky130_fd_pr__cap_mim_m3_1 l=3 w=3
X1656 B10 TOP sky130_fd_pr__cap_mim_m3_1 l=3 w=3
X1657 B11 TOP sky130_fd_pr__cap_mim_m3_1 l=3 w=3
X1658 B10 TOP sky130_fd_pr__cap_mim_m3_1 l=3 w=3
X1659 B10 TOP sky130_fd_pr__cap_mim_m3_1 l=3 w=3
X1660 B11 TOP sky130_fd_pr__cap_mim_m3_1 l=3 w=3
X1661 B10 TOP sky130_fd_pr__cap_mim_m3_1 l=3 w=3
X1662 B11 TOP sky130_fd_pr__cap_mim_m3_1 l=3 w=3
X1663 B10 TOP sky130_fd_pr__cap_mim_m3_1 l=3 w=3
X1664 B11 TOP sky130_fd_pr__cap_mim_m3_1 l=3 w=3
X1665 B11 TOP sky130_fd_pr__cap_mim_m3_1 l=3 w=3
X1666 B10 TOP sky130_fd_pr__cap_mim_m3_1 l=3 w=3
X1667 EDGE_BIAS EDGE_BIAS sky130_fd_pr__cap_mim_m3_1 l=3 w=3
X1668 B10 TOP sky130_fd_pr__cap_mim_m3_1 l=3 w=3
X1669 B10 TOP sky130_fd_pr__cap_mim_m3_1 l=3 w=3
X1670 B8 TOP sky130_fd_pr__cap_mim_m3_1 l=3 w=3
X1671 B11 TOP sky130_fd_pr__cap_mim_m3_1 l=3 w=3
X1672 B9 TOP sky130_fd_pr__cap_mim_m3_1 l=3 w=3
X1673 B11 TOP sky130_fd_pr__cap_mim_m3_1 l=3 w=3
X1674 B10 TOP sky130_fd_pr__cap_mim_m3_1 l=3 w=3
X1675 B8 TOP sky130_fd_pr__cap_mim_m3_1 l=3 w=3
X1676 B11 TOP sky130_fd_pr__cap_mim_m3_1 l=3 w=3
X1677 B11 TOP sky130_fd_pr__cap_mim_m3_1 l=3 w=3
X1678 B10 TOP sky130_fd_pr__cap_mim_m3_1 l=3 w=3
X1679 B9 TOP sky130_fd_pr__cap_mim_m3_1 l=3 w=3
X1680 B11 TOP sky130_fd_pr__cap_mim_m3_1 l=3 w=3
X1681 B11 TOP sky130_fd_pr__cap_mim_m3_1 l=3 w=3
X1682 EDGE_BIAS EDGE_BIAS sky130_fd_pr__cap_mim_m3_1 l=3 w=3
X1683 B11 TOP sky130_fd_pr__cap_mim_m3_1 l=3 w=3
X1684 B11 TOP sky130_fd_pr__cap_mim_m3_1 l=3 w=3
X1685 B10 TOP sky130_fd_pr__cap_mim_m3_1 l=3 w=3
X1686 B7 TOP sky130_fd_pr__cap_mim_m3_1 l=3 w=3
X1687 B11 TOP sky130_fd_pr__cap_mim_m3_1 l=3 w=3
X1688 B9 TOP sky130_fd_pr__cap_mim_m3_1 l=3 w=3
X1689 B11 TOP sky130_fd_pr__cap_mim_m3_1 l=3 w=3
X1690 B9 TOP sky130_fd_pr__cap_mim_m3_1 l=3 w=3
X1691 B3 TOP sky130_fd_pr__cap_mim_m3_1 l=3 w=3
X1692 B11 TOP sky130_fd_pr__cap_mim_m3_1 l=3 w=3
X1693 B11 TOP sky130_fd_pr__cap_mim_m3_1 l=3 w=3
X1694 B9 TOP sky130_fd_pr__cap_mim_m3_1 l=3 w=3
X1695 B11 TOP sky130_fd_pr__cap_mim_m3_1 l=3 w=3
X1696 B10 TOP sky130_fd_pr__cap_mim_m3_1 l=3 w=3
X1697 B9 TOP sky130_fd_pr__cap_mim_m3_1 l=3 w=3
X1698 B6 TOP sky130_fd_pr__cap_mim_m3_1 l=3 w=3
X1699 B10 TOP sky130_fd_pr__cap_mim_m3_1 l=3 w=3
X1700 B10 TOP sky130_fd_pr__cap_mim_m3_1 l=3 w=3
X1701 B11 TOP sky130_fd_pr__cap_mim_m3_1 l=3 w=3
X1702 B11 TOP sky130_fd_pr__cap_mim_m3_1 l=3 w=3
X1703 B10 TOP sky130_fd_pr__cap_mim_m3_1 l=3 w=3
X1704 B11 TOP sky130_fd_pr__cap_mim_m3_1 l=3 w=3
X1705 B10 TOP sky130_fd_pr__cap_mim_m3_1 l=3 w=3
X1706 B11 TOP sky130_fd_pr__cap_mim_m3_1 l=3 w=3
X1707 EDGE_BIAS EDGE_BIAS sky130_fd_pr__cap_mim_m3_1 l=3 w=3
X1708 B8 TOP sky130_fd_pr__cap_mim_m3_1 l=3 w=3
X1709 B10 TOP sky130_fd_pr__cap_mim_m3_1 l=3 w=3
X1710 B11 TOP sky130_fd_pr__cap_mim_m3_1 l=3 w=3
X1711 B9 TOP sky130_fd_pr__cap_mim_m3_1 l=3 w=3
X1712 B11 TOP sky130_fd_pr__cap_mim_m3_1 l=3 w=3
X1713 B9 TOP sky130_fd_pr__cap_mim_m3_1 l=3 w=3
X1714 EDGE_BIAS EDGE_BIAS sky130_fd_pr__cap_mim_m3_1 l=3 w=3
X1715 B11 TOP sky130_fd_pr__cap_mim_m3_1 l=3 w=3
X1716 B11 TOP sky130_fd_pr__cap_mim_m3_1 l=3 w=3
X1717 B6 TOP sky130_fd_pr__cap_mim_m3_1 l=3 w=3
X1718 B11 TOP sky130_fd_pr__cap_mim_m3_1 l=3 w=3
X1719 B11 TOP sky130_fd_pr__cap_mim_m3_1 l=3 w=3
X1720 EDGE_BIAS EDGE_BIAS sky130_fd_pr__cap_mim_m3_1 l=3 w=3
X1721 B9 TOP sky130_fd_pr__cap_mim_m3_1 l=3 w=3
X1722 B9 TOP sky130_fd_pr__cap_mim_m3_1 l=3 w=3
X1723 B10 TOP sky130_fd_pr__cap_mim_m3_1 l=3 w=3
X1724 B11 TOP sky130_fd_pr__cap_mim_m3_1 l=3 w=3
X1725 B11 TOP sky130_fd_pr__cap_mim_m3_1 l=3 w=3
X1726 EDGE_BIAS EDGE_BIAS sky130_fd_pr__cap_mim_m3_1 l=3 w=3
X1727 EDGE_BIAS EDGE_BIAS sky130_fd_pr__cap_mim_m3_1 l=3 w=3
X1728 B11 TOP sky130_fd_pr__cap_mim_m3_1 l=3 w=3
X1729 B11 TOP sky130_fd_pr__cap_mim_m3_1 l=3 w=3
X1730 B11 TOP sky130_fd_pr__cap_mim_m3_1 l=3 w=3
X1731 B11 TOP sky130_fd_pr__cap_mim_m3_1 l=3 w=3
X1732 B11 TOP sky130_fd_pr__cap_mim_m3_1 l=3 w=3
X1733 B10 TOP sky130_fd_pr__cap_mim_m3_1 l=3 w=3
X1734 B11 TOP sky130_fd_pr__cap_mim_m3_1 l=3 w=3
X1735 B11 TOP sky130_fd_pr__cap_mim_m3_1 l=3 w=3
X1736 B9 TOP sky130_fd_pr__cap_mim_m3_1 l=3 w=3
X1737 B10 TOP sky130_fd_pr__cap_mim_m3_1 l=3 w=3
X1738 B11 TOP sky130_fd_pr__cap_mim_m3_1 l=3 w=3
X1739 B11 TOP sky130_fd_pr__cap_mim_m3_1 l=3 w=3
X1740 B10 TOP sky130_fd_pr__cap_mim_m3_1 l=3 w=3
X1741 EDGE_BIAS EDGE_BIAS sky130_fd_pr__cap_mim_m3_1 l=3 w=3
X1742 B10 TOP sky130_fd_pr__cap_mim_m3_1 l=3 w=3
X1743 B10 TOP sky130_fd_pr__cap_mim_m3_1 l=3 w=3
X1744 B5 TOP sky130_fd_pr__cap_mim_m3_1 l=3 w=3
X1745 B11 TOP sky130_fd_pr__cap_mim_m3_1 l=3 w=3
X1746 B10 TOP sky130_fd_pr__cap_mim_m3_1 l=3 w=3
X1747 B10 TOP sky130_fd_pr__cap_mim_m3_1 l=3 w=3
X1748 B10 TOP sky130_fd_pr__cap_mim_m3_1 l=3 w=3
X1749 B11 TOP sky130_fd_pr__cap_mim_m3_1 l=3 w=3
X1750 B10 TOP sky130_fd_pr__cap_mim_m3_1 l=3 w=3
X1751 B4 TOP sky130_fd_pr__cap_mim_m3_1 l=3 w=3
X1752 B9 TOP sky130_fd_pr__cap_mim_m3_1 l=3 w=3
X1753 B10 TOP sky130_fd_pr__cap_mim_m3_1 l=3 w=3
X1754 B11 TOP sky130_fd_pr__cap_mim_m3_1 l=3 w=3
X1755 EDGE_BIAS EDGE_BIAS sky130_fd_pr__cap_mim_m3_1 l=3 w=3
X1756 EDGE_BIAS EDGE_BIAS sky130_fd_pr__cap_mim_m3_1 l=3 w=3
X1757 B11 TOP sky130_fd_pr__cap_mim_m3_1 l=3 w=3
X1758 B11 TOP sky130_fd_pr__cap_mim_m3_1 l=3 w=3
X1759 B11 TOP sky130_fd_pr__cap_mim_m3_1 l=3 w=3
X1760 B11 TOP sky130_fd_pr__cap_mim_m3_1 l=3 w=3
X1761 B10 TOP sky130_fd_pr__cap_mim_m3_1 l=3 w=3
X1762 B9 TOP sky130_fd_pr__cap_mim_m3_1 l=3 w=3
X1763 B11 TOP sky130_fd_pr__cap_mim_m3_1 l=3 w=3
X1764 B10 TOP sky130_fd_pr__cap_mim_m3_1 l=3 w=3
X1765 B9 TOP sky130_fd_pr__cap_mim_m3_1 l=3 w=3
X1766 B11 TOP sky130_fd_pr__cap_mim_m3_1 l=3 w=3
X1767 B11 TOP sky130_fd_pr__cap_mim_m3_1 l=3 w=3
X1768 B6 TOP sky130_fd_pr__cap_mim_m3_1 l=3 w=3
X1769 B10 TOP sky130_fd_pr__cap_mim_m3_1 l=3 w=3
X1770 B9 TOP sky130_fd_pr__cap_mim_m3_1 l=3 w=3
X1771 B11 TOP sky130_fd_pr__cap_mim_m3_1 l=3 w=3
X1772 B11 TOP sky130_fd_pr__cap_mim_m3_1 l=3 w=3
X1773 B11 TOP sky130_fd_pr__cap_mim_m3_1 l=3 w=3
X1774 B10 TOP sky130_fd_pr__cap_mim_m3_1 l=3 w=3
X1775 B11 TOP sky130_fd_pr__cap_mim_m3_1 l=3 w=3
X1776 B11 TOP sky130_fd_pr__cap_mim_m3_1 l=3 w=3
X1777 B11 TOP sky130_fd_pr__cap_mim_m3_1 l=3 w=3
X1778 B10 TOP sky130_fd_pr__cap_mim_m3_1 l=3 w=3
X1779 B11 TOP sky130_fd_pr__cap_mim_m3_1 l=3 w=3
X1780 B11 TOP sky130_fd_pr__cap_mim_m3_1 l=3 w=3
X1781 B9 TOP sky130_fd_pr__cap_mim_m3_1 l=3 w=3
X1782 B11 TOP sky130_fd_pr__cap_mim_m3_1 l=3 w=3
X1783 B11 TOP sky130_fd_pr__cap_mim_m3_1 l=3 w=3
X1784 B11 TOP sky130_fd_pr__cap_mim_m3_1 l=3 w=3
X1785 B11 TOP sky130_fd_pr__cap_mim_m3_1 l=3 w=3
X1786 B11 TOP sky130_fd_pr__cap_mim_m3_1 l=3 w=3
X1787 B11 TOP sky130_fd_pr__cap_mim_m3_1 l=3 w=3
X1788 B10 TOP sky130_fd_pr__cap_mim_m3_1 l=3 w=3
X1789 B9 TOP sky130_fd_pr__cap_mim_m3_1 l=3 w=3
X1790 B11 TOP sky130_fd_pr__cap_mim_m3_1 l=3 w=3
X1791 B10 TOP sky130_fd_pr__cap_mim_m3_1 l=3 w=3
X1792 B11 TOP sky130_fd_pr__cap_mim_m3_1 l=3 w=3
X1793 B10 TOP sky130_fd_pr__cap_mim_m3_1 l=3 w=3
X1794 B10 TOP sky130_fd_pr__cap_mim_m3_1 l=3 w=3
X1795 B10 TOP sky130_fd_pr__cap_mim_m3_1 l=3 w=3
X1796 B11 TOP sky130_fd_pr__cap_mim_m3_1 l=3 w=3
X1797 B10 TOP sky130_fd_pr__cap_mim_m3_1 l=3 w=3
X1798 B10 TOP sky130_fd_pr__cap_mim_m3_1 l=3 w=3
X1799 B11 TOP sky130_fd_pr__cap_mim_m3_1 l=3 w=3
X1800 B10 TOP sky130_fd_pr__cap_mim_m3_1 l=3 w=3
X1801 B9 TOP sky130_fd_pr__cap_mim_m3_1 l=3 w=3
X1802 B8 TOP sky130_fd_pr__cap_mim_m3_1 l=3 w=3
X1803 B11 TOP sky130_fd_pr__cap_mim_m3_1 l=3 w=3
X1804 EDGE_BIAS EDGE_BIAS sky130_fd_pr__cap_mim_m3_1 l=3 w=3
X1805 B10 TOP sky130_fd_pr__cap_mim_m3_1 l=3 w=3
X1806 B11 TOP sky130_fd_pr__cap_mim_m3_1 l=3 w=3
X1807 B9 TOP sky130_fd_pr__cap_mim_m3_1 l=3 w=3
X1808 B11 TOP sky130_fd_pr__cap_mim_m3_1 l=3 w=3
X1809 B10 TOP sky130_fd_pr__cap_mim_m3_1 l=3 w=3
X1810 B11 TOP sky130_fd_pr__cap_mim_m3_1 l=3 w=3
X1811 B11 TOP sky130_fd_pr__cap_mim_m3_1 l=3 w=3
X1812 B11 TOP sky130_fd_pr__cap_mim_m3_1 l=3 w=3
X1813 B9 TOP sky130_fd_pr__cap_mim_m3_1 l=3 w=3
X1814 B11 TOP sky130_fd_pr__cap_mim_m3_1 l=3 w=3
X1815 B9 TOP sky130_fd_pr__cap_mim_m3_1 l=3 w=3
X1816 B11 TOP sky130_fd_pr__cap_mim_m3_1 l=3 w=3
X1817 B11 TOP sky130_fd_pr__cap_mim_m3_1 l=3 w=3
X1818 EDGE_BIAS EDGE_BIAS sky130_fd_pr__cap_mim_m3_1 l=3 w=3
X1819 B11 TOP sky130_fd_pr__cap_mim_m3_1 l=3 w=3
X1820 B11 TOP sky130_fd_pr__cap_mim_m3_1 l=3 w=3
X1821 B11 TOP sky130_fd_pr__cap_mim_m3_1 l=3 w=3
X1822 B11 TOP sky130_fd_pr__cap_mim_m3_1 l=3 w=3
X1823 B11 TOP sky130_fd_pr__cap_mim_m3_1 l=3 w=3
X1824 B11 TOP sky130_fd_pr__cap_mim_m3_1 l=3 w=3
X1825 B10 TOP sky130_fd_pr__cap_mim_m3_1 l=3 w=3
X1826 B7 TOP sky130_fd_pr__cap_mim_m3_1 l=3 w=3
X1827 B9 TOP sky130_fd_pr__cap_mim_m3_1 l=3 w=3
X1828 B11 TOP sky130_fd_pr__cap_mim_m3_1 l=3 w=3
X1829 B11 TOP sky130_fd_pr__cap_mim_m3_1 l=3 w=3
X1830 B11 TOP sky130_fd_pr__cap_mim_m3_1 l=3 w=3
X1831 B10 TOP sky130_fd_pr__cap_mim_m3_1 l=3 w=3
X1832 B9 TOP sky130_fd_pr__cap_mim_m3_1 l=3 w=3
X1833 B8 TOP sky130_fd_pr__cap_mim_m3_1 l=3 w=3
X1834 B11 TOP sky130_fd_pr__cap_mim_m3_1 l=3 w=3
X1835 B8 TOP sky130_fd_pr__cap_mim_m3_1 l=3 w=3
X1836 B10 TOP sky130_fd_pr__cap_mim_m3_1 l=3 w=3
X1837 B6 TOP sky130_fd_pr__cap_mim_m3_1 l=3 w=3
X1838 B10 TOP sky130_fd_pr__cap_mim_m3_1 l=3 w=3
X1839 B11 TOP sky130_fd_pr__cap_mim_m3_1 l=3 w=3
X1840 B10 TOP sky130_fd_pr__cap_mim_m3_1 l=3 w=3
X1841 B11 TOP sky130_fd_pr__cap_mim_m3_1 l=3 w=3
X1842 B10 TOP sky130_fd_pr__cap_mim_m3_1 l=3 w=3
X1843 B11 TOP sky130_fd_pr__cap_mim_m3_1 l=3 w=3
X1844 B11 TOP sky130_fd_pr__cap_mim_m3_1 l=3 w=3
X1845 B10 TOP sky130_fd_pr__cap_mim_m3_1 l=3 w=3
X1846 B11 TOP sky130_fd_pr__cap_mim_m3_1 l=3 w=3
X1847 EDGE_BIAS EDGE_BIAS sky130_fd_pr__cap_mim_m3_1 l=3 w=3
X1848 B11 TOP sky130_fd_pr__cap_mim_m3_1 l=3 w=3
X1849 B10 TOP sky130_fd_pr__cap_mim_m3_1 l=3 w=3
X1850 B6 TOP sky130_fd_pr__cap_mim_m3_1 l=3 w=3
X1851 B10 TOP sky130_fd_pr__cap_mim_m3_1 l=3 w=3
X1852 B9 TOP sky130_fd_pr__cap_mim_m3_1 l=3 w=3
X1853 B9 TOP sky130_fd_pr__cap_mim_m3_1 l=3 w=3
X1854 B11 TOP sky130_fd_pr__cap_mim_m3_1 l=3 w=3
X1855 B11 TOP sky130_fd_pr__cap_mim_m3_1 l=3 w=3
X1856 B10 TOP sky130_fd_pr__cap_mim_m3_1 l=3 w=3
X1857 B6 TOP sky130_fd_pr__cap_mim_m3_1 l=3 w=3
X1858 B9 TOP sky130_fd_pr__cap_mim_m3_1 l=3 w=3
X1859 B9 TOP sky130_fd_pr__cap_mim_m3_1 l=3 w=3
X1860 B11 TOP sky130_fd_pr__cap_mim_m3_1 l=3 w=3
X1861 B10 TOP sky130_fd_pr__cap_mim_m3_1 l=3 w=3
X1862 B9 TOP sky130_fd_pr__cap_mim_m3_1 l=3 w=3
X1863 B11 TOP sky130_fd_pr__cap_mim_m3_1 l=3 w=3
X1864 B9 TOP sky130_fd_pr__cap_mim_m3_1 l=3 w=3
X1865 B10 TOP sky130_fd_pr__cap_mim_m3_1 l=3 w=3
X1866 B9 TOP sky130_fd_pr__cap_mim_m3_1 l=3 w=3
X1867 B11 TOP sky130_fd_pr__cap_mim_m3_1 l=3 w=3
X1868 B11 TOP sky130_fd_pr__cap_mim_m3_1 l=3 w=3
X1869 B11 TOP sky130_fd_pr__cap_mim_m3_1 l=3 w=3
X1870 B11 TOP sky130_fd_pr__cap_mim_m3_1 l=3 w=3
X1871 B11 TOP sky130_fd_pr__cap_mim_m3_1 l=3 w=3
X1872 B11 TOP sky130_fd_pr__cap_mim_m3_1 l=3 w=3
X1873 B11 TOP sky130_fd_pr__cap_mim_m3_1 l=3 w=3
X1874 B11 TOP sky130_fd_pr__cap_mim_m3_1 l=3 w=3
X1875 B8 TOP sky130_fd_pr__cap_mim_m3_1 l=3 w=3
X1876 B10 TOP sky130_fd_pr__cap_mim_m3_1 l=3 w=3
X1877 B11 TOP sky130_fd_pr__cap_mim_m3_1 l=3 w=3
X1878 B10 TOP sky130_fd_pr__cap_mim_m3_1 l=3 w=3
X1879 B11 TOP sky130_fd_pr__cap_mim_m3_1 l=3 w=3
X1880 EDGE_BIAS EDGE_BIAS sky130_fd_pr__cap_mim_m3_1 l=3 w=3
X1881 B11 TOP sky130_fd_pr__cap_mim_m3_1 l=3 w=3
X1882 B10 TOP sky130_fd_pr__cap_mim_m3_1 l=3 w=3
X1883 B8 TOP sky130_fd_pr__cap_mim_m3_1 l=3 w=3
X1884 B11 TOP sky130_fd_pr__cap_mim_m3_1 l=3 w=3
X1885 B11 TOP sky130_fd_pr__cap_mim_m3_1 l=3 w=3
X1886 B11 TOP sky130_fd_pr__cap_mim_m3_1 l=3 w=3
X1887 B11 TOP sky130_fd_pr__cap_mim_m3_1 l=3 w=3
X1888 B10 TOP sky130_fd_pr__cap_mim_m3_1 l=3 w=3
X1889 B10 TOP sky130_fd_pr__cap_mim_m3_1 l=3 w=3
X1890 B5 TOP sky130_fd_pr__cap_mim_m3_1 l=3 w=3
X1891 B10 TOP sky130_fd_pr__cap_mim_m3_1 l=3 w=3
X1892 B11 TOP sky130_fd_pr__cap_mim_m3_1 l=3 w=3
X1893 B9 TOP sky130_fd_pr__cap_mim_m3_1 l=3 w=3
X1894 EDGE_BIAS EDGE_BIAS sky130_fd_pr__cap_mim_m3_1 l=3 w=3
X1895 B10 TOP sky130_fd_pr__cap_mim_m3_1 l=3 w=3
X1896 B5 TOP sky130_fd_pr__cap_mim_m3_1 l=3 w=3
X1897 B10 TOP sky130_fd_pr__cap_mim_m3_1 l=3 w=3
X1898 B11 TOP sky130_fd_pr__cap_mim_m3_1 l=3 w=3
X1899 B11 TOP sky130_fd_pr__cap_mim_m3_1 l=3 w=3
X1900 B11 TOP sky130_fd_pr__cap_mim_m3_1 l=3 w=3
X1901 B11 TOP sky130_fd_pr__cap_mim_m3_1 l=3 w=3
X1902 B10 TOP sky130_fd_pr__cap_mim_m3_1 l=3 w=3
X1903 B11 TOP sky130_fd_pr__cap_mim_m3_1 l=3 w=3
X1904 B10 TOP sky130_fd_pr__cap_mim_m3_1 l=3 w=3
X1905 B9 TOP sky130_fd_pr__cap_mim_m3_1 l=3 w=3
X1906 B11 TOP sky130_fd_pr__cap_mim_m3_1 l=3 w=3
X1907 B11 TOP sky130_fd_pr__cap_mim_m3_1 l=3 w=3
X1908 B11 TOP sky130_fd_pr__cap_mim_m3_1 l=3 w=3
X1909 B10 TOP sky130_fd_pr__cap_mim_m3_1 l=3 w=3
X1910 B9 TOP sky130_fd_pr__cap_mim_m3_1 l=3 w=3
X1911 B10 TOP sky130_fd_pr__cap_mim_m3_1 l=3 w=3
X1912 B11 TOP sky130_fd_pr__cap_mim_m3_1 l=3 w=3
X1913 B11 TOP sky130_fd_pr__cap_mim_m3_1 l=3 w=3
X1914 B11 TOP sky130_fd_pr__cap_mim_m3_1 l=3 w=3
X1915 B11 TOP sky130_fd_pr__cap_mim_m3_1 l=3 w=3
X1916 B11 TOP sky130_fd_pr__cap_mim_m3_1 l=3 w=3
X1917 B11 TOP sky130_fd_pr__cap_mim_m3_1 l=3 w=3
X1918 B10 TOP sky130_fd_pr__cap_mim_m3_1 l=3 w=3
X1919 B8 TOP sky130_fd_pr__cap_mim_m3_1 l=3 w=3
X1920 B10 TOP sky130_fd_pr__cap_mim_m3_1 l=3 w=3
X1921 B11 TOP sky130_fd_pr__cap_mim_m3_1 l=3 w=3
X1922 B10 TOP sky130_fd_pr__cap_mim_m3_1 l=3 w=3
X1923 B11 TOP sky130_fd_pr__cap_mim_m3_1 l=3 w=3
X1924 B11 TOP sky130_fd_pr__cap_mim_m3_1 l=3 w=3
X1925 B10 TOP sky130_fd_pr__cap_mim_m3_1 l=3 w=3
X1926 B11 TOP sky130_fd_pr__cap_mim_m3_1 l=3 w=3
X1927 B10 TOP sky130_fd_pr__cap_mim_m3_1 l=3 w=3
X1928 B10 TOP sky130_fd_pr__cap_mim_m3_1 l=3 w=3
X1929 B10 TOP sky130_fd_pr__cap_mim_m3_1 l=3 w=3
X1930 B11 TOP sky130_fd_pr__cap_mim_m3_1 l=3 w=3
X1931 B10 TOP sky130_fd_pr__cap_mim_m3_1 l=3 w=3
X1932 B10 TOP sky130_fd_pr__cap_mim_m3_1 l=3 w=3
X1933 B10 TOP sky130_fd_pr__cap_mim_m3_1 l=3 w=3
X1934 B11 TOP sky130_fd_pr__cap_mim_m3_1 l=3 w=3
X1935 B3 TOP sky130_fd_pr__cap_mim_m3_1 l=3 w=3
X1936 B11 TOP sky130_fd_pr__cap_mim_m3_1 l=3 w=3
X1937 B10 TOP sky130_fd_pr__cap_mim_m3_1 l=3 w=3
X1938 B9 TOP sky130_fd_pr__cap_mim_m3_1 l=3 w=3
X1939 B10 TOP sky130_fd_pr__cap_mim_m3_1 l=3 w=3
X1940 B11 TOP sky130_fd_pr__cap_mim_m3_1 l=3 w=3
X1941 B10 TOP sky130_fd_pr__cap_mim_m3_1 l=3 w=3
X1942 B6 TOP sky130_fd_pr__cap_mim_m3_1 l=3 w=3
X1943 B9 TOP sky130_fd_pr__cap_mim_m3_1 l=3 w=3
X1944 B11 TOP sky130_fd_pr__cap_mim_m3_1 l=3 w=3
X1945 B10 TOP sky130_fd_pr__cap_mim_m3_1 l=3 w=3
X1946 B11 TOP sky130_fd_pr__cap_mim_m3_1 l=3 w=3
X1947 B11 TOP sky130_fd_pr__cap_mim_m3_1 l=3 w=3
X1948 B11 TOP sky130_fd_pr__cap_mim_m3_1 l=3 w=3
X1949 B11 TOP sky130_fd_pr__cap_mim_m3_1 l=3 w=3
X1950 B10 TOP sky130_fd_pr__cap_mim_m3_1 l=3 w=3
X1951 B8 TOP sky130_fd_pr__cap_mim_m3_1 l=3 w=3
X1952 B11 TOP sky130_fd_pr__cap_mim_m3_1 l=3 w=3
X1953 B10 TOP sky130_fd_pr__cap_mim_m3_1 l=3 w=3
X1954 B9 TOP sky130_fd_pr__cap_mim_m3_1 l=3 w=3
X1955 B11 TOP sky130_fd_pr__cap_mim_m3_1 l=3 w=3
X1956 B7 TOP sky130_fd_pr__cap_mim_m3_1 l=3 w=3
X1957 B11 TOP sky130_fd_pr__cap_mim_m3_1 l=3 w=3
X1958 B9 TOP sky130_fd_pr__cap_mim_m3_1 l=3 w=3
X1959 B11 TOP sky130_fd_pr__cap_mim_m3_1 l=3 w=3
X1960 B11 TOP sky130_fd_pr__cap_mim_m3_1 l=3 w=3
X1961 B11 TOP sky130_fd_pr__cap_mim_m3_1 l=3 w=3
X1962 B9 TOP sky130_fd_pr__cap_mim_m3_1 l=3 w=3
X1963 B10 TOP sky130_fd_pr__cap_mim_m3_1 l=3 w=3
X1964 B7 TOP sky130_fd_pr__cap_mim_m3_1 l=3 w=3
X1965 B11 TOP sky130_fd_pr__cap_mim_m3_1 l=3 w=3
X1966 B11 TOP sky130_fd_pr__cap_mim_m3_1 l=3 w=3
X1967 B10 TOP sky130_fd_pr__cap_mim_m3_1 l=3 w=3
X1968 B11 TOP sky130_fd_pr__cap_mim_m3_1 l=3 w=3
X1969 B11 TOP sky130_fd_pr__cap_mim_m3_1 l=3 w=3
X1970 B10 TOP sky130_fd_pr__cap_mim_m3_1 l=3 w=3
X1971 B10 TOP sky130_fd_pr__cap_mim_m3_1 l=3 w=3
X1972 B9 TOP sky130_fd_pr__cap_mim_m3_1 l=3 w=3
X1973 B9 TOP sky130_fd_pr__cap_mim_m3_1 l=3 w=3
X1974 B11 TOP sky130_fd_pr__cap_mim_m3_1 l=3 w=3
X1975 B8 TOP sky130_fd_pr__cap_mim_m3_1 l=3 w=3
X1976 B9 TOP sky130_fd_pr__cap_mim_m3_1 l=3 w=3
X1977 B10 TOP sky130_fd_pr__cap_mim_m3_1 l=3 w=3
X1978 B10 TOP sky130_fd_pr__cap_mim_m3_1 l=3 w=3
X1979 B8 TOP sky130_fd_pr__cap_mim_m3_1 l=3 w=3
X1980 EDGE_BIAS EDGE_BIAS sky130_fd_pr__cap_mim_m3_1 l=3 w=3
X1981 B10 TOP sky130_fd_pr__cap_mim_m3_1 l=3 w=3
X1982 B10 TOP sky130_fd_pr__cap_mim_m3_1 l=3 w=3
X1983 B5 TOP sky130_fd_pr__cap_mim_m3_1 l=3 w=3
X1984 B11 TOP sky130_fd_pr__cap_mim_m3_1 l=3 w=3
X1985 B11 TOP sky130_fd_pr__cap_mim_m3_1 l=3 w=3
X1986 B11 TOP sky130_fd_pr__cap_mim_m3_1 l=3 w=3
X1987 EDGE_BIAS EDGE_BIAS sky130_fd_pr__cap_mim_m3_1 l=3 w=3
X1988 B4 TOP sky130_fd_pr__cap_mim_m3_1 l=3 w=3
X1989 B10 TOP sky130_fd_pr__cap_mim_m3_1 l=3 w=3
X1990 B6 TOP sky130_fd_pr__cap_mim_m3_1 l=3 w=3
X1991 B11 TOP sky130_fd_pr__cap_mim_m3_1 l=3 w=3
X1992 EDGE_BIAS EDGE_BIAS sky130_fd_pr__cap_mim_m3_1 l=3 w=3
X1993 B11 TOP sky130_fd_pr__cap_mim_m3_1 l=3 w=3
X1994 EDGE_BIAS EDGE_BIAS sky130_fd_pr__cap_mim_m3_1 l=3 w=3
X1995 B11 TOP sky130_fd_pr__cap_mim_m3_1 l=3 w=3
X1996 B8 TOP sky130_fd_pr__cap_mim_m3_1 l=3 w=3
X1997 B8 TOP sky130_fd_pr__cap_mim_m3_1 l=3 w=3
X1998 B11 TOP sky130_fd_pr__cap_mim_m3_1 l=3 w=3
X1999 B11 TOP sky130_fd_pr__cap_mim_m3_1 l=3 w=3
X2000 B10 TOP sky130_fd_pr__cap_mim_m3_1 l=3 w=3
X2001 B9 TOP sky130_fd_pr__cap_mim_m3_1 l=3 w=3
X2002 B11 TOP sky130_fd_pr__cap_mim_m3_1 l=3 w=3
X2003 B7 TOP sky130_fd_pr__cap_mim_m3_1 l=3 w=3
X2004 B9 TOP sky130_fd_pr__cap_mim_m3_1 l=3 w=3
X2005 B9 TOP sky130_fd_pr__cap_mim_m3_1 l=3 w=3
X2006 B10 TOP sky130_fd_pr__cap_mim_m3_1 l=3 w=3
X2007 B10 TOP sky130_fd_pr__cap_mim_m3_1 l=3 w=3
X2008 B11 TOP sky130_fd_pr__cap_mim_m3_1 l=3 w=3
X2009 B11 TOP sky130_fd_pr__cap_mim_m3_1 l=3 w=3
X2010 B9 TOP sky130_fd_pr__cap_mim_m3_1 l=3 w=3
X2011 B10 TOP sky130_fd_pr__cap_mim_m3_1 l=3 w=3
X2012 B11 TOP sky130_fd_pr__cap_mim_m3_1 l=3 w=3
X2013 B9 TOP sky130_fd_pr__cap_mim_m3_1 l=3 w=3
X2014 EDGE_BIAS EDGE_BIAS sky130_fd_pr__cap_mim_m3_1 l=3 w=3
X2015 B10 TOP sky130_fd_pr__cap_mim_m3_1 l=3 w=3
X2016 B11 TOP sky130_fd_pr__cap_mim_m3_1 l=3 w=3
X2017 B11 TOP sky130_fd_pr__cap_mim_m3_1 l=3 w=3
X2018 B10 TOP sky130_fd_pr__cap_mim_m3_1 l=3 w=3
X2019 B11 TOP sky130_fd_pr__cap_mim_m3_1 l=3 w=3
X2020 B11 TOP sky130_fd_pr__cap_mim_m3_1 l=3 w=3
X2021 B11 TOP sky130_fd_pr__cap_mim_m3_1 l=3 w=3
X2022 B11 TOP sky130_fd_pr__cap_mim_m3_1 l=3 w=3
X2023 B10 TOP sky130_fd_pr__cap_mim_m3_1 l=3 w=3
X2024 B9 TOP sky130_fd_pr__cap_mim_m3_1 l=3 w=3
X2025 B11 TOP sky130_fd_pr__cap_mim_m3_1 l=3 w=3
X2026 B10 TOP sky130_fd_pr__cap_mim_m3_1 l=3 w=3
X2027 B11 TOP sky130_fd_pr__cap_mim_m3_1 l=3 w=3
X2028 B11 TOP sky130_fd_pr__cap_mim_m3_1 l=3 w=3
X2029 B11 TOP sky130_fd_pr__cap_mim_m3_1 l=3 w=3
X2030 B11 TOP sky130_fd_pr__cap_mim_m3_1 l=3 w=3
X2031 B10 TOP sky130_fd_pr__cap_mim_m3_1 l=3 w=3
X2032 B10 TOP sky130_fd_pr__cap_mim_m3_1 l=3 w=3
X2033 B8 TOP sky130_fd_pr__cap_mim_m3_1 l=3 w=3
X2034 B11 TOP sky130_fd_pr__cap_mim_m3_1 l=3 w=3
X2035 B10 TOP sky130_fd_pr__cap_mim_m3_1 l=3 w=3
X2036 B11 TOP sky130_fd_pr__cap_mim_m3_1 l=3 w=3
X2037 B4 TOP sky130_fd_pr__cap_mim_m3_1 l=3 w=3
X2038 B11 TOP sky130_fd_pr__cap_mim_m3_1 l=3 w=3
X2039 B9 TOP sky130_fd_pr__cap_mim_m3_1 l=3 w=3
X2040 B10 TOP sky130_fd_pr__cap_mim_m3_1 l=3 w=3
X2041 B5 TOP sky130_fd_pr__cap_mim_m3_1 l=3 w=3
X2042 B11 TOP sky130_fd_pr__cap_mim_m3_1 l=3 w=3
X2043 B10 TOP sky130_fd_pr__cap_mim_m3_1 l=3 w=3
X2044 B11 TOP sky130_fd_pr__cap_mim_m3_1 l=3 w=3
X2045 B11 TOP sky130_fd_pr__cap_mim_m3_1 l=3 w=3
X2046 B11 TOP sky130_fd_pr__cap_mim_m3_1 l=3 w=3
X2047 B11 TOP sky130_fd_pr__cap_mim_m3_1 l=3 w=3
X2048 B11 TOP sky130_fd_pr__cap_mim_m3_1 l=3 w=3
X2049 B11 TOP sky130_fd_pr__cap_mim_m3_1 l=3 w=3
X2050 B11 TOP sky130_fd_pr__cap_mim_m3_1 l=3 w=3
X2051 B11 TOP sky130_fd_pr__cap_mim_m3_1 l=3 w=3
X2052 B10 TOP sky130_fd_pr__cap_mim_m3_1 l=3 w=3
X2053 B11 TOP sky130_fd_pr__cap_mim_m3_1 l=3 w=3
X2054 B11 TOP sky130_fd_pr__cap_mim_m3_1 l=3 w=3
X2055 B9 TOP sky130_fd_pr__cap_mim_m3_1 l=3 w=3
X2056 B3 TOP sky130_fd_pr__cap_mim_m3_1 l=3 w=3
X2057 B9 TOP sky130_fd_pr__cap_mim_m3_1 l=3 w=3
X2058 B11 TOP sky130_fd_pr__cap_mim_m3_1 l=3 w=3
X2059 B11 TOP sky130_fd_pr__cap_mim_m3_1 l=3 w=3
X2060 B10 TOP sky130_fd_pr__cap_mim_m3_1 l=3 w=3
X2061 B10 TOP sky130_fd_pr__cap_mim_m3_1 l=3 w=3
X2062 B10 TOP sky130_fd_pr__cap_mim_m3_1 l=3 w=3
X2063 EDGE_BIAS EDGE_BIAS sky130_fd_pr__cap_mim_m3_1 l=3 w=3
X2064 B11 TOP sky130_fd_pr__cap_mim_m3_1 l=3 w=3
X2065 B9 TOP sky130_fd_pr__cap_mim_m3_1 l=3 w=3
X2066 B11 TOP sky130_fd_pr__cap_mim_m3_1 l=3 w=3
X2067 B10 TOP sky130_fd_pr__cap_mim_m3_1 l=3 w=3
X2068 B10 TOP sky130_fd_pr__cap_mim_m3_1 l=3 w=3
X2069 B11 TOP sky130_fd_pr__cap_mim_m3_1 l=3 w=3
X2070 B11 TOP sky130_fd_pr__cap_mim_m3_1 l=3 w=3
X2071 EDGE_BIAS EDGE_BIAS sky130_fd_pr__cap_mim_m3_1 l=3 w=3
X2072 B11 TOP sky130_fd_pr__cap_mim_m3_1 l=3 w=3
X2073 B10 TOP sky130_fd_pr__cap_mim_m3_1 l=3 w=3
X2074 B10 TOP sky130_fd_pr__cap_mim_m3_1 l=3 w=3
X2075 B10 TOP sky130_fd_pr__cap_mim_m3_1 l=3 w=3
X2076 B10 TOP sky130_fd_pr__cap_mim_m3_1 l=3 w=3
X2077 B8 TOP sky130_fd_pr__cap_mim_m3_1 l=3 w=3
X2078 B10 TOP sky130_fd_pr__cap_mim_m3_1 l=3 w=3
X2079 B11 TOP sky130_fd_pr__cap_mim_m3_1 l=3 w=3
X2080 B10 TOP sky130_fd_pr__cap_mim_m3_1 l=3 w=3
X2081 B8 TOP sky130_fd_pr__cap_mim_m3_1 l=3 w=3
X2082 B11 TOP sky130_fd_pr__cap_mim_m3_1 l=3 w=3
X2083 B11 TOP sky130_fd_pr__cap_mim_m3_1 l=3 w=3
X2084 B9 TOP sky130_fd_pr__cap_mim_m3_1 l=3 w=3
X2085 B10 TOP sky130_fd_pr__cap_mim_m3_1 l=3 w=3
X2086 B6 TOP sky130_fd_pr__cap_mim_m3_1 l=3 w=3
X2087 B11 TOP sky130_fd_pr__cap_mim_m3_1 l=3 w=3
X2088 B10 TOP sky130_fd_pr__cap_mim_m3_1 l=3 w=3
X2089 B9 TOP sky130_fd_pr__cap_mim_m3_1 l=3 w=3
X2090 B11 TOP sky130_fd_pr__cap_mim_m3_1 l=3 w=3
X2091 B10 TOP sky130_fd_pr__cap_mim_m3_1 l=3 w=3
X2092 B11 TOP sky130_fd_pr__cap_mim_m3_1 l=3 w=3
X2093 B8 TOP sky130_fd_pr__cap_mim_m3_1 l=3 w=3
X2094 B10 TOP sky130_fd_pr__cap_mim_m3_1 l=3 w=3
X2095 B9 TOP sky130_fd_pr__cap_mim_m3_1 l=3 w=3
X2096 B6 TOP sky130_fd_pr__cap_mim_m3_1 l=3 w=3
X2097 B11 TOP sky130_fd_pr__cap_mim_m3_1 l=3 w=3
X2098 B11 TOP sky130_fd_pr__cap_mim_m3_1 l=3 w=3
X2099 B7 TOP sky130_fd_pr__cap_mim_m3_1 l=3 w=3
X2100 B11 TOP sky130_fd_pr__cap_mim_m3_1 l=3 w=3
X2101 B9 TOP sky130_fd_pr__cap_mim_m3_1 l=3 w=3
X2102 EDGE_BIAS EDGE_BIAS sky130_fd_pr__cap_mim_m3_1 l=3 w=3
X2103 B11 TOP sky130_fd_pr__cap_mim_m3_1 l=3 w=3
X2104 B11 TOP sky130_fd_pr__cap_mim_m3_1 l=3 w=3
X2105 B10 TOP sky130_fd_pr__cap_mim_m3_1 l=3 w=3
X2106 B9 TOP sky130_fd_pr__cap_mim_m3_1 l=3 w=3
X2107 B10 TOP sky130_fd_pr__cap_mim_m3_1 l=3 w=3
X2108 B9 TOP sky130_fd_pr__cap_mim_m3_1 l=3 w=3
X2109 B10 TOP sky130_fd_pr__cap_mim_m3_1 l=3 w=3
X2110 B11 TOP sky130_fd_pr__cap_mim_m3_1 l=3 w=3
X2111 B10 TOP sky130_fd_pr__cap_mim_m3_1 l=3 w=3
X2112 B11 TOP sky130_fd_pr__cap_mim_m3_1 l=3 w=3
X2113 B7 TOP sky130_fd_pr__cap_mim_m3_1 l=3 w=3
X2114 B10 TOP sky130_fd_pr__cap_mim_m3_1 l=3 w=3
X2115 B9 TOP sky130_fd_pr__cap_mim_m3_1 l=3 w=3
X2116 B8 TOP sky130_fd_pr__cap_mim_m3_1 l=3 w=3
X2117 B10 TOP sky130_fd_pr__cap_mim_m3_1 l=3 w=3
X2118 B11 TOP sky130_fd_pr__cap_mim_m3_1 l=3 w=3
X2119 B11 TOP sky130_fd_pr__cap_mim_m3_1 l=3 w=3
X2120 B10 TOP sky130_fd_pr__cap_mim_m3_1 l=3 w=3
X2121 B10 TOP sky130_fd_pr__cap_mim_m3_1 l=3 w=3
X2122 B8 TOP sky130_fd_pr__cap_mim_m3_1 l=3 w=3
X2123 B11 TOP sky130_fd_pr__cap_mim_m3_1 l=3 w=3
X2124 EDGE_BIAS EDGE_BIAS sky130_fd_pr__cap_mim_m3_1 l=3 w=3
X2125 B5 TOP sky130_fd_pr__cap_mim_m3_1 l=3 w=3
X2126 B11 TOP sky130_fd_pr__cap_mim_m3_1 l=3 w=3
X2127 EDGE_BIAS EDGE_BIAS sky130_fd_pr__cap_mim_m3_1 l=3 w=3
X2128 B10 TOP sky130_fd_pr__cap_mim_m3_1 l=3 w=3
X2129 B11 TOP sky130_fd_pr__cap_mim_m3_1 l=3 w=3
X2130 B9 TOP sky130_fd_pr__cap_mim_m3_1 l=3 w=3
X2131 B9 TOP sky130_fd_pr__cap_mim_m3_1 l=3 w=3
X2132 B9 TOP sky130_fd_pr__cap_mim_m3_1 l=3 w=3
X2133 B11 TOP sky130_fd_pr__cap_mim_m3_1 l=3 w=3
X2134 B5 TOP sky130_fd_pr__cap_mim_m3_1 l=3 w=3
X2135 B10 TOP sky130_fd_pr__cap_mim_m3_1 l=3 w=3
X2136 B6 TOP sky130_fd_pr__cap_mim_m3_1 l=3 w=3
X2137 B11 TOP sky130_fd_pr__cap_mim_m3_1 l=3 w=3
X2138 B9 TOP sky130_fd_pr__cap_mim_m3_1 l=3 w=3
X2139 EDGE_BIAS EDGE_BIAS sky130_fd_pr__cap_mim_m3_1 l=3 w=3
X2140 B11 TOP sky130_fd_pr__cap_mim_m3_1 l=3 w=3
X2141 B11 TOP sky130_fd_pr__cap_mim_m3_1 l=3 w=3
X2142 B11 TOP sky130_fd_pr__cap_mim_m3_1 l=3 w=3
X2143 B11 TOP sky130_fd_pr__cap_mim_m3_1 l=3 w=3
X2144 B11 TOP sky130_fd_pr__cap_mim_m3_1 l=3 w=3
X2145 B11 TOP sky130_fd_pr__cap_mim_m3_1 l=3 w=3
X2146 B10 TOP sky130_fd_pr__cap_mim_m3_1 l=3 w=3
X2147 B11 TOP sky130_fd_pr__cap_mim_m3_1 l=3 w=3
X2148 B7 TOP sky130_fd_pr__cap_mim_m3_1 l=3 w=3
X2149 B11 TOP sky130_fd_pr__cap_mim_m3_1 l=3 w=3
X2150 B11 TOP sky130_fd_pr__cap_mim_m3_1 l=3 w=3
X2151 B9 TOP sky130_fd_pr__cap_mim_m3_1 l=3 w=3
X2152 B10 TOP sky130_fd_pr__cap_mim_m3_1 l=3 w=3
X2153 B10 TOP sky130_fd_pr__cap_mim_m3_1 l=3 w=3
X2154 EDGE_BIAS EDGE_BIAS sky130_fd_pr__cap_mim_m3_1 l=3 w=3
X2155 B9 TOP sky130_fd_pr__cap_mim_m3_1 l=3 w=3
X2156 B11 TOP sky130_fd_pr__cap_mim_m3_1 l=3 w=3
X2157 B9 TOP sky130_fd_pr__cap_mim_m3_1 l=3 w=3
X2158 B11 TOP sky130_fd_pr__cap_mim_m3_1 l=3 w=3
X2159 B10 TOP sky130_fd_pr__cap_mim_m3_1 l=3 w=3
X2160 B10 TOP sky130_fd_pr__cap_mim_m3_1 l=3 w=3
X2161 B10 TOP sky130_fd_pr__cap_mim_m3_1 l=3 w=3
X2162 B11 TOP sky130_fd_pr__cap_mim_m3_1 l=3 w=3
X2163 EDGE_BIAS EDGE_BIAS sky130_fd_pr__cap_mim_m3_1 l=3 w=3
X2164 B11 TOP sky130_fd_pr__cap_mim_m3_1 l=3 w=3
X2165 B10 TOP sky130_fd_pr__cap_mim_m3_1 l=3 w=3
X2166 B6 TOP sky130_fd_pr__cap_mim_m3_1 l=3 w=3
X2167 B10 TOP sky130_fd_pr__cap_mim_m3_1 l=3 w=3
X2168 B11 TOP sky130_fd_pr__cap_mim_m3_1 l=3 w=3
X2169 B9 TOP sky130_fd_pr__cap_mim_m3_1 l=3 w=3
X2170 B10 TOP sky130_fd_pr__cap_mim_m3_1 l=3 w=3
X2171 B11 TOP sky130_fd_pr__cap_mim_m3_1 l=3 w=3
X2172 B11 TOP sky130_fd_pr__cap_mim_m3_1 l=3 w=3
X2173 B9 TOP sky130_fd_pr__cap_mim_m3_1 l=3 w=3
X2174 B11 TOP sky130_fd_pr__cap_mim_m3_1 l=3 w=3
X2175 B10 TOP sky130_fd_pr__cap_mim_m3_1 l=3 w=3
X2176 B8 TOP sky130_fd_pr__cap_mim_m3_1 l=3 w=3
X2177 B11 TOP sky130_fd_pr__cap_mim_m3_1 l=3 w=3
X2178 B11 TOP sky130_fd_pr__cap_mim_m3_1 l=3 w=3
X2179 B10 TOP sky130_fd_pr__cap_mim_m3_1 l=3 w=3
X2180 B11 TOP sky130_fd_pr__cap_mim_m3_1 l=3 w=3
X2181 B11 TOP sky130_fd_pr__cap_mim_m3_1 l=3 w=3
X2182 B11 TOP sky130_fd_pr__cap_mim_m3_1 l=3 w=3
X2183 B10 TOP sky130_fd_pr__cap_mim_m3_1 l=3 w=3
X2184 B9 TOP sky130_fd_pr__cap_mim_m3_1 l=3 w=3
X2185 B9 TOP sky130_fd_pr__cap_mim_m3_1 l=3 w=3
X2186 B11 TOP sky130_fd_pr__cap_mim_m3_1 l=3 w=3
X2187 B6 TOP sky130_fd_pr__cap_mim_m3_1 l=3 w=3
X2188 B11 TOP sky130_fd_pr__cap_mim_m3_1 l=3 w=3
X2189 B11 TOP sky130_fd_pr__cap_mim_m3_1 l=3 w=3
X2190 B11 TOP sky130_fd_pr__cap_mim_m3_1 l=3 w=3
X2191 B10 TOP sky130_fd_pr__cap_mim_m3_1 l=3 w=3
X2192 B11 TOP sky130_fd_pr__cap_mim_m3_1 l=3 w=3
X2193 B10 TOP sky130_fd_pr__cap_mim_m3_1 l=3 w=3
X2194 B11 TOP sky130_fd_pr__cap_mim_m3_1 l=3 w=3
X2195 B11 TOP sky130_fd_pr__cap_mim_m3_1 l=3 w=3
X2196 B9 TOP sky130_fd_pr__cap_mim_m3_1 l=3 w=3
X2197 B11 TOP sky130_fd_pr__cap_mim_m3_1 l=3 w=3
X2198 B11 TOP sky130_fd_pr__cap_mim_m3_1 l=3 w=3
X2199 B10 TOP sky130_fd_pr__cap_mim_m3_1 l=3 w=3
X2200 B11 TOP sky130_fd_pr__cap_mim_m3_1 l=3 w=3
X2201 B11 TOP sky130_fd_pr__cap_mim_m3_1 l=3 w=3
X2202 B11 TOP sky130_fd_pr__cap_mim_m3_1 l=3 w=3
X2203 B11 TOP sky130_fd_pr__cap_mim_m3_1 l=3 w=3
X2204 B7 TOP sky130_fd_pr__cap_mim_m3_1 l=3 w=3
X2205 B9 TOP sky130_fd_pr__cap_mim_m3_1 l=3 w=3
X2206 B11 TOP sky130_fd_pr__cap_mim_m3_1 l=3 w=3
X2207 B11 TOP sky130_fd_pr__cap_mim_m3_1 l=3 w=3
X2208 B10 TOP sky130_fd_pr__cap_mim_m3_1 l=3 w=3
X2209 B10 TOP sky130_fd_pr__cap_mim_m3_1 l=3 w=3
X2210 B10 TOP sky130_fd_pr__cap_mim_m3_1 l=3 w=3
X2211 B11 TOP sky130_fd_pr__cap_mim_m3_1 l=3 w=3
X2212 B10 TOP sky130_fd_pr__cap_mim_m3_1 l=3 w=3
X2213 B9 TOP sky130_fd_pr__cap_mim_m3_1 l=3 w=3
X2214 B11 TOP sky130_fd_pr__cap_mim_m3_1 l=3 w=3
X2215 B10 TOP sky130_fd_pr__cap_mim_m3_1 l=3 w=3
X2216 EDGE_BIAS EDGE_BIAS sky130_fd_pr__cap_mim_m3_1 l=3 w=3
X2217 B11 TOP sky130_fd_pr__cap_mim_m3_1 l=3 w=3
X2218 B10 TOP sky130_fd_pr__cap_mim_m3_1 l=3 w=3
X2219 B7 TOP sky130_fd_pr__cap_mim_m3_1 l=3 w=3
X2220 B10 TOP sky130_fd_pr__cap_mim_m3_1 l=3 w=3
X2221 B10 TOP sky130_fd_pr__cap_mim_m3_1 l=3 w=3
X2222 B9 TOP sky130_fd_pr__cap_mim_m3_1 l=3 w=3
X2223 B11 TOP sky130_fd_pr__cap_mim_m3_1 l=3 w=3
X2224 B10 TOP sky130_fd_pr__cap_mim_m3_1 l=3 w=3
X2225 B9 TOP sky130_fd_pr__cap_mim_m3_1 l=3 w=3
X2226 B10 TOP sky130_fd_pr__cap_mim_m3_1 l=3 w=3
X2227 EDGE_BIAS EDGE_BIAS sky130_fd_pr__cap_mim_m3_1 l=3 w=3
X2228 B11 TOP sky130_fd_pr__cap_mim_m3_1 l=3 w=3
X2229 B10 TOP sky130_fd_pr__cap_mim_m3_1 l=3 w=3
X2230 B11 TOP sky130_fd_pr__cap_mim_m3_1 l=3 w=3
X2231 B11 TOP sky130_fd_pr__cap_mim_m3_1 l=3 w=3
X2232 B10 TOP sky130_fd_pr__cap_mim_m3_1 l=3 w=3
X2233 B11 TOP sky130_fd_pr__cap_mim_m3_1 l=3 w=3
X2234 B10 TOP sky130_fd_pr__cap_mim_m3_1 l=3 w=3
X2235 B9 TOP sky130_fd_pr__cap_mim_m3_1 l=3 w=3
X2236 B11 TOP sky130_fd_pr__cap_mim_m3_1 l=3 w=3
X2237 B9 TOP sky130_fd_pr__cap_mim_m3_1 l=3 w=3
X2238 B11 TOP sky130_fd_pr__cap_mim_m3_1 l=3 w=3
X2239 B11 TOP sky130_fd_pr__cap_mim_m3_1 l=3 w=3
X2240 B6 TOP sky130_fd_pr__cap_mim_m3_1 l=3 w=3
X2241 B11 TOP sky130_fd_pr__cap_mim_m3_1 l=3 w=3
X2242 B11 TOP sky130_fd_pr__cap_mim_m3_1 l=3 w=3
X2243 B9 TOP sky130_fd_pr__cap_mim_m3_1 l=3 w=3
X2244 EDGE_BIAS EDGE_BIAS sky130_fd_pr__cap_mim_m3_1 l=3 w=3
X2245 B11 TOP sky130_fd_pr__cap_mim_m3_1 l=3 w=3
X2246 B11 TOP sky130_fd_pr__cap_mim_m3_1 l=3 w=3
X2247 B11 TOP sky130_fd_pr__cap_mim_m3_1 l=3 w=3
X2248 B8 TOP sky130_fd_pr__cap_mim_m3_1 l=3 w=3
X2249 B8 TOP sky130_fd_pr__cap_mim_m3_1 l=3 w=3
X2250 B11 TOP sky130_fd_pr__cap_mim_m3_1 l=3 w=3
X2251 B11 TOP sky130_fd_pr__cap_mim_m3_1 l=3 w=3
X2252 B11 TOP sky130_fd_pr__cap_mim_m3_1 l=3 w=3
X2253 B7 TOP sky130_fd_pr__cap_mim_m3_1 l=3 w=3
X2254 B7 TOP sky130_fd_pr__cap_mim_m3_1 l=3 w=3
X2255 B11 TOP sky130_fd_pr__cap_mim_m3_1 l=3 w=3
X2256 B11 TOP sky130_fd_pr__cap_mim_m3_1 l=3 w=3
X2257 B9 TOP sky130_fd_pr__cap_mim_m3_1 l=3 w=3
X2258 B10 TOP sky130_fd_pr__cap_mim_m3_1 l=3 w=3
X2259 B8 TOP sky130_fd_pr__cap_mim_m3_1 l=3 w=3
X2260 B9 TOP sky130_fd_pr__cap_mim_m3_1 l=3 w=3
X2261 B9 TOP sky130_fd_pr__cap_mim_m3_1 l=3 w=3
X2262 B10 TOP sky130_fd_pr__cap_mim_m3_1 l=3 w=3
X2263 B10 TOP sky130_fd_pr__cap_mim_m3_1 l=3 w=3
X2264 B11 TOP sky130_fd_pr__cap_mim_m3_1 l=3 w=3
X2265 B10 TOP sky130_fd_pr__cap_mim_m3_1 l=3 w=3
X2266 B11 TOP sky130_fd_pr__cap_mim_m3_1 l=3 w=3
X2267 B10 TOP sky130_fd_pr__cap_mim_m3_1 l=3 w=3
X2268 B11 TOP sky130_fd_pr__cap_mim_m3_1 l=3 w=3
X2269 B10 TOP sky130_fd_pr__cap_mim_m3_1 l=3 w=3
X2270 EDGE_BIAS EDGE_BIAS sky130_fd_pr__cap_mim_m3_1 l=3 w=3
X2271 B10 TOP sky130_fd_pr__cap_mim_m3_1 l=3 w=3
X2272 B9 TOP sky130_fd_pr__cap_mim_m3_1 l=3 w=3
X2273 B11 TOP sky130_fd_pr__cap_mim_m3_1 l=3 w=3
X2274 B10 TOP sky130_fd_pr__cap_mim_m3_1 l=3 w=3
X2275 B9 TOP sky130_fd_pr__cap_mim_m3_1 l=3 w=3
X2276 EDGE_BIAS EDGE_BIAS sky130_fd_pr__cap_mim_m3_1 l=3 w=3
X2277 B11 TOP sky130_fd_pr__cap_mim_m3_1 l=3 w=3
X2278 B8 TOP sky130_fd_pr__cap_mim_m3_1 l=3 w=3
X2279 B10 TOP sky130_fd_pr__cap_mim_m3_1 l=3 w=3
X2280 B3 TOP sky130_fd_pr__cap_mim_m3_1 l=3 w=3
X2281 B11 TOP sky130_fd_pr__cap_mim_m3_1 l=3 w=3
X2282 B9 TOP sky130_fd_pr__cap_mim_m3_1 l=3 w=3
X2283 B9 TOP sky130_fd_pr__cap_mim_m3_1 l=3 w=3
X2284 B10 TOP sky130_fd_pr__cap_mim_m3_1 l=3 w=3
X2285 B9 TOP sky130_fd_pr__cap_mim_m3_1 l=3 w=3
X2286 B9 TOP sky130_fd_pr__cap_mim_m3_1 l=3 w=3
X2287 B11 TOP sky130_fd_pr__cap_mim_m3_1 l=3 w=3
X2288 B10 TOP sky130_fd_pr__cap_mim_m3_1 l=3 w=3
X2289 B0 TOP sky130_fd_pr__cap_mim_m3_1 l=3 w=3
X2290 B11 TOP sky130_fd_pr__cap_mim_m3_1 l=3 w=3
X2291 B10 TOP sky130_fd_pr__cap_mim_m3_1 l=3 w=3
X2292 B9 TOP sky130_fd_pr__cap_mim_m3_1 l=3 w=3
X2293 B11 TOP sky130_fd_pr__cap_mim_m3_1 l=3 w=3
X2294 B9 TOP sky130_fd_pr__cap_mim_m3_1 l=3 w=3
X2295 B11 TOP sky130_fd_pr__cap_mim_m3_1 l=3 w=3
X2296 B11 TOP sky130_fd_pr__cap_mim_m3_1 l=3 w=3
X2297 B11 TOP sky130_fd_pr__cap_mim_m3_1 l=3 w=3
X2298 B11 TOP sky130_fd_pr__cap_mim_m3_1 l=3 w=3
X2299 B11 TOP sky130_fd_pr__cap_mim_m3_1 l=3 w=3
X2300 B11 TOP sky130_fd_pr__cap_mim_m3_1 l=3 w=3
X2301 B11 TOP sky130_fd_pr__cap_mim_m3_1 l=3 w=3
X2302 B10 TOP sky130_fd_pr__cap_mim_m3_1 l=3 w=3
X2303 B7 TOP sky130_fd_pr__cap_mim_m3_1 l=3 w=3
X2304 B11 TOP sky130_fd_pr__cap_mim_m3_1 l=3 w=3
X2305 B7 TOP sky130_fd_pr__cap_mim_m3_1 l=3 w=3
X2306 B9 TOP sky130_fd_pr__cap_mim_m3_1 l=3 w=3
X2307 B11 TOP sky130_fd_pr__cap_mim_m3_1 l=3 w=3
X2308 B11 TOP sky130_fd_pr__cap_mim_m3_1 l=3 w=3
X2309 B11 TOP sky130_fd_pr__cap_mim_m3_1 l=3 w=3
X2310 EDGE_BIAS EDGE_BIAS sky130_fd_pr__cap_mim_m3_1 l=3 w=3
X2311 B10 TOP sky130_fd_pr__cap_mim_m3_1 l=3 w=3
X2312 B10 TOP sky130_fd_pr__cap_mim_m3_1 l=3 w=3
X2313 B9 TOP sky130_fd_pr__cap_mim_m3_1 l=3 w=3
X2314 B8 TOP sky130_fd_pr__cap_mim_m3_1 l=3 w=3
X2315 B10 TOP sky130_fd_pr__cap_mim_m3_1 l=3 w=3
X2316 B11 TOP sky130_fd_pr__cap_mim_m3_1 l=3 w=3
X2317 B11 TOP sky130_fd_pr__cap_mim_m3_1 l=3 w=3
X2318 B10 TOP sky130_fd_pr__cap_mim_m3_1 l=3 w=3
X2319 B10 TOP sky130_fd_pr__cap_mim_m3_1 l=3 w=3
X2320 B8 TOP sky130_fd_pr__cap_mim_m3_1 l=3 w=3
X2321 B10 TOP sky130_fd_pr__cap_mim_m3_1 l=3 w=3
X2322 B6 TOP sky130_fd_pr__cap_mim_m3_1 l=3 w=3
X2323 B10 TOP sky130_fd_pr__cap_mim_m3_1 l=3 w=3
X2324 B11 TOP sky130_fd_pr__cap_mim_m3_1 l=3 w=3
X2325 B10 TOP sky130_fd_pr__cap_mim_m3_1 l=3 w=3
X2326 B10 TOP sky130_fd_pr__cap_mim_m3_1 l=3 w=3
X2327 B11 TOP sky130_fd_pr__cap_mim_m3_1 l=3 w=3
X2328 B11 TOP sky130_fd_pr__cap_mim_m3_1 l=3 w=3
X2329 B11 TOP sky130_fd_pr__cap_mim_m3_1 l=3 w=3
X2330 B11 TOP sky130_fd_pr__cap_mim_m3_1 l=3 w=3
X2331 B11 TOP sky130_fd_pr__cap_mim_m3_1 l=3 w=3
X2332 B11 TOP sky130_fd_pr__cap_mim_m3_1 l=3 w=3
X2333 B8 TOP sky130_fd_pr__cap_mim_m3_1 l=3 w=3
X2334 B11 TOP sky130_fd_pr__cap_mim_m3_1 l=3 w=3
X2335 B10 TOP sky130_fd_pr__cap_mim_m3_1 l=3 w=3
X2336 B11 TOP sky130_fd_pr__cap_mim_m3_1 l=3 w=3
X2337 B9 TOP sky130_fd_pr__cap_mim_m3_1 l=3 w=3
X2338 B11 TOP sky130_fd_pr__cap_mim_m3_1 l=3 w=3
X2339 B10 TOP sky130_fd_pr__cap_mim_m3_1 l=3 w=3
X2340 B9 TOP sky130_fd_pr__cap_mim_m3_1 l=3 w=3
X2341 B11 TOP sky130_fd_pr__cap_mim_m3_1 l=3 w=3
X2342 B11 TOP sky130_fd_pr__cap_mim_m3_1 l=3 w=3
X2343 B11 TOP sky130_fd_pr__cap_mim_m3_1 l=3 w=3
X2344 B6 TOP sky130_fd_pr__cap_mim_m3_1 l=3 w=3
X2345 B11 TOP sky130_fd_pr__cap_mim_m3_1 l=3 w=3
X2346 B11 TOP sky130_fd_pr__cap_mim_m3_1 l=3 w=3
X2347 EDGE_BIAS EDGE_BIAS sky130_fd_pr__cap_mim_m3_1 l=3 w=3
X2348 B10 TOP sky130_fd_pr__cap_mim_m3_1 l=3 w=3
X2349 B9 TOP sky130_fd_pr__cap_mim_m3_1 l=3 w=3
X2350 B10 TOP sky130_fd_pr__cap_mim_m3_1 l=3 w=3
X2351 B8 TOP sky130_fd_pr__cap_mim_m3_1 l=3 w=3
X2352 B9 TOP sky130_fd_pr__cap_mim_m3_1 l=3 w=3
X2353 B10 TOP sky130_fd_pr__cap_mim_m3_1 l=3 w=3
X2354 B11 TOP sky130_fd_pr__cap_mim_m3_1 l=3 w=3
X2355 B11 TOP sky130_fd_pr__cap_mim_m3_1 l=3 w=3
X2356 B11 TOP sky130_fd_pr__cap_mim_m3_1 l=3 w=3
X2357 EDGE_BIAS EDGE_BIAS sky130_fd_pr__cap_mim_m3_1 l=3 w=3
X2358 B11 TOP sky130_fd_pr__cap_mim_m3_1 l=3 w=3
X2359 B11 TOP sky130_fd_pr__cap_mim_m3_1 l=3 w=3
X2360 B11 TOP sky130_fd_pr__cap_mim_m3_1 l=3 w=3
X2361 B10 TOP sky130_fd_pr__cap_mim_m3_1 l=3 w=3
X2362 B11 TOP sky130_fd_pr__cap_mim_m3_1 l=3 w=3
X2363 B11 TOP sky130_fd_pr__cap_mim_m3_1 l=3 w=3
X2364 B11 TOP sky130_fd_pr__cap_mim_m3_1 l=3 w=3
X2365 B10 TOP sky130_fd_pr__cap_mim_m3_1 l=3 w=3
X2366 B10 TOP sky130_fd_pr__cap_mim_m3_1 l=3 w=3
X2367 B11 TOP sky130_fd_pr__cap_mim_m3_1 l=3 w=3
X2368 B10 TOP sky130_fd_pr__cap_mim_m3_1 l=3 w=3
X2369 B10 TOP sky130_fd_pr__cap_mim_m3_1 l=3 w=3
X2370 B9 TOP sky130_fd_pr__cap_mim_m3_1 l=3 w=3
X2371 B10 TOP sky130_fd_pr__cap_mim_m3_1 l=3 w=3
X2372 B11 TOP sky130_fd_pr__cap_mim_m3_1 l=3 w=3
X2373 B11 TOP sky130_fd_pr__cap_mim_m3_1 l=3 w=3
X2374 B10 TOP sky130_fd_pr__cap_mim_m3_1 l=3 w=3
X2375 B10 TOP sky130_fd_pr__cap_mim_m3_1 l=3 w=3
X2376 B11 TOP sky130_fd_pr__cap_mim_m3_1 l=3 w=3
X2377 B10 TOP sky130_fd_pr__cap_mim_m3_1 l=3 w=3
X2378 B7 TOP sky130_fd_pr__cap_mim_m3_1 l=3 w=3
X2379 B5 TOP sky130_fd_pr__cap_mim_m3_1 l=3 w=3
X2380 B11 TOP sky130_fd_pr__cap_mim_m3_1 l=3 w=3
X2381 B10 TOP sky130_fd_pr__cap_mim_m3_1 l=3 w=3
X2382 B10 TOP sky130_fd_pr__cap_mim_m3_1 l=3 w=3
X2383 B10 TOP sky130_fd_pr__cap_mim_m3_1 l=3 w=3
X2384 B11 TOP sky130_fd_pr__cap_mim_m3_1 l=3 w=3
X2385 B10 TOP sky130_fd_pr__cap_mim_m3_1 l=3 w=3
X2386 B4 TOP sky130_fd_pr__cap_mim_m3_1 l=3 w=3
X2387 B11 TOP sky130_fd_pr__cap_mim_m3_1 l=3 w=3
X2388 B11 TOP sky130_fd_pr__cap_mim_m3_1 l=3 w=3
X2389 B11 TOP sky130_fd_pr__cap_mim_m3_1 l=3 w=3
X2390 B10 TOP sky130_fd_pr__cap_mim_m3_1 l=3 w=3
X2391 B10 TOP sky130_fd_pr__cap_mim_m3_1 l=3 w=3
X2392 B8 TOP sky130_fd_pr__cap_mim_m3_1 l=3 w=3
X2393 B11 TOP sky130_fd_pr__cap_mim_m3_1 l=3 w=3
X2394 B9 TOP sky130_fd_pr__cap_mim_m3_1 l=3 w=3
X2395 B10 TOP sky130_fd_pr__cap_mim_m3_1 l=3 w=3
X2396 B11 TOP sky130_fd_pr__cap_mim_m3_1 l=3 w=3
X2397 B11 TOP sky130_fd_pr__cap_mim_m3_1 l=3 w=3
X2398 B10 TOP sky130_fd_pr__cap_mim_m3_1 l=3 w=3
X2399 B8 TOP sky130_fd_pr__cap_mim_m3_1 l=3 w=3
X2400 B11 TOP sky130_fd_pr__cap_mim_m3_1 l=3 w=3
X2401 B11 TOP sky130_fd_pr__cap_mim_m3_1 l=3 w=3
X2402 B10 TOP sky130_fd_pr__cap_mim_m3_1 l=3 w=3
X2403 B9 TOP sky130_fd_pr__cap_mim_m3_1 l=3 w=3
X2404 B11 TOP sky130_fd_pr__cap_mim_m3_1 l=3 w=3
X2405 B9 TOP sky130_fd_pr__cap_mim_m3_1 l=3 w=3
X2406 B11 TOP sky130_fd_pr__cap_mim_m3_1 l=3 w=3
X2407 EDGE_BIAS EDGE_BIAS sky130_fd_pr__cap_mim_m3_1 l=3 w=3
X2408 B9 TOP sky130_fd_pr__cap_mim_m3_1 l=3 w=3
X2409 B11 TOP sky130_fd_pr__cap_mim_m3_1 l=3 w=3
X2410 B11 TOP sky130_fd_pr__cap_mim_m3_1 l=3 w=3
X2411 B11 TOP sky130_fd_pr__cap_mim_m3_1 l=3 w=3
X2412 B9 TOP sky130_fd_pr__cap_mim_m3_1 l=3 w=3
X2413 B11 TOP sky130_fd_pr__cap_mim_m3_1 l=3 w=3
X2414 B11 TOP sky130_fd_pr__cap_mim_m3_1 l=3 w=3
X2415 B10 TOP sky130_fd_pr__cap_mim_m3_1 l=3 w=3
X2416 B11 TOP sky130_fd_pr__cap_mim_m3_1 l=3 w=3
X2417 B11 TOP sky130_fd_pr__cap_mim_m3_1 l=3 w=3
X2418 B10 TOP sky130_fd_pr__cap_mim_m3_1 l=3 w=3
X2419 B11 TOP sky130_fd_pr__cap_mim_m3_1 l=3 w=3
X2420 B10 TOP sky130_fd_pr__cap_mim_m3_1 l=3 w=3
X2421 B10 TOP sky130_fd_pr__cap_mim_m3_1 l=3 w=3
X2422 B9 TOP sky130_fd_pr__cap_mim_m3_1 l=3 w=3
X2423 B7 TOP sky130_fd_pr__cap_mim_m3_1 l=3 w=3
X2424 B11 TOP sky130_fd_pr__cap_mim_m3_1 l=3 w=3
X2425 B7 TOP sky130_fd_pr__cap_mim_m3_1 l=3 w=3
X2426 B9 TOP sky130_fd_pr__cap_mim_m3_1 l=3 w=3
X2427 B9 TOP sky130_fd_pr__cap_mim_m3_1 l=3 w=3
X2428 B11 TOP sky130_fd_pr__cap_mim_m3_1 l=3 w=3
X2429 B10 TOP sky130_fd_pr__cap_mim_m3_1 l=3 w=3
X2430 B11 TOP sky130_fd_pr__cap_mim_m3_1 l=3 w=3
X2431 B10 TOP sky130_fd_pr__cap_mim_m3_1 l=3 w=3
X2432 B9 TOP sky130_fd_pr__cap_mim_m3_1 l=3 w=3
X2433 B8 TOP sky130_fd_pr__cap_mim_m3_1 l=3 w=3
X2434 B9 TOP sky130_fd_pr__cap_mim_m3_1 l=3 w=3
X2435 B10 TOP sky130_fd_pr__cap_mim_m3_1 l=3 w=3
X2436 B11 TOP sky130_fd_pr__cap_mim_m3_1 l=3 w=3
X2437 B10 TOP sky130_fd_pr__cap_mim_m3_1 l=3 w=3
X2438 B11 TOP sky130_fd_pr__cap_mim_m3_1 l=3 w=3
X2439 EDGE_BIAS EDGE_BIAS sky130_fd_pr__cap_mim_m3_1 l=3 w=3
X2440 B11 TOP sky130_fd_pr__cap_mim_m3_1 l=3 w=3
X2441 B10 TOP sky130_fd_pr__cap_mim_m3_1 l=3 w=3
X2442 B11 TOP sky130_fd_pr__cap_mim_m3_1 l=3 w=3
X2443 B6 TOP sky130_fd_pr__cap_mim_m3_1 l=3 w=3
X2444 B11 TOP sky130_fd_pr__cap_mim_m3_1 l=3 w=3
X2445 B10 TOP sky130_fd_pr__cap_mim_m3_1 l=3 w=3
X2446 B4 TOP sky130_fd_pr__cap_mim_m3_1 l=3 w=3
X2447 B10 TOP sky130_fd_pr__cap_mim_m3_1 l=3 w=3
X2448 B5 TOP sky130_fd_pr__cap_mim_m3_1 l=3 w=3
X2449 B11 TOP sky130_fd_pr__cap_mim_m3_1 l=3 w=3
X2450 B8 TOP sky130_fd_pr__cap_mim_m3_1 l=3 w=3
X2451 B11 TOP sky130_fd_pr__cap_mim_m3_1 l=3 w=3
X2452 B8 TOP sky130_fd_pr__cap_mim_m3_1 l=3 w=3
X2453 B11 TOP sky130_fd_pr__cap_mim_m3_1 l=3 w=3
X2454 B8 TOP sky130_fd_pr__cap_mim_m3_1 l=3 w=3
X2455 B11 TOP sky130_fd_pr__cap_mim_m3_1 l=3 w=3
X2456 EDGE_BIAS EDGE_BIAS sky130_fd_pr__cap_mim_m3_1 l=3 w=3
X2457 B8 TOP sky130_fd_pr__cap_mim_m3_1 l=3 w=3
X2458 B10 TOP sky130_fd_pr__cap_mim_m3_1 l=3 w=3
X2459 B10 TOP sky130_fd_pr__cap_mim_m3_1 l=3 w=3
X2460 B11 TOP sky130_fd_pr__cap_mim_m3_1 l=3 w=3
X2461 B9 TOP sky130_fd_pr__cap_mim_m3_1 l=3 w=3
X2462 B9 TOP sky130_fd_pr__cap_mim_m3_1 l=3 w=3
X2463 B10 TOP sky130_fd_pr__cap_mim_m3_1 l=3 w=3
X2464 B11 TOP sky130_fd_pr__cap_mim_m3_1 l=3 w=3
X2465 B7 TOP sky130_fd_pr__cap_mim_m3_1 l=3 w=3
X2466 B9 TOP sky130_fd_pr__cap_mim_m3_1 l=3 w=3
X2467 B11 TOP sky130_fd_pr__cap_mim_m3_1 l=3 w=3
X2468 B9 TOP sky130_fd_pr__cap_mim_m3_1 l=3 w=3
X2469 EDGE_BIAS EDGE_BIAS sky130_fd_pr__cap_mim_m3_1 l=3 w=3
X2470 B1 TOP sky130_fd_pr__cap_mim_m3_1 l=3 w=3
X2471 B9 TOP sky130_fd_pr__cap_mim_m3_1 l=3 w=3
X2472 B10 TOP sky130_fd_pr__cap_mim_m3_1 l=3 w=3
X2473 B10 TOP sky130_fd_pr__cap_mim_m3_1 l=3 w=3
X2474 EDGE_BIAS EDGE_BIAS sky130_fd_pr__cap_mim_m3_1 l=3 w=3
X2475 B11 TOP sky130_fd_pr__cap_mim_m3_1 l=3 w=3
X2476 B11 TOP sky130_fd_pr__cap_mim_m3_1 l=3 w=3
X2477 EDGE_BIAS EDGE_BIAS sky130_fd_pr__cap_mim_m3_1 l=3 w=3
X2478 B11 TOP sky130_fd_pr__cap_mim_m3_1 l=3 w=3
X2479 B11 TOP sky130_fd_pr__cap_mim_m3_1 l=3 w=3
X2480 B10 TOP sky130_fd_pr__cap_mim_m3_1 l=3 w=3
X2481 B11 TOP sky130_fd_pr__cap_mim_m3_1 l=3 w=3
X2482 B11 TOP sky130_fd_pr__cap_mim_m3_1 l=3 w=3
X2483 B11 TOP sky130_fd_pr__cap_mim_m3_1 l=3 w=3
X2484 B10 TOP sky130_fd_pr__cap_mim_m3_1 l=3 w=3
X2485 B11 TOP sky130_fd_pr__cap_mim_m3_1 l=3 w=3
X2486 B11 TOP sky130_fd_pr__cap_mim_m3_1 l=3 w=3
X2487 B10 TOP sky130_fd_pr__cap_mim_m3_1 l=3 w=3
X2488 B11 TOP sky130_fd_pr__cap_mim_m3_1 l=3 w=3
X2489 B11 TOP sky130_fd_pr__cap_mim_m3_1 l=3 w=3
X2490 B9 TOP sky130_fd_pr__cap_mim_m3_1 l=3 w=3
X2491 B11 TOP sky130_fd_pr__cap_mim_m3_1 l=3 w=3
X2492 B11 TOP sky130_fd_pr__cap_mim_m3_1 l=3 w=3
X2493 B10 TOP sky130_fd_pr__cap_mim_m3_1 l=3 w=3
X2494 B9 TOP sky130_fd_pr__cap_mim_m3_1 l=3 w=3
X2495 B8 TOP sky130_fd_pr__cap_mim_m3_1 l=3 w=3
X2496 B10 TOP sky130_fd_pr__cap_mim_m3_1 l=3 w=3
X2497 B11 TOP sky130_fd_pr__cap_mim_m3_1 l=3 w=3
X2498 B11 TOP sky130_fd_pr__cap_mim_m3_1 l=3 w=3
X2499 B10 TOP sky130_fd_pr__cap_mim_m3_1 l=3 w=3
X2500 B8 TOP sky130_fd_pr__cap_mim_m3_1 l=3 w=3
X2501 B10 TOP sky130_fd_pr__cap_mim_m3_1 l=3 w=3
X2502 B6 TOP sky130_fd_pr__cap_mim_m3_1 l=3 w=3
X2503 B11 TOP sky130_fd_pr__cap_mim_m3_1 l=3 w=3
X2504 B11 TOP sky130_fd_pr__cap_mim_m3_1 l=3 w=3
X2505 B10 TOP sky130_fd_pr__cap_mim_m3_1 l=3 w=3
X2506 B11 TOP sky130_fd_pr__cap_mim_m3_1 l=3 w=3
X2507 B10 TOP sky130_fd_pr__cap_mim_m3_1 l=3 w=3
X2508 B10 TOP sky130_fd_pr__cap_mim_m3_1 l=3 w=3
X2509 B11 TOP sky130_fd_pr__cap_mim_m3_1 l=3 w=3
X2510 B11 TOP sky130_fd_pr__cap_mim_m3_1 l=3 w=3
X2511 B11 TOP sky130_fd_pr__cap_mim_m3_1 l=3 w=3
X2512 B11 TOP sky130_fd_pr__cap_mim_m3_1 l=3 w=3
X2513 B11 TOP sky130_fd_pr__cap_mim_m3_1 l=3 w=3
X2514 B11 TOP sky130_fd_pr__cap_mim_m3_1 l=3 w=3
X2515 B11 TOP sky130_fd_pr__cap_mim_m3_1 l=3 w=3
X2516 B11 TOP sky130_fd_pr__cap_mim_m3_1 l=3 w=3
X2517 B11 TOP sky130_fd_pr__cap_mim_m3_1 l=3 w=3
X2518 B10 TOP sky130_fd_pr__cap_mim_m3_1 l=3 w=3
X2519 B6 TOP sky130_fd_pr__cap_mim_m3_1 l=3 w=3
X2520 B10 TOP sky130_fd_pr__cap_mim_m3_1 l=3 w=3
X2521 B9 TOP sky130_fd_pr__cap_mim_m3_1 l=3 w=3
X2522 B9 TOP sky130_fd_pr__cap_mim_m3_1 l=3 w=3
X2523 B11 TOP sky130_fd_pr__cap_mim_m3_1 l=3 w=3
X2524 B11 TOP sky130_fd_pr__cap_mim_m3_1 l=3 w=3
X2525 B10 TOP sky130_fd_pr__cap_mim_m3_1 l=3 w=3
X2526 B9 TOP sky130_fd_pr__cap_mim_m3_1 l=3 w=3
X2527 B11 TOP sky130_fd_pr__cap_mim_m3_1 l=3 w=3
X2528 B9 TOP sky130_fd_pr__cap_mim_m3_1 l=3 w=3
X2529 B11 TOP sky130_fd_pr__cap_mim_m3_1 l=3 w=3
X2530 B10 TOP sky130_fd_pr__cap_mim_m3_1 l=3 w=3
X2531 B9 TOP sky130_fd_pr__cap_mim_m3_1 l=3 w=3
X2532 B11 TOP sky130_fd_pr__cap_mim_m3_1 l=3 w=3
X2533 B11 TOP sky130_fd_pr__cap_mim_m3_1 l=3 w=3
X2534 B11 TOP sky130_fd_pr__cap_mim_m3_1 l=3 w=3
X2535 B9 TOP sky130_fd_pr__cap_mim_m3_1 l=3 w=3
X2536 B10 TOP sky130_fd_pr__cap_mim_m3_1 l=3 w=3
X2537 B9 TOP sky130_fd_pr__cap_mim_m3_1 l=3 w=3
X2538 B11 TOP sky130_fd_pr__cap_mim_m3_1 l=3 w=3
X2539 B11 TOP sky130_fd_pr__cap_mim_m3_1 l=3 w=3
X2540 B11 TOP sky130_fd_pr__cap_mim_m3_1 l=3 w=3
X2541 B11 TOP sky130_fd_pr__cap_mim_m3_1 l=3 w=3
X2542 B11 TOP sky130_fd_pr__cap_mim_m3_1 l=3 w=3
X2543 B10 TOP sky130_fd_pr__cap_mim_m3_1 l=3 w=3
X2544 B11 TOP sky130_fd_pr__cap_mim_m3_1 l=3 w=3
X2545 B10 TOP sky130_fd_pr__cap_mim_m3_1 l=3 w=3
X2546 B11 TOP sky130_fd_pr__cap_mim_m3_1 l=3 w=3
X2547 B10 TOP sky130_fd_pr__cap_mim_m3_1 l=3 w=3
X2548 B11 TOP sky130_fd_pr__cap_mim_m3_1 l=3 w=3
X2549 B10 TOP sky130_fd_pr__cap_mim_m3_1 l=3 w=3
X2550 B8 TOP sky130_fd_pr__cap_mim_m3_1 l=3 w=3
X2551 B10 TOP sky130_fd_pr__cap_mim_m3_1 l=3 w=3
X2552 EDGE_BIAS EDGE_BIAS sky130_fd_pr__cap_mim_m3_1 l=3 w=3
X2553 B10 TOP sky130_fd_pr__cap_mim_m3_1 l=3 w=3
X2554 B11 TOP sky130_fd_pr__cap_mim_m3_1 l=3 w=3
X2555 B10 TOP sky130_fd_pr__cap_mim_m3_1 l=3 w=3
X2556 B10 TOP sky130_fd_pr__cap_mim_m3_1 l=3 w=3
X2557 B8 TOP sky130_fd_pr__cap_mim_m3_1 l=3 w=3
X2558 B11 TOP sky130_fd_pr__cap_mim_m3_1 l=3 w=3
X2559 B11 TOP sky130_fd_pr__cap_mim_m3_1 l=3 w=3
X2560 B11 TOP sky130_fd_pr__cap_mim_m3_1 l=3 w=3
X2561 B10 TOP sky130_fd_pr__cap_mim_m3_1 l=3 w=3
X2562 B10 TOP sky130_fd_pr__cap_mim_m3_1 l=3 w=3
X2563 B5 TOP sky130_fd_pr__cap_mim_m3_1 l=3 w=3
X2564 B9 TOP sky130_fd_pr__cap_mim_m3_1 l=3 w=3
X2565 B11 TOP sky130_fd_pr__cap_mim_m3_1 l=3 w=3
X2566 EDGE_BIAS EDGE_BIAS sky130_fd_pr__cap_mim_m3_1 l=3 w=3
X2567 B10 TOP sky130_fd_pr__cap_mim_m3_1 l=3 w=3
X2568 B5 TOP sky130_fd_pr__cap_mim_m3_1 l=3 w=3
X2569 B10 TOP sky130_fd_pr__cap_mim_m3_1 l=3 w=3
X2570 B10 TOP sky130_fd_pr__cap_mim_m3_1 l=3 w=3
X2571 B8 TOP sky130_fd_pr__cap_mim_m3_1 l=3 w=3
X2572 B9 TOP sky130_fd_pr__cap_mim_m3_1 l=3 w=3
X2573 B11 TOP sky130_fd_pr__cap_mim_m3_1 l=3 w=3
X2574 B8 TOP sky130_fd_pr__cap_mim_m3_1 l=3 w=3
X2575 B10 TOP sky130_fd_pr__cap_mim_m3_1 l=3 w=3
X2576 B11 TOP sky130_fd_pr__cap_mim_m3_1 l=3 w=3
X2577 B11 TOP sky130_fd_pr__cap_mim_m3_1 l=3 w=3
X2578 B9 TOP sky130_fd_pr__cap_mim_m3_1 l=3 w=3
X2579 B11 TOP sky130_fd_pr__cap_mim_m3_1 l=3 w=3
X2580 B10 TOP sky130_fd_pr__cap_mim_m3_1 l=3 w=3
X2581 B11 TOP sky130_fd_pr__cap_mim_m3_1 l=3 w=3
X2582 EDGE_BIAS EDGE_BIAS sky130_fd_pr__cap_mim_m3_1 l=3 w=3
X2583 B11 TOP sky130_fd_pr__cap_mim_m3_1 l=3 w=3
X2584 B9 TOP sky130_fd_pr__cap_mim_m3_1 l=3 w=3
X2585 B9 TOP sky130_fd_pr__cap_mim_m3_1 l=3 w=3
X2586 B11 TOP sky130_fd_pr__cap_mim_m3_1 l=3 w=3
X2587 B10 TOP sky130_fd_pr__cap_mim_m3_1 l=3 w=3
X2588 B9 TOP sky130_fd_pr__cap_mim_m3_1 l=3 w=3
X2589 B10 TOP sky130_fd_pr__cap_mim_m3_1 l=3 w=3
X2590 B11 TOP sky130_fd_pr__cap_mim_m3_1 l=3 w=3
X2591 B11 TOP sky130_fd_pr__cap_mim_m3_1 l=3 w=3
X2592 B9 TOP sky130_fd_pr__cap_mim_m3_1 l=3 w=3
X2593 B10 TOP sky130_fd_pr__cap_mim_m3_1 l=3 w=3
X2594 B8 TOP sky130_fd_pr__cap_mim_m3_1 l=3 w=3
X2595 B10 TOP sky130_fd_pr__cap_mim_m3_1 l=3 w=3
X2596 B11 TOP sky130_fd_pr__cap_mim_m3_1 l=3 w=3
X2597 B11 TOP sky130_fd_pr__cap_mim_m3_1 l=3 w=3
X2598 B7 TOP sky130_fd_pr__cap_mim_m3_1 l=3 w=3
X2599 B7 TOP sky130_fd_pr__cap_mim_m3_1 l=3 w=3
X2600 B9 TOP sky130_fd_pr__cap_mim_m3_1 l=3 w=3
X2601 B11 TOP sky130_fd_pr__cap_mim_m3_1 l=3 w=3
X2602 B11 TOP sky130_fd_pr__cap_mim_m3_1 l=3 w=3
X2603 B10 TOP sky130_fd_pr__cap_mim_m3_1 l=3 w=3
X2604 B9 TOP sky130_fd_pr__cap_mim_m3_1 l=3 w=3
X2605 B8 TOP sky130_fd_pr__cap_mim_m3_1 l=3 w=3
X2606 B10 TOP sky130_fd_pr__cap_mim_m3_1 l=3 w=3
X2607 B10 TOP sky130_fd_pr__cap_mim_m3_1 l=3 w=3
X2608 B11 TOP sky130_fd_pr__cap_mim_m3_1 l=3 w=3
X2609 B11 TOP sky130_fd_pr__cap_mim_m3_1 l=3 w=3
X2610 EDGE_BIAS EDGE_BIAS sky130_fd_pr__cap_mim_m3_1 l=3 w=3
X2611 B10 TOP sky130_fd_pr__cap_mim_m3_1 l=3 w=3
X2612 B9 TOP sky130_fd_pr__cap_mim_m3_1 l=3 w=3
X2613 B8 TOP sky130_fd_pr__cap_mim_m3_1 l=3 w=3
X2614 EDGE_BIAS EDGE_BIAS sky130_fd_pr__cap_mim_m3_1 l=3 w=3
X2615 B11 TOP sky130_fd_pr__cap_mim_m3_1 l=3 w=3
X2616 B8 TOP sky130_fd_pr__cap_mim_m3_1 l=3 w=3
X2617 B11 TOP sky130_fd_pr__cap_mim_m3_1 l=3 w=3
X2618 B10 TOP sky130_fd_pr__cap_mim_m3_1 l=3 w=3
X2619 B6 TOP sky130_fd_pr__cap_mim_m3_1 l=3 w=3
X2620 B2 TOP sky130_fd_pr__cap_mim_m3_1 l=3 w=3
X2621 B11 TOP sky130_fd_pr__cap_mim_m3_1 l=3 w=3
X2622 B10 TOP sky130_fd_pr__cap_mim_m3_1 l=3 w=3
X2623 B9 TOP sky130_fd_pr__cap_mim_m3_1 l=3 w=3
X2624 EDGE_BIAS EDGE_BIAS sky130_fd_pr__cap_mim_m3_1 l=3 w=3
X2625 B11 TOP sky130_fd_pr__cap_mim_m3_1 l=3 w=3
X2626 B10 TOP sky130_fd_pr__cap_mim_m3_1 l=3 w=3
X2627 B6 TOP sky130_fd_pr__cap_mim_m3_1 l=3 w=3
X2628 B9 TOP sky130_fd_pr__cap_mim_m3_1 l=3 w=3
X2629 B11 TOP sky130_fd_pr__cap_mim_m3_1 l=3 w=3
X2630 B11 TOP sky130_fd_pr__cap_mim_m3_1 l=3 w=3
X2631 B11 TOP sky130_fd_pr__cap_mim_m3_1 l=3 w=3
X2632 B11 TOP sky130_fd_pr__cap_mim_m3_1 l=3 w=3
X2633 B11 TOP sky130_fd_pr__cap_mim_m3_1 l=3 w=3
X2634 B11 TOP sky130_fd_pr__cap_mim_m3_1 l=3 w=3
X2635 B10 TOP sky130_fd_pr__cap_mim_m3_1 l=3 w=3
X2636 B8 TOP sky130_fd_pr__cap_mim_m3_1 l=3 w=3
X2637 B11 TOP sky130_fd_pr__cap_mim_m3_1 l=3 w=3
X2638 B10 TOP sky130_fd_pr__cap_mim_m3_1 l=3 w=3
X2639 B9 TOP sky130_fd_pr__cap_mim_m3_1 l=3 w=3
X2640 B10 TOP sky130_fd_pr__cap_mim_m3_1 l=3 w=3
X2641 B11 TOP sky130_fd_pr__cap_mim_m3_1 l=3 w=3
X2642 B7 TOP sky130_fd_pr__cap_mim_m3_1 l=3 w=3
X2643 B9 TOP sky130_fd_pr__cap_mim_m3_1 l=3 w=3
X2644 EDGE_BIAS EDGE_BIAS sky130_fd_pr__cap_mim_m3_1 l=3 w=3
X2645 B9 TOP sky130_fd_pr__cap_mim_m3_1 l=3 w=3
X2646 B9 TOP sky130_fd_pr__cap_mim_m3_1 l=3 w=3
X2647 EDGE_BIAS EDGE_BIAS sky130_fd_pr__cap_mim_m3_1 l=3 w=3
X2648 B10 TOP sky130_fd_pr__cap_mim_m3_1 l=3 w=3
X2649 B9 TOP sky130_fd_pr__cap_mim_m3_1 l=3 w=3
X2650 B10 TOP sky130_fd_pr__cap_mim_m3_1 l=3 w=3
X2651 B11 TOP sky130_fd_pr__cap_mim_m3_1 l=3 w=3
X2652 B10 TOP sky130_fd_pr__cap_mim_m3_1 l=3 w=3
X2653 B10 TOP sky130_fd_pr__cap_mim_m3_1 l=3 w=3
X2654 B11 TOP sky130_fd_pr__cap_mim_m3_1 l=3 w=3
X2655 B11 TOP sky130_fd_pr__cap_mim_m3_1 l=3 w=3
X2656 B11 TOP sky130_fd_pr__cap_mim_m3_1 l=3 w=3
X2657 B10 TOP sky130_fd_pr__cap_mim_m3_1 l=3 w=3
X2658 B11 TOP sky130_fd_pr__cap_mim_m3_1 l=3 w=3
X2659 B10 TOP sky130_fd_pr__cap_mim_m3_1 l=3 w=3
X2660 B11 TOP sky130_fd_pr__cap_mim_m3_1 l=3 w=3
X2661 B11 TOP sky130_fd_pr__cap_mim_m3_1 l=3 w=3
X2662 B11 TOP sky130_fd_pr__cap_mim_m3_1 l=3 w=3
X2663 B10 TOP sky130_fd_pr__cap_mim_m3_1 l=3 w=3
X2664 B11 TOP sky130_fd_pr__cap_mim_m3_1 l=3 w=3
X2665 B10 TOP sky130_fd_pr__cap_mim_m3_1 l=3 w=3
X2666 B9 TOP sky130_fd_pr__cap_mim_m3_1 l=3 w=3
X2667 B9 TOP sky130_fd_pr__cap_mim_m3_1 l=3 w=3
X2668 B11 TOP sky130_fd_pr__cap_mim_m3_1 l=3 w=3
X2669 B8 TOP sky130_fd_pr__cap_mim_m3_1 l=3 w=3
X2670 B11 TOP sky130_fd_pr__cap_mim_m3_1 l=3 w=3
X2671 B10 TOP sky130_fd_pr__cap_mim_m3_1 l=3 w=3
X2672 B11 TOP sky130_fd_pr__cap_mim_m3_1 l=3 w=3
X2673 B10 TOP sky130_fd_pr__cap_mim_m3_1 l=3 w=3
X2674 B10 TOP sky130_fd_pr__cap_mim_m3_1 l=3 w=3
X2675 B8 TOP sky130_fd_pr__cap_mim_m3_1 l=3 w=3
X2676 B11 TOP sky130_fd_pr__cap_mim_m3_1 l=3 w=3
X2677 B5 TOP sky130_fd_pr__cap_mim_m3_1 l=3 w=3
X2678 B11 TOP sky130_fd_pr__cap_mim_m3_1 l=3 w=3
X2679 B11 TOP sky130_fd_pr__cap_mim_m3_1 l=3 w=3
X2680 B10 TOP sky130_fd_pr__cap_mim_m3_1 l=3 w=3
X2681 B10 TOP sky130_fd_pr__cap_mim_m3_1 l=3 w=3
X2682 B11 TOP sky130_fd_pr__cap_mim_m3_1 l=3 w=3
X2683 B11 TOP sky130_fd_pr__cap_mim_m3_1 l=3 w=3
X2684 B11 TOP sky130_fd_pr__cap_mim_m3_1 l=3 w=3
X2685 EDGE_BIAS EDGE_BIAS sky130_fd_pr__cap_mim_m3_1 l=3 w=3
X2686 B4 TOP sky130_fd_pr__cap_mim_m3_1 l=3 w=3
X2687 B9 TOP sky130_fd_pr__cap_mim_m3_1 l=3 w=3
X2688 B10 TOP sky130_fd_pr__cap_mim_m3_1 l=3 w=3
X2689 B10 TOP sky130_fd_pr__cap_mim_m3_1 l=3 w=3
X2690 B6 TOP sky130_fd_pr__cap_mim_m3_1 l=3 w=3
X2691 B11 TOP sky130_fd_pr__cap_mim_m3_1 l=3 w=3
X2692 B11 TOP sky130_fd_pr__cap_mim_m3_1 l=3 w=3
X2693 B10 TOP sky130_fd_pr__cap_mim_m3_1 l=3 w=3
X2694 EDGE_BIAS EDGE_BIAS sky130_fd_pr__cap_mim_m3_1 l=3 w=3
X2695 B11 TOP sky130_fd_pr__cap_mim_m3_1 l=3 w=3
X2696 B11 TOP sky130_fd_pr__cap_mim_m3_1 l=3 w=3
X2697 B11 TOP sky130_fd_pr__cap_mim_m3_1 l=3 w=3
X2698 B11 TOP sky130_fd_pr__cap_mim_m3_1 l=3 w=3
X2699 B11 TOP sky130_fd_pr__cap_mim_m3_1 l=3 w=3
X2700 B8 TOP sky130_fd_pr__cap_mim_m3_1 l=3 w=3
X2701 B8 TOP sky130_fd_pr__cap_mim_m3_1 l=3 w=3
X2702 B11 TOP sky130_fd_pr__cap_mim_m3_1 l=3 w=3
X2703 EDGE_BIAS EDGE_BIAS sky130_fd_pr__cap_mim_m3_1 l=3 w=3
X2704 B10 TOP sky130_fd_pr__cap_mim_m3_1 l=3 w=3
X2705 B11 TOP sky130_fd_pr__cap_mim_m3_1 l=3 w=3
X2706 B11 TOP sky130_fd_pr__cap_mim_m3_1 l=3 w=3
X2707 B11 TOP sky130_fd_pr__cap_mim_m3_1 l=3 w=3
X2708 B7 TOP sky130_fd_pr__cap_mim_m3_1 l=3 w=3
X2709 B9 TOP sky130_fd_pr__cap_mim_m3_1 l=3 w=3
X2710 B11 TOP sky130_fd_pr__cap_mim_m3_1 l=3 w=3
X2711 B9 TOP sky130_fd_pr__cap_mim_m3_1 l=3 w=3
X2712 B10 TOP sky130_fd_pr__cap_mim_m3_1 l=3 w=3
X2713 B10 TOP sky130_fd_pr__cap_mim_m3_1 l=3 w=3
X2714 B10 TOP sky130_fd_pr__cap_mim_m3_1 l=3 w=3
X2715 B11 TOP sky130_fd_pr__cap_mim_m3_1 l=3 w=3
X2716 B9 TOP sky130_fd_pr__cap_mim_m3_1 l=3 w=3
X2717 EDGE_BIAS EDGE_BIAS sky130_fd_pr__cap_mim_m3_1 l=3 w=3
X2718 B11 TOP sky130_fd_pr__cap_mim_m3_1 l=3 w=3
X2719 B10 TOP sky130_fd_pr__cap_mim_m3_1 l=3 w=3
X2720 B10 TOP sky130_fd_pr__cap_mim_m3_1 l=3 w=3
X2721 B9 TOP sky130_fd_pr__cap_mim_m3_1 l=3 w=3
X2722 B11 TOP sky130_fd_pr__cap_mim_m3_1 l=3 w=3
X2723 B10 TOP sky130_fd_pr__cap_mim_m3_1 l=3 w=3
X2724 B11 TOP sky130_fd_pr__cap_mim_m3_1 l=3 w=3
X2725 B11 TOP sky130_fd_pr__cap_mim_m3_1 l=3 w=3
X2726 B11 TOP sky130_fd_pr__cap_mim_m3_1 l=3 w=3
X2727 B10 TOP sky130_fd_pr__cap_mim_m3_1 l=3 w=3
X2728 B10 TOP sky130_fd_pr__cap_mim_m3_1 l=3 w=3
X2729 B10 TOP sky130_fd_pr__cap_mim_m3_1 l=3 w=3
X2730 B9 TOP sky130_fd_pr__cap_mim_m3_1 l=3 w=3
X2731 B11 TOP sky130_fd_pr__cap_mim_m3_1 l=3 w=3
X2732 B11 TOP sky130_fd_pr__cap_mim_m3_1 l=3 w=3
X2733 B10 TOP sky130_fd_pr__cap_mim_m3_1 l=3 w=3
X2734 B10 TOP sky130_fd_pr__cap_mim_m3_1 l=3 w=3
X2735 B10 TOP sky130_fd_pr__cap_mim_m3_1 l=3 w=3
X2736 B11 TOP sky130_fd_pr__cap_mim_m3_1 l=3 w=3
X2737 B11 TOP sky130_fd_pr__cap_mim_m3_1 l=3 w=3
X2738 B10 TOP sky130_fd_pr__cap_mim_m3_1 l=3 w=3
X2739 B10 TOP sky130_fd_pr__cap_mim_m3_1 l=3 w=3
X2740 B9 TOP sky130_fd_pr__cap_mim_m3_1 l=3 w=3
X2741 B10 TOP sky130_fd_pr__cap_mim_m3_1 l=3 w=3
X2742 B8 TOP sky130_fd_pr__cap_mim_m3_1 l=3 w=3
X2743 B11 TOP sky130_fd_pr__cap_mim_m3_1 l=3 w=3
X2744 B4 TOP sky130_fd_pr__cap_mim_m3_1 l=3 w=3
X2745 B11 TOP sky130_fd_pr__cap_mim_m3_1 l=3 w=3
X2746 B11 TOP sky130_fd_pr__cap_mim_m3_1 l=3 w=3
X2747 B10 TOP sky130_fd_pr__cap_mim_m3_1 l=3 w=3
X2748 B11 TOP sky130_fd_pr__cap_mim_m3_1 l=3 w=3
X2749 B9 TOP sky130_fd_pr__cap_mim_m3_1 l=3 w=3
X2750 B11 TOP sky130_fd_pr__cap_mim_m3_1 l=3 w=3
X2751 B5 TOP sky130_fd_pr__cap_mim_m3_1 l=3 w=3
X2752 B11 TOP sky130_fd_pr__cap_mim_m3_1 l=3 w=3
X2753 B10 TOP sky130_fd_pr__cap_mim_m3_1 l=3 w=3
X2754 B8 TOP sky130_fd_pr__cap_mim_m3_1 l=3 w=3
X2755 B8 TOP sky130_fd_pr__cap_mim_m3_1 l=3 w=3
X2756 B11 TOP sky130_fd_pr__cap_mim_m3_1 l=3 w=3
X2757 B11 TOP sky130_fd_pr__cap_mim_m3_1 l=3 w=3
X2758 B11 TOP sky130_fd_pr__cap_mim_m3_1 l=3 w=3
X2759 B8 TOP sky130_fd_pr__cap_mim_m3_1 l=3 w=3
X2760 B11 TOP sky130_fd_pr__cap_mim_m3_1 l=3 w=3
X2761 B9 TOP sky130_fd_pr__cap_mim_m3_1 l=3 w=3
X2762 B11 TOP sky130_fd_pr__cap_mim_m3_1 l=3 w=3
X2763 B9 TOP sky130_fd_pr__cap_mim_m3_1 l=3 w=3
X2764 B10 TOP sky130_fd_pr__cap_mim_m3_1 l=3 w=3
X2765 B11 TOP sky130_fd_pr__cap_mim_m3_1 l=3 w=3
X2766 B7 TOP sky130_fd_pr__cap_mim_m3_1 l=3 w=3
X2767 B11 TOP sky130_fd_pr__cap_mim_m3_1 l=3 w=3
X2768 B11 TOP sky130_fd_pr__cap_mim_m3_1 l=3 w=3
X2769 B9 TOP sky130_fd_pr__cap_mim_m3_1 l=3 w=3
X2770 B7 TOP sky130_fd_pr__cap_mim_m3_1 l=3 w=3
X2771 B7 TOP sky130_fd_pr__cap_mim_m3_1 l=3 w=3
X2772 B11 TOP sky130_fd_pr__cap_mim_m3_1 l=3 w=3
X2773 B9 TOP sky130_fd_pr__cap_mim_m3_1 l=3 w=3
X2774 B3 TOP sky130_fd_pr__cap_mim_m3_1 l=3 w=3
X2775 B9 TOP sky130_fd_pr__cap_mim_m3_1 l=3 w=3
X2776 B10 TOP sky130_fd_pr__cap_mim_m3_1 l=3 w=3
X2777 B10 TOP sky130_fd_pr__cap_mim_m3_1 l=3 w=3
X2778 B10 TOP sky130_fd_pr__cap_mim_m3_1 l=3 w=3
X2779 B11 TOP sky130_fd_pr__cap_mim_m3_1 l=3 w=3
X2780 B11 TOP sky130_fd_pr__cap_mim_m3_1 l=3 w=3
X2781 B9 TOP sky130_fd_pr__cap_mim_m3_1 l=3 w=3
X2782 B10 TOP sky130_fd_pr__cap_mim_m3_1 l=3 w=3
X2783 B10 TOP sky130_fd_pr__cap_mim_m3_1 l=3 w=3
X2784 B11 TOP sky130_fd_pr__cap_mim_m3_1 l=3 w=3
X2785 B10 TOP sky130_fd_pr__cap_mim_m3_1 l=3 w=3
X2786 EDGE_BIAS EDGE_BIAS sky130_fd_pr__cap_mim_m3_1 l=3 w=3
X2787 B11 TOP sky130_fd_pr__cap_mim_m3_1 l=3 w=3
X2788 B10 TOP sky130_fd_pr__cap_mim_m3_1 l=3 w=3
X2789 B9 TOP sky130_fd_pr__cap_mim_m3_1 l=3 w=3
X2790 B11 TOP sky130_fd_pr__cap_mim_m3_1 l=3 w=3
X2791 B10 TOP sky130_fd_pr__cap_mim_m3_1 l=3 w=3
X2792 B8 TOP sky130_fd_pr__cap_mim_m3_1 l=3 w=3
X2793 B10 TOP sky130_fd_pr__cap_mim_m3_1 l=3 w=3
X2794 B10 TOP sky130_fd_pr__cap_mim_m3_1 l=3 w=3
X2795 B9 TOP sky130_fd_pr__cap_mim_m3_1 l=3 w=3
X2796 B8 TOP sky130_fd_pr__cap_mim_m3_1 l=3 w=3
X2797 B5 TOP sky130_fd_pr__cap_mim_m3_1 l=3 w=3
X2798 B8 TOP sky130_fd_pr__cap_mim_m3_1 l=3 w=3
X2799 B10 TOP sky130_fd_pr__cap_mim_m3_1 l=3 w=3
X2800 B11 TOP sky130_fd_pr__cap_mim_m3_1 l=3 w=3
X2801 B10 TOP sky130_fd_pr__cap_mim_m3_1 l=3 w=3
X2802 B9 TOP sky130_fd_pr__cap_mim_m3_1 l=3 w=3
X2803 B11 TOP sky130_fd_pr__cap_mim_m3_1 l=3 w=3
X2804 B11 TOP sky130_fd_pr__cap_mim_m3_1 l=3 w=3
X2805 B11 TOP sky130_fd_pr__cap_mim_m3_1 l=3 w=3
X2806 B11 TOP sky130_fd_pr__cap_mim_m3_1 l=3 w=3
X2807 B9 TOP sky130_fd_pr__cap_mim_m3_1 l=3 w=3
X2808 B10 TOP sky130_fd_pr__cap_mim_m3_1 l=3 w=3
X2809 B6 TOP sky130_fd_pr__cap_mim_m3_1 l=3 w=3
X2810 B11 TOP sky130_fd_pr__cap_mim_m3_1 l=3 w=3
X2811 B9 TOP sky130_fd_pr__cap_mim_m3_1 l=3 w=3
X2812 B11 TOP sky130_fd_pr__cap_mim_m3_1 l=3 w=3
X2813 B11 TOP sky130_fd_pr__cap_mim_m3_1 l=3 w=3
X2814 B10 TOP sky130_fd_pr__cap_mim_m3_1 l=3 w=3
X2815 B11 TOP sky130_fd_pr__cap_mim_m3_1 l=3 w=3
X2816 B8 TOP sky130_fd_pr__cap_mim_m3_1 l=3 w=3
X2817 B11 TOP sky130_fd_pr__cap_mim_m3_1 l=3 w=3
X2818 B11 TOP sky130_fd_pr__cap_mim_m3_1 l=3 w=3
X2819 B10 TOP sky130_fd_pr__cap_mim_m3_1 l=3 w=3
X2820 B11 TOP sky130_fd_pr__cap_mim_m3_1 l=3 w=3
X2821 B9 TOP sky130_fd_pr__cap_mim_m3_1 l=3 w=3
X2822 EDGE_BIAS EDGE_BIAS sky130_fd_pr__cap_mim_m3_1 l=3 w=3
X2823 B11 TOP sky130_fd_pr__cap_mim_m3_1 l=3 w=3
X2824 B7 TOP sky130_fd_pr__cap_mim_m3_1 l=3 w=3
X2825 B7 TOP sky130_fd_pr__cap_mim_m3_1 l=3 w=3
X2826 B9 TOP sky130_fd_pr__cap_mim_m3_1 l=3 w=3
X2827 B11 TOP sky130_fd_pr__cap_mim_m3_1 l=3 w=3
X2828 B10 TOP sky130_fd_pr__cap_mim_m3_1 l=3 w=3
X2829 B10 TOP sky130_fd_pr__cap_mim_m3_1 l=3 w=3
X2830 B11 TOP sky130_fd_pr__cap_mim_m3_1 l=3 w=3
X2831 B10 TOP sky130_fd_pr__cap_mim_m3_1 l=3 w=3
X2832 B8 TOP sky130_fd_pr__cap_mim_m3_1 l=3 w=3
X2833 EDGE_BIAS EDGE_BIAS sky130_fd_pr__cap_mim_m3_1 l=3 w=3
X2834 B10 TOP sky130_fd_pr__cap_mim_m3_1 l=3 w=3
X2835 B9 TOP sky130_fd_pr__cap_mim_m3_1 l=3 w=3
X2836 B10 TOP sky130_fd_pr__cap_mim_m3_1 l=3 w=3
X2837 B11 TOP sky130_fd_pr__cap_mim_m3_1 l=3 w=3
X2838 B11 TOP sky130_fd_pr__cap_mim_m3_1 l=3 w=3
X2839 B9 TOP sky130_fd_pr__cap_mim_m3_1 l=3 w=3
X2840 B10 TOP sky130_fd_pr__cap_mim_m3_1 l=3 w=3
X2841 B11 TOP sky130_fd_pr__cap_mim_m3_1 l=3 w=3
X2842 B10 TOP sky130_fd_pr__cap_mim_m3_1 l=3 w=3
X2843 B7 TOP sky130_fd_pr__cap_mim_m3_1 l=3 w=3
X2844 B10 TOP sky130_fd_pr__cap_mim_m3_1 l=3 w=3
X2845 B11 TOP sky130_fd_pr__cap_mim_m3_1 l=3 w=3
X2846 B11 TOP sky130_fd_pr__cap_mim_m3_1 l=3 w=3
X2847 B11 TOP sky130_fd_pr__cap_mim_m3_1 l=3 w=3
X2848 B9 TOP sky130_fd_pr__cap_mim_m3_1 l=3 w=3
X2849 B11 TOP sky130_fd_pr__cap_mim_m3_1 l=3 w=3
X2850 B8 TOP sky130_fd_pr__cap_mim_m3_1 l=3 w=3
X2851 B11 TOP sky130_fd_pr__cap_mim_m3_1 l=3 w=3
X2852 B11 TOP sky130_fd_pr__cap_mim_m3_1 l=3 w=3
X2853 B11 TOP sky130_fd_pr__cap_mim_m3_1 l=3 w=3
X2854 B11 TOP sky130_fd_pr__cap_mim_m3_1 l=3 w=3
X2855 B10 TOP sky130_fd_pr__cap_mim_m3_1 l=3 w=3
X2856 B10 TOP sky130_fd_pr__cap_mim_m3_1 l=3 w=3
X2857 B8 TOP sky130_fd_pr__cap_mim_m3_1 l=3 w=3
X2858 B11 TOP sky130_fd_pr__cap_mim_m3_1 l=3 w=3
X2859 B11 TOP sky130_fd_pr__cap_mim_m3_1 l=3 w=3
X2860 B10 TOP sky130_fd_pr__cap_mim_m3_1 l=3 w=3
X2861 B4 TOP sky130_fd_pr__cap_mim_m3_1 l=3 w=3
X2862 B11 TOP sky130_fd_pr__cap_mim_m3_1 l=3 w=3
X2863 B11 TOP sky130_fd_pr__cap_mim_m3_1 l=3 w=3
X2864 B11 TOP sky130_fd_pr__cap_mim_m3_1 l=3 w=3
X2865 EDGE_BIAS EDGE_BIAS sky130_fd_pr__cap_mim_m3_1 l=3 w=3
X2866 B10 TOP sky130_fd_pr__cap_mim_m3_1 l=3 w=3
X2867 B9 TOP sky130_fd_pr__cap_mim_m3_1 l=3 w=3
X2868 B9 TOP sky130_fd_pr__cap_mim_m3_1 l=3 w=3
X2869 B9 TOP sky130_fd_pr__cap_mim_m3_1 l=3 w=3
X2870 B11 TOP sky130_fd_pr__cap_mim_m3_1 l=3 w=3
X2871 B10 TOP sky130_fd_pr__cap_mim_m3_1 l=3 w=3
X2872 B5 TOP sky130_fd_pr__cap_mim_m3_1 l=3 w=3
X2873 B11 TOP sky130_fd_pr__cap_mim_m3_1 l=3 w=3
X2874 B10 TOP sky130_fd_pr__cap_mim_m3_1 l=3 w=3
X2875 B6 TOP sky130_fd_pr__cap_mim_m3_1 l=3 w=3
X2876 B11 TOP sky130_fd_pr__cap_mim_m3_1 l=3 w=3
X2877 B9 TOP sky130_fd_pr__cap_mim_m3_1 l=3 w=3
X2878 B11 TOP sky130_fd_pr__cap_mim_m3_1 l=3 w=3
X2879 B11 TOP sky130_fd_pr__cap_mim_m3_1 l=3 w=3
X2880 B11 TOP sky130_fd_pr__cap_mim_m3_1 l=3 w=3
X2881 B11 TOP sky130_fd_pr__cap_mim_m3_1 l=3 w=3
X2882 B11 TOP sky130_fd_pr__cap_mim_m3_1 l=3 w=3
X2883 B11 TOP sky130_fd_pr__cap_mim_m3_1 l=3 w=3
X2884 B10 TOP sky130_fd_pr__cap_mim_m3_1 l=3 w=3
X2885 B11 TOP sky130_fd_pr__cap_mim_m3_1 l=3 w=3
X2886 B11 TOP sky130_fd_pr__cap_mim_m3_1 l=3 w=3
X2887 B11 TOP sky130_fd_pr__cap_mim_m3_1 l=3 w=3
X2888 B11 TOP sky130_fd_pr__cap_mim_m3_1 l=3 w=3
X2889 B10 TOP sky130_fd_pr__cap_mim_m3_1 l=3 w=3
X2890 B10 TOP sky130_fd_pr__cap_mim_m3_1 l=3 w=3
X2891 B10 TOP sky130_fd_pr__cap_mim_m3_1 l=3 w=3
X2892 B11 TOP sky130_fd_pr__cap_mim_m3_1 l=3 w=3
X2893 B11 TOP sky130_fd_pr__cap_mim_m3_1 l=3 w=3
X2894 B11 TOP sky130_fd_pr__cap_mim_m3_1 l=3 w=3
X2895 B7 TOP sky130_fd_pr__cap_mim_m3_1 l=3 w=3
X2896 B11 TOP sky130_fd_pr__cap_mim_m3_1 l=3 w=3
X2897 B9 TOP sky130_fd_pr__cap_mim_m3_1 l=3 w=3
X2898 B10 TOP sky130_fd_pr__cap_mim_m3_1 l=3 w=3
X2899 B10 TOP sky130_fd_pr__cap_mim_m3_1 l=3 w=3
X2900 B11 TOP sky130_fd_pr__cap_mim_m3_1 l=3 w=3
X2901 EDGE_BIAS EDGE_BIAS sky130_fd_pr__cap_mim_m3_1 l=3 w=3
X2902 B10 TOP sky130_fd_pr__cap_mim_m3_1 l=3 w=3
X2903 B9 TOP sky130_fd_pr__cap_mim_m3_1 l=3 w=3
X2904 B11 TOP sky130_fd_pr__cap_mim_m3_1 l=3 w=3
X2905 B10 TOP sky130_fd_pr__cap_mim_m3_1 l=3 w=3
X2906 B8 TOP sky130_fd_pr__cap_mim_m3_1 l=3 w=3
X2907 B10 TOP sky130_fd_pr__cap_mim_m3_1 l=3 w=3
X2908 B11 TOP sky130_fd_pr__cap_mim_m3_1 l=3 w=3
X2909 B10 TOP sky130_fd_pr__cap_mim_m3_1 l=3 w=3
X2910 B6 TOP sky130_fd_pr__cap_mim_m3_1 l=3 w=3
X2911 B10 TOP sky130_fd_pr__cap_mim_m3_1 l=3 w=3
X2912 B11 TOP sky130_fd_pr__cap_mim_m3_1 l=3 w=3
X2913 B11 TOP sky130_fd_pr__cap_mim_m3_1 l=3 w=3
X2914 B10 TOP sky130_fd_pr__cap_mim_m3_1 l=3 w=3
X2915 B8 TOP sky130_fd_pr__cap_mim_m3_1 l=3 w=3
X2916 B11 TOP sky130_fd_pr__cap_mim_m3_1 l=3 w=3
X2917 B10 TOP sky130_fd_pr__cap_mim_m3_1 l=3 w=3
X2918 B10 TOP sky130_fd_pr__cap_mim_m3_1 l=3 w=3
X2919 B10 TOP sky130_fd_pr__cap_mim_m3_1 l=3 w=3
X2920 B11 TOP sky130_fd_pr__cap_mim_m3_1 l=3 w=3
X2921 B8 TOP sky130_fd_pr__cap_mim_m3_1 l=3 w=3
X2922 EDGE_BIAS EDGE_BIAS sky130_fd_pr__cap_mim_m3_1 l=3 w=3
X2923 B10 TOP sky130_fd_pr__cap_mim_m3_1 l=3 w=3
X2924 B9 TOP sky130_fd_pr__cap_mim_m3_1 l=3 w=3
X2925 B9 TOP sky130_fd_pr__cap_mim_m3_1 l=3 w=3
X2926 B11 TOP sky130_fd_pr__cap_mim_m3_1 l=3 w=3
X2927 B11 TOP sky130_fd_pr__cap_mim_m3_1 l=3 w=3
X2928 B10 TOP sky130_fd_pr__cap_mim_m3_1 l=3 w=3
X2929 B10 TOP sky130_fd_pr__cap_mim_m3_1 l=3 w=3
X2930 B11 TOP sky130_fd_pr__cap_mim_m3_1 l=3 w=3
X2931 B8 TOP sky130_fd_pr__cap_mim_m3_1 l=3 w=3
X2932 B11 TOP sky130_fd_pr__cap_mim_m3_1 l=3 w=3
X2933 B11 TOP sky130_fd_pr__cap_mim_m3_1 l=3 w=3
X2934 B10 TOP sky130_fd_pr__cap_mim_m3_1 l=3 w=3
X2935 EDGE_BIAS EDGE_BIAS sky130_fd_pr__cap_mim_m3_1 l=3 w=3
X2936 B11 TOP sky130_fd_pr__cap_mim_m3_1 l=3 w=3
X2937 B9 TOP sky130_fd_pr__cap_mim_m3_1 l=3 w=3
X2938 B11 TOP sky130_fd_pr__cap_mim_m3_1 l=3 w=3
X2939 B9 TOP sky130_fd_pr__cap_mim_m3_1 l=3 w=3
X2940 B11 TOP sky130_fd_pr__cap_mim_m3_1 l=3 w=3
X2941 B6 TOP sky130_fd_pr__cap_mim_m3_1 l=3 w=3
X2942 B9 TOP sky130_fd_pr__cap_mim_m3_1 l=3 w=3
X2943 B11 TOP sky130_fd_pr__cap_mim_m3_1 l=3 w=3
X2944 B11 TOP sky130_fd_pr__cap_mim_m3_1 l=3 w=3
X2945 B10 TOP sky130_fd_pr__cap_mim_m3_1 l=3 w=3
X2946 B11 TOP sky130_fd_pr__cap_mim_m3_1 l=3 w=3
X2947 B10 TOP sky130_fd_pr__cap_mim_m3_1 l=3 w=3
X2948 B11 TOP sky130_fd_pr__cap_mim_m3_1 l=3 w=3
X2949 B10 TOP sky130_fd_pr__cap_mim_m3_1 l=3 w=3
X2950 B9 TOP sky130_fd_pr__cap_mim_m3_1 l=3 w=3
X2951 B11 TOP sky130_fd_pr__cap_mim_m3_1 l=3 w=3
X2952 B10 TOP sky130_fd_pr__cap_mim_m3_1 l=3 w=3
X2953 B8 TOP sky130_fd_pr__cap_mim_m3_1 l=3 w=3
X2954 B9 TOP sky130_fd_pr__cap_mim_m3_1 l=3 w=3
X2955 B11 TOP sky130_fd_pr__cap_mim_m3_1 l=3 w=3
X2956 B11 TOP sky130_fd_pr__cap_mim_m3_1 l=3 w=3
X2957 B10 TOP sky130_fd_pr__cap_mim_m3_1 l=3 w=3
X2958 B11 TOP sky130_fd_pr__cap_mim_m3_1 l=3 w=3
X2959 B11 TOP sky130_fd_pr__cap_mim_m3_1 l=3 w=3
X2960 B11 TOP sky130_fd_pr__cap_mim_m3_1 l=3 w=3
X2961 B11 TOP sky130_fd_pr__cap_mim_m3_1 l=3 w=3
X2962 B7 TOP sky130_fd_pr__cap_mim_m3_1 l=3 w=3
X2963 B7 TOP sky130_fd_pr__cap_mim_m3_1 l=3 w=3
X2964 B7 TOP sky130_fd_pr__cap_mim_m3_1 l=3 w=3
X2965 B9 TOP sky130_fd_pr__cap_mim_m3_1 l=3 w=3
X2966 B9 TOP sky130_fd_pr__cap_mim_m3_1 l=3 w=3
X2967 B10 TOP sky130_fd_pr__cap_mim_m3_1 l=3 w=3
X2968 B11 TOP sky130_fd_pr__cap_mim_m3_1 l=3 w=3
X2969 B10 TOP sky130_fd_pr__cap_mim_m3_1 l=3 w=3
X2970 B11 TOP sky130_fd_pr__cap_mim_m3_1 l=3 w=3
X2971 B10 TOP sky130_fd_pr__cap_mim_m3_1 l=3 w=3
X2972 EDGE_BIAS EDGE_BIAS sky130_fd_pr__cap_mim_m3_1 l=3 w=3
X2973 B9 TOP sky130_fd_pr__cap_mim_m3_1 l=3 w=3
X2974 B11 TOP sky130_fd_pr__cap_mim_m3_1 l=3 w=3
X2975 B10 TOP sky130_fd_pr__cap_mim_m3_1 l=3 w=3
X2976 B11 TOP sky130_fd_pr__cap_mim_m3_1 l=3 w=3
X2977 B10 TOP sky130_fd_pr__cap_mim_m3_1 l=3 w=3
X2978 B6 TOP sky130_fd_pr__cap_mim_m3_1 l=3 w=3
X2979 B11 TOP sky130_fd_pr__cap_mim_m3_1 l=3 w=3
X2980 B10 TOP sky130_fd_pr__cap_mim_m3_1 l=3 w=3
X2981 B7 TOP sky130_fd_pr__cap_mim_m3_1 l=3 w=3
X2982 B11 TOP sky130_fd_pr__cap_mim_m3_1 l=3 w=3
X2983 B9 TOP sky130_fd_pr__cap_mim_m3_1 l=3 w=3
X2984 B9 TOP sky130_fd_pr__cap_mim_m3_1 l=3 w=3
X2985 B8 TOP sky130_fd_pr__cap_mim_m3_1 l=3 w=3
X2986 B11 TOP sky130_fd_pr__cap_mim_m3_1 l=3 w=3
X2987 B8 TOP sky130_fd_pr__cap_mim_m3_1 l=3 w=3
X2988 B11 TOP sky130_fd_pr__cap_mim_m3_1 l=3 w=3
X2989 B10 TOP sky130_fd_pr__cap_mim_m3_1 l=3 w=3
X2990 B9 TOP sky130_fd_pr__cap_mim_m3_1 l=3 w=3
X2991 B10 TOP sky130_fd_pr__cap_mim_m3_1 l=3 w=3
X2992 EDGE_BIAS EDGE_BIAS sky130_fd_pr__cap_mim_m3_1 l=3 w=3
X2993 B10 TOP sky130_fd_pr__cap_mim_m3_1 l=3 w=3
X2994 B8 TOP sky130_fd_pr__cap_mim_m3_1 l=3 w=3
X2995 B11 TOP sky130_fd_pr__cap_mim_m3_1 l=3 w=3
X2996 B10 TOP sky130_fd_pr__cap_mim_m3_1 l=3 w=3
X2997 B8 TOP sky130_fd_pr__cap_mim_m3_1 l=3 w=3
X2998 B11 TOP sky130_fd_pr__cap_mim_m3_1 l=3 w=3
X2999 B11 TOP sky130_fd_pr__cap_mim_m3_1 l=3 w=3
X3000 B10 TOP sky130_fd_pr__cap_mim_m3_1 l=3 w=3
X3001 B9 TOP sky130_fd_pr__cap_mim_m3_1 l=3 w=3
X3002 EDGE_BIAS EDGE_BIAS sky130_fd_pr__cap_mim_m3_1 l=3 w=3
X3003 B6 TOP sky130_fd_pr__cap_mim_m3_1 l=3 w=3
X3004 B9 TOP sky130_fd_pr__cap_mim_m3_1 l=3 w=3
X3005 B9 TOP sky130_fd_pr__cap_mim_m3_1 l=3 w=3
X3006 B11 TOP sky130_fd_pr__cap_mim_m3_1 l=3 w=3
X3007 B9 TOP sky130_fd_pr__cap_mim_m3_1 l=3 w=3
X3008 B11 TOP sky130_fd_pr__cap_mim_m3_1 l=3 w=3
X3009 B6 TOP sky130_fd_pr__cap_mim_m3_1 l=3 w=3
X3010 B11 TOP sky130_fd_pr__cap_mim_m3_1 l=3 w=3
X3011 B11 TOP sky130_fd_pr__cap_mim_m3_1 l=3 w=3
X3012 B9 TOP sky130_fd_pr__cap_mim_m3_1 l=3 w=3
X3013 EDGE_BIAS EDGE_BIAS sky130_fd_pr__cap_mim_m3_1 l=3 w=3
X3014 B10 TOP sky130_fd_pr__cap_mim_m3_1 l=3 w=3
X3015 B11 TOP sky130_fd_pr__cap_mim_m3_1 l=3 w=3
X3016 B11 TOP sky130_fd_pr__cap_mim_m3_1 l=3 w=3
X3017 B11 TOP sky130_fd_pr__cap_mim_m3_1 l=3 w=3
X3018 B11 TOP sky130_fd_pr__cap_mim_m3_1 l=3 w=3
X3019 B11 TOP sky130_fd_pr__cap_mim_m3_1 l=3 w=3
X3020 B11 TOP sky130_fd_pr__cap_mim_m3_1 l=3 w=3
X3021 B11 TOP sky130_fd_pr__cap_mim_m3_1 l=3 w=3
X3022 B10 TOP sky130_fd_pr__cap_mim_m3_1 l=3 w=3
X3023 B7 TOP sky130_fd_pr__cap_mim_m3_1 l=3 w=3
X3024 B11 TOP sky130_fd_pr__cap_mim_m3_1 l=3 w=3
X3025 B11 TOP sky130_fd_pr__cap_mim_m3_1 l=3 w=3
X3026 B7 TOP sky130_fd_pr__cap_mim_m3_1 l=3 w=3
X3027 B11 TOP sky130_fd_pr__cap_mim_m3_1 l=3 w=3
X3028 B11 TOP sky130_fd_pr__cap_mim_m3_1 l=3 w=3
X3029 B9 TOP sky130_fd_pr__cap_mim_m3_1 l=3 w=3
X3030 B10 TOP sky130_fd_pr__cap_mim_m3_1 l=3 w=3
X3031 B9 TOP sky130_fd_pr__cap_mim_m3_1 l=3 w=3
X3032 B10 TOP sky130_fd_pr__cap_mim_m3_1 l=3 w=3
X3033 B8 TOP sky130_fd_pr__cap_mim_m3_1 l=3 w=3
X3034 B10 TOP sky130_fd_pr__cap_mim_m3_1 l=3 w=3
X3035 B9 TOP sky130_fd_pr__cap_mim_m3_1 l=3 w=3
X3036 B9 TOP sky130_fd_pr__cap_mim_m3_1 l=3 w=3
X3037 B11 TOP sky130_fd_pr__cap_mim_m3_1 l=3 w=3
X3038 B10 TOP sky130_fd_pr__cap_mim_m3_1 l=3 w=3
X3039 B11 TOP sky130_fd_pr__cap_mim_m3_1 l=3 w=3
X3040 B10 TOP sky130_fd_pr__cap_mim_m3_1 l=3 w=3
X3041 B10 TOP sky130_fd_pr__cap_mim_m3_1 l=3 w=3
X3042 B11 TOP sky130_fd_pr__cap_mim_m3_1 l=3 w=3
X3043 B11 TOP sky130_fd_pr__cap_mim_m3_1 l=3 w=3
X3044 B10 TOP sky130_fd_pr__cap_mim_m3_1 l=3 w=3
X3045 B11 TOP sky130_fd_pr__cap_mim_m3_1 l=3 w=3
X3046 B11 TOP sky130_fd_pr__cap_mim_m3_1 l=3 w=3
X3047 B10 TOP sky130_fd_pr__cap_mim_m3_1 l=3 w=3
X3048 B11 TOP sky130_fd_pr__cap_mim_m3_1 l=3 w=3
X3049 EDGE_BIAS EDGE_BIAS sky130_fd_pr__cap_mim_m3_1 l=3 w=3
X3050 B11 TOP sky130_fd_pr__cap_mim_m3_1 l=3 w=3
X3051 B9 TOP sky130_fd_pr__cap_mim_m3_1 l=3 w=3
X3052 B11 TOP sky130_fd_pr__cap_mim_m3_1 l=3 w=3
X3053 B11 TOP sky130_fd_pr__cap_mim_m3_1 l=3 w=3
X3054 B10 TOP sky130_fd_pr__cap_mim_m3_1 l=3 w=3
X3055 B11 TOP sky130_fd_pr__cap_mim_m3_1 l=3 w=3
X3056 B9 TOP sky130_fd_pr__cap_mim_m3_1 l=3 w=3
X3057 B11 TOP sky130_fd_pr__cap_mim_m3_1 l=3 w=3
X3058 EDGE_BIAS EDGE_BIAS sky130_fd_pr__cap_mim_m3_1 l=3 w=3
X3059 B8 TOP sky130_fd_pr__cap_mim_m3_1 l=3 w=3
X3060 B11 TOP sky130_fd_pr__cap_mim_m3_1 l=3 w=3
X3061 B10 TOP sky130_fd_pr__cap_mim_m3_1 l=3 w=3
X3062 B11 TOP sky130_fd_pr__cap_mim_m3_1 l=3 w=3
X3063 B11 TOP sky130_fd_pr__cap_mim_m3_1 l=3 w=3
X3064 B9 TOP sky130_fd_pr__cap_mim_m3_1 l=3 w=3
X3065 B9 TOP sky130_fd_pr__cap_mim_m3_1 l=3 w=3
X3066 B11 TOP sky130_fd_pr__cap_mim_m3_1 l=3 w=3
X3067 B10 TOP sky130_fd_pr__cap_mim_m3_1 l=3 w=3
X3068 B9 TOP sky130_fd_pr__cap_mim_m3_1 l=3 w=3
X3069 B9 TOP sky130_fd_pr__cap_mim_m3_1 l=3 w=3
X3070 B11 TOP sky130_fd_pr__cap_mim_m3_1 l=3 w=3
X3071 B11 TOP sky130_fd_pr__cap_mim_m3_1 l=3 w=3
X3072 B10 TOP sky130_fd_pr__cap_mim_m3_1 l=3 w=3
X3073 B11 TOP sky130_fd_pr__cap_mim_m3_1 l=3 w=3
X3074 B9 TOP sky130_fd_pr__cap_mim_m3_1 l=3 w=3
X3075 B11 TOP sky130_fd_pr__cap_mim_m3_1 l=3 w=3
X3076 B11 TOP sky130_fd_pr__cap_mim_m3_1 l=3 w=3
X3077 B9 TOP sky130_fd_pr__cap_mim_m3_1 l=3 w=3
X3078 B11 TOP sky130_fd_pr__cap_mim_m3_1 l=3 w=3
X3079 B10 TOP sky130_fd_pr__cap_mim_m3_1 l=3 w=3
X3080 B11 TOP sky130_fd_pr__cap_mim_m3_1 l=3 w=3
X3081 B11 TOP sky130_fd_pr__cap_mim_m3_1 l=3 w=3
X3082 B11 TOP sky130_fd_pr__cap_mim_m3_1 l=3 w=3
X3083 B10 TOP sky130_fd_pr__cap_mim_m3_1 l=3 w=3
X3084 B11 TOP sky130_fd_pr__cap_mim_m3_1 l=3 w=3
X3085 B11 TOP sky130_fd_pr__cap_mim_m3_1 l=3 w=3
X3086 B11 TOP sky130_fd_pr__cap_mim_m3_1 l=3 w=3
X3087 B11 TOP sky130_fd_pr__cap_mim_m3_1 l=3 w=3
X3088 B10 TOP sky130_fd_pr__cap_mim_m3_1 l=3 w=3
X3089 B10 TOP sky130_fd_pr__cap_mim_m3_1 l=3 w=3
X3090 B11 TOP sky130_fd_pr__cap_mim_m3_1 l=3 w=3
X3091 B11 TOP sky130_fd_pr__cap_mim_m3_1 l=3 w=3
X3092 B7 TOP sky130_fd_pr__cap_mim_m3_1 l=3 w=3
X3093 B11 TOP sky130_fd_pr__cap_mim_m3_1 l=3 w=3
X3094 B7 TOP sky130_fd_pr__cap_mim_m3_1 l=3 w=3
X3095 B9 TOP sky130_fd_pr__cap_mim_m3_1 l=3 w=3
X3096 B10 TOP sky130_fd_pr__cap_mim_m3_1 l=3 w=3
X3097 B11 TOP sky130_fd_pr__cap_mim_m3_1 l=3 w=3
X3098 EDGE_BIAS EDGE_BIAS sky130_fd_pr__cap_mim_m3_1 l=3 w=3
X3099 B10 TOP sky130_fd_pr__cap_mim_m3_1 l=3 w=3
X3100 B11 TOP sky130_fd_pr__cap_mim_m3_1 l=3 w=3
X3101 B10 TOP sky130_fd_pr__cap_mim_m3_1 l=3 w=3
X3102 B9 TOP sky130_fd_pr__cap_mim_m3_1 l=3 w=3
X3103 B8 TOP sky130_fd_pr__cap_mim_m3_1 l=3 w=3
X3104 B10 TOP sky130_fd_pr__cap_mim_m3_1 l=3 w=3
X3105 B11 TOP sky130_fd_pr__cap_mim_m3_1 l=3 w=3
X3106 B11 TOP sky130_fd_pr__cap_mim_m3_1 l=3 w=3
X3107 B10 TOP sky130_fd_pr__cap_mim_m3_1 l=3 w=3
X3108 B8 TOP sky130_fd_pr__cap_mim_m3_1 l=3 w=3
X3109 B10 TOP sky130_fd_pr__cap_mim_m3_1 l=3 w=3
X3110 B11 TOP sky130_fd_pr__cap_mim_m3_1 l=3 w=3
X3111 B11 TOP sky130_fd_pr__cap_mim_m3_1 l=3 w=3
X3112 B10 TOP sky130_fd_pr__cap_mim_m3_1 l=3 w=3
X3113 B6 TOP sky130_fd_pr__cap_mim_m3_1 l=3 w=3
X3114 B10 TOP sky130_fd_pr__cap_mim_m3_1 l=3 w=3
X3115 B10 TOP sky130_fd_pr__cap_mim_m3_1 l=3 w=3
X3116 B10 TOP sky130_fd_pr__cap_mim_m3_1 l=3 w=3
X3117 B10 TOP sky130_fd_pr__cap_mim_m3_1 l=3 w=3
X3118 B10 TOP sky130_fd_pr__cap_mim_m3_1 l=3 w=3
X3119 B11 TOP sky130_fd_pr__cap_mim_m3_1 l=3 w=3
X3120 B11 TOP sky130_fd_pr__cap_mim_m3_1 l=3 w=3
X3121 B8 TOP sky130_fd_pr__cap_mim_m3_1 l=3 w=3
X3122 B11 TOP sky130_fd_pr__cap_mim_m3_1 l=3 w=3
X3123 B11 TOP sky130_fd_pr__cap_mim_m3_1 l=3 w=3
X3124 B10 TOP sky130_fd_pr__cap_mim_m3_1 l=3 w=3
X3125 B9 TOP sky130_fd_pr__cap_mim_m3_1 l=3 w=3
X3126 EDGE_BIAS EDGE_BIAS sky130_fd_pr__cap_mim_m3_1 l=3 w=3
X3127 B11 TOP sky130_fd_pr__cap_mim_m3_1 l=3 w=3
X3128 B11 TOP sky130_fd_pr__cap_mim_m3_1 l=3 w=3
X3129 B11 TOP sky130_fd_pr__cap_mim_m3_1 l=3 w=3
X3130 B10 TOP sky130_fd_pr__cap_mim_m3_1 l=3 w=3
X3131 B11 TOP sky130_fd_pr__cap_mim_m3_1 l=3 w=3
X3132 B10 TOP sky130_fd_pr__cap_mim_m3_1 l=3 w=3
X3133 B9 TOP sky130_fd_pr__cap_mim_m3_1 l=3 w=3
X3134 B9 TOP sky130_fd_pr__cap_mim_m3_1 l=3 w=3
X3135 B9 TOP sky130_fd_pr__cap_mim_m3_1 l=3 w=3
X3136 B11 TOP sky130_fd_pr__cap_mim_m3_1 l=3 w=3
X3137 B10 TOP sky130_fd_pr__cap_mim_m3_1 l=3 w=3
X3138 B9 TOP sky130_fd_pr__cap_mim_m3_1 l=3 w=3
X3139 B11 TOP sky130_fd_pr__cap_mim_m3_1 l=3 w=3
X3140 B9 TOP sky130_fd_pr__cap_mim_m3_1 l=3 w=3
X3141 B6 TOP sky130_fd_pr__cap_mim_m3_1 l=3 w=3
X3142 B11 TOP sky130_fd_pr__cap_mim_m3_1 l=3 w=3
X3143 B10 TOP sky130_fd_pr__cap_mim_m3_1 l=3 w=3
X3144 B9 TOP sky130_fd_pr__cap_mim_m3_1 l=3 w=3
X3145 B10 TOP sky130_fd_pr__cap_mim_m3_1 l=3 w=3
X3146 B8 TOP sky130_fd_pr__cap_mim_m3_1 l=3 w=3
X3147 B10 TOP sky130_fd_pr__cap_mim_m3_1 l=3 w=3
X3148 B11 TOP sky130_fd_pr__cap_mim_m3_1 l=3 w=3
X3149 B11 TOP sky130_fd_pr__cap_mim_m3_1 l=3 w=3
X3150 B11 TOP sky130_fd_pr__cap_mim_m3_1 l=3 w=3
X3151 B8 TOP sky130_fd_pr__cap_mim_m3_1 l=3 w=3
X3152 EDGE_BIAS EDGE_BIAS sky130_fd_pr__cap_mim_m3_1 l=3 w=3
X3153 EDGE_BIAS EDGE_BIAS sky130_fd_pr__cap_mim_m3_1 l=3 w=3
X3154 B11 TOP sky130_fd_pr__cap_mim_m3_1 l=3 w=3
X3155 B11 TOP sky130_fd_pr__cap_mim_m3_1 l=3 w=3
X3156 B11 TOP sky130_fd_pr__cap_mim_m3_1 l=3 w=3
X3157 B10 TOP sky130_fd_pr__cap_mim_m3_1 l=3 w=3
X3158 B7 TOP sky130_fd_pr__cap_mim_m3_1 l=3 w=3
X3159 B11 TOP sky130_fd_pr__cap_mim_m3_1 l=3 w=3
X3160 B11 TOP sky130_fd_pr__cap_mim_m3_1 l=3 w=3
X3161 B11 TOP sky130_fd_pr__cap_mim_m3_1 l=3 w=3
X3162 B7 TOP sky130_fd_pr__cap_mim_m3_1 l=3 w=3
X3163 EDGE_BIAS EDGE_BIAS sky130_fd_pr__cap_mim_m3_1 l=3 w=3
X3164 B11 TOP sky130_fd_pr__cap_mim_m3_1 l=3 w=3
X3165 B10 TOP sky130_fd_pr__cap_mim_m3_1 l=3 w=3
X3166 B9 TOP sky130_fd_pr__cap_mim_m3_1 l=3 w=3
X3167 B10 TOP sky130_fd_pr__cap_mim_m3_1 l=3 w=3
X3168 B8 TOP sky130_fd_pr__cap_mim_m3_1 l=3 w=3
X3169 B9 TOP sky130_fd_pr__cap_mim_m3_1 l=3 w=3
X3170 B8 TOP sky130_fd_pr__cap_mim_m3_1 l=3 w=3
X3171 B10 TOP sky130_fd_pr__cap_mim_m3_1 l=3 w=3
X3172 B11 TOP sky130_fd_pr__cap_mim_m3_1 l=3 w=3
X3173 B10 TOP sky130_fd_pr__cap_mim_m3_1 l=3 w=3
X3174 B8 TOP sky130_fd_pr__cap_mim_m3_1 l=3 w=3
X3175 EDGE_BIAS EDGE_BIAS sky130_fd_pr__cap_mim_m3_1 l=3 w=3
X3176 B11 TOP sky130_fd_pr__cap_mim_m3_1 l=3 w=3
X3177 B10 TOP sky130_fd_pr__cap_mim_m3_1 l=3 w=3
X3178 B5 TOP sky130_fd_pr__cap_mim_m3_1 l=3 w=3
X3179 B11 TOP sky130_fd_pr__cap_mim_m3_1 l=3 w=3
X3180 B11 TOP sky130_fd_pr__cap_mim_m3_1 l=3 w=3
X3181 B10 TOP sky130_fd_pr__cap_mim_m3_1 l=3 w=3
X3182 B9 TOP sky130_fd_pr__cap_mim_m3_1 l=3 w=3
X3183 B4 TOP sky130_fd_pr__cap_mim_m3_1 l=3 w=3
X3184 B11 TOP sky130_fd_pr__cap_mim_m3_1 l=3 w=3
X3185 B11 TOP sky130_fd_pr__cap_mim_m3_1 l=3 w=3
X3186 B11 TOP sky130_fd_pr__cap_mim_m3_1 l=3 w=3
X3187 B10 TOP sky130_fd_pr__cap_mim_m3_1 l=3 w=3
X3188 B10 TOP sky130_fd_pr__cap_mim_m3_1 l=3 w=3
X3189 B8 TOP sky130_fd_pr__cap_mim_m3_1 l=3 w=3
X3190 B11 TOP sky130_fd_pr__cap_mim_m3_1 l=3 w=3
X3191 B9 TOP sky130_fd_pr__cap_mim_m3_1 l=3 w=3
X3192 B8 TOP sky130_fd_pr__cap_mim_m3_1 l=3 w=3
X3193 EDGE_BIAS EDGE_BIAS sky130_fd_pr__cap_mim_m3_1 l=3 w=3
X3194 B11 TOP sky130_fd_pr__cap_mim_m3_1 l=3 w=3
X3195 B10 TOP sky130_fd_pr__cap_mim_m3_1 l=3 w=3
X3196 B8 TOP sky130_fd_pr__cap_mim_m3_1 l=3 w=3
X3197 B11 TOP sky130_fd_pr__cap_mim_m3_1 l=3 w=3
X3198 B10 TOP sky130_fd_pr__cap_mim_m3_1 l=3 w=3
X3199 B9 TOP sky130_fd_pr__cap_mim_m3_1 l=3 w=3
X3200 B10 TOP sky130_fd_pr__cap_mim_m3_1 l=3 w=3
X3201 B10 TOP sky130_fd_pr__cap_mim_m3_1 l=3 w=3
X3202 B11 TOP sky130_fd_pr__cap_mim_m3_1 l=3 w=3
X3203 B9 TOP sky130_fd_pr__cap_mim_m3_1 l=3 w=3
X3204 B9 TOP sky130_fd_pr__cap_mim_m3_1 l=3 w=3
X3205 B11 TOP sky130_fd_pr__cap_mim_m3_1 l=3 w=3
X3206 B9 TOP sky130_fd_pr__cap_mim_m3_1 l=3 w=3
X3207 B11 TOP sky130_fd_pr__cap_mim_m3_1 l=3 w=3
X3208 B11 TOP sky130_fd_pr__cap_mim_m3_1 l=3 w=3
X3209 EDGE_BIAS EDGE_BIAS sky130_fd_pr__cap_mim_m3_1 l=3 w=3
X3210 B10 TOP sky130_fd_pr__cap_mim_m3_1 l=3 w=3
X3211 B11 TOP sky130_fd_pr__cap_mim_m3_1 l=3 w=3
X3212 B9 TOP sky130_fd_pr__cap_mim_m3_1 l=3 w=3
X3213 B11 TOP sky130_fd_pr__cap_mim_m3_1 l=3 w=3
X3214 B11 TOP sky130_fd_pr__cap_mim_m3_1 l=3 w=3
X3215 B11 TOP sky130_fd_pr__cap_mim_m3_1 l=3 w=3
X3216 B10 TOP sky130_fd_pr__cap_mim_m3_1 l=3 w=3
X3217 B11 TOP sky130_fd_pr__cap_mim_m3_1 l=3 w=3
X3218 B11 TOP sky130_fd_pr__cap_mim_m3_1 l=3 w=3
X3219 B10 TOP sky130_fd_pr__cap_mim_m3_1 l=3 w=3
X3220 B11 TOP sky130_fd_pr__cap_mim_m3_1 l=3 w=3
X3221 B11 TOP sky130_fd_pr__cap_mim_m3_1 l=3 w=3
X3222 B11 TOP sky130_fd_pr__cap_mim_m3_1 l=3 w=3
X3223 EDGE_BIAS EDGE_BIAS sky130_fd_pr__cap_mim_m3_1 l=3 w=3
X3224 B10 TOP sky130_fd_pr__cap_mim_m3_1 l=3 w=3
X3225 B9 TOP sky130_fd_pr__cap_mim_m3_1 l=3 w=3
X3226 B7 TOP sky130_fd_pr__cap_mim_m3_1 l=3 w=3
X3227 B7 TOP sky130_fd_pr__cap_mim_m3_1 l=3 w=3
X3228 B11 TOP sky130_fd_pr__cap_mim_m3_1 l=3 w=3
X3229 B11 TOP sky130_fd_pr__cap_mim_m3_1 l=3 w=3
X3230 B10 TOP sky130_fd_pr__cap_mim_m3_1 l=3 w=3
X3231 B9 TOP sky130_fd_pr__cap_mim_m3_1 l=3 w=3
X3232 B11 TOP sky130_fd_pr__cap_mim_m3_1 l=3 w=3
X3233 B11 TOP sky130_fd_pr__cap_mim_m3_1 l=3 w=3
X3234 B11 TOP sky130_fd_pr__cap_mim_m3_1 l=3 w=3
X3235 B10 TOP sky130_fd_pr__cap_mim_m3_1 l=3 w=3
X3236 B10 TOP sky130_fd_pr__cap_mim_m3_1 l=3 w=3
X3237 B8 TOP sky130_fd_pr__cap_mim_m3_1 l=3 w=3
X3238 B9 TOP sky130_fd_pr__cap_mim_m3_1 l=3 w=3
X3239 B10 TOP sky130_fd_pr__cap_mim_m3_1 l=3 w=3
X3240 B11 TOP sky130_fd_pr__cap_mim_m3_1 l=3 w=3
X3241 B11 TOP sky130_fd_pr__cap_mim_m3_1 l=3 w=3
X3242 B10 TOP sky130_fd_pr__cap_mim_m3_1 l=3 w=3
X3243 B11 TOP sky130_fd_pr__cap_mim_m3_1 l=3 w=3
X3244 B11 TOP sky130_fd_pr__cap_mim_m3_1 l=3 w=3
X3245 B10 TOP sky130_fd_pr__cap_mim_m3_1 l=3 w=3
X3246 EDGE_BIAS EDGE_BIAS sky130_fd_pr__cap_mim_m3_1 l=3 w=3
X3247 B11 TOP sky130_fd_pr__cap_mim_m3_1 l=3 w=3
X3248 B11 TOP sky130_fd_pr__cap_mim_m3_1 l=3 w=3
X3249 B6 TOP sky130_fd_pr__cap_mim_m3_1 l=3 w=3
X3250 B4 TOP sky130_fd_pr__cap_mim_m3_1 l=3 w=3
X3251 B11 TOP sky130_fd_pr__cap_mim_m3_1 l=3 w=3
X3252 B10 TOP sky130_fd_pr__cap_mim_m3_1 l=3 w=3
X3253 B11 TOP sky130_fd_pr__cap_mim_m3_1 l=3 w=3
X3254 B11 TOP sky130_fd_pr__cap_mim_m3_1 l=3 w=3
X3255 B10 TOP sky130_fd_pr__cap_mim_m3_1 l=3 w=3
X3256 B11 TOP sky130_fd_pr__cap_mim_m3_1 l=3 w=3
X3257 B5 TOP sky130_fd_pr__cap_mim_m3_1 l=3 w=3
X3258 B11 TOP sky130_fd_pr__cap_mim_m3_1 l=3 w=3
X3259 B11 TOP sky130_fd_pr__cap_mim_m3_1 l=3 w=3
X3260 B8 TOP sky130_fd_pr__cap_mim_m3_1 l=3 w=3
X3261 B11 TOP sky130_fd_pr__cap_mim_m3_1 l=3 w=3
X3262 EDGE_BIAS EDGE_BIAS sky130_fd_pr__cap_mim_m3_1 l=3 w=3
X3263 B8 TOP sky130_fd_pr__cap_mim_m3_1 l=3 w=3
X3264 B11 TOP sky130_fd_pr__cap_mim_m3_1 l=3 w=3
X3265 B11 TOP sky130_fd_pr__cap_mim_m3_1 l=3 w=3
X3266 B11 TOP sky130_fd_pr__cap_mim_m3_1 l=3 w=3
X3267 B8 TOP sky130_fd_pr__cap_mim_m3_1 l=3 w=3
X3268 B11 TOP sky130_fd_pr__cap_mim_m3_1 l=3 w=3
X3269 B10 TOP sky130_fd_pr__cap_mim_m3_1 l=3 w=3
X3270 B11 TOP sky130_fd_pr__cap_mim_m3_1 l=3 w=3
X3271 B10 TOP sky130_fd_pr__cap_mim_m3_1 l=3 w=3
X3272 B10 TOP sky130_fd_pr__cap_mim_m3_1 l=3 w=3
X3273 B11 TOP sky130_fd_pr__cap_mim_m3_1 l=3 w=3
X3274 B9 TOP sky130_fd_pr__cap_mim_m3_1 l=3 w=3
X3275 B11 TOP sky130_fd_pr__cap_mim_m3_1 l=3 w=3
X3276 B7 TOP sky130_fd_pr__cap_mim_m3_1 l=3 w=3
X3277 B9 TOP sky130_fd_pr__cap_mim_m3_1 l=3 w=3
X3278 B11 TOP sky130_fd_pr__cap_mim_m3_1 l=3 w=3
X3279 B9 TOP sky130_fd_pr__cap_mim_m3_1 l=3 w=3
X3280 B11 TOP sky130_fd_pr__cap_mim_m3_1 l=3 w=3
X3281 B11 TOP sky130_fd_pr__cap_mim_m3_1 l=3 w=3
X3282 EDGE_BIAS EDGE_BIAS sky130_fd_pr__cap_mim_m3_1 l=3 w=3
X3283 B9 TOP sky130_fd_pr__cap_mim_m3_1 l=3 w=3
X3284 B10 TOP sky130_fd_pr__cap_mim_m3_1 l=3 w=3
X3285 B10 TOP sky130_fd_pr__cap_mim_m3_1 l=3 w=3
X3286 EDGE_BIAS EDGE_BIAS sky130_fd_pr__cap_mim_m3_1 l=3 w=3
X3287 B10 TOP sky130_fd_pr__cap_mim_m3_1 l=3 w=3
X3288 B9 TOP sky130_fd_pr__cap_mim_m3_1 l=3 w=3
X3289 B11 TOP sky130_fd_pr__cap_mim_m3_1 l=3 w=3
X3290 B11 TOP sky130_fd_pr__cap_mim_m3_1 l=3 w=3
X3291 B10 TOP sky130_fd_pr__cap_mim_m3_1 l=3 w=3
X3292 B11 TOP sky130_fd_pr__cap_mim_m3_1 l=3 w=3
X3293 B11 TOP sky130_fd_pr__cap_mim_m3_1 l=3 w=3
X3294 B10 TOP sky130_fd_pr__cap_mim_m3_1 l=3 w=3
X3295 B11 TOP sky130_fd_pr__cap_mim_m3_1 l=3 w=3
X3296 B11 TOP sky130_fd_pr__cap_mim_m3_1 l=3 w=3
X3297 B10 TOP sky130_fd_pr__cap_mim_m3_1 l=3 w=3
X3298 B11 TOP sky130_fd_pr__cap_mim_m3_1 l=3 w=3
X3299 EDGE_BIAS EDGE_BIAS sky130_fd_pr__cap_mim_m3_1 l=3 w=3
X3300 B11 TOP sky130_fd_pr__cap_mim_m3_1 l=3 w=3
X3301 EDGE_BIAS EDGE_BIAS sky130_fd_pr__cap_mim_m3_1 l=3 w=3
X3302 B11 TOP sky130_fd_pr__cap_mim_m3_1 l=3 w=3
X3303 B10 TOP sky130_fd_pr__cap_mim_m3_1 l=3 w=3
X3304 B10 TOP sky130_fd_pr__cap_mim_m3_1 l=3 w=3
X3305 B10 TOP sky130_fd_pr__cap_mim_m3_1 l=3 w=3
X3306 B9 TOP sky130_fd_pr__cap_mim_m3_1 l=3 w=3
X3307 B10 TOP sky130_fd_pr__cap_mim_m3_1 l=3 w=3
X3308 B8 TOP sky130_fd_pr__cap_mim_m3_1 l=3 w=3
X3309 B11 TOP sky130_fd_pr__cap_mim_m3_1 l=3 w=3
X3310 B10 TOP sky130_fd_pr__cap_mim_m3_1 l=3 w=3
X3311 B9 TOP sky130_fd_pr__cap_mim_m3_1 l=3 w=3
X3312 B11 TOP sky130_fd_pr__cap_mim_m3_1 l=3 w=3
X3313 B10 TOP sky130_fd_pr__cap_mim_m3_1 l=3 w=3
X3314 B11 TOP sky130_fd_pr__cap_mim_m3_1 l=3 w=3
X3315 B10 TOP sky130_fd_pr__cap_mim_m3_1 l=3 w=3
X3316 B8 TOP sky130_fd_pr__cap_mim_m3_1 l=3 w=3
X3317 B11 TOP sky130_fd_pr__cap_mim_m3_1 l=3 w=3
X3318 B11 TOP sky130_fd_pr__cap_mim_m3_1 l=3 w=3
X3319 B10 TOP sky130_fd_pr__cap_mim_m3_1 l=3 w=3
X3320 B6 TOP sky130_fd_pr__cap_mim_m3_1 l=3 w=3
X3321 B11 TOP sky130_fd_pr__cap_mim_m3_1 l=3 w=3
X3322 B7 TOP sky130_fd_pr__cap_mim_m3_1 l=3 w=3
X3323 B10 TOP sky130_fd_pr__cap_mim_m3_1 l=3 w=3
X3324 B10 TOP sky130_fd_pr__cap_mim_m3_1 l=3 w=3
X3325 B11 TOP sky130_fd_pr__cap_mim_m3_1 l=3 w=3
X3326 B11 TOP sky130_fd_pr__cap_mim_m3_1 l=3 w=3
X3327 B11 TOP sky130_fd_pr__cap_mim_m3_1 l=3 w=3
X3328 B8 TOP sky130_fd_pr__cap_mim_m3_1 l=3 w=3
X3329 B9 TOP sky130_fd_pr__cap_mim_m3_1 l=3 w=3
X3330 B9 TOP sky130_fd_pr__cap_mim_m3_1 l=3 w=3
X3331 B11 TOP sky130_fd_pr__cap_mim_m3_1 l=3 w=3
X3332 B10 TOP sky130_fd_pr__cap_mim_m3_1 l=3 w=3
X3333 B8 TOP sky130_fd_pr__cap_mim_m3_1 l=3 w=3
X3334 B11 TOP sky130_fd_pr__cap_mim_m3_1 l=3 w=3
X3335 B11 TOP sky130_fd_pr__cap_mim_m3_1 l=3 w=3
X3336 B11 TOP sky130_fd_pr__cap_mim_m3_1 l=3 w=3
X3337 B8 TOP sky130_fd_pr__cap_mim_m3_1 l=3 w=3
X3338 B11 TOP sky130_fd_pr__cap_mim_m3_1 l=3 w=3
X3339 B11 TOP sky130_fd_pr__cap_mim_m3_1 l=3 w=3
X3340 B10 TOP sky130_fd_pr__cap_mim_m3_1 l=3 w=3
X3341 B9 TOP sky130_fd_pr__cap_mim_m3_1 l=3 w=3
X3342 B9 TOP sky130_fd_pr__cap_mim_m3_1 l=3 w=3
X3343 B6 TOP sky130_fd_pr__cap_mim_m3_1 l=3 w=3
X3344 B10 TOP sky130_fd_pr__cap_mim_m3_1 l=3 w=3
X3345 B9 TOP sky130_fd_pr__cap_mim_m3_1 l=3 w=3
X3346 B11 TOP sky130_fd_pr__cap_mim_m3_1 l=3 w=3
X3347 B7 TOP sky130_fd_pr__cap_mim_m3_1 l=3 w=3
X3348 B9 TOP sky130_fd_pr__cap_mim_m3_1 l=3 w=3
X3349 EDGE_BIAS EDGE_BIAS sky130_fd_pr__cap_mim_m3_1 l=3 w=3
X3350 B9 TOP sky130_fd_pr__cap_mim_m3_1 l=3 w=3
X3351 B11 TOP sky130_fd_pr__cap_mim_m3_1 l=3 w=3
X3352 B10 TOP sky130_fd_pr__cap_mim_m3_1 l=3 w=3
X3353 B9 TOP sky130_fd_pr__cap_mim_m3_1 l=3 w=3
X3354 B10 TOP sky130_fd_pr__cap_mim_m3_1 l=3 w=3
X3355 B11 TOP sky130_fd_pr__cap_mim_m3_1 l=3 w=3
X3356 B9 TOP sky130_fd_pr__cap_mim_m3_1 l=3 w=3
X3357 B11 TOP sky130_fd_pr__cap_mim_m3_1 l=3 w=3
X3358 B11 TOP sky130_fd_pr__cap_mim_m3_1 l=3 w=3
X3359 B11 TOP sky130_fd_pr__cap_mim_m3_1 l=3 w=3
X3360 B11 TOP sky130_fd_pr__cap_mim_m3_1 l=3 w=3
X3361 B10 TOP sky130_fd_pr__cap_mim_m3_1 l=3 w=3
X3362 B10 TOP sky130_fd_pr__cap_mim_m3_1 l=3 w=3
X3363 B7 TOP sky130_fd_pr__cap_mim_m3_1 l=3 w=3
X3364 B10 TOP sky130_fd_pr__cap_mim_m3_1 l=3 w=3
X3365 B7 TOP sky130_fd_pr__cap_mim_m3_1 l=3 w=3
X3366 B9 TOP sky130_fd_pr__cap_mim_m3_1 l=3 w=3
X3367 B11 TOP sky130_fd_pr__cap_mim_m3_1 l=3 w=3
X3368 B10 TOP sky130_fd_pr__cap_mim_m3_1 l=3 w=3
X3369 B9 TOP sky130_fd_pr__cap_mim_m3_1 l=3 w=3
X3370 B10 TOP sky130_fd_pr__cap_mim_m3_1 l=3 w=3
X3371 B8 TOP sky130_fd_pr__cap_mim_m3_1 l=3 w=3
X3372 B8 TOP sky130_fd_pr__cap_mim_m3_1 l=3 w=3
X3373 B10 TOP sky130_fd_pr__cap_mim_m3_1 l=3 w=3
X3374 B10 TOP sky130_fd_pr__cap_mim_m3_1 l=3 w=3
X3375 B9 TOP sky130_fd_pr__cap_mim_m3_1 l=3 w=3
X3376 EDGE_BIAS EDGE_BIAS sky130_fd_pr__cap_mim_m3_1 l=3 w=3
X3377 B11 TOP sky130_fd_pr__cap_mim_m3_1 l=3 w=3
X3378 B11 TOP sky130_fd_pr__cap_mim_m3_1 l=3 w=3
X3379 B10 TOP sky130_fd_pr__cap_mim_m3_1 l=3 w=3
X3380 B10 TOP sky130_fd_pr__cap_mim_m3_1 l=3 w=3
X3381 B8 TOP sky130_fd_pr__cap_mim_m3_1 l=3 w=3
X3382 B11 TOP sky130_fd_pr__cap_mim_m3_1 l=3 w=3
X3383 B11 TOP sky130_fd_pr__cap_mim_m3_1 l=3 w=3
X3384 B5 TOP sky130_fd_pr__cap_mim_m3_1 l=3 w=3
X3385 B11 TOP sky130_fd_pr__cap_mim_m3_1 l=3 w=3
X3386 B10 TOP sky130_fd_pr__cap_mim_m3_1 l=3 w=3
X3387 B9 TOP sky130_fd_pr__cap_mim_m3_1 l=3 w=3
X3388 B11 TOP sky130_fd_pr__cap_mim_m3_1 l=3 w=3
X3389 EDGE_BIAS EDGE_BIAS sky130_fd_pr__cap_mim_m3_1 l=3 w=3
X3390 EDGE_BIAS EDGE_BIAS sky130_fd_pr__cap_mim_m3_1 l=3 w=3
X3391 B10 TOP sky130_fd_pr__cap_mim_m3_1 l=3 w=3
X3392 B5 TOP sky130_fd_pr__cap_mim_m3_1 l=3 w=3
X3393 B8 TOP sky130_fd_pr__cap_mim_m3_1 l=3 w=3
X3394 B11 TOP sky130_fd_pr__cap_mim_m3_1 l=3 w=3
X3395 B11 TOP sky130_fd_pr__cap_mim_m3_1 l=3 w=3
X3396 B6 TOP sky130_fd_pr__cap_mim_m3_1 l=3 w=3
X3397 B11 TOP sky130_fd_pr__cap_mim_m3_1 l=3 w=3
X3398 B8 TOP sky130_fd_pr__cap_mim_m3_1 l=3 w=3
X3399 B10 TOP sky130_fd_pr__cap_mim_m3_1 l=3 w=3
X3400 B11 TOP sky130_fd_pr__cap_mim_m3_1 l=3 w=3
X3401 B9 TOP sky130_fd_pr__cap_mim_m3_1 l=3 w=3
X3402 B11 TOP sky130_fd_pr__cap_mim_m3_1 l=3 w=3
X3403 B10 TOP sky130_fd_pr__cap_mim_m3_1 l=3 w=3
X3404 B11 TOP sky130_fd_pr__cap_mim_m3_1 l=3 w=3
X3405 B9 TOP sky130_fd_pr__cap_mim_m3_1 l=3 w=3
X3406 B11 TOP sky130_fd_pr__cap_mim_m3_1 l=3 w=3
X3407 B9 TOP sky130_fd_pr__cap_mim_m3_1 l=3 w=3
X3408 B7 TOP sky130_fd_pr__cap_mim_m3_1 l=3 w=3
X3409 EDGE_BIAS EDGE_BIAS sky130_fd_pr__cap_mim_m3_1 l=3 w=3
X3410 B9 TOP sky130_fd_pr__cap_mim_m3_1 l=3 w=3
X3411 B11 TOP sky130_fd_pr__cap_mim_m3_1 l=3 w=3
X3412 B10 TOP sky130_fd_pr__cap_mim_m3_1 l=3 w=3
X3413 B11 TOP sky130_fd_pr__cap_mim_m3_1 l=3 w=3
X3414 B11 TOP sky130_fd_pr__cap_mim_m3_1 l=3 w=3
X3415 B9 TOP sky130_fd_pr__cap_mim_m3_1 l=3 w=3
X3416 B10 TOP sky130_fd_pr__cap_mim_m3_1 l=3 w=3
X3417 B11 TOP sky130_fd_pr__cap_mim_m3_1 l=3 w=3
X3418 B11 TOP sky130_fd_pr__cap_mim_m3_1 l=3 w=3
X3419 B9 TOP sky130_fd_pr__cap_mim_m3_1 l=3 w=3
X3420 B10 TOP sky130_fd_pr__cap_mim_m3_1 l=3 w=3
X3421 B11 TOP sky130_fd_pr__cap_mim_m3_1 l=3 w=3
X3422 B11 TOP sky130_fd_pr__cap_mim_m3_1 l=3 w=3
X3423 B8 TOP sky130_fd_pr__cap_mim_m3_1 l=3 w=3
X3424 B10 TOP sky130_fd_pr__cap_mim_m3_1 l=3 w=3
X3425 B11 TOP sky130_fd_pr__cap_mim_m3_1 l=3 w=3
X3426 B11 TOP sky130_fd_pr__cap_mim_m3_1 l=3 w=3
X3427 B11 TOP sky130_fd_pr__cap_mim_m3_1 l=3 w=3
X3428 B7 TOP sky130_fd_pr__cap_mim_m3_1 l=3 w=3
X3429 B11 TOP sky130_fd_pr__cap_mim_m3_1 l=3 w=3
X3430 B11 TOP sky130_fd_pr__cap_mim_m3_1 l=3 w=3
X3431 B11 TOP sky130_fd_pr__cap_mim_m3_1 l=3 w=3
X3432 B10 TOP sky130_fd_pr__cap_mim_m3_1 l=3 w=3
X3433 B9 TOP sky130_fd_pr__cap_mim_m3_1 l=3 w=3
X3434 B8 TOP sky130_fd_pr__cap_mim_m3_1 l=3 w=3
X3435 B10 TOP sky130_fd_pr__cap_mim_m3_1 l=3 w=3
X3436 B10 TOP sky130_fd_pr__cap_mim_m3_1 l=3 w=3
X3437 B11 TOP sky130_fd_pr__cap_mim_m3_1 l=3 w=3
X3438 B11 TOP sky130_fd_pr__cap_mim_m3_1 l=3 w=3
X3439 B11 TOP sky130_fd_pr__cap_mim_m3_1 l=3 w=3
X3440 EDGE_BIAS EDGE_BIAS sky130_fd_pr__cap_mim_m3_1 l=3 w=3
X3441 B10 TOP sky130_fd_pr__cap_mim_m3_1 l=3 w=3
X3442 B8 TOP sky130_fd_pr__cap_mim_m3_1 l=3 w=3
X3443 B8 TOP sky130_fd_pr__cap_mim_m3_1 l=3 w=3
X3444 B11 TOP sky130_fd_pr__cap_mim_m3_1 l=3 w=3
X3445 B10 TOP sky130_fd_pr__cap_mim_m3_1 l=3 w=3
X3446 B11 TOP sky130_fd_pr__cap_mim_m3_1 l=3 w=3
X3447 B10 TOP sky130_fd_pr__cap_mim_m3_1 l=3 w=3
X3448 B6 TOP sky130_fd_pr__cap_mim_m3_1 l=3 w=3
X3449 B2 TOP sky130_fd_pr__cap_mim_m3_1 l=3 w=3
X3450 B11 TOP sky130_fd_pr__cap_mim_m3_1 l=3 w=3
X3451 B9 TOP sky130_fd_pr__cap_mim_m3_1 l=3 w=3
X3452 B11 TOP sky130_fd_pr__cap_mim_m3_1 l=3 w=3
X3453 B11 TOP sky130_fd_pr__cap_mim_m3_1 l=3 w=3
X3454 B10 TOP sky130_fd_pr__cap_mim_m3_1 l=3 w=3
X3455 EDGE_BIAS EDGE_BIAS sky130_fd_pr__cap_mim_m3_1 l=3 w=3
X3456 B6 TOP sky130_fd_pr__cap_mim_m3_1 l=3 w=3
X3457 B9 TOP sky130_fd_pr__cap_mim_m3_1 l=3 w=3
X3458 B11 TOP sky130_fd_pr__cap_mim_m3_1 l=3 w=3
X3459 B11 TOP sky130_fd_pr__cap_mim_m3_1 l=3 w=3
X3460 B11 TOP sky130_fd_pr__cap_mim_m3_1 l=3 w=3
X3461 B11 TOP sky130_fd_pr__cap_mim_m3_1 l=3 w=3
X3462 B11 TOP sky130_fd_pr__cap_mim_m3_1 l=3 w=3
X3463 B10 TOP sky130_fd_pr__cap_mim_m3_1 l=3 w=3
X3464 B11 TOP sky130_fd_pr__cap_mim_m3_1 l=3 w=3
X3465 B10 TOP sky130_fd_pr__cap_mim_m3_1 l=3 w=3
X3466 B11 TOP sky130_fd_pr__cap_mim_m3_1 l=3 w=3
X3467 B11 TOP sky130_fd_pr__cap_mim_m3_1 l=3 w=3
X3468 B11 TOP sky130_fd_pr__cap_mim_m3_1 l=3 w=3
X3469 B11 TOP sky130_fd_pr__cap_mim_m3_1 l=3 w=3
X3470 B10 TOP sky130_fd_pr__cap_mim_m3_1 l=3 w=3
X3471 B8 TOP sky130_fd_pr__cap_mim_m3_1 l=3 w=3
X3472 B11 TOP sky130_fd_pr__cap_mim_m3_1 l=3 w=3
X3473 B10 TOP sky130_fd_pr__cap_mim_m3_1 l=3 w=3
X3474 B9 TOP sky130_fd_pr__cap_mim_m3_1 l=3 w=3
X3475 B10 TOP sky130_fd_pr__cap_mim_m3_1 l=3 w=3
X3476 B11 TOP sky130_fd_pr__cap_mim_m3_1 l=3 w=3
X3477 B11 TOP sky130_fd_pr__cap_mim_m3_1 l=3 w=3
X3478 B7 TOP sky130_fd_pr__cap_mim_m3_1 l=3 w=3
X3479 B9 TOP sky130_fd_pr__cap_mim_m3_1 l=3 w=3
X3480 B11 TOP sky130_fd_pr__cap_mim_m3_1 l=3 w=3
X3481 EDGE_BIAS EDGE_BIAS sky130_fd_pr__cap_mim_m3_1 l=3 w=3
X3482 B9 TOP sky130_fd_pr__cap_mim_m3_1 l=3 w=3
X3483 B11 TOP sky130_fd_pr__cap_mim_m3_1 l=3 w=3
X3484 B10 TOP sky130_fd_pr__cap_mim_m3_1 l=3 w=3
X3485 B8 TOP sky130_fd_pr__cap_mim_m3_1 l=3 w=3
X3486 B9 TOP sky130_fd_pr__cap_mim_m3_1 l=3 w=3
X3487 B10 TOP sky130_fd_pr__cap_mim_m3_1 l=3 w=3
X3488 B11 TOP sky130_fd_pr__cap_mim_m3_1 l=3 w=3
X3489 B10 TOP sky130_fd_pr__cap_mim_m3_1 l=3 w=3
X3490 B10 TOP sky130_fd_pr__cap_mim_m3_1 l=3 w=3
X3491 B11 TOP sky130_fd_pr__cap_mim_m3_1 l=3 w=3
X3492 B11 TOP sky130_fd_pr__cap_mim_m3_1 l=3 w=3
X3493 B10 TOP sky130_fd_pr__cap_mim_m3_1 l=3 w=3
X3494 B11 TOP sky130_fd_pr__cap_mim_m3_1 l=3 w=3
X3495 B11 TOP sky130_fd_pr__cap_mim_m3_1 l=3 w=3
X3496 B10 TOP sky130_fd_pr__cap_mim_m3_1 l=3 w=3
X3497 B11 TOP sky130_fd_pr__cap_mim_m3_1 l=3 w=3
X3498 B7 TOP sky130_fd_pr__cap_mim_m3_1 l=3 w=3
X3499 B10 TOP sky130_fd_pr__cap_mim_m3_1 l=3 w=3
X3500 B11 TOP sky130_fd_pr__cap_mim_m3_1 l=3 w=3
X3501 B11 TOP sky130_fd_pr__cap_mim_m3_1 l=3 w=3
X3502 B11 TOP sky130_fd_pr__cap_mim_m3_1 l=3 w=3
X3503 B10 TOP sky130_fd_pr__cap_mim_m3_1 l=3 w=3
X3504 B11 TOP sky130_fd_pr__cap_mim_m3_1 l=3 w=3
X3505 B10 TOP sky130_fd_pr__cap_mim_m3_1 l=3 w=3
X3506 B11 TOP sky130_fd_pr__cap_mim_m3_1 l=3 w=3
X3507 B10 TOP sky130_fd_pr__cap_mim_m3_1 l=3 w=3
X3508 B10 TOP sky130_fd_pr__cap_mim_m3_1 l=3 w=3
X3509 B9 TOP sky130_fd_pr__cap_mim_m3_1 l=3 w=3
X3510 B9 TOP sky130_fd_pr__cap_mim_m3_1 l=3 w=3
X3511 B10 TOP sky130_fd_pr__cap_mim_m3_1 l=3 w=3
X3512 B8 TOP sky130_fd_pr__cap_mim_m3_1 l=3 w=3
X3513 B11 TOP sky130_fd_pr__cap_mim_m3_1 l=3 w=3
X3514 B11 TOP sky130_fd_pr__cap_mim_m3_1 l=3 w=3
X3515 B11 TOP sky130_fd_pr__cap_mim_m3_1 l=3 w=3
X3516 B10 TOP sky130_fd_pr__cap_mim_m3_1 l=3 w=3
X3517 B11 TOP sky130_fd_pr__cap_mim_m3_1 l=3 w=3
X3518 B10 TOP sky130_fd_pr__cap_mim_m3_1 l=3 w=3
X3519 B8 TOP sky130_fd_pr__cap_mim_m3_1 l=3 w=3
X3520 B11 TOP sky130_fd_pr__cap_mim_m3_1 l=3 w=3
X3521 B5 TOP sky130_fd_pr__cap_mim_m3_1 l=3 w=3
X3522 B11 TOP sky130_fd_pr__cap_mim_m3_1 l=3 w=3
X3523 B11 TOP sky130_fd_pr__cap_mim_m3_1 l=3 w=3
X3524 B10 TOP sky130_fd_pr__cap_mim_m3_1 l=3 w=3
X3525 B10 TOP sky130_fd_pr__cap_mim_m3_1 l=3 w=3
X3526 B11 TOP sky130_fd_pr__cap_mim_m3_1 l=3 w=3
X3527 B9 TOP sky130_fd_pr__cap_mim_m3_1 l=3 w=3
X3528 B11 TOP sky130_fd_pr__cap_mim_m3_1 l=3 w=3
X3529 B4 TOP sky130_fd_pr__cap_mim_m3_1 l=3 w=3
X3530 B10 TOP sky130_fd_pr__cap_mim_m3_1 l=3 w=3
X3531 B10 TOP sky130_fd_pr__cap_mim_m3_1 l=3 w=3
X3532 B10 TOP sky130_fd_pr__cap_mim_m3_1 l=3 w=3
X3533 B8 TOP sky130_fd_pr__cap_mim_m3_1 l=3 w=3
X3534 B11 TOP sky130_fd_pr__cap_mim_m3_1 l=3 w=3
X3535 B10 TOP sky130_fd_pr__cap_mim_m3_1 l=3 w=3
X3536 EDGE_BIAS EDGE_BIAS sky130_fd_pr__cap_mim_m3_1 l=3 w=3
X3537 B9 TOP sky130_fd_pr__cap_mim_m3_1 l=3 w=3
X3538 B11 TOP sky130_fd_pr__cap_mim_m3_1 l=3 w=3
X3539 B11 TOP sky130_fd_pr__cap_mim_m3_1 l=3 w=3
X3540 B11 TOP sky130_fd_pr__cap_mim_m3_1 l=3 w=3
X3541 B10 TOP sky130_fd_pr__cap_mim_m3_1 l=3 w=3
X3542 B8 TOP sky130_fd_pr__cap_mim_m3_1 l=3 w=3
X3543 B11 TOP sky130_fd_pr__cap_mim_m3_1 l=3 w=3
X3544 B8 TOP sky130_fd_pr__cap_mim_m3_1 l=3 w=3
X3545 B8 TOP sky130_fd_pr__cap_mim_m3_1 l=3 w=3
X3546 B11 TOP sky130_fd_pr__cap_mim_m3_1 l=3 w=3
X3547 B10 TOP sky130_fd_pr__cap_mim_m3_1 l=3 w=3
X3548 EDGE_BIAS EDGE_BIAS sky130_fd_pr__cap_mim_m3_1 l=3 w=3
X3549 B9 TOP sky130_fd_pr__cap_mim_m3_1 l=3 w=3
X3550 B10 TOP sky130_fd_pr__cap_mim_m3_1 l=3 w=3
X3551 B11 TOP sky130_fd_pr__cap_mim_m3_1 l=3 w=3
X3552 EDGE_BIAS EDGE_BIAS sky130_fd_pr__cap_mim_m3_1 l=3 w=3
X3553 B11 TOP sky130_fd_pr__cap_mim_m3_1 l=3 w=3
X3554 B11 TOP sky130_fd_pr__cap_mim_m3_1 l=3 w=3
X3555 B11 TOP sky130_fd_pr__cap_mim_m3_1 l=3 w=3
X3556 B7 TOP sky130_fd_pr__cap_mim_m3_1 l=3 w=3
X3557 B11 TOP sky130_fd_pr__cap_mim_m3_1 l=3 w=3
X3558 B9 TOP sky130_fd_pr__cap_mim_m3_1 l=3 w=3
X3559 B10 TOP sky130_fd_pr__cap_mim_m3_1 l=3 w=3
X3560 B10 TOP sky130_fd_pr__cap_mim_m3_1 l=3 w=3
X3561 B11 TOP sky130_fd_pr__cap_mim_m3_1 l=3 w=3
X3562 B9 TOP sky130_fd_pr__cap_mim_m3_1 l=3 w=3
X3563 B11 TOP sky130_fd_pr__cap_mim_m3_1 l=3 w=3
X3564 B10 TOP sky130_fd_pr__cap_mim_m3_1 l=3 w=3
X3565 B11 TOP sky130_fd_pr__cap_mim_m3_1 l=3 w=3
X3566 B9 TOP sky130_fd_pr__cap_mim_m3_1 l=3 w=3
X3567 B11 TOP sky130_fd_pr__cap_mim_m3_1 l=3 w=3
X3568 B7 TOP sky130_fd_pr__cap_mim_m3_1 l=3 w=3
X3569 B11 TOP sky130_fd_pr__cap_mim_m3_1 l=3 w=3
X3570 B11 TOP sky130_fd_pr__cap_mim_m3_1 l=3 w=3
X3571 B11 TOP sky130_fd_pr__cap_mim_m3_1 l=3 w=3
X3572 B10 TOP sky130_fd_pr__cap_mim_m3_1 l=3 w=3
X3573 B9 TOP sky130_fd_pr__cap_mim_m3_1 l=3 w=3
X3574 B10 TOP sky130_fd_pr__cap_mim_m3_1 l=3 w=3
X3575 B8 TOP sky130_fd_pr__cap_mim_m3_1 l=3 w=3
X3576 B9 TOP sky130_fd_pr__cap_mim_m3_1 l=3 w=3
X3577 B10 TOP sky130_fd_pr__cap_mim_m3_1 l=3 w=3
X3578 B10 TOP sky130_fd_pr__cap_mim_m3_1 l=3 w=3
X3579 B8 TOP sky130_fd_pr__cap_mim_m3_1 l=3 w=3
X3580 B10 TOP sky130_fd_pr__cap_mim_m3_1 l=3 w=3
X3581 EDGE_BIAS EDGE_BIAS sky130_fd_pr__cap_mim_m3_1 l=3 w=3
X3582 B11 TOP sky130_fd_pr__cap_mim_m3_1 l=3 w=3
X3583 B11 TOP sky130_fd_pr__cap_mim_m3_1 l=3 w=3
X3584 B10 TOP sky130_fd_pr__cap_mim_m3_1 l=3 w=3
X3585 B10 TOP sky130_fd_pr__cap_mim_m3_1 l=3 w=3
X3586 B9 TOP sky130_fd_pr__cap_mim_m3_1 l=3 w=3
X3587 B10 TOP sky130_fd_pr__cap_mim_m3_1 l=3 w=3
X3588 B8 TOP sky130_fd_pr__cap_mim_m3_1 l=3 w=3
X3589 B11 TOP sky130_fd_pr__cap_mim_m3_1 l=3 w=3
X3590 B10 TOP sky130_fd_pr__cap_mim_m3_1 l=3 w=3
X3591 B4 TOP sky130_fd_pr__cap_mim_m3_1 l=3 w=3
X3592 B11 TOP sky130_fd_pr__cap_mim_m3_1 l=3 w=3
X3593 B11 TOP sky130_fd_pr__cap_mim_m3_1 l=3 w=3
X3594 B11 TOP sky130_fd_pr__cap_mim_m3_1 l=3 w=3
X3595 B11 TOP sky130_fd_pr__cap_mim_m3_1 l=3 w=3
X3596 B11 TOP sky130_fd_pr__cap_mim_m3_1 l=3 w=3
X3597 B9 TOP sky130_fd_pr__cap_mim_m3_1 l=3 w=3
X3598 B9 TOP sky130_fd_pr__cap_mim_m3_1 l=3 w=3
X3599 B11 TOP sky130_fd_pr__cap_mim_m3_1 l=3 w=3
X3600 EDGE_BIAS EDGE_BIAS sky130_fd_pr__cap_mim_m3_1 l=3 w=3
X3601 B5 TOP sky130_fd_pr__cap_mim_m3_1 l=3 w=3
X3602 B11 TOP sky130_fd_pr__cap_mim_m3_1 l=3 w=3
X3603 B11 TOP sky130_fd_pr__cap_mim_m3_1 l=3 w=3
X3604 B11 TOP sky130_fd_pr__cap_mim_m3_1 l=3 w=3
X3605 B11 TOP sky130_fd_pr__cap_mim_m3_1 l=3 w=3
X3606 B11 TOP sky130_fd_pr__cap_mim_m3_1 l=3 w=3
X3607 B11 TOP sky130_fd_pr__cap_mim_m3_1 l=3 w=3
X3608 B8 TOP sky130_fd_pr__cap_mim_m3_1 l=3 w=3
X3609 B11 TOP sky130_fd_pr__cap_mim_m3_1 l=3 w=3
X3610 B11 TOP sky130_fd_pr__cap_mim_m3_1 l=3 w=3
X3611 B9 TOP sky130_fd_pr__cap_mim_m3_1 l=3 w=3
X3612 B11 TOP sky130_fd_pr__cap_mim_m3_1 l=3 w=3
X3613 B10 TOP sky130_fd_pr__cap_mim_m3_1 l=3 w=3
X3614 EDGE_BIAS EDGE_BIAS sky130_fd_pr__cap_mim_m3_1 l=3 w=3
X3615 B11 TOP sky130_fd_pr__cap_mim_m3_1 l=3 w=3
X3616 B11 TOP sky130_fd_pr__cap_mim_m3_1 l=3 w=3
X3617 B7 TOP sky130_fd_pr__cap_mim_m3_1 l=3 w=3
X3618 B7 TOP sky130_fd_pr__cap_mim_m3_1 l=3 w=3
X3619 B11 TOP sky130_fd_pr__cap_mim_m3_1 l=3 w=3
X3620 B11 TOP sky130_fd_pr__cap_mim_m3_1 l=3 w=3
X3621 B9 TOP sky130_fd_pr__cap_mim_m3_1 l=3 w=3
X3622 B7 TOP sky130_fd_pr__cap_mim_m3_1 l=3 w=3
X3623 B9 TOP sky130_fd_pr__cap_mim_m3_1 l=3 w=3
X3624 B9 TOP sky130_fd_pr__cap_mim_m3_1 l=3 w=3
X3625 B3 TOP sky130_fd_pr__cap_mim_m3_1 l=3 w=3
X3626 B10 TOP sky130_fd_pr__cap_mim_m3_1 l=3 w=3
X3627 B10 TOP sky130_fd_pr__cap_mim_m3_1 l=3 w=3
X3628 B10 TOP sky130_fd_pr__cap_mim_m3_1 l=3 w=3
X3629 B10 TOP sky130_fd_pr__cap_mim_m3_1 l=3 w=3
X3630 B11 TOP sky130_fd_pr__cap_mim_m3_1 l=3 w=3
X3631 B11 TOP sky130_fd_pr__cap_mim_m3_1 l=3 w=3
X3632 B9 TOP sky130_fd_pr__cap_mim_m3_1 l=3 w=3
X3633 B11 TOP sky130_fd_pr__cap_mim_m3_1 l=3 w=3
X3634 B11 TOP sky130_fd_pr__cap_mim_m3_1 l=3 w=3
X3635 B11 TOP sky130_fd_pr__cap_mim_m3_1 l=3 w=3
X3636 B10 TOP sky130_fd_pr__cap_mim_m3_1 l=3 w=3
X3637 B11 TOP sky130_fd_pr__cap_mim_m3_1 l=3 w=3
X3638 B11 TOP sky130_fd_pr__cap_mim_m3_1 l=3 w=3
X3639 B11 TOP sky130_fd_pr__cap_mim_m3_1 l=3 w=3
X3640 EDGE_BIAS EDGE_BIAS sky130_fd_pr__cap_mim_m3_1 l=3 w=3
X3641 B11 TOP sky130_fd_pr__cap_mim_m3_1 l=3 w=3
X3642 B11 TOP sky130_fd_pr__cap_mim_m3_1 l=3 w=3
X3643 B11 TOP sky130_fd_pr__cap_mim_m3_1 l=3 w=3
X3644 B10 TOP sky130_fd_pr__cap_mim_m3_1 l=3 w=3
X3645 B9 TOP sky130_fd_pr__cap_mim_m3_1 l=3 w=3
X3646 EDGE_BIAS EDGE_BIAS sky130_fd_pr__cap_mim_m3_1 l=3 w=3
X3647 B10 TOP sky130_fd_pr__cap_mim_m3_1 l=3 w=3
X3648 B8 TOP sky130_fd_pr__cap_mim_m3_1 l=3 w=3
X3649 B11 TOP sky130_fd_pr__cap_mim_m3_1 l=3 w=3
X3650 B10 TOP sky130_fd_pr__cap_mim_m3_1 l=3 w=3
X3651 B9 TOP sky130_fd_pr__cap_mim_m3_1 l=3 w=3
X3652 B11 TOP sky130_fd_pr__cap_mim_m3_1 l=3 w=3
X3653 B10 TOP sky130_fd_pr__cap_mim_m3_1 l=3 w=3
X3654 B8 TOP sky130_fd_pr__cap_mim_m3_1 l=3 w=3
X3655 B11 TOP sky130_fd_pr__cap_mim_m3_1 l=3 w=3
X3656 B11 TOP sky130_fd_pr__cap_mim_m3_1 l=3 w=3
X3657 B8 TOP sky130_fd_pr__cap_mim_m3_1 l=3 w=3
X3658 B10 TOP sky130_fd_pr__cap_mim_m3_1 l=3 w=3
X3659 B11 TOP sky130_fd_pr__cap_mim_m3_1 l=3 w=3
X3660 B11 TOP sky130_fd_pr__cap_mim_m3_1 l=3 w=3
X3661 B9 TOP sky130_fd_pr__cap_mim_m3_1 l=3 w=3
X3662 B11 TOP sky130_fd_pr__cap_mim_m3_1 l=3 w=3
X3663 B9 TOP sky130_fd_pr__cap_mim_m3_1 l=3 w=3
X3664 B11 TOP sky130_fd_pr__cap_mim_m3_1 l=3 w=3
X3665 B11 TOP sky130_fd_pr__cap_mim_m3_1 l=3 w=3
X3666 B11 TOP sky130_fd_pr__cap_mim_m3_1 l=3 w=3
X3667 B6 TOP sky130_fd_pr__cap_mim_m3_1 l=3 w=3
X3668 B11 TOP sky130_fd_pr__cap_mim_m3_1 l=3 w=3
X3669 B11 TOP sky130_fd_pr__cap_mim_m3_1 l=3 w=3
X3670 B11 TOP sky130_fd_pr__cap_mim_m3_1 l=3 w=3
X3671 B11 TOP sky130_fd_pr__cap_mim_m3_1 l=3 w=3
X3672 B9 TOP sky130_fd_pr__cap_mim_m3_1 l=3 w=3
X3673 B10 TOP sky130_fd_pr__cap_mim_m3_1 l=3 w=3
X3674 B11 TOP sky130_fd_pr__cap_mim_m3_1 l=3 w=3
X3675 B11 TOP sky130_fd_pr__cap_mim_m3_1 l=3 w=3
X3676 B11 TOP sky130_fd_pr__cap_mim_m3_1 l=3 w=3
X3677 B10 TOP sky130_fd_pr__cap_mim_m3_1 l=3 w=3
X3678 B10 TOP sky130_fd_pr__cap_mim_m3_1 l=3 w=3
X3679 B11 TOP sky130_fd_pr__cap_mim_m3_1 l=3 w=3
X3680 B11 TOP sky130_fd_pr__cap_mim_m3_1 l=3 w=3
X3681 B11 TOP sky130_fd_pr__cap_mim_m3_1 l=3 w=3
X3682 B8 TOP sky130_fd_pr__cap_mim_m3_1 l=3 w=3
X3683 EDGE_BIAS EDGE_BIAS sky130_fd_pr__cap_mim_m3_1 l=3 w=3
X3684 B10 TOP sky130_fd_pr__cap_mim_m3_1 l=3 w=3
X3685 B11 TOP sky130_fd_pr__cap_mim_m3_1 l=3 w=3
X3686 B11 TOP sky130_fd_pr__cap_mim_m3_1 l=3 w=3
X3687 B11 TOP sky130_fd_pr__cap_mim_m3_1 l=3 w=3
X3688 B11 TOP sky130_fd_pr__cap_mim_m3_1 l=3 w=3
X3689 B11 TOP sky130_fd_pr__cap_mim_m3_1 l=3 w=3
X3690 B7 TOP sky130_fd_pr__cap_mim_m3_1 l=3 w=3
X3691 B7 TOP sky130_fd_pr__cap_mim_m3_1 l=3 w=3
X3692 B11 TOP sky130_fd_pr__cap_mim_m3_1 l=3 w=3
X3693 B9 TOP sky130_fd_pr__cap_mim_m3_1 l=3 w=3
X3694 B11 TOP sky130_fd_pr__cap_mim_m3_1 l=3 w=3
X3695 B10 TOP sky130_fd_pr__cap_mim_m3_1 l=3 w=3
X3696 B10 TOP sky130_fd_pr__cap_mim_m3_1 l=3 w=3
X3697 B10 TOP sky130_fd_pr__cap_mim_m3_1 l=3 w=3
X3698 B8 TOP sky130_fd_pr__cap_mim_m3_1 l=3 w=3
X3699 B11 TOP sky130_fd_pr__cap_mim_m3_1 l=3 w=3
X3700 B10 TOP sky130_fd_pr__cap_mim_m3_1 l=3 w=3
X3701 B9 TOP sky130_fd_pr__cap_mim_m3_1 l=3 w=3
X3702 B11 TOP sky130_fd_pr__cap_mim_m3_1 l=3 w=3
X3703 EDGE_BIAS EDGE_BIAS sky130_fd_pr__cap_mim_m3_1 l=3 w=3
X3704 B10 TOP sky130_fd_pr__cap_mim_m3_1 l=3 w=3
X3705 B9 TOP sky130_fd_pr__cap_mim_m3_1 l=3 w=3
X3706 B11 TOP sky130_fd_pr__cap_mim_m3_1 l=3 w=3
X3707 B10 TOP sky130_fd_pr__cap_mim_m3_1 l=3 w=3
X3708 B10 TOP sky130_fd_pr__cap_mim_m3_1 l=3 w=3
X3709 B11 TOP sky130_fd_pr__cap_mim_m3_1 l=3 w=3
X3710 B10 TOP sky130_fd_pr__cap_mim_m3_1 l=3 w=3
X3711 B7 TOP sky130_fd_pr__cap_mim_m3_1 l=3 w=3
X3712 B10 TOP sky130_fd_pr__cap_mim_m3_1 l=3 w=3
X3713 B11 TOP sky130_fd_pr__cap_mim_m3_1 l=3 w=3
X3714 B11 TOP sky130_fd_pr__cap_mim_m3_1 l=3 w=3
X3715 B10 TOP sky130_fd_pr__cap_mim_m3_1 l=3 w=3
X3716 B10 TOP sky130_fd_pr__cap_mim_m3_1 l=3 w=3
X3717 B9 TOP sky130_fd_pr__cap_mim_m3_1 l=3 w=3
X3718 B11 TOP sky130_fd_pr__cap_mim_m3_1 l=3 w=3
X3719 EDGE_BIAS EDGE_BIAS sky130_fd_pr__cap_mim_m3_1 l=3 w=3
X3720 B10 TOP sky130_fd_pr__cap_mim_m3_1 l=3 w=3
X3721 B11 TOP sky130_fd_pr__cap_mim_m3_1 l=3 w=3
X3722 B11 TOP sky130_fd_pr__cap_mim_m3_1 l=3 w=3
X3723 B10 TOP sky130_fd_pr__cap_mim_m3_1 l=3 w=3
X3724 B9 TOP sky130_fd_pr__cap_mim_m3_1 l=3 w=3
X3725 B9 TOP sky130_fd_pr__cap_mim_m3_1 l=3 w=3
X3726 B11 TOP sky130_fd_pr__cap_mim_m3_1 l=3 w=3
X3727 B10 TOP sky130_fd_pr__cap_mim_m3_1 l=3 w=3
X3728 B8 TOP sky130_fd_pr__cap_mim_m3_1 l=3 w=3
X3729 B11 TOP sky130_fd_pr__cap_mim_m3_1 l=3 w=3
X3730 B11 TOP sky130_fd_pr__cap_mim_m3_1 l=3 w=3
X3731 B10 TOP sky130_fd_pr__cap_mim_m3_1 l=3 w=3
X3732 B4 TOP sky130_fd_pr__cap_mim_m3_1 l=3 w=3
X3733 B11 TOP sky130_fd_pr__cap_mim_m3_1 l=3 w=3
X3734 B9 TOP sky130_fd_pr__cap_mim_m3_1 l=3 w=3
X3735 B10 TOP sky130_fd_pr__cap_mim_m3_1 l=3 w=3
X3736 B9 TOP sky130_fd_pr__cap_mim_m3_1 l=3 w=3
X3737 B9 TOP sky130_fd_pr__cap_mim_m3_1 l=3 w=3
X3738 B11 TOP sky130_fd_pr__cap_mim_m3_1 l=3 w=3
X3739 B10 TOP sky130_fd_pr__cap_mim_m3_1 l=3 w=3
X3740 B5 TOP sky130_fd_pr__cap_mim_m3_1 l=3 w=3
X3741 B11 TOP sky130_fd_pr__cap_mim_m3_1 l=3 w=3
X3742 B10 TOP sky130_fd_pr__cap_mim_m3_1 l=3 w=3
X3743 B8 TOP sky130_fd_pr__cap_mim_m3_1 l=3 w=3
X3744 B11 TOP sky130_fd_pr__cap_mim_m3_1 l=3 w=3
X3745 B11 TOP sky130_fd_pr__cap_mim_m3_1 l=3 w=3
X3746 B10 TOP sky130_fd_pr__cap_mim_m3_1 l=3 w=3
X3747 B11 TOP sky130_fd_pr__cap_mim_m3_1 l=3 w=3
X3748 B11 TOP sky130_fd_pr__cap_mim_m3_1 l=3 w=3
X3749 B11 TOP sky130_fd_pr__cap_mim_m3_1 l=3 w=3
X3750 B11 TOP sky130_fd_pr__cap_mim_m3_1 l=3 w=3
X3751 B8 TOP sky130_fd_pr__cap_mim_m3_1 l=3 w=3
X3752 B11 TOP sky130_fd_pr__cap_mim_m3_1 l=3 w=3
X3753 B11 TOP sky130_fd_pr__cap_mim_m3_1 l=3 w=3
X3754 B10 TOP sky130_fd_pr__cap_mim_m3_1 l=3 w=3
X3755 EDGE_BIAS EDGE_BIAS sky130_fd_pr__cap_mim_m3_1 l=3 w=3
X3756 EDGE_BIAS EDGE_BIAS sky130_fd_pr__cap_mim_m3_1 l=3 w=3
X3757 B11 TOP sky130_fd_pr__cap_mim_m3_1 l=3 w=3
X3758 B9 TOP sky130_fd_pr__cap_mim_m3_1 l=3 w=3
X3759 B7 TOP sky130_fd_pr__cap_mim_m3_1 l=3 w=3
X3760 B7 TOP sky130_fd_pr__cap_mim_m3_1 l=3 w=3
X3761 B11 TOP sky130_fd_pr__cap_mim_m3_1 l=3 w=3
X3762 B11 TOP sky130_fd_pr__cap_mim_m3_1 l=3 w=3
X3763 B7 TOP sky130_fd_pr__cap_mim_m3_1 l=3 w=3
X3764 B11 TOP sky130_fd_pr__cap_mim_m3_1 l=3 w=3
X3765 B9 TOP sky130_fd_pr__cap_mim_m3_1 l=3 w=3
X3766 B10 TOP sky130_fd_pr__cap_mim_m3_1 l=3 w=3
X3767 B10 TOP sky130_fd_pr__cap_mim_m3_1 l=3 w=3
X3768 B8 TOP sky130_fd_pr__cap_mim_m3_1 l=3 w=3
X3769 B10 TOP sky130_fd_pr__cap_mim_m3_1 l=3 w=3
X3770 B9 TOP sky130_fd_pr__cap_mim_m3_1 l=3 w=3
X3771 B11 TOP sky130_fd_pr__cap_mim_m3_1 l=3 w=3
X3772 B7 TOP sky130_fd_pr__cap_mim_m3_1 l=3 w=3
X3773 B10 TOP sky130_fd_pr__cap_mim_m3_1 l=3 w=3
X3774 B11 TOP sky130_fd_pr__cap_mim_m3_1 l=3 w=3
X3775 B6 TOP sky130_fd_pr__cap_mim_m3_1 l=3 w=3
X3776 B11 TOP sky130_fd_pr__cap_mim_m3_1 l=3 w=3
X3777 B11 TOP sky130_fd_pr__cap_mim_m3_1 l=3 w=3
X3778 EDGE_BIAS EDGE_BIAS sky130_fd_pr__cap_mim_m3_1 l=3 w=3
X3779 B10 TOP sky130_fd_pr__cap_mim_m3_1 l=3 w=3
X3780 B9 TOP sky130_fd_pr__cap_mim_m3_1 l=3 w=3
X3781 B10 TOP sky130_fd_pr__cap_mim_m3_1 l=3 w=3
X3782 B11 TOP sky130_fd_pr__cap_mim_m3_1 l=3 w=3
X3783 B8 TOP sky130_fd_pr__cap_mim_m3_1 l=3 w=3
X3784 EDGE_BIAS EDGE_BIAS sky130_fd_pr__cap_mim_m3_1 l=3 w=3
X3785 B10 TOP sky130_fd_pr__cap_mim_m3_1 l=3 w=3
X3786 B10 TOP sky130_fd_pr__cap_mim_m3_1 l=3 w=3
X3787 B9 TOP sky130_fd_pr__cap_mim_m3_1 l=3 w=3
X3788 B9 TOP sky130_fd_pr__cap_mim_m3_1 l=3 w=3
X3789 B8 TOP sky130_fd_pr__cap_mim_m3_1 l=3 w=3
X3790 B11 TOP sky130_fd_pr__cap_mim_m3_1 l=3 w=3
X3791 B11 TOP sky130_fd_pr__cap_mim_m3_1 l=3 w=3
X3792 B11 TOP sky130_fd_pr__cap_mim_m3_1 l=3 w=3
X3793 B11 TOP sky130_fd_pr__cap_mim_m3_1 l=3 w=3
X3794 B8 TOP sky130_fd_pr__cap_mim_m3_1 l=3 w=3
X3795 B11 TOP sky130_fd_pr__cap_mim_m3_1 l=3 w=3
X3796 B10 TOP sky130_fd_pr__cap_mim_m3_1 l=3 w=3
X3797 B11 TOP sky130_fd_pr__cap_mim_m3_1 l=3 w=3
X3798 EDGE_BIAS EDGE_BIAS sky130_fd_pr__cap_mim_m3_1 l=3 w=3
X3799 B9 TOP sky130_fd_pr__cap_mim_m3_1 l=3 w=3
X3800 B11 TOP sky130_fd_pr__cap_mim_m3_1 l=3 w=3
X3801 B10 TOP sky130_fd_pr__cap_mim_m3_1 l=3 w=3
X3802 B11 TOP sky130_fd_pr__cap_mim_m3_1 l=3 w=3
X3803 B9 TOP sky130_fd_pr__cap_mim_m3_1 l=3 w=3
X3804 EDGE_BIAS EDGE_BIAS sky130_fd_pr__cap_mim_m3_1 l=3 w=3
X3805 B6 TOP sky130_fd_pr__cap_mim_m3_1 l=3 w=3
X3806 B11 TOP sky130_fd_pr__cap_mim_m3_1 l=3 w=3
X3807 B11 TOP sky130_fd_pr__cap_mim_m3_1 l=3 w=3
X3808 B11 TOP sky130_fd_pr__cap_mim_m3_1 l=3 w=3
X3809 B10 TOP sky130_fd_pr__cap_mim_m3_1 l=3 w=3
X3810 B11 TOP sky130_fd_pr__cap_mim_m3_1 l=3 w=3
X3811 B10 TOP sky130_fd_pr__cap_mim_m3_1 l=3 w=3
X3812 B9 TOP sky130_fd_pr__cap_mim_m3_1 l=3 w=3
X3813 EDGE_BIAS EDGE_BIAS sky130_fd_pr__cap_mim_m3_1 l=3 w=3
X3814 B8 TOP sky130_fd_pr__cap_mim_m3_1 l=3 w=3
X3815 B11 TOP sky130_fd_pr__cap_mim_m3_1 l=3 w=3
X3816 B11 TOP sky130_fd_pr__cap_mim_m3_1 l=3 w=3
X3817 B11 TOP sky130_fd_pr__cap_mim_m3_1 l=3 w=3
X3818 B11 TOP sky130_fd_pr__cap_mim_m3_1 l=3 w=3
X3819 B10 TOP sky130_fd_pr__cap_mim_m3_1 l=3 w=3
X3820 B11 TOP sky130_fd_pr__cap_mim_m3_1 l=3 w=3
X3821 B10 TOP sky130_fd_pr__cap_mim_m3_1 l=3 w=3
X3822 B11 TOP sky130_fd_pr__cap_mim_m3_1 l=3 w=3
X3823 B11 TOP sky130_fd_pr__cap_mim_m3_1 l=3 w=3
X3824 B7 TOP sky130_fd_pr__cap_mim_m3_1 l=3 w=3
X3825 B7 TOP sky130_fd_pr__cap_mim_m3_1 l=3 w=3
X3826 B7 TOP sky130_fd_pr__cap_mim_m3_1 l=3 w=3
X3827 B9 TOP sky130_fd_pr__cap_mim_m3_1 l=3 w=3
X3828 B10 TOP sky130_fd_pr__cap_mim_m3_1 l=3 w=3
X3829 B11 TOP sky130_fd_pr__cap_mim_m3_1 l=3 w=3
X3830 B10 TOP sky130_fd_pr__cap_mim_m3_1 l=3 w=3
X3831 B11 TOP sky130_fd_pr__cap_mim_m3_1 l=3 w=3
X3832 B11 TOP sky130_fd_pr__cap_mim_m3_1 l=3 w=3
X3833 B10 TOP sky130_fd_pr__cap_mim_m3_1 l=3 w=3
X3834 B9 TOP sky130_fd_pr__cap_mim_m3_1 l=3 w=3
X3835 EDGE_BIAS EDGE_BIAS sky130_fd_pr__cap_mim_m3_1 l=3 w=3
X3836 B10 TOP sky130_fd_pr__cap_mim_m3_1 l=3 w=3
X3837 B11 TOP sky130_fd_pr__cap_mim_m3_1 l=3 w=3
X3838 B11 TOP sky130_fd_pr__cap_mim_m3_1 l=3 w=3
X3839 B11 TOP sky130_fd_pr__cap_mim_m3_1 l=3 w=3
X3840 B11 TOP sky130_fd_pr__cap_mim_m3_1 l=3 w=3
X3841 B10 TOP sky130_fd_pr__cap_mim_m3_1 l=3 w=3
X3842 B11 TOP sky130_fd_pr__cap_mim_m3_1 l=3 w=3
X3843 B11 TOP sky130_fd_pr__cap_mim_m3_1 l=3 w=3
X3844 B6 TOP sky130_fd_pr__cap_mim_m3_1 l=3 w=3
X3845 B11 TOP sky130_fd_pr__cap_mim_m3_1 l=3 w=3
X3846 B10 TOP sky130_fd_pr__cap_mim_m3_1 l=3 w=3
X3847 B11 TOP sky130_fd_pr__cap_mim_m3_1 l=3 w=3
X3848 B7 TOP sky130_fd_pr__cap_mim_m3_1 l=3 w=3
X3849 EDGE_BIAS EDGE_BIAS sky130_fd_pr__cap_mim_m3_1 l=3 w=3
X3850 B9 TOP sky130_fd_pr__cap_mim_m3_1 l=3 w=3
X3851 B11 TOP sky130_fd_pr__cap_mim_m3_1 l=3 w=3
X3852 B11 TOP sky130_fd_pr__cap_mim_m3_1 l=3 w=3
X3853 B11 TOP sky130_fd_pr__cap_mim_m3_1 l=3 w=3
X3854 B11 TOP sky130_fd_pr__cap_mim_m3_1 l=3 w=3
X3855 B8 TOP sky130_fd_pr__cap_mim_m3_1 l=3 w=3
X3856 B11 TOP sky130_fd_pr__cap_mim_m3_1 l=3 w=3
X3857 B11 TOP sky130_fd_pr__cap_mim_m3_1 l=3 w=3
X3858 B10 TOP sky130_fd_pr__cap_mim_m3_1 l=3 w=3
X3859 B9 TOP sky130_fd_pr__cap_mim_m3_1 l=3 w=3
X3860 B10 TOP sky130_fd_pr__cap_mim_m3_1 l=3 w=3
X3861 B10 TOP sky130_fd_pr__cap_mim_m3_1 l=3 w=3
X3862 B11 TOP sky130_fd_pr__cap_mim_m3_1 l=3 w=3
X3863 B11 TOP sky130_fd_pr__cap_mim_m3_1 l=3 w=3
X3864 B10 TOP sky130_fd_pr__cap_mim_m3_1 l=3 w=3
X3865 B8 TOP sky130_fd_pr__cap_mim_m3_1 l=3 w=3
X3866 B11 TOP sky130_fd_pr__cap_mim_m3_1 l=3 w=3
X3867 B11 TOP sky130_fd_pr__cap_mim_m3_1 l=3 w=3
X3868 B9 TOP sky130_fd_pr__cap_mim_m3_1 l=3 w=3
X3869 B11 TOP sky130_fd_pr__cap_mim_m3_1 l=3 w=3
X3870 EDGE_BIAS EDGE_BIAS sky130_fd_pr__cap_mim_m3_1 l=3 w=3
X3871 B9 TOP sky130_fd_pr__cap_mim_m3_1 l=3 w=3
X3872 B9 TOP sky130_fd_pr__cap_mim_m3_1 l=3 w=3
X3873 B11 TOP sky130_fd_pr__cap_mim_m3_1 l=3 w=3
X3874 B11 TOP sky130_fd_pr__cap_mim_m3_1 l=3 w=3
X3875 B9 TOP sky130_fd_pr__cap_mim_m3_1 l=3 w=3
X3876 B11 TOP sky130_fd_pr__cap_mim_m3_1 l=3 w=3
X3877 B10 TOP sky130_fd_pr__cap_mim_m3_1 l=3 w=3
X3878 B6 TOP sky130_fd_pr__cap_mim_m3_1 l=3 w=3
X3879 B11 TOP sky130_fd_pr__cap_mim_m3_1 l=3 w=3
X3880 B9 TOP sky130_fd_pr__cap_mim_m3_1 l=3 w=3
X3881 B10 TOP sky130_fd_pr__cap_mim_m3_1 l=3 w=3
X3882 B10 TOP sky130_fd_pr__cap_mim_m3_1 l=3 w=3
X3883 B11 TOP sky130_fd_pr__cap_mim_m3_1 l=3 w=3
X3884 B11 TOP sky130_fd_pr__cap_mim_m3_1 l=3 w=3
X3885 B11 TOP sky130_fd_pr__cap_mim_m3_1 l=3 w=3
X3886 B11 TOP sky130_fd_pr__cap_mim_m3_1 l=3 w=3
X3887 B11 TOP sky130_fd_pr__cap_mim_m3_1 l=3 w=3
X3888 EDGE_BIAS EDGE_BIAS sky130_fd_pr__cap_mim_m3_1 l=3 w=3
X3889 B11 TOP sky130_fd_pr__cap_mim_m3_1 l=3 w=3
X3890 B11 TOP sky130_fd_pr__cap_mim_m3_1 l=3 w=3
X3891 B10 TOP sky130_fd_pr__cap_mim_m3_1 l=3 w=3
X3892 B10 TOP sky130_fd_pr__cap_mim_m3_1 l=3 w=3
X3893 B7 TOP sky130_fd_pr__cap_mim_m3_1 l=3 w=3
X3894 EDGE_BIAS EDGE_BIAS sky130_fd_pr__cap_mim_m3_1 l=3 w=3
X3895 B11 TOP sky130_fd_pr__cap_mim_m3_1 l=3 w=3
X3896 B11 TOP sky130_fd_pr__cap_mim_m3_1 l=3 w=3
X3897 B11 TOP sky130_fd_pr__cap_mim_m3_1 l=3 w=3
X3898 B7 TOP sky130_fd_pr__cap_mim_m3_1 l=3 w=3
X3899 B11 TOP sky130_fd_pr__cap_mim_m3_1 l=3 w=3
X3900 B9 TOP sky130_fd_pr__cap_mim_m3_1 l=3 w=3
X3901 B9 TOP sky130_fd_pr__cap_mim_m3_1 l=3 w=3
X3902 B10 TOP sky130_fd_pr__cap_mim_m3_1 l=3 w=3
X3903 B10 TOP sky130_fd_pr__cap_mim_m3_1 l=3 w=3
X3904 B8 TOP sky130_fd_pr__cap_mim_m3_1 l=3 w=3
X3905 B9 TOP sky130_fd_pr__cap_mim_m3_1 l=3 w=3
X3906 B11 TOP sky130_fd_pr__cap_mim_m3_1 l=3 w=3
X3907 B10 TOP sky130_fd_pr__cap_mim_m3_1 l=3 w=3
X3908 B11 TOP sky130_fd_pr__cap_mim_m3_1 l=3 w=3
X3909 B10 TOP sky130_fd_pr__cap_mim_m3_1 l=3 w=3
X3910 B10 TOP sky130_fd_pr__cap_mim_m3_1 l=3 w=3
X3911 B11 TOP sky130_fd_pr__cap_mim_m3_1 l=3 w=3
X3912 B11 TOP sky130_fd_pr__cap_mim_m3_1 l=3 w=3
X3913 B11 TOP sky130_fd_pr__cap_mim_m3_1 l=3 w=3
X3914 B10 TOP sky130_fd_pr__cap_mim_m3_1 l=3 w=3
X3915 B11 TOP sky130_fd_pr__cap_mim_m3_1 l=3 w=3
X3916 B10 TOP sky130_fd_pr__cap_mim_m3_1 l=3 w=3
X3917 EDGE_BIAS EDGE_BIAS sky130_fd_pr__cap_mim_m3_1 l=3 w=3
X3918 B10 TOP sky130_fd_pr__cap_mim_m3_1 l=3 w=3
X3919 B10 TOP sky130_fd_pr__cap_mim_m3_1 l=3 w=3
X3920 B11 TOP sky130_fd_pr__cap_mim_m3_1 l=3 w=3
X3921 B8 TOP sky130_fd_pr__cap_mim_m3_1 l=3 w=3
X3922 B11 TOP sky130_fd_pr__cap_mim_m3_1 l=3 w=3
X3923 B10 TOP sky130_fd_pr__cap_mim_m3_1 l=3 w=3
X3924 B9 TOP sky130_fd_pr__cap_mim_m3_1 l=3 w=3
X3925 B8 TOP sky130_fd_pr__cap_mim_m3_1 l=3 w=3
X3926 B11 TOP sky130_fd_pr__cap_mim_m3_1 l=3 w=3
X3927 B9 TOP sky130_fd_pr__cap_mim_m3_1 l=3 w=3
X3928 B8 TOP sky130_fd_pr__cap_mim_m3_1 l=3 w=3
X3929 B8 TOP sky130_fd_pr__cap_mim_m3_1 l=3 w=3
X3930 B11 TOP sky130_fd_pr__cap_mim_m3_1 l=3 w=3
X3931 B11 TOP sky130_fd_pr__cap_mim_m3_1 l=3 w=3
X3932 EDGE_BIAS EDGE_BIAS sky130_fd_pr__cap_mim_m3_1 l=3 w=3
X3933 B10 TOP sky130_fd_pr__cap_mim_m3_1 l=3 w=3
X3934 B11 TOP sky130_fd_pr__cap_mim_m3_1 l=3 w=3
X3935 B11 TOP sky130_fd_pr__cap_mim_m3_1 l=3 w=3
X3936 B9 TOP sky130_fd_pr__cap_mim_m3_1 l=3 w=3
X3937 B9 TOP sky130_fd_pr__cap_mim_m3_1 l=3 w=3
X3938 B10 TOP sky130_fd_pr__cap_mim_m3_1 l=3 w=3
X3939 B9 TOP sky130_fd_pr__cap_mim_m3_1 l=3 w=3
X3940 B11 TOP sky130_fd_pr__cap_mim_m3_1 l=3 w=3
X3941 B11 TOP sky130_fd_pr__cap_mim_m3_1 l=3 w=3
X3942 B9 TOP sky130_fd_pr__cap_mim_m3_1 l=3 w=3
X3943 B11 TOP sky130_fd_pr__cap_mim_m3_1 l=3 w=3
X3944 B11 TOP sky130_fd_pr__cap_mim_m3_1 l=3 w=3
X3945 B11 TOP sky130_fd_pr__cap_mim_m3_1 l=3 w=3
X3946 B10 TOP sky130_fd_pr__cap_mim_m3_1 l=3 w=3
X3947 B11 TOP sky130_fd_pr__cap_mim_m3_1 l=3 w=3
X3948 B11 TOP sky130_fd_pr__cap_mim_m3_1 l=3 w=3
X3949 B10 TOP sky130_fd_pr__cap_mim_m3_1 l=3 w=3
X3950 B8 TOP sky130_fd_pr__cap_mim_m3_1 l=3 w=3
X3951 B11 TOP sky130_fd_pr__cap_mim_m3_1 l=3 w=3
X3952 B11 TOP sky130_fd_pr__cap_mim_m3_1 l=3 w=3
X3953 B10 TOP sky130_fd_pr__cap_mim_m3_1 l=3 w=3
X3954 B10 TOP sky130_fd_pr__cap_mim_m3_1 l=3 w=3
X3955 B11 TOP sky130_fd_pr__cap_mim_m3_1 l=3 w=3
X3956 B11 TOP sky130_fd_pr__cap_mim_m3_1 l=3 w=3
X3957 B7 TOP sky130_fd_pr__cap_mim_m3_1 l=3 w=3
X3958 B7 TOP sky130_fd_pr__cap_mim_m3_1 l=3 w=3
X3959 B7 TOP sky130_fd_pr__cap_mim_m3_1 l=3 w=3
X3960 B9 TOP sky130_fd_pr__cap_mim_m3_1 l=3 w=3
X3961 B11 TOP sky130_fd_pr__cap_mim_m3_1 l=3 w=3
X3962 B10 TOP sky130_fd_pr__cap_mim_m3_1 l=3 w=3
X3963 B11 TOP sky130_fd_pr__cap_mim_m3_1 l=3 w=3
X3964 B10 TOP sky130_fd_pr__cap_mim_m3_1 l=3 w=3
X3965 EDGE_BIAS EDGE_BIAS sky130_fd_pr__cap_mim_m3_1 l=3 w=3
X3966 B9 TOP sky130_fd_pr__cap_mim_m3_1 l=3 w=3
X3967 B10 TOP sky130_fd_pr__cap_mim_m3_1 l=3 w=3
X3968 B11 TOP sky130_fd_pr__cap_mim_m3_1 l=3 w=3
X3969 B11 TOP sky130_fd_pr__cap_mim_m3_1 l=3 w=3
X3970 B10 TOP sky130_fd_pr__cap_mim_m3_1 l=3 w=3
X3971 B9 TOP sky130_fd_pr__cap_mim_m3_1 l=3 w=3
X3972 B8 TOP sky130_fd_pr__cap_mim_m3_1 l=3 w=3
X3973 B10 TOP sky130_fd_pr__cap_mim_m3_1 l=3 w=3
X3974 B11 TOP sky130_fd_pr__cap_mim_m3_1 l=3 w=3
X3975 B8 TOP sky130_fd_pr__cap_mim_m3_1 l=3 w=3
X3976 B10 TOP sky130_fd_pr__cap_mim_m3_1 l=3 w=3
X3977 B11 TOP sky130_fd_pr__cap_mim_m3_1 l=3 w=3
X3978 B11 TOP sky130_fd_pr__cap_mim_m3_1 l=3 w=3
X3979 B10 TOP sky130_fd_pr__cap_mim_m3_1 l=3 w=3
X3980 B6 TOP sky130_fd_pr__cap_mim_m3_1 l=3 w=3
X3981 B11 TOP sky130_fd_pr__cap_mim_m3_1 l=3 w=3
X3982 EDGE_BIAS EDGE_BIAS sky130_fd_pr__cap_mim_m3_1 l=3 w=3
X3983 B9 TOP sky130_fd_pr__cap_mim_m3_1 l=3 w=3
X3984 B11 TOP sky130_fd_pr__cap_mim_m3_1 l=3 w=3
X3985 B8 TOP sky130_fd_pr__cap_mim_m3_1 l=3 w=3
X3986 B11 TOP sky130_fd_pr__cap_mim_m3_1 l=3 w=3
X3987 B9 TOP sky130_fd_pr__cap_mim_m3_1 l=3 w=3
X3988 B11 TOP sky130_fd_pr__cap_mim_m3_1 l=3 w=3
X3989 B11 TOP sky130_fd_pr__cap_mim_m3_1 l=3 w=3
X3990 B11 TOP sky130_fd_pr__cap_mim_m3_1 l=3 w=3
X3991 B11 TOP sky130_fd_pr__cap_mim_m3_1 l=3 w=3
X3992 EDGE_BIAS EDGE_BIAS sky130_fd_pr__cap_mim_m3_1 l=3 w=3
X3993 B11 TOP sky130_fd_pr__cap_mim_m3_1 l=3 w=3
X3994 B10 TOP sky130_fd_pr__cap_mim_m3_1 l=3 w=3
X3995 B9 TOP sky130_fd_pr__cap_mim_m3_1 l=3 w=3
X3996 B10 TOP sky130_fd_pr__cap_mim_m3_1 l=3 w=3
X3997 B11 TOP sky130_fd_pr__cap_mim_m3_1 l=3 w=3
X3998 B11 TOP sky130_fd_pr__cap_mim_m3_1 l=3 w=3
X3999 B9 TOP sky130_fd_pr__cap_mim_m3_1 l=3 w=3
X4000 B9 TOP sky130_fd_pr__cap_mim_m3_1 l=3 w=3
X4001 B11 TOP sky130_fd_pr__cap_mim_m3_1 l=3 w=3
X4002 B9 TOP sky130_fd_pr__cap_mim_m3_1 l=3 w=3
X4003 B9 TOP sky130_fd_pr__cap_mim_m3_1 l=3 w=3
X4004 B11 TOP sky130_fd_pr__cap_mim_m3_1 l=3 w=3
X4005 B10 TOP sky130_fd_pr__cap_mim_m3_1 l=3 w=3
X4006 B11 TOP sky130_fd_pr__cap_mim_m3_1 l=3 w=3
X4007 B9 TOP sky130_fd_pr__cap_mim_m3_1 l=3 w=3
X4008 B11 TOP sky130_fd_pr__cap_mim_m3_1 l=3 w=3
X4009 B8 TOP sky130_fd_pr__cap_mim_m3_1 l=3 w=3
X4010 B10 TOP sky130_fd_pr__cap_mim_m3_1 l=3 w=3
X4011 B11 TOP sky130_fd_pr__cap_mim_m3_1 l=3 w=3
X4012 B11 TOP sky130_fd_pr__cap_mim_m3_1 l=3 w=3
X4013 B11 TOP sky130_fd_pr__cap_mim_m3_1 l=3 w=3
X4014 B11 TOP sky130_fd_pr__cap_mim_m3_1 l=3 w=3
X4015 EDGE_BIAS EDGE_BIAS sky130_fd_pr__cap_mim_m3_1 l=3 w=3
X4016 EDGE_BIAS EDGE_BIAS sky130_fd_pr__cap_mim_m3_1 l=3 w=3
X4017 B11 TOP sky130_fd_pr__cap_mim_m3_1 l=3 w=3
X4018 B11 TOP sky130_fd_pr__cap_mim_m3_1 l=3 w=3
X4019 B11 TOP sky130_fd_pr__cap_mim_m3_1 l=3 w=3
X4020 B11 TOP sky130_fd_pr__cap_mim_m3_1 l=3 w=3
X4021 B11 TOP sky130_fd_pr__cap_mim_m3_1 l=3 w=3
X4022 B11 TOP sky130_fd_pr__cap_mim_m3_1 l=3 w=3
X4023 B10 TOP sky130_fd_pr__cap_mim_m3_1 l=3 w=3
X4024 B11 TOP sky130_fd_pr__cap_mim_m3_1 l=3 w=3
X4025 B11 TOP sky130_fd_pr__cap_mim_m3_1 l=3 w=3
X4026 B7 TOP sky130_fd_pr__cap_mim_m3_1 l=3 w=3
X4027 B11 TOP sky130_fd_pr__cap_mim_m3_1 l=3 w=3
X4028 B10 TOP sky130_fd_pr__cap_mim_m3_1 l=3 w=3
X4029 EDGE_BIAS EDGE_BIAS sky130_fd_pr__cap_mim_m3_1 l=3 w=3
X4030 EDGE_BIAS EDGE_BIAS sky130_fd_pr__cap_mim_m3_1 l=3 w=3
X4031 B10 TOP sky130_fd_pr__cap_mim_m3_1 l=3 w=3
X4032 B8 TOP sky130_fd_pr__cap_mim_m3_1 l=3 w=3
X4033 B8 TOP sky130_fd_pr__cap_mim_m3_1 l=3 w=3
X4034 B10 TOP sky130_fd_pr__cap_mim_m3_1 l=3 w=3
X4035 B9 TOP sky130_fd_pr__cap_mim_m3_1 l=3 w=3
X4036 B10 TOP sky130_fd_pr__cap_mim_m3_1 l=3 w=3
X4037 B11 TOP sky130_fd_pr__cap_mim_m3_1 l=3 w=3
X4038 B8 TOP sky130_fd_pr__cap_mim_m3_1 l=3 w=3
X4039 B11 TOP sky130_fd_pr__cap_mim_m3_1 l=3 w=3
X4040 B11 TOP sky130_fd_pr__cap_mim_m3_1 l=3 w=3
X4041 B11 TOP sky130_fd_pr__cap_mim_m3_1 l=3 w=3
X4042 B10 TOP sky130_fd_pr__cap_mim_m3_1 l=3 w=3
X4043 B11 TOP sky130_fd_pr__cap_mim_m3_1 l=3 w=3
X4044 B5 TOP sky130_fd_pr__cap_mim_m3_1 l=3 w=3
X4045 B4 TOP sky130_fd_pr__cap_mim_m3_1 l=3 w=3
X4046 B11 TOP sky130_fd_pr__cap_mim_m3_1 l=3 w=3
X4047 B10 TOP sky130_fd_pr__cap_mim_m3_1 l=3 w=3
X4048 EDGE_BIAS EDGE_BIAS sky130_fd_pr__cap_mim_m3_1 l=3 w=3
X4049 B11 TOP sky130_fd_pr__cap_mim_m3_1 l=3 w=3
X4050 B11 TOP sky130_fd_pr__cap_mim_m3_1 l=3 w=3
X4051 B11 TOP sky130_fd_pr__cap_mim_m3_1 l=3 w=3
X4052 B11 TOP sky130_fd_pr__cap_mim_m3_1 l=3 w=3
X4053 B10 TOP sky130_fd_pr__cap_mim_m3_1 l=3 w=3
X4054 B10 TOP sky130_fd_pr__cap_mim_m3_1 l=3 w=3
X4055 B8 TOP sky130_fd_pr__cap_mim_m3_1 l=3 w=3
X4056 B11 TOP sky130_fd_pr__cap_mim_m3_1 l=3 w=3
X4057 B9 TOP sky130_fd_pr__cap_mim_m3_1 l=3 w=3
X4058 B8 TOP sky130_fd_pr__cap_mim_m3_1 l=3 w=3
X4059 B11 TOP sky130_fd_pr__cap_mim_m3_1 l=3 w=3
X4060 B10 TOP sky130_fd_pr__cap_mim_m3_1 l=3 w=3
X4061 B11 TOP sky130_fd_pr__cap_mim_m3_1 l=3 w=3
X4062 EDGE_BIAS EDGE_BIAS sky130_fd_pr__cap_mim_m3_1 l=3 w=3
X4063 B11 TOP sky130_fd_pr__cap_mim_m3_1 l=3 w=3
X4064 B9 TOP sky130_fd_pr__cap_mim_m3_1 l=3 w=3
X4065 B11 TOP sky130_fd_pr__cap_mim_m3_1 l=3 w=3
X4066 B10 TOP sky130_fd_pr__cap_mim_m3_1 l=3 w=3
X4067 B10 TOP sky130_fd_pr__cap_mim_m3_1 l=3 w=3
X4068 B11 TOP sky130_fd_pr__cap_mim_m3_1 l=3 w=3
X4069 B9 TOP sky130_fd_pr__cap_mim_m3_1 l=3 w=3
X4070 B9 TOP sky130_fd_pr__cap_mim_m3_1 l=3 w=3
X4071 B11 TOP sky130_fd_pr__cap_mim_m3_1 l=3 w=3
X4072 B9 TOP sky130_fd_pr__cap_mim_m3_1 l=3 w=3
X4073 B11 TOP sky130_fd_pr__cap_mim_m3_1 l=3 w=3
X4074 EDGE_BIAS EDGE_BIAS sky130_fd_pr__cap_mim_m3_1 l=3 w=3
X4075 B10 TOP sky130_fd_pr__cap_mim_m3_1 l=3 w=3
X4076 B11 TOP sky130_fd_pr__cap_mim_m3_1 l=3 w=3
X4077 B9 TOP sky130_fd_pr__cap_mim_m3_1 l=3 w=3
X4078 B10 TOP sky130_fd_pr__cap_mim_m3_1 l=3 w=3
X4079 B11 TOP sky130_fd_pr__cap_mim_m3_1 l=3 w=3
X4080 B11 TOP sky130_fd_pr__cap_mim_m3_1 l=3 w=3
X4081 B6 TOP sky130_fd_pr__cap_mim_m3_1 l=3 w=3
X4082 B11 TOP sky130_fd_pr__cap_mim_m3_1 l=3 w=3
X4083 B10 TOP sky130_fd_pr__cap_mim_m3_1 l=3 w=3
X4084 B11 TOP sky130_fd_pr__cap_mim_m3_1 l=3 w=3
X4085 B11 TOP sky130_fd_pr__cap_mim_m3_1 l=3 w=3
X4086 B11 TOP sky130_fd_pr__cap_mim_m3_1 l=3 w=3
X4087 B10 TOP sky130_fd_pr__cap_mim_m3_1 l=3 w=3
X4088 B11 TOP sky130_fd_pr__cap_mim_m3_1 l=3 w=3
X4089 B10 TOP sky130_fd_pr__cap_mim_m3_1 l=3 w=3
X4090 B11 TOP sky130_fd_pr__cap_mim_m3_1 l=3 w=3
X4091 B10 TOP sky130_fd_pr__cap_mim_m3_1 l=3 w=3
X4092 B9 TOP sky130_fd_pr__cap_mim_m3_1 l=3 w=3
X4093 B7 TOP sky130_fd_pr__cap_mim_m3_1 l=3 w=3
X4094 B11 TOP sky130_fd_pr__cap_mim_m3_1 l=3 w=3
X4095 EDGE_BIAS EDGE_BIAS sky130_fd_pr__cap_mim_m3_1 l=3 w=3
X4096 B7 TOP sky130_fd_pr__cap_mim_m3_1 l=3 w=3
X4097 B11 TOP sky130_fd_pr__cap_mim_m3_1 l=3 w=3
X4098 B11 TOP sky130_fd_pr__cap_mim_m3_1 l=3 w=3
X4099 B10 TOP sky130_fd_pr__cap_mim_m3_1 l=3 w=3
X4100 B9 TOP sky130_fd_pr__cap_mim_m3_1 l=3 w=3
X4101 B11 TOP sky130_fd_pr__cap_mim_m3_1 l=3 w=3
X4102 B11 TOP sky130_fd_pr__cap_mim_m3_1 l=3 w=3
X4103 B10 TOP sky130_fd_pr__cap_mim_m3_1 l=3 w=3
X4104 B8 TOP sky130_fd_pr__cap_mim_m3_1 l=3 w=3
X4105 B10 TOP sky130_fd_pr__cap_mim_m3_1 l=3 w=3
X4106 B11 TOP sky130_fd_pr__cap_mim_m3_1 l=3 w=3
X4107 B10 TOP sky130_fd_pr__cap_mim_m3_1 l=3 w=3
X4108 B11 TOP sky130_fd_pr__cap_mim_m3_1 l=3 w=3
X4109 B11 TOP sky130_fd_pr__cap_mim_m3_1 l=3 w=3
X4110 B10 TOP sky130_fd_pr__cap_mim_m3_1 l=3 w=3
X4111 B11 TOP sky130_fd_pr__cap_mim_m3_1 l=3 w=3
X4112 B11 TOP sky130_fd_pr__cap_mim_m3_1 l=3 w=3
X4113 B6 TOP sky130_fd_pr__cap_mim_m3_1 l=3 w=3
X4114 B11 TOP sky130_fd_pr__cap_mim_m3_1 l=3 w=3
X4115 B10 TOP sky130_fd_pr__cap_mim_m3_1 l=3 w=3
X4116 B10 TOP sky130_fd_pr__cap_mim_m3_1 l=3 w=3
X4117 B10 TOP sky130_fd_pr__cap_mim_m3_1 l=3 w=3
X4118 B10 TOP sky130_fd_pr__cap_mim_m3_1 l=3 w=3
X4119 B10 TOP sky130_fd_pr__cap_mim_m3_1 l=3 w=3
X4120 B11 TOP sky130_fd_pr__cap_mim_m3_1 l=3 w=3
X4121 EDGE_BIAS EDGE_BIAS sky130_fd_pr__cap_mim_m3_1 l=3 w=3
X4122 B11 TOP sky130_fd_pr__cap_mim_m3_1 l=3 w=3
X4123 B11 TOP sky130_fd_pr__cap_mim_m3_1 l=3 w=3
X4124 B8 TOP sky130_fd_pr__cap_mim_m3_1 l=3 w=3
X4125 B8 TOP sky130_fd_pr__cap_mim_m3_1 l=3 w=3
X4126 B8 TOP sky130_fd_pr__cap_mim_m3_1 l=3 w=3
X4127 B11 TOP sky130_fd_pr__cap_mim_m3_1 l=3 w=3
X4128 B9 TOP sky130_fd_pr__cap_mim_m3_1 l=3 w=3
X4129 B10 TOP sky130_fd_pr__cap_mim_m3_1 l=3 w=3
X4130 EDGE_BIAS EDGE_BIAS sky130_fd_pr__cap_mim_m3_1 l=3 w=3
X4131 B11 TOP sky130_fd_pr__cap_mim_m3_1 l=3 w=3
X4132 B11 TOP sky130_fd_pr__cap_mim_m3_1 l=3 w=3
X4133 B11 TOP sky130_fd_pr__cap_mim_m3_1 l=3 w=3
X4134 B8 TOP sky130_fd_pr__cap_mim_m3_1 l=3 w=3
X4135 B11 TOP sky130_fd_pr__cap_mim_m3_1 l=3 w=3
X4136 B10 TOP sky130_fd_pr__cap_mim_m3_1 l=3 w=3
X4137 B10 TOP sky130_fd_pr__cap_mim_m3_1 l=3 w=3
X4138 B11 TOP sky130_fd_pr__cap_mim_m3_1 l=3 w=3
X4139 B9 TOP sky130_fd_pr__cap_mim_m3_1 l=3 w=3
X4140 B11 TOP sky130_fd_pr__cap_mim_m3_1 l=3 w=3
X4141 B7 TOP sky130_fd_pr__cap_mim_m3_1 l=3 w=3
X4142 B9 TOP sky130_fd_pr__cap_mim_m3_1 l=3 w=3
X4143 B11 TOP sky130_fd_pr__cap_mim_m3_1 l=3 w=3
X4144 B9 TOP sky130_fd_pr__cap_mim_m3_1 l=3 w=3
X4145 B11 TOP sky130_fd_pr__cap_mim_m3_1 l=3 w=3
X4146 B10 TOP sky130_fd_pr__cap_mim_m3_1 l=3 w=3
X4147 B11 TOP sky130_fd_pr__cap_mim_m3_1 l=3 w=3
X4148 B9 TOP sky130_fd_pr__cap_mim_m3_1 l=3 w=3
X4149 B11 TOP sky130_fd_pr__cap_mim_m3_1 l=3 w=3
X4150 B11 TOP sky130_fd_pr__cap_mim_m3_1 l=3 w=3
X4151 B11 TOP sky130_fd_pr__cap_mim_m3_1 l=3 w=3
X4152 B11 TOP sky130_fd_pr__cap_mim_m3_1 l=3 w=3
X4153 B10 TOP sky130_fd_pr__cap_mim_m3_1 l=3 w=3
X4154 B11 TOP sky130_fd_pr__cap_mim_m3_1 l=3 w=3
X4155 B10 TOP sky130_fd_pr__cap_mim_m3_1 l=3 w=3
X4156 B11 TOP sky130_fd_pr__cap_mim_m3_1 l=3 w=3
X4157 B7 TOP sky130_fd_pr__cap_mim_m3_1 l=3 w=3
X4158 EDGE_BIAS EDGE_BIAS sky130_fd_pr__cap_mim_m3_1 l=3 w=3
X4159 EDGE_BIAS EDGE_BIAS sky130_fd_pr__cap_mim_m3_1 l=3 w=3
X4160 B11 TOP sky130_fd_pr__cap_mim_m3_1 l=3 w=3
X4161 B10 TOP sky130_fd_pr__cap_mim_m3_1 l=3 w=3
X4162 B10 TOP sky130_fd_pr__cap_mim_m3_1 l=3 w=3
X4163 B10 TOP sky130_fd_pr__cap_mim_m3_1 l=3 w=3
X4164 B9 TOP sky130_fd_pr__cap_mim_m3_1 l=3 w=3
X4165 B11 TOP sky130_fd_pr__cap_mim_m3_1 l=3 w=3
X4166 B10 TOP sky130_fd_pr__cap_mim_m3_1 l=3 w=3
X4167 B8 TOP sky130_fd_pr__cap_mim_m3_1 l=3 w=3
X4168 B6 TOP sky130_fd_pr__cap_mim_m3_1 l=3 w=3
X4169 B10 TOP sky130_fd_pr__cap_mim_m3_1 l=3 w=3
X4170 B11 TOP sky130_fd_pr__cap_mim_m3_1 l=3 w=3
X4171 B10 TOP sky130_fd_pr__cap_mim_m3_1 l=3 w=3
X4172 B11 TOP sky130_fd_pr__cap_mim_m3_1 l=3 w=3
X4173 B10 TOP sky130_fd_pr__cap_mim_m3_1 l=3 w=3
X4174 B8 TOP sky130_fd_pr__cap_mim_m3_1 l=3 w=3
X4175 B11 TOP sky130_fd_pr__cap_mim_m3_1 l=3 w=3
X4176 B11 TOP sky130_fd_pr__cap_mim_m3_1 l=3 w=3
X4177 B6 TOP sky130_fd_pr__cap_mim_m3_1 l=3 w=3
X4178 B11 TOP sky130_fd_pr__cap_mim_m3_1 l=3 w=3
X4179 B11 TOP sky130_fd_pr__cap_mim_m3_1 l=3 w=3
X4180 B11 TOP sky130_fd_pr__cap_mim_m3_1 l=3 w=3
X4181 EDGE_BIAS EDGE_BIAS sky130_fd_pr__cap_mim_m3_1 l=3 w=3
X4182 B11 TOP sky130_fd_pr__cap_mim_m3_1 l=3 w=3
X4183 B8 TOP sky130_fd_pr__cap_mim_m3_1 l=3 w=3
X4184 EDGE_BIAS EDGE_BIAS sky130_fd_pr__cap_mim_m3_1 l=3 w=3
X4185 B9 TOP sky130_fd_pr__cap_mim_m3_1 l=3 w=3
X4186 B11 TOP sky130_fd_pr__cap_mim_m3_1 l=3 w=3
X4187 B8 TOP sky130_fd_pr__cap_mim_m3_1 l=3 w=3
X4188 B11 TOP sky130_fd_pr__cap_mim_m3_1 l=3 w=3
X4189 B11 TOP sky130_fd_pr__cap_mim_m3_1 l=3 w=3
X4190 B11 TOP sky130_fd_pr__cap_mim_m3_1 l=3 w=3
X4191 B11 TOP sky130_fd_pr__cap_mim_m3_1 l=3 w=3
X4192 B11 TOP sky130_fd_pr__cap_mim_m3_1 l=3 w=3
X4193 B8 TOP sky130_fd_pr__cap_mim_m3_1 l=3 w=3
X4194 B11 TOP sky130_fd_pr__cap_mim_m3_1 l=3 w=3
X4195 B11 TOP sky130_fd_pr__cap_mim_m3_1 l=3 w=3
X4196 B10 TOP sky130_fd_pr__cap_mim_m3_1 l=3 w=3
X4197 B9 TOP sky130_fd_pr__cap_mim_m3_1 l=3 w=3
X4198 B9 TOP sky130_fd_pr__cap_mim_m3_1 l=3 w=3
X4199 B6 TOP sky130_fd_pr__cap_mim_m3_1 l=3 w=3
X4200 B10 TOP sky130_fd_pr__cap_mim_m3_1 l=3 w=3
X4201 B11 TOP sky130_fd_pr__cap_mim_m3_1 l=3 w=3
X4202 B7 TOP sky130_fd_pr__cap_mim_m3_1 l=3 w=3
X4203 B9 TOP sky130_fd_pr__cap_mim_m3_1 l=3 w=3
X4204 EDGE_BIAS EDGE_BIAS sky130_fd_pr__cap_mim_m3_1 l=3 w=3
X4205 B9 TOP sky130_fd_pr__cap_mim_m3_1 l=3 w=3
X4206 B10 TOP sky130_fd_pr__cap_mim_m3_1 l=3 w=3
X4207 B11 TOP sky130_fd_pr__cap_mim_m3_1 l=3 w=3
X4208 B10 TOP sky130_fd_pr__cap_mim_m3_1 l=3 w=3
X4209 B11 TOP sky130_fd_pr__cap_mim_m3_1 l=3 w=3
X4210 B11 TOP sky130_fd_pr__cap_mim_m3_1 l=3 w=3
X4211 B11 TOP sky130_fd_pr__cap_mim_m3_1 l=3 w=3
X4212 B9 TOP sky130_fd_pr__cap_mim_m3_1 l=3 w=3
X4213 B11 TOP sky130_fd_pr__cap_mim_m3_1 l=3 w=3
X4214 B11 TOP sky130_fd_pr__cap_mim_m3_1 l=3 w=3
X4215 B11 TOP sky130_fd_pr__cap_mim_m3_1 l=3 w=3
X4216 B11 TOP sky130_fd_pr__cap_mim_m3_1 l=3 w=3
X4217 B11 TOP sky130_fd_pr__cap_mim_m3_1 l=3 w=3
X4218 B10 TOP sky130_fd_pr__cap_mim_m3_1 l=3 w=3
X4219 EDGE_BIAS EDGE_BIAS sky130_fd_pr__cap_mim_m3_1 l=3 w=3
X4220 B7 TOP sky130_fd_pr__cap_mim_m3_1 l=3 w=3
X4221 B10 TOP sky130_fd_pr__cap_mim_m3_1 l=3 w=3
X4222 B9 TOP sky130_fd_pr__cap_mim_m3_1 l=3 w=3
X4223 B11 TOP sky130_fd_pr__cap_mim_m3_1 l=3 w=3
X4224 B10 TOP sky130_fd_pr__cap_mim_m3_1 l=3 w=3
X4225 B9 TOP sky130_fd_pr__cap_mim_m3_1 l=3 w=3
X4226 B10 TOP sky130_fd_pr__cap_mim_m3_1 l=3 w=3
X4227 B8 TOP sky130_fd_pr__cap_mim_m3_1 l=3 w=3
X4228 B8 TOP sky130_fd_pr__cap_mim_m3_1 l=3 w=3
X4229 B10 TOP sky130_fd_pr__cap_mim_m3_1 l=3 w=3
X4230 B11 TOP sky130_fd_pr__cap_mim_m3_1 l=3 w=3
X4231 B11 TOP sky130_fd_pr__cap_mim_m3_1 l=3 w=3
X4232 B11 TOP sky130_fd_pr__cap_mim_m3_1 l=3 w=3
X4233 B10 TOP sky130_fd_pr__cap_mim_m3_1 l=3 w=3
X4234 B9 TOP sky130_fd_pr__cap_mim_m3_1 l=3 w=3
X4235 B11 TOP sky130_fd_pr__cap_mim_m3_1 l=3 w=3
X4236 B8 TOP sky130_fd_pr__cap_mim_m3_1 l=3 w=3
X4237 B11 TOP sky130_fd_pr__cap_mim_m3_1 l=3 w=3
X4238 B11 TOP sky130_fd_pr__cap_mim_m3_1 l=3 w=3
X4239 B11 TOP sky130_fd_pr__cap_mim_m3_1 l=3 w=3
X4240 B5 TOP sky130_fd_pr__cap_mim_m3_1 l=3 w=3
X4241 B11 TOP sky130_fd_pr__cap_mim_m3_1 l=3 w=3
X4242 B11 TOP sky130_fd_pr__cap_mim_m3_1 l=3 w=3
X4243 B11 TOP sky130_fd_pr__cap_mim_m3_1 l=3 w=3
X4244 B11 TOP sky130_fd_pr__cap_mim_m3_1 l=3 w=3
X4245 B9 TOP sky130_fd_pr__cap_mim_m3_1 l=3 w=3
X4246 B11 TOP sky130_fd_pr__cap_mim_m3_1 l=3 w=3
X4247 EDGE_BIAS EDGE_BIAS sky130_fd_pr__cap_mim_m3_1 l=3 w=3
X4248 B10 TOP sky130_fd_pr__cap_mim_m3_1 l=3 w=3
X4249 B5 TOP sky130_fd_pr__cap_mim_m3_1 l=3 w=3
X4250 B11 TOP sky130_fd_pr__cap_mim_m3_1 l=3 w=3
X4251 B8 TOP sky130_fd_pr__cap_mim_m3_1 l=3 w=3
X4252 B11 TOP sky130_fd_pr__cap_mim_m3_1 l=3 w=3
X4253 B11 TOP sky130_fd_pr__cap_mim_m3_1 l=3 w=3
X4254 EDGE_BIAS EDGE_BIAS sky130_fd_pr__cap_mim_m3_1 l=3 w=3
X4255 EDGE_BIAS EDGE_BIAS sky130_fd_pr__cap_mim_m3_1 l=3 w=3
X4256 B11 TOP sky130_fd_pr__cap_mim_m3_1 l=3 w=3
X4257 B11 TOP sky130_fd_pr__cap_mim_m3_1 l=3 w=3
X4258 B11 TOP sky130_fd_pr__cap_mim_m3_1 l=3 w=3
X4259 B8 TOP sky130_fd_pr__cap_mim_m3_1 l=3 w=3
X4260 B11 TOP sky130_fd_pr__cap_mim_m3_1 l=3 w=3
X4261 B11 TOP sky130_fd_pr__cap_mim_m3_1 l=3 w=3
X4262 B10 TOP sky130_fd_pr__cap_mim_m3_1 l=3 w=3
X4263 B11 TOP sky130_fd_pr__cap_mim_m3_1 l=3 w=3
X4264 B9 TOP sky130_fd_pr__cap_mim_m3_1 l=3 w=3
X4265 B11 TOP sky130_fd_pr__cap_mim_m3_1 l=3 w=3
X4266 B10 TOP sky130_fd_pr__cap_mim_m3_1 l=3 w=3
X4267 B11 TOP sky130_fd_pr__cap_mim_m3_1 l=3 w=3
X4268 B11 TOP sky130_fd_pr__cap_mim_m3_1 l=3 w=3
X4269 B9 TOP sky130_fd_pr__cap_mim_m3_1 l=3 w=3
X4270 B7 TOP sky130_fd_pr__cap_mim_m3_1 l=3 w=3
X4271 B11 TOP sky130_fd_pr__cap_mim_m3_1 l=3 w=3
X4272 B10 TOP sky130_fd_pr__cap_mim_m3_1 l=3 w=3
X4273 B9 TOP sky130_fd_pr__cap_mim_m3_1 l=3 w=3
X4274 B9 TOP sky130_fd_pr__cap_mim_m3_1 l=3 w=3
X4275 B10 TOP sky130_fd_pr__cap_mim_m3_1 l=3 w=3
X4276 B10 TOP sky130_fd_pr__cap_mim_m3_1 l=3 w=3
X4277 B10 TOP sky130_fd_pr__cap_mim_m3_1 l=3 w=3
X4278 B11 TOP sky130_fd_pr__cap_mim_m3_1 l=3 w=3
X4279 B11 TOP sky130_fd_pr__cap_mim_m3_1 l=3 w=3
X4280 B8 TOP sky130_fd_pr__cap_mim_m3_1 l=3 w=3
X4281 B10 TOP sky130_fd_pr__cap_mim_m3_1 l=3 w=3
X4282 B11 TOP sky130_fd_pr__cap_mim_m3_1 l=3 w=3
X4283 B10 TOP sky130_fd_pr__cap_mim_m3_1 l=3 w=3
X4284 B11 TOP sky130_fd_pr__cap_mim_m3_1 l=3 w=3
X4285 B11 TOP sky130_fd_pr__cap_mim_m3_1 l=3 w=3
X4286 EDGE_BIAS EDGE_BIAS sky130_fd_pr__cap_mim_m3_1 l=3 w=3
X4287 B11 TOP sky130_fd_pr__cap_mim_m3_1 l=3 w=3
X4288 B11 TOP sky130_fd_pr__cap_mim_m3_1 l=3 w=3
X4289 B11 TOP sky130_fd_pr__cap_mim_m3_1 l=3 w=3
X4290 B11 TOP sky130_fd_pr__cap_mim_m3_1 l=3 w=3
X4291 B10 TOP sky130_fd_pr__cap_mim_m3_1 l=3 w=3
X4292 B10 TOP sky130_fd_pr__cap_mim_m3_1 l=3 w=3
X4293 B9 TOP sky130_fd_pr__cap_mim_m3_1 l=3 w=3
X4294 B11 TOP sky130_fd_pr__cap_mim_m3_1 l=3 w=3
X4295 B10 TOP sky130_fd_pr__cap_mim_m3_1 l=3 w=3
X4296 B8 TOP sky130_fd_pr__cap_mim_m3_1 l=3 w=3
X4297 B10 TOP sky130_fd_pr__cap_mim_m3_1 l=3 w=3
X4298 B10 TOP sky130_fd_pr__cap_mim_m3_1 l=3 w=3
X4299 B11 TOP sky130_fd_pr__cap_mim_m3_1 l=3 w=3
X4300 B10 TOP sky130_fd_pr__cap_mim_m3_1 l=3 w=3
X4301 B9 TOP sky130_fd_pr__cap_mim_m3_1 l=3 w=3
X4302 B8 TOP sky130_fd_pr__cap_mim_m3_1 l=3 w=3
X4303 B10 TOP sky130_fd_pr__cap_mim_m3_1 l=3 w=3
X4304 B6 TOP sky130_fd_pr__cap_mim_m3_1 l=3 w=3
X4305 B11 TOP sky130_fd_pr__cap_mim_m3_1 l=3 w=3
X4306 B10 TOP sky130_fd_pr__cap_mim_m3_1 l=3 w=3
X4307 B10 TOP sky130_fd_pr__cap_mim_m3_1 l=3 w=3
X4308 B11 TOP sky130_fd_pr__cap_mim_m3_1 l=3 w=3
X4309 B11 TOP sky130_fd_pr__cap_mim_m3_1 l=3 w=3
X4310 B11 TOP sky130_fd_pr__cap_mim_m3_1 l=3 w=3
X4311 B10 TOP sky130_fd_pr__cap_mim_m3_1 l=3 w=3
X4312 EDGE_BIAS EDGE_BIAS sky130_fd_pr__cap_mim_m3_1 l=3 w=3
X4313 B9 TOP sky130_fd_pr__cap_mim_m3_1 l=3 w=3
X4314 B11 TOP sky130_fd_pr__cap_mim_m3_1 l=3 w=3
X4315 B11 TOP sky130_fd_pr__cap_mim_m3_1 l=3 w=3
X4316 B8 TOP sky130_fd_pr__cap_mim_m3_1 l=3 w=3
X4317 B11 TOP sky130_fd_pr__cap_mim_m3_1 l=3 w=3
X4318 B11 TOP sky130_fd_pr__cap_mim_m3_1 l=3 w=3
X4319 B10 TOP sky130_fd_pr__cap_mim_m3_1 l=3 w=3
X4320 B9 TOP sky130_fd_pr__cap_mim_m3_1 l=3 w=3
X4321 B11 TOP sky130_fd_pr__cap_mim_m3_1 l=3 w=3
X4322 B11 TOP sky130_fd_pr__cap_mim_m3_1 l=3 w=3
X4323 B11 TOP sky130_fd_pr__cap_mim_m3_1 l=3 w=3
X4324 B10 TOP sky130_fd_pr__cap_mim_m3_1 l=3 w=3
X4325 B8 TOP sky130_fd_pr__cap_mim_m3_1 l=3 w=3
X4326 B9 TOP sky130_fd_pr__cap_mim_m3_1 l=3 w=3
X4327 B11 TOP sky130_fd_pr__cap_mim_m3_1 l=3 w=3
X4328 B10 TOP sky130_fd_pr__cap_mim_m3_1 l=3 w=3
X4329 B11 TOP sky130_fd_pr__cap_mim_m3_1 l=3 w=3
X4330 B11 TOP sky130_fd_pr__cap_mim_m3_1 l=3 w=3
X4331 B7 TOP sky130_fd_pr__cap_mim_m3_1 l=3 w=3
X4332 B7 TOP sky130_fd_pr__cap_mim_m3_1 l=3 w=3
X4333 B9 TOP sky130_fd_pr__cap_mim_m3_1 l=3 w=3
X4334 B11 TOP sky130_fd_pr__cap_mim_m3_1 l=3 w=3
X4335 B9 TOP sky130_fd_pr__cap_mim_m3_1 l=3 w=3
X4336 B11 TOP sky130_fd_pr__cap_mim_m3_1 l=3 w=3
X4337 B10 TOP sky130_fd_pr__cap_mim_m3_1 l=3 w=3
X4338 B8 TOP sky130_fd_pr__cap_mim_m3_1 l=3 w=3
X4339 B10 TOP sky130_fd_pr__cap_mim_m3_1 l=3 w=3
X4340 B11 TOP sky130_fd_pr__cap_mim_m3_1 l=3 w=3
X4341 B11 TOP sky130_fd_pr__cap_mim_m3_1 l=3 w=3
X4342 B11 TOP sky130_fd_pr__cap_mim_m3_1 l=3 w=3
X4343 B11 TOP sky130_fd_pr__cap_mim_m3_1 l=3 w=3
X4344 B11 TOP sky130_fd_pr__cap_mim_m3_1 l=3 w=3
X4345 EDGE_BIAS EDGE_BIAS sky130_fd_pr__cap_mim_m3_1 l=3 w=3
X4346 B10 TOP sky130_fd_pr__cap_mim_m3_1 l=3 w=3
X4347 B11 TOP sky130_fd_pr__cap_mim_m3_1 l=3 w=3
X4348 B11 TOP sky130_fd_pr__cap_mim_m3_1 l=3 w=3
X4349 B10 TOP sky130_fd_pr__cap_mim_m3_1 l=3 w=3
X4350 B7 TOP sky130_fd_pr__cap_mim_m3_1 l=3 w=3
X4351 B10 TOP sky130_fd_pr__cap_mim_m3_1 l=3 w=3
X4352 B10 TOP sky130_fd_pr__cap_mim_m3_1 l=3 w=3
X4353 B9 TOP sky130_fd_pr__cap_mim_m3_1 l=3 w=3
X4354 B9 TOP sky130_fd_pr__cap_mim_m3_1 l=3 w=3
X4355 B8 TOP sky130_fd_pr__cap_mim_m3_1 l=3 w=3
C0 TOP B2 18.8508f
C1 EDGE_BIAS B10 12.6376f
C2 B10 B11 53.8385f
C3 B8 B4 3.91035f
C4 B5 B9 7.38986f
C5 B3 B9 7.38986f
C6 B10 DUMMY 7.09567f
C7 B2 B9 7.3497f
C8 B8 B7 43.2062f
C9 B3 B5 0.0046f
C10 B4 TOP 34.3218f
C11 B5 B2 0.00179f
C12 B3 B2 6.86104f
C13 B7 TOP 0.16252p
C14 B4 B9 7.38986f
C15 B10 B0 7.09567f
C16 B7 B9 3.17486f
C17 B8 B6 1.85405f
C18 B8 B1 3.75071f
C19 EDGE_BIAS B8 3.44842f
C20 B8 B11 11.5652f
C21 B4 B5 2.17927f
C22 B4 B3 5.29905f
C23 B4 B2 0.0046f
C24 B8 DUMMY 1.93432f
C25 B7 B5 4.71688f
C26 B3 B7 2.75917f
C27 B7 B2 2.42699f
C28 TOP B6 81.359f
C29 TOP B1 16.2426f
C30 EDGE_BIAS TOP 28.0951f
C31 B11 TOP 2.59515p
C32 B6 B9 3.27116f
C33 B1 B9 7.07213f
C34 TOP DUMMY 7.8185f
C35 EDGE_BIAS B9 6.28886f
C36 B11 B9 11.7155f
C37 DUMMY B9 3.65477f
C38 B8 B0 1.93432f
C39 B4 B7 3.41174f
C40 B5 B6 5.7937f
C41 B5 B1 0
C42 B3 B6 2.46714f
C43 B3 B1 0.0046f
C44 B2 B6 1.79645f
C45 EDGE_BIAS B5 1.69285f
C46 B2 B1 11.1363f
C47 EDGE_BIAS B3 1.69285f
C48 B11 B5 28.2925f
C49 B3 B11 28.2925f
C50 EDGE_BIAS B2 1.67822f
C51 B11 B2 28.1366f
C52 DUMMY B5 0.27615f
C53 B3 DUMMY 0.21387f
C54 DUMMY B2 0.21387f
C55 B10 B8 5.94575f
C56 TOP B0 8.17169f
C57 B0 B9 3.65477f
C58 B4 B6 4.18835f
C59 B4 B1 0.00179f
C60 EDGE_BIAS B4 1.69285f
C61 B4 B11 28.2925f
C62 B7 B6 37.2462f
C63 B7 B1 2.18304f
C64 B10 TOP 1.29996p
C65 EDGE_BIAS B7 2.99253f
C66 B4 DUMMY 0.21387f
C67 B7 B11 11.5176f
C68 B5 B0 1.0588f
C69 B3 B0 0.21387f
C70 B2 B0 0.21387f
C71 B10 B9 47.647f
C72 B7 DUMMY 1.12173f
C73 B10 B5 14.3489f
C74 B10 B3 14.3489f
C75 B10 B2 14.2701f
C76 B1 B6 1.44444f
C77 EDGE_BIAS B6 18.5527f
C78 B4 B0 0.21387f
C79 EDGE_BIAS B1 1.68024f
C80 B11 B6 12.0706f
C81 B11 B1 27.0414f
C82 EDGE_BIAS B11 39.809f
C83 B7 B0 1.14058f
C84 DUMMY B6 0.22787f
C85 DUMMY B1 0.29323f
C86 EDGE_BIAS DUMMY 0.82814f
C87 B8 TOP 0.32499p
C88 B11 DUMMY 13.9903f
C89 B10 B4 14.3489f
C90 B8 B9 44.716f
C91 B10 B7 5.91729f
C92 B0 B6 0.22787f
C93 B8 B5 3.91035f
C94 B1 B0 0.72147f
C95 B8 B3 3.91035f
C96 B8 B2 3.88949f
C97 EDGE_BIAS B0 0.8318f
C98 TOP B9 0.64998p
C99 B11 B0 13.9903f
C100 DUMMY B0 4.00118f
C101 B10 B6 6.12572f
C102 TOP B5 54.6765f
C103 B10 B1 13.715f
C104 B3 TOP 24.1465f
C105 TOP VSUBS 3.11487p
.ends
