* NGSPICE file created from cdac_diff_routed.ext - technology: sky130A

.subckt mim_unit C2 C1
X0 C1 C2 sky130_fd_pr__cap_mim_m3_1 l=3 w=3
.ends

.subckt cdac_side_n_routed TOP B11 B10 B9 B8 B7 B6 B5 B4 B3 B2 B1 B0 DUMMY EDGE_BIAS
XXN_r44_c34_B10 TOP B10 mim_unit
XXN_r41_c03_B10 TOP B10 mim_unit
XXN_r32_c35_B6 TOP B6 mim_unit
XXN_r11_c33_B11 TOP B11 mim_unit
XXN_r13_c01_B10 TOP B10 mim_unit
XXN_r14_c64_B11 TOP B11 mim_unit
XXN_r30_c30_B8 TOP B8 mim_unit
XXN_r00_c16_EDGE EDGE_BIAS EDGE_BIAS mim_unit
XXN_r26_c21_B9 TOP B9 mim_unit
XXN_r11_c24_B11 TOP B11 mim_unit
XXN_r14_c55_B11 TOP B11 mim_unit
XXN_r19_c54_B10 TOP B10 mim_unit
XXN_r47_c56_B10 TOP B10 mim_unit
XXN_r44_c25_B10 TOP B10 mim_unit
XXN_r19_c45_B10 TOP B10 mim_unit
XXN_r20_c63_B10 TOP B10 mim_unit
XXN_r47_c47_B10 TOP B10 mim_unit
XXN_r44_c16_B10 TOP B10 mim_unit
XXN_r37_c51_B9 TOP B9 mim_unit
XXN_r11_c15_B11 TOP B11 mim_unit
XXN_r14_c46_B11 TOP B11 mim_unit
XXN_r00_c39_EDGE EDGE_BIAS EDGE_BIAS mim_unit
XXN_r17_c01_B11 TOP B11 mim_unit
XXN_r28_c12_B9 TOP B9 mim_unit
XXN_r11_c06_B11 TOP B11 mim_unit
XXN_r14_c37_B11 TOP B11 mim_unit
XXN_r19_c36_B10 TOP B10 mim_unit
XXN_r20_c54_B10 TOP B10 mim_unit
XXN_r47_c38_B10 TOP B10 mim_unit
XXN_r44_c07_B10 TOP B10 mim_unit
XXN_r30_c25_B8 TOP B8 mim_unit
XXN_r26_c16_B9 TOP B9 mim_unit
XXN_r39_c42_B9 TOP B9 mim_unit
XXN_r19_c27_B10 TOP B10 mim_unit
XXN_r20_c45_B10 TOP B10 mim_unit
XXN_r58_c60_B11 TOP B11 mim_unit
XXN_r47_c29_B10 TOP B10 mim_unit
XXN_r14_c28_B11 TOP B11 mim_unit
XXN_r65_c03_EDGE EDGE_BIAS EDGE_BIAS mim_unit
XXN_r37_c46_B9 TOP B9 mim_unit
XXN_r28_c00_EDGE EDGE_BIAS EDGE_BIAS mim_unit
XXN_r14_c19_B11 TOP B11 mim_unit
XXN_r19_c18_B10 TOP B10 mim_unit
XXN_r20_c36_B10 TOP B10 mim_unit
XXN_r58_c51_B11 TOP B11 mim_unit
XXN_r55_c20_B11 TOP B11 mim_unit
XXN_r38_c65_EDGE EDGE_BIAS EDGE_BIAS mim_unit
XXN_r28_c07_B9 TOP B9 mim_unit
XXN_r52_c56_B11 TOP B11 mim_unit
XXN_r23_c58_B10 TOP B10 mim_unit
XXN_r20_c27_B10 TOP B10 mim_unit
XXN_r58_c42_B11 TOP B11 mim_unit
XXN_r55_c11_B11 TOP B11 mim_unit
XXN_r36_c03_B8 TOP B8 mim_unit
XXN_r19_c09_B10 TOP B10 mim_unit
XXN_r65_c26_EDGE EDGE_BIAS EDGE_BIAS mim_unit
XXN_r52_c47_B11 TOP B11 mim_unit
XXN_r39_c37_B9 TOP B9 mim_unit
XXN_r23_c49_B10 TOP B10 mim_unit
XXN_r20_c18_B10 TOP B10 mim_unit
XXN_r58_c33_B11 TOP B11 mim_unit
XXN_r55_c02_B11 TOP B11 mim_unit
XXN_r34_c23_B7 TOP B7 mim_unit
XXN_r52_c38_B11 TOP B11 mim_unit
XXN_r58_c24_B11 TOP B11 mim_unit
XXN_r20_c09_B10 TOP B10 mim_unit
XXN_r65_c49_EDGE EDGE_BIAS EDGE_BIAS mim_unit
XXN_r32_c43_B6 TOP B6 mim_unit
XXN_r52_c29_B11 TOP B11 mim_unit
XXN_r06_c60_B11 TOP B11 mim_unit
XXN_r58_c15_B11 TOP B11 mim_unit
XXN_r34_c18_B7 TOP B7 mim_unit
XXN_r03_c20_B11 TOP B11 mim_unit
XXN_r06_c51_B11 TOP B11 mim_unit
XXN_r62_c55_B11 TOP B11 mim_unit
XXN_r58_c06_B11 TOP B11 mim_unit
XXN_r43_c00_EDGE EDGE_BIAS EDGE_BIAS mim_unit
XXN_r03_c11_B11 TOP B11 mim_unit
XXN_r06_c42_B11 TOP B11 mim_unit
XXN_r53_c65_EDGE EDGE_BIAS EDGE_BIAS mim_unit
XXN_r32_c38_B6 TOP B6 mim_unit
XXN_r28_c20_B9 TOP B9 mim_unit
XXN_r62_c46_B11 TOP B11 mim_unit
XXN_r30_c33_B8 TOP B8 mim_unit
XXN_r26_c24_B9 TOP B9 mim_unit
XXN_r03_c02_B11 TOP B11 mim_unit
XXN_r06_c33_B11 TOP B11 mim_unit
XXN_r09_c64_B11 TOP B11 mim_unit
XXN_r62_c37_B11 TOP B11 mim_unit
XXN_r39_c50_B9 TOP B9 mim_unit
XXN_r06_c24_B11 TOP B11 mim_unit
XXN_r09_c55_B11 TOP B11 mim_unit
XXN_r37_c54_B9 TOP B9 mim_unit
XXN_r62_c28_B11 TOP B11 mim_unit
XXN_r28_c15_B9 TOP B9 mim_unit
XXN_r06_c15_B11 TOP B11 mim_unit
XXN_r09_c46_B11 TOP B11 mim_unit
XXN_r10_c64_B11 TOP B11 mim_unit
XXN_r62_c19_B11 TOP B11 mim_unit
XXN_r30_c28_B8 TOP B8 mim_unit
XXN_r16_c50_B11 TOP B11 mim_unit
XXN_r46_c20_B10 TOP B10 mim_unit
XXN_r36_c11_B8 TOP B8 mim_unit
XXN_r26_c19_B9 TOP B9 mim_unit
XXN_r39_c45_B9 TOP B9 mim_unit
XXN_r06_c06_B11 TOP B11 mim_unit
XXN_r09_c37_B11 TOP B11 mim_unit
XXN_r10_c55_B11 TOP B11 mim_unit
XXN_r43_c56_B10 TOP B10 mim_unit
XXN_r46_c11_B10 TOP B10 mim_unit
XXN_r13_c10_B11 TOP B11 mim_unit
XXN_r16_c41_B11 TOP B11 mim_unit
XXN_r37_c49_B9 TOP B9 mim_unit
XXN_r34_c31_B7 TOP B7 mim_unit
XXN_r43_c47_B10 TOP B10 mim_unit
XXN_r09_c28_B11 TOP B11 mim_unit
XXN_r10_c46_B11 TOP B11 mim_unit
XXN_r16_c32_B11 TOP B11 mim_unit
XXN_r62_c64_B8 TOP B8 mim_unit
XXN_r46_c02_B10 TOP B10 mim_unit
XXN_r32_c51_B6 TOP B6 mim_unit
XXN_r09_c19_B11 TOP B11 mim_unit
XXN_r10_c37_B11 TOP B11 mim_unit
XXN_r43_c38_B10 TOP B10 mim_unit
XXN_r36_c06_B8 TOP B8 mim_unit
XXN_r16_c23_B11 TOP B11 mim_unit
XXN_r22_c40_B10 TOP B10 mim_unit
XXN_r18_c58_B10 TOP B10 mim_unit
XXN_r54_c60_B11 TOP B11 mim_unit
XXN_r43_c29_B10 TOP B10 mim_unit
XXN_r10_c28_B11 TOP B11 mim_unit
XXN_r13_c59_B11 TOP B11 mim_unit
XXN_r34_c26_B7 TOP B7 mim_unit
XXN_r16_c14_B11 TOP B11 mim_unit
XXN_r22_c31_B10 TOP B10 mim_unit
XXN_r53_c64_B10 TOP B10 mim_unit
XXN_r10_c19_B11 TOP B11 mim_unit
XXN_r18_c49_B10 TOP B10 mim_unit
XXN_r54_c51_B11 TOP B11 mim_unit
XXN_r51_c20_B11 TOP B11 mim_unit
XXN_r40_c01_B9 TOP B9 mim_unit
XXN_r32_c46_B6 TOP B6 mim_unit
XXN_r16_c05_B11 TOP B11 mim_unit
XXN_r22_c22_B10 TOP B10 mim_unit
XXN_r54_c42_B11 TOP B11 mim_unit
XXN_r51_c11_B11 TOP B11 mim_unit
XXN_r30_c41_B8 TOP B8 mim_unit
XXN_r26_c32_B9 TOP B9 mim_unit
XXN_r22_c13_B10 TOP B10 mim_unit
XXN_r54_c33_B11 TOP B11 mim_unit
XXN_r51_c02_B11 TOP B11 mim_unit
XXN_r37_c62_B9 TOP B9 mim_unit
XXN_r00_c06_EDGE EDGE_BIAS EDGE_BIAS mim_unit
XXN_r22_c04_B10 TOP B10 mim_unit
XXN_r57_c55_B11 TOP B11 mim_unit
XXN_r54_c24_B11 TOP B11 mim_unit
XXN_r28_c23_B9 TOP B9 mim_unit
XXN_r07_c65_EDGE EDGE_BIAS EDGE_BIAS mim_unit
XXN_r30_c36_B8 TOP B8 mim_unit
XXN_r02_c60_B11 TOP B11 mim_unit
XXN_r26_c27_B9 TOP B9 mim_unit
XXN_r57_c46_B11 TOP B11 mim_unit
XXN_r54_c15_B11 TOP B11 mim_unit
XXN_r39_c53_B9 TOP B9 mim_unit
XXN_r64_c50_B11 TOP B11 mim_unit
XXN_r00_c29_EDGE EDGE_BIAS EDGE_BIAS mim_unit
XXN_r02_c51_B11 TOP B11 mim_unit
XXN_r57_c37_B11 TOP B11 mim_unit
XXN_r54_c06_B11 TOP B11 mim_unit
XXN_r37_c57_B9 TOP B9 mim_unit
XXN_r64_c41_B11 TOP B11 mim_unit
XXN_r61_c10_B11 TOP B11 mim_unit
XXN_r28_c18_B9 TOP B9 mim_unit
XXN_r02_c42_B11 TOP B11 mim_unit
XXN_r57_c28_B11 TOP B11 mim_unit
XXN_r64_c32_B11 TOP B11 mim_unit
XXN_r36_c14_B8 TOP B8 mim_unit
XXN_r05_c64_B11 TOP B11 mim_unit
XXN_r61_c01_B11 TOP B11 mim_unit
XXN_r02_c33_B11 TOP B11 mim_unit
XXN_r57_c19_B11 TOP B11 mim_unit
XXN_r39_c48_B9 TOP B9 mim_unit
XXN_r64_c23_B11 TOP B11 mim_unit
XXN_r34_c34_B7 TOP B7 mim_unit
XXN_r05_c55_B11 TOP B11 mim_unit
XXN_r02_c24_B11 TOP B11 mim_unit
XXN_r61_c59_B11 TOP B11 mim_unit
XXN_r45_c60_B10 TOP B10 mim_unit
XXN_r08_c10_B11 TOP B11 mim_unit
XXN_r64_c14_B11 TOP B11 mim_unit
XXN_r05_c46_B11 TOP B11 mim_unit
XXN_r12_c00_EDGE EDGE_BIAS EDGE_BIAS mim_unit
XXN_r65_c16_EDGE EDGE_BIAS EDGE_BIAS mim_unit
XXN_r32_c54_B6 TOP B6 mim_unit
XXN_r22_c65_EDGE EDGE_BIAS EDGE_BIAS mim_unit
XXN_r02_c15_B11 TOP B11 mim_unit
XXN_r12_c50_B11 TOP B11 mim_unit
XXN_r45_c51_B10 TOP B10 mim_unit
XXN_r42_c20_B10 TOP B10 mim_unit
XXN_r36_c09_B8 TOP B8 mim_unit
XXN_r26_c40_B9 TOP B9 mim_unit
XXN_r64_c05_B11 TOP B11 mim_unit
XXN_r05_c37_B11 TOP B11 mim_unit
XXN_r02_c06_B11 TOP B11 mim_unit
XXN_r17_c40_B10 TOP B10 mim_unit
XXN_r45_c42_B10 TOP B10 mim_unit
XXN_r42_c11_B10 TOP B10 mim_unit
XXN_r34_c29_B7 TOP B7 mim_unit
XXN_r12_c41_B11 TOP B11 mim_unit
XXN_r65_c39_EDGE EDGE_BIAS EDGE_BIAS mim_unit
XXN_r08_c59_B11 TOP B11 mim_unit
XXN_r49_c60_B11 TOP B11 mim_unit
XXN_r05_c28_B11 TOP B11 mim_unit
XXN_r12_c32_B11 TOP B11 mim_unit
XXN_r15_c63_B11 TOP B11 mim_unit
XXN_r17_c31_B10 TOP B10 mim_unit
XXN_r45_c33_B10 TOP B10 mim_unit
XXN_r42_c02_B10 TOP B10 mim_unit
XXN_r40_c04_B9 TOP B9 mim_unit
XXN_r32_c49_B6 TOP B6 mim_unit
XXN_r28_c31_B9 TOP B9 mim_unit
XXN_r05_c19_B11 TOP B11 mim_unit
XXN_r49_c51_B11 TOP B11 mim_unit
XXN_r30_c44_B8 TOP B8 mim_unit
XXN_r17_c22_B10 TOP B10 mim_unit
XXN_r48_c55_B10 TOP B10 mim_unit
XXN_r45_c24_B10 TOP B10 mim_unit
XXN_r26_c35_B9 TOP B9 mim_unit
XXN_r12_c23_B11 TOP B11 mim_unit
XXN_r15_c54_B11 TOP B11 mim_unit
XXN_r39_c61_B9 TOP B9 mim_unit
XXN_r50_c60_B11 TOP B11 mim_unit
XXN_r49_c42_B11 TOP B11 mim_unit
XXN_r12_c14_B11 TOP B11 mim_unit
XXN_r15_c45_B11 TOP B11 mim_unit
XXN_r17_c13_B10 TOP B10 mim_unit
XXN_r21_c62_B10 TOP B10 mim_unit
XXN_r48_c46_B10 TOP B10 mim_unit
XXN_r45_c15_B10 TOP B10 mim_unit
XXN_r50_c51_B11 TOP B11 mim_unit
XXN_r49_c33_B11 TOP B11 mim_unit
XXN_r38_c02_B9 TOP B9 mim_unit
XXN_r28_c26_B9 TOP B9 mim_unit
XXN_r17_c04_B10 TOP B10 mim_unit
XXN_r21_c53_B10 TOP B10 mim_unit
XXN_r48_c37_B10 TOP B10 mim_unit
XXN_r45_c06_B10 TOP B10 mim_unit
XXN_r12_c05_B11 TOP B11 mim_unit
XXN_r15_c36_B11 TOP B11 mim_unit
XXN_r30_c39_B8 TOP B8 mim_unit
XXN_r50_c42_B11 TOP B11 mim_unit
XXN_r49_c24_B11 TOP B11 mim_unit
XXN_r36_c22_B8 TOP B8 mim_unit
XXN_r00_c62_EDGE EDGE_BIAS EDGE_BIAS mim_unit
XXN_r39_c56_B9 TOP B9 mim_unit
XXN_r15_c27_B11 TOP B11 mim_unit
XXN_r21_c44_B10 TOP B10 mim_unit
XXN_r48_c28_B10 TOP B10 mim_unit
XXN_r50_c33_B11 TOP B11 mim_unit
XXN_r49_c15_B11 TOP B11 mim_unit
XXN_r34_c42_B7 TOP B7 mim_unit
XXN_r21_c35_B10 TOP B10 mim_unit
XXN_r59_c50_B11 TOP B11 mim_unit
XXN_r48_c19_B10 TOP B10 mim_unit
XXN_r15_c18_B11 TOP B11 mim_unit
XXN_r53_c55_B11 TOP B11 mim_unit
XXN_r50_c24_B11 TOP B11 mim_unit
XXN_r49_c06_B11 TOP B11 mim_unit
XXN_r32_c62_B6 TOP B6 mim_unit
XXN_r24_c57_B10 TOP B10 mim_unit
XXN_r15_c09_B11 TOP B11 mim_unit
XXN_r21_c26_B10 TOP B10 mim_unit
XXN_r59_c41_B11 TOP B11 mim_unit
XXN_r56_c10_B11 TOP B11 mim_unit
XXN_r36_c17_B8 TOP B8 mim_unit
XXN_r53_c46_B11 TOP B11 mim_unit
XXN_r50_c15_B11 TOP B11 mim_unit
XXN_r24_c48_B10 TOP B10 mim_unit
XXN_r21_c17_B10 TOP B10 mim_unit
XXN_r60_c50_B11 TOP B11 mim_unit
XXN_r59_c32_B11 TOP B11 mim_unit
XXN_r56_c01_B11 TOP B11 mim_unit
XXN_r34_c37_B7 TOP B7 mim_unit
XXN_r53_c37_B11 TOP B11 mim_unit
XXN_r50_c06_B11 TOP B11 mim_unit
XXN_r37_c00_EDGE EDGE_BIAS EDGE_BIAS mim_unit
XXN_r24_c39_B10 TOP B10 mim_unit
XXN_r21_c08_B10 TOP B10 mim_unit
XXN_r60_c41_B11 TOP B11 mim_unit
XXN_r59_c23_B11 TOP B11 mim_unit
XXN_r47_c65_EDGE EDGE_BIAS EDGE_BIAS mim_unit
XXN_r40_c12_B9 TOP B9 mim_unit
XXN_r32_c57_B6 TOP B6 mim_unit
XXN_r56_c59_B11 TOP B11 mim_unit
XXN_r53_c28_B11 TOP B11 mim_unit
XXN_r63_c63_B11 TOP B11 mim_unit
XXN_r60_c32_B11 TOP B11 mim_unit
XXN_r59_c14_B11 TOP B11 mim_unit
XXN_r30_c52_B8 TOP B8 mim_unit
XXN_r01_c64_B11 TOP B11 mim_unit
XXN_r26_c43_B9 TOP B9 mim_unit
XXN_r53_c19_B11 TOP B11 mim_unit
XXN_r07_c50_B11 TOP B11 mim_unit
XXN_r63_c54_B11 TOP B11 mim_unit
XXN_r60_c23_B11 TOP B11 mim_unit
XXN_r59_c05_B11 TOP B11 mim_unit
XXN_r01_c55_B11 TOP B11 mim_unit
XXN_r41_c60_B10 TOP B10 mim_unit
XXN_r38_c10_B9 TOP B9 mim_unit
XXN_r04_c10_B11 TOP B11 mim_unit
XXN_r07_c41_B11 TOP B11 mim_unit
XXN_r63_c45_B11 TOP B11 mim_unit
XXN_r60_c14_B11 TOP B11 mim_unit
XXN_r28_c34_B9 TOP B9 mim_unit
XXN_r01_c46_B11 TOP B11 mim_unit
XXN_r40_c07_B9 TOP B9 mim_unit
XXN_r30_c47_B8 TOP B8 mim_unit
XXN_r07_c32_B11 TOP B11 mim_unit
XXN_r41_c51_B10 TOP B10 mim_unit
XXN_r36_c30_B8 TOP B8 mim_unit
XXN_r26_c38_B9 TOP B9 mim_unit
XXN_r63_c36_B11 TOP B11 mim_unit
XXN_r60_c05_B11 TOP B11 mim_unit
XXN_r01_c37_B11 TOP B11 mim_unit
XXN_r41_c42_B10 TOP B10 mim_unit
XXN_r07_c23_B11 TOP B11 mim_unit
XXN_r63_c27_B11 TOP B11 mim_unit
XXN_r34_c50_B7 TOP B7 mim_unit
XXN_r04_c59_B11 TOP B11 mim_unit
XXN_r01_c28_B11 TOP B11 mim_unit
XXN_r52_c00_EDGE EDGE_BIAS EDGE_BIAS mim_unit
XXN_r38_c05_B9 TOP B9 mim_unit
XXN_r28_c29_B9 TOP B9 mim_unit
XXN_r07_c14_B11 TOP B11 mim_unit
XXN_r11_c63_B11 TOP B11 mim_unit
XXN_r41_c33_B10 TOP B10 mim_unit
XXN_r62_c65_EDGE EDGE_BIAS EDGE_BIAS mim_unit
XXN_r63_c18_B11 TOP B11 mim_unit
XXN_r00_c19_EDGE EDGE_BIAS EDGE_BIAS mim_unit
XXN_r01_c19_B11 TOP B11 mim_unit
XXN_r36_c25_B8 TOP B8 mim_unit
XXN_r11_c54_B11 TOP B11 mim_unit
XXN_r44_c55_B10 TOP B10 mim_unit
XXN_r41_c24_B10 TOP B10 mim_unit
XXN_r07_c05_B11 TOP B11 mim_unit
XXN_r63_c09_B11 TOP B11 mim_unit
XXN_r39_c59_B9 TOP B9 mim_unit
XXN_r47_c10_B10 TOP B10 mim_unit
XXN_r34_c45_B7 TOP B7 mim_unit
XXN_r11_c45_B11 TOP B11 mim_unit
XXN_r44_c46_B10 TOP B10 mim_unit
XXN_r41_c15_B10 TOP B10 mim_unit
XXN_r48_c64_B11 TOP B11 mim_unit
XXN_r47_c01_B10 TOP B10 mim_unit
XXN_r44_c37_B10 TOP B10 mim_unit
XXN_r40_c20_B9 TOP B9 mim_unit
XXN_r41_c06_B10 TOP B10 mim_unit
XXN_r11_c36_B11 TOP B11 mim_unit
XXN_r33_c02_B6 TOP B6 mim_unit
XXN_r30_c60_B8 TOP B8 mim_unit
XXN_r26_c51_B9 TOP B9 mim_unit
XXN_r11_c27_B11 TOP B11 mim_unit
XXN_r14_c58_B11 TOP B11 mim_unit
XXN_r19_c57_B10 TOP B10 mim_unit
XXN_r47_c59_B10 TOP B10 mim_unit
XXN_r44_c28_B10 TOP B10 mim_unit
XXN_r23_c30_B10 TOP B10 mim_unit
XXN_r65_c06_EDGE EDGE_BIAS EDGE_BIAS mim_unit
XXN_r14_c49_B11 TOP B11 mim_unit
XXN_r19_c48_B10 TOP B10 mim_unit
XXN_r55_c50_B11 TOP B11 mim_unit
XXN_r44_c19_B10 TOP B10 mim_unit
XXN_r11_c18_B11 TOP B11 mim_unit
XXN_r23_c21_B10 TOP B10 mim_unit
XXN_r40_c15_B9 TOP B9 mim_unit
XXN_r28_c42_B9 TOP B9 mim_unit
XXN_r11_c09_B11 TOP B11 mim_unit
XXN_r19_c39_B10 TOP B10 mim_unit
XXN_r20_c57_B10 TOP B10 mim_unit
XXN_r55_c41_B11 TOP B11 mim_unit
XXN_r52_c10_B11 TOP B11 mim_unit
XXN_r30_c55_B8 TOP B8 mim_unit
XXN_r65_c29_EDGE EDGE_BIAS EDGE_BIAS mim_unit
XXN_r26_c46_B9 TOP B9 mim_unit
XXN_r23_c12_B10 TOP B10 mim_unit
XXN_r20_c48_B10 TOP B10 mim_unit
XXN_r58_c63_B11 TOP B11 mim_unit
XXN_r55_c32_B11 TOP B11 mim_unit
XXN_r52_c01_B11 TOP B11 mim_unit
XXN_r23_c03_B10 TOP B10 mim_unit
XXN_r20_c39_B10 TOP B10 mim_unit
XXN_r58_c54_B11 TOP B11 mim_unit
XXN_r55_c23_B11 TOP B11 mim_unit
XXN_r38_c13_B9 TOP B9 mim_unit
XXN_r28_c37_B9 TOP B9 mim_unit
XXN_r52_c59_B11 TOP B11 mim_unit
XXN_r58_c45_B11 TOP B11 mim_unit
XXN_r55_c14_B11 TOP B11 mim_unit
XXN_r36_c33_B8 TOP B8 mim_unit
XXN_r31_c03_B7 TOP B7 mim_unit
XXN_r03_c50_B11 TOP B11 mim_unit
XXN_r58_c36_B11 TOP B11 mim_unit
XXN_r55_c05_B11 TOP B11 mim_unit
XXN_r34_c53_B7 TOP B7 mim_unit
XXN_r03_c41_B11 TOP B11 mim_unit
XXN_r06_c00_EDGE EDGE_BIAS EDGE_BIAS mim_unit
XXN_r38_c08_B9 TOP B9 mim_unit
XXN_r00_c52_EDGE EDGE_BIAS EDGE_BIAS mim_unit
XXN_r58_c27_B11 TOP B11 mim_unit
XXN_r16_c65_EDGE EDGE_BIAS EDGE_BIAS mim_unit
XXN_r33_c10_B6 TOP B6 mim_unit
XXN_r03_c32_B11 TOP B11 mim_unit
XXN_r06_c63_B11 TOP B11 mim_unit
XXN_r36_c28_B8 TOP B8 mim_unit
XXN_r58_c18_B11 TOP B11 mim_unit
XXN_r03_c23_B11 TOP B11 mim_unit
XXN_r06_c54_B11 TOP B11 mim_unit
XXN_r34_c48_B7 TOP B7 mim_unit
XXN_r62_c58_B11 TOP B11 mim_unit
XXN_r58_c09_B11 TOP B11 mim_unit
XXN_r03_c14_B11 TOP B11 mim_unit
XXN_r06_c45_B11 TOP B11 mim_unit
XXN_r40_c23_B9 TOP B9 mim_unit
XXN_r28_c50_B9 TOP B9 mim_unit
XXN_r62_c49_B11 TOP B11 mim_unit
XXN_r46_c50_B10 TOP B10 mim_unit
XXN_r33_c05_B6 TOP B6 mim_unit
XXN_r30_c63_B8 TOP B8 mim_unit
XXN_r06_c36_B11 TOP B11 mim_unit
XXN_r26_c54_B9 TOP B9 mim_unit
XXN_r03_c05_B11 TOP B11 mim_unit
XXN_r13_c40_B11 TOP B11 mim_unit
XXN_r46_c41_B10 TOP B10 mim_unit
XXN_r43_c10_B10 TOP B10 mim_unit
XXN_r06_c27_B11 TOP B11 mim_unit
XXN_r09_c58_B11 TOP B11 mim_unit
XXN_r18_c30_B10 TOP B10 mim_unit
XXN_r46_c32_B10 TOP B10 mim_unit
XXN_r44_c64_B11 TOP B11 mim_unit
XXN_r43_c01_B10 TOP B10 mim_unit
XXN_r38_c21_B9 TOP B9 mim_unit
XXN_r13_c31_B11 TOP B11 mim_unit
XXN_r16_c62_B11 TOP B11 mim_unit
XXN_r28_c45_B9 TOP B9 mim_unit
XXN_r06_c18_B11 TOP B11 mim_unit
XXN_r09_c49_B11 TOP B11 mim_unit
XXN_r21_c00_EDGE EDGE_BIAS EDGE_BIAS mim_unit
XXN_r65_c62_EDGE EDGE_BIAS EDGE_BIAS mim_unit
XXN_r40_c18_B9 TOP B9 mim_unit
XXN_r31_c65_EDGE EDGE_BIAS EDGE_BIAS mim_unit
XXN_r30_c58_B8 TOP B8 mim_unit
XXN_r13_c22_B11 TOP B11 mim_unit
XXN_r16_c53_B11 TOP B11 mim_unit
XXN_r18_c21_B10 TOP B10 mim_unit
XXN_r46_c23_B10 TOP B10 mim_unit
XXN_r36_c41_B8 TOP B8 mim_unit
XXN_r26_c49_B9 TOP B9 mim_unit
XXN_r43_c59_B10 TOP B10 mim_unit
XXN_r06_c09_B11 TOP B11 mim_unit
XXN_r10_c58_B11 TOP B11 mim_unit
XXN_r31_c11_B7 TOP B7 mim_unit
XXN_r22_c61_B10 TOP B10 mim_unit
XXN_r18_c12_B10 TOP B10 mim_unit
XXN_r46_c14_B10 TOP B10 mim_unit
XXN_r13_c13_B11 TOP B11 mim_unit
XXN_r16_c44_B11 TOP B11 mim_unit
XXN_r34_c61_B7 TOP B7 mim_unit
XXN_r10_c49_B11 TOP B11 mim_unit
XXN_r51_c50_B11 TOP B11 mim_unit
XXN_r38_c16_B9 TOP B9 mim_unit
XXN_r22_c52_B10 TOP B10 mim_unit
XXN_r13_c04_B11 TOP B11 mim_unit
XXN_r16_c35_B11 TOP B11 mim_unit
XXN_r18_c03_B10 TOP B10 mim_unit
XXN_r46_c05_B10 TOP B10 mim_unit
XXN_r51_c41_B11 TOP B11 mim_unit
XXN_r36_c36_B8 TOP B8 mim_unit
XXN_r22_c43_B10 TOP B10 mim_unit
XXN_r16_c26_B11 TOP B11 mim_unit
XXN_r31_c06_B7 TOP B7 mim_unit
XXN_r54_c63_B11 TOP B11 mim_unit
XXN_r51_c32_B11 TOP B11 mim_unit
XXN_r34_c56_B7 TOP B7 mim_unit
XXN_r16_c17_B11 TOP B11 mim_unit
XXN_r22_c34_B10 TOP B10 mim_unit
XXN_r00_c09_EDGE EDGE_BIAS EDGE_BIAS mim_unit
XXN_r54_c54_B11 TOP B11 mim_unit
XXN_r51_c23_B11 TOP B11 mim_unit
XXN_r22_c25_B10 TOP B10 mim_unit
XXN_r40_c31_B9 TOP B9 mim_unit
XXN_r16_c08_B11 TOP B11 mim_unit
XXN_r33_c13_B6 TOP B6 mim_unit
XXN_r54_c45_B11 TOP B11 mim_unit
XXN_r51_c14_B11 TOP B11 mim_unit
XXN_r26_c62_B9 TOP B9 mim_unit
XXN_r22_c16_B10 TOP B10 mim_unit
XXN_r54_c36_B11 TOP B11 mim_unit
XXN_r51_c05_B11 TOP B11 mim_unit
XXN_r22_c07_B10 TOP B10 mim_unit
XXN_r61_c40_B11 TOP B11 mim_unit
XXN_r25_c03_B9 TOP B9 mim_unit
XXN_r57_c58_B11 TOP B11 mim_unit
XXN_r54_c27_B11 TOP B11 mim_unit
XXN_r40_c26_B9 TOP B9 mim_unit
XXN_r28_c53_B9 TOP B9 mim_unit
XXN_r64_c62_B11 TOP B11 mim_unit
XXN_r61_c31_B11 TOP B11 mim_unit
XXN_r33_c08_B6 TOP B6 mim_unit
XXN_r02_c63_B11 TOP B11 mim_unit
XXN_r57_c49_B11 TOP B11 mim_unit
XXN_r26_c57_B9 TOP B9 mim_unit
XXN_r54_c18_B11 TOP B11 mim_unit
XXN_r64_c53_B11 TOP B11 mim_unit
XXN_r61_c22_B11 TOP B11 mim_unit
XXN_r02_c54_B11 TOP B11 mim_unit
XXN_r54_c09_B11 TOP B11 mim_unit
XXN_r08_c40_B11 TOP B11 mim_unit
XXN_r46_c00_EDGE EDGE_BIAS EDGE_BIAS mim_unit
XXN_r64_c44_B11 TOP B11 mim_unit
XXN_r65_c19_EDGE EDGE_BIAS EDGE_BIAS mim_unit
XXN_r61_c13_B11 TOP B11 mim_unit
XXN_r56_c65_EDGE EDGE_BIAS EDGE_BIAS mim_unit
XXN_r38_c24_B9 TOP B9 mim_unit
XXN_r28_c48_B9 TOP B9 mim_unit
XXN_r02_c45_B11 TOP B11 mim_unit
XXN_r42_c50_B10 TOP B10 mim_unit
XXN_r39_c64_B11 TOP B11 mim_unit
XXN_r08_c31_B11 TOP B11 mim_unit
XXN_r64_c35_B11 TOP B11 mim_unit
XXN_r61_c04_B11 TOP B11 mim_unit
XXN_r36_c44_B8 TOP B8 mim_unit
XXN_r02_c36_B11 TOP B11 mim_unit
XXN_r31_c14_B7 TOP B7 mim_unit
XXN_r08_c22_B11 TOP B11 mim_unit
XXN_r42_c41_B10 TOP B10 mim_unit
XXN_r64_c26_B11 TOP B11 mim_unit
XXN_r05_c58_B11 TOP B11 mim_unit
XXN_r02_c27_B11 TOP B11 mim_unit
XXN_r12_c62_B11 TOP B11 mim_unit
XXN_r17_c61_B10 TOP B10 mim_unit
XXN_r45_c63_B10 TOP B10 mim_unit
XXN_r42_c32_B10 TOP B10 mim_unit
XXN_r40_c64_B11 TOP B11 mim_unit
XXN_r38_c19_B9 TOP B9 mim_unit
XXN_r08_c13_B11 TOP B11 mim_unit
XXN_r64_c17_B11 TOP B11 mim_unit
XXN_r05_c49_B11 TOP B11 mim_unit
XXN_r02_c18_B11 TOP B11 mim_unit
XXN_r06_c01_B9 TOP B9 mim_unit
XXN_r33_c21_B6 TOP B6 mim_unit
XXN_r08_c04_B11 TOP B11 mim_unit
XXN_r12_c53_B11 TOP B11 mim_unit
XXN_r17_c52_B10 TOP B10 mim_unit
XXN_r45_c54_B10 TOP B10 mim_unit
XXN_r42_c23_B10 TOP B10 mim_unit
XXN_r36_c39_B8 TOP B8 mim_unit
XXN_r64_c08_B11 TOP B11 mim_unit
XXN_r31_c09_B7 TOP B7 mim_unit
XXN_r02_c09_B11 TOP B11 mim_unit
XXN_r33_c62_B2 TOP B2 mim_unit
XXN_r00_c42_EDGE EDGE_BIAS EDGE_BIAS mim_unit
XXN_r12_c44_B11 TOP B11 mim_unit
XXN_r17_c43_B10 TOP B10 mim_unit
XXN_r45_c45_B10 TOP B10 mim_unit
XXN_r42_c14_B10 TOP B10 mim_unit
XXN_r34_c59_B7 TOP B7 mim_unit
XXN_r49_c63_B11 TOP B11 mim_unit
XXN_r25_c11_B9 TOP B9 mim_unit
XXN_r61_c00_EDGE EDGE_BIAS EDGE_BIAS mim_unit
XXN_r32_c03_B2 TOP B2 mim_unit
XXN_r12_c35_B11 TOP B11 mim_unit
XXN_r17_c34_B10 TOP B10 mim_unit
XXN_r45_c36_B10 TOP B10 mim_unit
XXN_r42_c05_B10 TOP B10 mim_unit
XXN_r40_c34_B9 TOP B9 mim_unit
XXN_r28_c61_B9 TOP B9 mim_unit
XXN_r49_c54_B11 TOP B11 mim_unit
XXN_r00_c65_EDGE EDGE_BIAS EDGE_BIAS mim_unit
XXN_r33_c16_B6 TOP B6 mim_unit
XXN_r12_c26_B11 TOP B11 mim_unit
XXN_r15_c57_B11 TOP B11 mim_unit
XXN_r17_c25_B10 TOP B10 mim_unit
XXN_r48_c58_B10 TOP B10 mim_unit
XXN_r45_c27_B10 TOP B10 mim_unit
XXN_r27_c02_B9 TOP B9 mim_unit
XXN_r50_c63_B11 TOP B11 mim_unit
XXN_r49_c45_B11 TOP B11 mim_unit
XXN_r48_c49_B10 TOP B10 mim_unit
XXN_r12_c17_B11 TOP B11 mim_unit
XXN_r15_c48_B11 TOP B11 mim_unit
XXN_r17_c16_B10 TOP B10 mim_unit
XXN_r45_c18_B10 TOP B10 mim_unit
XXN_r24_c20_B10 TOP B10 mim_unit
XXN_r25_c06_B9 TOP B9 mim_unit
XXN_r50_c54_B11 TOP B11 mim_unit
XXN_r49_c36_B11 TOP B11 mim_unit
XXN_r38_c32_B9 TOP B9 mim_unit
XXN_r28_c56_B9 TOP B9 mim_unit
XXN_r15_c39_B11 TOP B11 mim_unit
XXN_r17_c07_B10 TOP B10 mim_unit
XXN_r21_c56_B10 TOP B10 mim_unit
XXN_r56_c40_B11 TOP B11 mim_unit
XXN_r45_c09_B10 TOP B10 mim_unit
XXN_r40_c29_B9 TOP B9 mim_unit
XXN_r12_c08_B11 TOP B11 mim_unit
XXN_r24_c11_B10 TOP B10 mim_unit
XXN_r50_c45_B11 TOP B11 mim_unit
XXN_r49_c27_B11 TOP B11 mim_unit
XXN_r36_c52_B8 TOP B8 mim_unit
XXN_r21_c47_B10 TOP B10 mim_unit
XXN_r59_c62_B11 TOP B11 mim_unit
XXN_r56_c31_B11 TOP B11 mim_unit
XXN_r31_c22_B7 TOP B7 mim_unit
XXN_r24_c02_B10 TOP B10 mim_unit
XXN_r50_c36_B11 TOP B11 mim_unit
XXN_r49_c18_B11 TOP B11 mim_unit
XXN_r65_c52_EDGE EDGE_BIAS EDGE_BIAS mim_unit
XXN_r21_c38_B10 TOP B10 mim_unit
XXN_r59_c53_B11 TOP B11 mim_unit
XXN_r56_c22_B11 TOP B11 mim_unit
XXN_r38_c27_B9 TOP B9 mim_unit
XXN_r53_c58_B11 TOP B11 mim_unit
XXN_r50_c27_B11 TOP B11 mim_unit
XXN_r49_c09_B11 TOP B11 mim_unit
XXN_r21_c29_B10 TOP B10 mim_unit
XXN_r60_c62_B11 TOP B11 mim_unit
XXN_r59_c44_B11 TOP B11 mim_unit
XXN_r56_c13_B11 TOP B11 mim_unit
XXN_r36_c47_B8 TOP B8 mim_unit
XXN_r29_c04_B8 TOP B8 mim_unit
XXN_r53_c49_B11 TOP B11 mim_unit
XXN_r50_c18_B11 TOP B11 mim_unit
XXN_r31_c17_B7 TOP B7 mim_unit
XXN_r60_c53_B11 TOP B11 mim_unit
XXN_r59_c35_B11 TOP B11 mim_unit
XXN_r56_c04_B11 TOP B11 mim_unit
XXN_r50_c09_B11 TOP B11 mim_unit
XXN_r04_c40_B11 TOP B11 mim_unit
XXN_r60_c44_B11 TOP B11 mim_unit
XXN_r59_c26_B11 TOP B11 mim_unit
XXN_r40_c42_B9 TOP B9 mim_unit
XXN_r04_c31_B11 TOP B11 mim_unit
XXN_r07_c62_B11 TOP B11 mim_unit
XXN_r35_c64_B11 TOP B11 mim_unit
XXN_r33_c24_B6 TOP B6 mim_unit
XXN_r60_c35_B11 TOP B11 mim_unit
XXN_r59_c17_B11 TOP B11 mim_unit
XXN_r33_c40_B5 TOP B5 mim_unit
XXN_r27_c10_B9 TOP B9 mim_unit
XXN_r04_c22_B11 TOP B11 mim_unit
XXN_r07_c53_B11 TOP B11 mim_unit
XXN_r63_c57_B11 TOP B11 mim_unit
XXN_r60_c26_B11 TOP B11 mim_unit
XXN_r59_c08_B11 TOP B11 mim_unit
XXN_r01_c58_B11 TOP B11 mim_unit
XXN_r25_c14_B9 TOP B9 mim_unit
XXN_r04_c13_B11 TOP B11 mim_unit
XXN_r07_c44_B11 TOP B11 mim_unit
XXN_r15_c00_EDGE EDGE_BIAS EDGE_BIAS mim_unit
XXN_r41_c63_B10 TOP B10 mim_unit
XXN_r38_c40_B9 TOP B9 mim_unit
XXN_r63_c48_B11 TOP B11 mim_unit
XXN_r60_c17_B11 TOP B11 mim_unit
XXN_r40_c37_B9 TOP B9 mim_unit
XXN_r28_c64_B9 TOP B9 mim_unit
XXN_r25_c65_EDGE EDGE_BIAS EDGE_BIAS mim_unit
XXN_r01_c49_B11 TOP B11 mim_unit
XXN_r41_c54_B10 TOP B10 mim_unit
XXN_r33_c19_B6 TOP B6 mim_unit
XXN_r04_c04_B11 TOP B11 mim_unit
XXN_r07_c35_B11 TOP B11 mim_unit
XXN_r36_c60_B8 TOP B8 mim_unit
XXN_r33_c51_B4 TOP B4 mim_unit
XXN_r33_c35_B5 TOP B5 mim_unit
XXN_r63_c39_B11 TOP B11 mim_unit
XXN_r60_c08_B11 TOP B11 mim_unit
XXN_r47_c40_B10 TOP B10 mim_unit
XXN_r31_c30_B7 TOP B7 mim_unit
XXN_r27_c05_B9 TOP B9 mim_unit
XXN_r01_c01_B6 TOP B6 mim_unit
XXN_r07_c26_B11 TOP B11 mim_unit
XXN_r41_c45_B10 TOP B10 mim_unit
XXN_r35_c01_B8 TOP B8 mim_unit
XXN_r25_c09_B9 TOP B9 mim_unit
XXN_r14_c30_B11 TOP B11 mim_unit
XXN_r47_c31_B10 TOP B10 mim_unit
XXN_r38_c35_B9 TOP B9 mim_unit
XXN_r41_c36_B10 TOP B10 mim_unit
XXN_r28_c59_B9 TOP B9 mim_unit
XXN_r07_c17_B11 TOP B11 mim_unit
XXN_r32_c33_B0 TOP B0 mim_unit
XXN_r19_c20_B10 TOP B10 mim_unit
XXN_r47_c22_B10 TOP B10 mim_unit
XXN_r14_c21_B11 TOP B11 mim_unit
XXN_r36_c55_B8 TOP B8 mim_unit
XXN_r29_c12_B8 TOP B8 mim_unit
XXN_r07_c08_B11 TOP B11 mim_unit
XXN_r11_c57_B11 TOP B11 mim_unit
XXN_r44_c58_B10 TOP B10 mim_unit
XXN_r41_c27_B10 TOP B10 mim_unit
XXN_r31_c25_B7 TOP B7 mim_unit
XXN_r23_c60_B10 TOP B10 mim_unit
XXN_r14_c12_B11 TOP B11 mim_unit
XXN_r19_c11_B10 TOP B10 mim_unit
XXN_r65_c09_EDGE EDGE_BIAS EDGE_BIAS mim_unit
XXN_r47_c13_B10 TOP B10 mim_unit
XXN_r44_c49_B10 TOP B10 mim_unit
XXN_r41_c18_B10 TOP B10 mim_unit
XXN_r11_c48_B11 TOP B11 mim_unit
XXN_r23_c51_B10 TOP B10 mim_unit
XXN_r19_c02_B10 TOP B10 mim_unit
XXN_r20_c20_B10 TOP B10 mim_unit
XXN_r47_c04_B10 TOP B10 mim_unit
XXN_r14_c03_B11 TOP B11 mim_unit
XXN_r30_c00_EDGE EDGE_BIAS EDGE_BIAS mim_unit
XXN_r11_c39_B11 TOP B11 mim_unit
XXN_r52_c40_B11 TOP B11 mim_unit
XXN_r40_c65_EDGE EDGE_BIAS EDGE_BIAS mim_unit
XXN_r40_c50_B9 TOP B9 mim_unit
XXN_r41_c09_B10 TOP B10 mim_unit
XXN_r29_c07_B8 TOP B8 mim_unit
XXN_r23_c42_B10 TOP B10 mim_unit
XXN_r20_c11_B10 TOP B10 mim_unit
XXN_r55_c62_B11 TOP B11 mim_unit
XXN_r33_c57_B3 TOP B3 mim_unit
XXN_r52_c31_B11 TOP B11 mim_unit
XXN_r20_c02_B10 TOP B10 mim_unit
XXN_r23_c33_B10 TOP B10 mim_unit
XXN_r55_c53_B11 TOP B11 mim_unit
XXN_r52_c22_B11 TOP B11 mim_unit
XXN_r25_c22_B9 TOP B9 mim_unit
XXN_r23_c24_B10 TOP B10 mim_unit
XXN_r40_c45_B9 TOP B9 mim_unit
XXN_r00_c32_EDGE EDGE_BIAS EDGE_BIAS mim_unit
XXN_r55_c44_B11 TOP B11 mim_unit
XXN_r33_c27_B6 TOP B6 mim_unit
XXN_r52_c13_B11 TOP B11 mim_unit
XXN_r33_c43_B5 TOP B5 mim_unit
XXN_r23_c15_B10 TOP B10 mim_unit
XXN_r27_c13_B9 TOP B9 mim_unit
XXN_r55_c35_B11 TOP B11 mim_unit
XXN_r52_c04_B11 TOP B11 mim_unit
XXN_r23_c06_B10 TOP B10 mim_unit
XXN_r25_c17_B9 TOP B9 mim_unit
XXN_r00_c55_EDGE EDGE_BIAS EDGE_BIAS mim_unit
XXN_r58_c57_B11 TOP B11 mim_unit
XXN_r38_c43_B9 TOP B9 mim_unit
XXN_r55_c26_B11 TOP B11 mim_unit
XXN_r62_c30_B11 TOP B11 mim_unit
XXN_r03_c62_B11 TOP B11 mim_unit
XXN_r58_c48_B11 TOP B11 mim_unit
XXN_r55_c17_B11 TOP B11 mim_unit
XXN_r36_c63_B8 TOP B8 mim_unit
XXN_r33_c38_B5 TOP B5 mim_unit
XXN_r29_c20_B8 TOP B8 mim_unit
XXN_r33_c54_B4 TOP B4 mim_unit
XXN_r27_c08_B9 TOP B9 mim_unit
XXN_r62_c21_B11 TOP B11 mim_unit
XXN_r31_c33_B7 TOP B7 mim_unit
XXN_r03_c53_B11 TOP B11 mim_unit
XXN_r58_c39_B11 TOP B11 mim_unit
XXN_r55_c08_B11 TOP B11 mim_unit
XXN_r35_c04_B8 TOP B8 mim_unit
XXN_r62_c12_B11 TOP B11 mim_unit
XXN_r03_c44_B11 TOP B11 mim_unit
XXN_r38_c38_B9 TOP B9 mim_unit
XXN_r09_c30_B11 TOP B11 mim_unit
XXN_r62_c03_B11 TOP B11 mim_unit
XXN_r36_c58_B8 TOP B8 mim_unit
XXN_r29_c15_B8 TOP B8 mim_unit
XXN_r03_c35_B11 TOP B11 mim_unit
XXN_r65_c42_EDGE EDGE_BIAS EDGE_BIAS mim_unit
XXN_r33_c49_B4 TOP B4 mim_unit
XXN_r09_c21_B11 TOP B11 mim_unit
XXN_r43_c40_B10 TOP B10 mim_unit
XXN_r31_c28_B7 TOP B7 mim_unit
XXN_r03_c26_B11 TOP B11 mim_unit
XXN_r06_c57_B11 TOP B11 mim_unit
XXN_r46_c62_B10 TOP B10 mim_unit
XXN_r25_c30_B9 TOP B9 mim_unit
XXN_r09_c12_B11 TOP B11 mim_unit
XXN_r10_c30_B11 TOP B11 mim_unit
XXN_r13_c61_B11 TOP B11 mim_unit
XXN_r18_c60_B10 TOP B10 mim_unit
XXN_r55_c00_EDGE EDGE_BIAS EDGE_BIAS mim_unit
XXN_r43_c31_B10 TOP B10 mim_unit
XXN_r32_c06_B3 TOP B3 mim_unit
XXN_r65_c65_EDGE EDGE_BIAS EDGE_BIAS mim_unit
XXN_r03_c17_B11 TOP B11 mim_unit
XXN_r06_c48_B11 TOP B11 mim_unit
XXN_r40_c53_B9 TOP B9 mim_unit
XXN_r09_c03_B11 TOP B11 mim_unit
XXN_r10_c21_B11 TOP B11 mim_unit
XXN_r13_c52_B11 TOP B11 mim_unit
XXN_r18_c51_B10 TOP B10 mim_unit
XXN_r46_c53_B10 TOP B10 mim_unit
XXN_r43_c22_B10 TOP B10 mim_unit
XXN_r63_c64_B7 TOP B7 mim_unit
XXN_r03_c08_B11 TOP B11 mim_unit
XXN_r06_c39_B11 TOP B11 mim_unit
XXN_r46_c44_B10 TOP B10 mim_unit
XXN_r27_c21_B9 TOP B9 mim_unit
XXN_r10_c12_B11 TOP B11 mim_unit
XXN_r13_c43_B11 TOP B11 mim_unit
XXN_r18_c42_B10 TOP B10 mim_unit
XXN_r43_c13_B10 TOP B10 mim_unit
XXN_r25_c25_B9 TOP B9 mim_unit
XXN_r13_c34_B11 TOP B11 mim_unit
XXN_r18_c33_B10 TOP B10 mim_unit
XXN_r46_c35_B10 TOP B10 mim_unit
XXN_r43_c04_B10 TOP B10 mim_unit
XXN_r38_c51_B9 TOP B9 mim_unit
XXN_r10_c03_B11 TOP B11 mim_unit
XXN_r40_c48_B9 TOP B9 mim_unit
XXN_r13_c25_B11 TOP B11 mim_unit
XXN_r16_c56_B11 TOP B11 mim_unit
XXN_r18_c24_B10 TOP B10 mim_unit
XXN_r46_c26_B10 TOP B10 mim_unit
XXN_r33_c46_B5 TOP B5 mim_unit
XXN_r51_c62_B11 TOP B11 mim_unit
XXN_r31_c41_B7 TOP B7 mim_unit
XXN_r27_c16_B9 TOP B9 mim_unit
XXN_r22_c64_B10 TOP B10 mim_unit
XXN_r13_c16_B11 TOP B11 mim_unit
XXN_r16_c47_B11 TOP B11 mim_unit
XXN_r18_c15_B10 TOP B10 mim_unit
XXN_r46_c17_B10 TOP B10 mim_unit
XXN_r35_c12_B8 TOP B8 mim_unit
XXN_r51_c53_B11 TOP B11 mim_unit
XXN_r38_c46_B9 TOP B9 mim_unit
XXN_r22_c55_B10 TOP B10 mim_unit
XXN_r13_c07_B11 TOP B11 mim_unit
XXN_r16_c38_B11 TOP B11 mim_unit
XXN_r18_c06_B10 TOP B10 mim_unit
XXN_r46_c08_B10 TOP B10 mim_unit
XXN_r51_c44_B11 TOP B11 mim_unit
XXN_r29_c23_B8 TOP B8 mim_unit
XXN_r22_c46_B10 TOP B10 mim_unit
XXN_r16_c29_B11 TOP B11 mim_unit
XXN_r57_c30_B11 TOP B11 mim_unit
XXN_r31_c36_B7 TOP B7 mim_unit
XXN_r51_c35_B11 TOP B11 mim_unit
XXN_r22_c37_B10 TOP B10 mim_unit
XXN_r57_c21_B11 TOP B11 mim_unit
XXN_r35_c07_B8 TOP B8 mim_unit
XXN_r54_c57_B11 TOP B11 mim_unit
XXN_r51_c26_B11 TOP B11 mim_unit
XXN_r22_c28_B10 TOP B10 mim_unit
XXN_r61_c61_B11 TOP B11 mim_unit
XXN_r57_c12_B11 TOP B11 mim_unit
XXN_r40_c61_B9 TOP B9 mim_unit
XXN_r29_c18_B8 TOP B8 mim_unit
XXN_r54_c48_B11 TOP B11 mim_unit
XXN_r51_c17_B11 TOP B11 mim_unit
XXN_r61_c52_B11 TOP B11 mim_unit
XXN_r29_c01_B11 TOP B11 mim_unit
XXN_r22_c19_B10 TOP B10 mim_unit
XXN_r57_c03_B11 TOP B11 mim_unit
XXN_r54_c39_B11 TOP B11 mim_unit
XXN_r51_c08_B11 TOP B11 mim_unit
XXN_r09_c00_EDGE EDGE_BIAS EDGE_BIAS mim_unit
XXN_r61_c43_B11 TOP B11 mim_unit
XXN_r25_c33_B9 TOP B9 mim_unit
XXN_r19_c65_EDGE EDGE_BIAS EDGE_BIAS mim_unit
XXN_r40_c56_B9 TOP B9 mim_unit
XXN_r05_c30_B11 TOP B11 mim_unit
XXN_r08_c61_B11 TOP B11 mim_unit
XXN_r30_c01_B11 TOP B11 mim_unit
XXN_r61_c34_B11 TOP B11 mim_unit
XXN_r05_c21_B11 TOP B11 mim_unit
XXN_r08_c52_B11 TOP B11 mim_unit
XXN_r27_c24_B9 TOP B9 mim_unit
XXN_r64_c56_B11 TOP B11 mim_unit
XXN_r61_c25_B11 TOP B11 mim_unit
XXN_r02_c57_B11 TOP B11 mim_unit
XXN_r00_c22_EDGE EDGE_BIAS EDGE_BIAS mim_unit
XXN_r42_c62_B10 TOP B10 mim_unit
XXN_r35_c20_B8 TOP B8 mim_unit
XXN_r25_c28_B9 TOP B9 mim_unit
XXN_r05_c12_B11 TOP B11 mim_unit
XXN_r08_c43_B11 TOP B11 mim_unit
XXN_r64_c47_B11 TOP B11 mim_unit
XXN_r38_c54_B9 TOP B9 mim_unit
XXN_r32_c11_B4 TOP B4 mim_unit
XXN_r61_c16_B11 TOP B11 mim_unit
XXN_r02_c48_B11 TOP B11 mim_unit
XXN_r05_c03_B11 TOP B11 mim_unit
XXN_r08_c34_B11 TOP B11 mim_unit
XXN_r42_c53_B10 TOP B10 mim_unit
XXN_r29_c31_B8 TOP B8 mim_unit
XXN_r64_c38_B11 TOP B11 mim_unit
XXN_r61_c07_B11 TOP B11 mim_unit
XXN_r02_c39_B11 TOP B11 mim_unit
XXN_r27_c19_B9 TOP B9 mim_unit
XXN_r00_c45_EDGE EDGE_BIAS EDGE_BIAS mim_unit
XXN_r42_c44_B10 TOP B10 mim_unit
XXN_r31_c44_B7 TOP B7 mim_unit
XXN_r08_c25_B11 TOP B11 mim_unit
XXN_r57_c64_B9 TOP B9 mim_unit
XXN_r64_c29_B11 TOP B11 mim_unit
XXN_r48_c30_B10 TOP B10 mim_unit
XXN_r35_c15_B8 TOP B8 mim_unit
XXN_r08_c16_B11 TOP B11 mim_unit
XXN_r17_c64_B10 TOP B10 mim_unit
XXN_r42_c35_B10 TOP B10 mim_unit
XXN_r38_c49_B9 TOP B9 mim_unit
XXN_r24_c00_EDGE EDGE_BIAS EDGE_BIAS mim_unit
XXN_r34_c65_EDGE EDGE_BIAS EDGE_BIAS mim_unit
XXN_r15_c20_B11 TOP B11 mim_unit
XXN_r48_c21_B10 TOP B10 mim_unit
XXN_r17_c55_B10 TOP B10 mim_unit
XXN_r45_c57_B10 TOP B10 mim_unit
XXN_r42_c26_B10 TOP B10 mim_unit
XXN_r29_c26_B8 TOP B8 mim_unit
XXN_r08_c07_B11 TOP B11 mim_unit
XXN_r12_c56_B11 TOP B11 mim_unit
XXN_r48_c12_B10 TOP B10 mim_unit
XXN_r31_c39_B7 TOP B7 mim_unit
XXN_r15_c11_B11 TOP B11 mim_unit
XXN_r12_c47_B11 TOP B11 mim_unit
XXN_r17_c46_B10 TOP B10 mim_unit
XXN_r45_c48_B10 TOP B10 mim_unit
XXN_r42_c17_B10 TOP B10 mim_unit
XXN_r24_c50_B10 TOP B10 mim_unit
XXN_r25_c41_B9 TOP B9 mim_unit
XXN_r15_c02_B11 TOP B11 mim_unit
XXN_r48_c03_B10 TOP B10 mim_unit
XXN_r17_c37_B10 TOP B10 mim_unit
XXN_r65_c32_EDGE EDGE_BIAS EDGE_BIAS mim_unit
XXN_r45_c39_B10 TOP B10 mim_unit
XXN_r42_c08_B10 TOP B10 mim_unit
XXN_r12_c38_B11 TOP B11 mim_unit
XXN_r24_c41_B10 TOP B10 mim_unit
XXN_r21_c10_B10 TOP B10 mim_unit
XXN_r49_c57_B11 TOP B11 mim_unit
XXN_r12_c29_B11 TOP B11 mim_unit
XXN_r17_c28_B10 TOP B10 mim_unit
XXN_r56_c61_B11 TOP B11 mim_unit
XXN_r53_c30_B11 TOP B11 mim_unit
XXN_r27_c32_B9 TOP B9 mim_unit
XXN_r24_c32_B10 TOP B10 mim_unit
XXN_r65_c55_EDGE EDGE_BIAS EDGE_BIAS mim_unit
XXN_r49_c48_B11 TOP B11 mim_unit
XXN_r56_c52_B11 TOP B11 mim_unit
XXN_r53_c21_B11 TOP B11 mim_unit
XXN_r17_c19_B10 TOP B10 mim_unit
XXN_r25_c36_B9 TOP B9 mim_unit
XXN_r24_c23_B10 TOP B10 mim_unit
XXN_r50_c57_B11 TOP B11 mim_unit
XXN_r49_c39_B11 TOP B11 mim_unit
XXN_r38_c62_B9 TOP B9 mim_unit
XXN_r40_c59_B9 TOP B9 mim_unit
XXN_r21_c59_B10 TOP B10 mim_unit
XXN_r56_c43_B11 TOP B11 mim_unit
XXN_r53_c12_B11 TOP B11 mim_unit
XXN_r24_c14_B10 TOP B10 mim_unit
XXN_r50_c48_B11 TOP B11 mim_unit
XXN_r56_c34_B11 TOP B11 mim_unit
XXN_r37_c03_B9 TOP B9 mim_unit
XXN_r31_c52_B7 TOP B7 mim_unit
XXN_r27_c27_B9 TOP B9 mim_unit
XXN_r25_c01_B11 TOP B11 mim_unit
XXN_r53_c03_B11 TOP B11 mim_unit
XXN_r24_c05_B10 TOP B10 mim_unit
XXN_r50_c39_B11 TOP B11 mim_unit
XXN_r35_c23_B8 TOP B8 mim_unit
XXN_r59_c56_B11 TOP B11 mim_unit
XXN_r56_c25_B11 TOP B11 mim_unit
XXN_r38_c57_B9 TOP B9 mim_unit
XXN_r32_c14_B4 TOP B4 mim_unit
XXN_r01_c30_B11 TOP B11 mim_unit
XXN_r04_c61_B11 TOP B11 mim_unit
XXN_r59_c47_B11 TOP B11 mim_unit
XXN_r56_c16_B11 TOP B11 mim_unit
XXN_r29_c34_B8 TOP B8 mim_unit
XXN_r63_c20_B11 TOP B11 mim_unit
XXN_r04_c52_B11 TOP B11 mim_unit
XXN_r01_c21_B11 TOP B11 mim_unit
XXN_r31_c47_B7 TOP B7 mim_unit
XXN_r60_c56_B11 TOP B11 mim_unit
XXN_r59_c38_B11 TOP B11 mim_unit
XXN_r56_c07_B11 TOP B11 mim_unit
XXN_r49_c00_EDGE EDGE_BIAS EDGE_BIAS mim_unit
XXN_r63_c11_B11 TOP B11 mim_unit
XXN_r35_c18_B8 TOP B8 mim_unit
XXN_r32_c09_B4 TOP B4 mim_unit
XXN_r04_c43_B11 TOP B11 mim_unit
XXN_r01_c12_B11 TOP B11 mim_unit
XXN_r60_c47_B11 TOP B11 mim_unit
XXN_r59_c65_EDGE EDGE_BIAS EDGE_BIAS mim_unit
XXN_r59_c29_B11 TOP B11 mim_unit
XXN_r63_c02_B11 TOP B11 mim_unit
XXN_r04_c34_B11 TOP B11 mim_unit
XXN_r01_c03_B11 TOP B11 mim_unit
XXN_r29_c29_B8 TOP B8 mim_unit
XXN_r60_c38_B11 TOP B11 mim_unit
XXN_r27_c40_B9 TOP B9 mim_unit
XXN_r04_c25_B11 TOP B11 mim_unit
XXN_r07_c56_B11 TOP B11 mim_unit
XXN_r60_c29_B11 TOP B11 mim_unit
XXN_r14_c60_B11 TOP B11 mim_unit
XXN_r47_c61_B10 TOP B10 mim_unit
XXN_r44_c30_B10 TOP B10 mim_unit
XXN_r25_c44_B9 TOP B9 mim_unit
XXN_r04_c16_B11 TOP B11 mim_unit
XXN_r07_c47_B11 TOP B11 mim_unit
XXN_r47_c52_B10 TOP B10 mim_unit
XXN_r44_c21_B10 TOP B10 mim_unit
XXN_r11_c20_B11 TOP B11 mim_unit
XXN_r14_c51_B11 TOP B11 mim_unit
XXN_r19_c50_B10 TOP B10 mim_unit
XXN_r41_c57_B10 TOP B10 mim_unit
XXN_r04_c07_B11 TOP B11 mim_unit
XXN_r07_c38_B11 TOP B11 mim_unit
XXN_r37_c11_B9 TOP B9 mim_unit
XXN_r11_c11_B11 TOP B11 mim_unit
XXN_r14_c42_B11 TOP B11 mim_unit
XXN_r19_c41_B10 TOP B10 mim_unit
XXN_r47_c43_B10 TOP B10 mim_unit
XXN_r44_c12_B10 TOP B10 mim_unit
XXN_r31_c60_B7 TOP B7 mim_unit
XXN_r27_c35_B9 TOP B9 mim_unit
XXN_r07_c29_B11 TOP B11 mim_unit
XXN_r41_c48_B10 TOP B10 mim_unit
XXN_r47_c34_B10 TOP B10 mim_unit
XXN_r35_c31_B8 TOP B8 mim_unit
XXN_r25_c39_B9 TOP B9 mim_unit
XXN_r11_c02_B11 TOP B11 mim_unit
XXN_r14_c33_B11 TOP B11 mim_unit
XXN_r16_c01_B10 TOP B10 mim_unit
XXN_r19_c32_B10 TOP B10 mim_unit
XXN_r20_c50_B10 TOP B10 mim_unit
XXN_r64_c00_EDGE EDGE_BIAS EDGE_BIAS mim_unit
XXN_r44_c03_B10 TOP B10 mim_unit
XXN_r41_c39_B10 TOP B10 mim_unit
XXN_r39_c02_B9 TOP B9 mim_unit
XXN_r03_c65_EDGE EDGE_BIAS EDGE_BIAS mim_unit
XXN_r14_c24_B11 TOP B11 mim_unit
XXN_r19_c23_B10 TOP B10 mim_unit
XXN_r20_c41_B10 TOP B10 mim_unit
XXN_r47_c25_B10 TOP B10 mim_unit
XXN_r29_c42_B8 TOP B8 mim_unit
XXN_r00_c12_EDGE EDGE_BIAS EDGE_BIAS mim_unit
XXN_r52_c61_B11 TOP B11 mim_unit
XXN_r37_c06_B9 TOP B9 mim_unit
XXN_r23_c63_B10 TOP B10 mim_unit
XXN_r47_c16_B10 TOP B10 mim_unit
XXN_r31_c55_B7 TOP B7 mim_unit
XXN_r14_c15_B11 TOP B11 mim_unit
XXN_r19_c14_B10 TOP B10 mim_unit
XXN_r20_c32_B10 TOP B10 mim_unit
XXN_r52_c52_B11 TOP B11 mim_unit
XXN_r35_c26_B8 TOP B8 mim_unit
XXN_r23_c54_B10 TOP B10 mim_unit
XXN_r14_c06_B11 TOP B11 mim_unit
XXN_r19_c05_B10 TOP B10 mim_unit
XXN_r20_c23_B10 TOP B10 mim_unit
XXN_r47_c07_B10 TOP B10 mim_unit
XXN_r00_c35_EDGE EDGE_BIAS EDGE_BIAS mim_unit
XXN_r52_c43_B11 TOP B11 mim_unit
XXN_r29_c37_B8 TOP B8 mim_unit
XXN_r23_c45_B10 TOP B10 mim_unit
XXN_r20_c14_B10 TOP B10 mim_unit
XXN_r52_c34_B11 TOP B11 mim_unit
XXN_r21_c01_B11 TOP B11 mim_unit
XXN_r20_c05_B10 TOP B10 mim_unit
XXN_r23_c36_B10 TOP B10 mim_unit
XXN_r58_c20_B11 TOP B11 mim_unit
XXN_r00_c58_EDGE EDGE_BIAS EDGE_BIAS mim_unit
XXN_r25_c52_B9 TOP B9 mim_unit
XXN_r55_c56_B11 TOP B11 mim_unit
XXN_r52_c25_B11 TOP B11 mim_unit
XXN_r62_c60_B11 TOP B11 mim_unit
XXN_r23_c27_B10 TOP B10 mim_unit
XXN_r58_c11_B11 TOP B11 mim_unit
XXN_r55_c47_B11 TOP B11 mim_unit
XXN_r52_c16_B11 TOP B11 mim_unit
XXN_r23_c18_B10 TOP B10 mim_unit
XXN_r62_c51_B11 TOP B11 mim_unit
XXN_r58_c02_B11 TOP B11 mim_unit
XXN_r27_c43_B9 TOP B9 mim_unit
XXN_r65_c22_EDGE EDGE_BIAS EDGE_BIAS mim_unit
XXN_r55_c38_B11 TOP B11 mim_unit
XXN_r52_c07_B11 TOP B11 mim_unit
XXN_r62_c42_B11 TOP B11 mim_unit
XXN_r23_c09_B10 TOP B10 mim_unit
XXN_r25_c47_B9 TOP B9 mim_unit
XXN_r55_c29_B11 TOP B11 mim_unit
XXN_r09_c60_B11 TOP B11 mim_unit
XXN_r33_c32_DUMMY TOP DUMMY mim_unit
XXN_r62_c33_B11 TOP B11 mim_unit
XXN_r39_c10_B9 TOP B9 mim_unit
XXN_r65_c45_EDGE EDGE_BIAS EDGE_BIAS mim_unit
XXN_r29_c50_B8 TOP B8 mim_unit
XXN_r06_c20_B11 TOP B11 mim_unit
XXN_r09_c51_B11 TOP B11 mim_unit
XXN_r62_c24_B11 TOP B11 mim_unit
XXN_r37_c14_B9 TOP B9 mim_unit
XXN_r31_c63_B7 TOP B7 mim_unit
XXN_r27_c38_B9 TOP B9 mim_unit
XXN_r03_c56_B11 TOP B11 mim_unit
XXN_r06_c11_B11 TOP B11 mim_unit
XXN_r09_c42_B11 TOP B11 mim_unit
XXN_r10_c60_B11 TOP B11 mim_unit
XXN_r43_c61_B10 TOP B10 mim_unit
XXN_r35_c34_B8 TOP B8 mim_unit
XXN_r18_c00_EDGE EDGE_BIAS EDGE_BIAS mim_unit
XXN_r62_c15_B11 TOP B11 mim_unit
XXN_r03_c47_B11 TOP B11 mim_unit
XXN_r28_c65_EDGE EDGE_BIAS EDGE_BIAS mim_unit
XXN_r43_c52_B10 TOP B10 mim_unit
XXN_r39_c05_B9 TOP B9 mim_unit
XXN_r06_c02_B11 TOP B11 mim_unit
XXN_r09_c33_B11 TOP B11 mim_unit
XXN_r10_c51_B11 TOP B11 mim_unit
XXN_r62_c06_B11 TOP B11 mim_unit
XXN_r29_c45_B8 TOP B8 mim_unit
XXN_r03_c38_B11 TOP B11 mim_unit
XXN_r37_c09_B9 TOP B9 mim_unit
XXN_r09_c24_B11 TOP B11 mim_unit
XXN_r10_c42_B11 TOP B11 mim_unit
XXN_r43_c43_B10 TOP B10 mim_unit
XXN_r31_c58_B7 TOP B7 mim_unit
XXN_r03_c29_B11 TOP B11 mim_unit
XXN_r18_c63_B10 TOP B10 mim_unit
XXN_r43_c34_B10 TOP B10 mim_unit
XXN_r35_c29_B8 TOP B8 mim_unit
XXN_r25_c60_B9 TOP B9 mim_unit
XXN_r09_c15_B11 TOP B11 mim_unit
XXN_r10_c33_B11 TOP B11 mim_unit
XXN_r12_c01_B10 TOP B10 mim_unit
XXN_r13_c64_B11 TOP B11 mim_unit
XXN_r09_c06_B11 TOP B11 mim_unit
XXN_r10_c24_B11 TOP B11 mim_unit
XXN_r13_c55_B11 TOP B11 mim_unit
XXN_r18_c54_B10 TOP B10 mim_unit
XXN_r46_c56_B10 TOP B10 mim_unit
XXN_r43_c25_B10 TOP B10 mim_unit
XXN_r16_c10_B11 TOP B11 mim_unit
XXN_r18_c45_B10 TOP B10 mim_unit
XXN_r46_c47_B10 TOP B10 mim_unit
XXN_r43_c16_B10 TOP B10 mim_unit
XXN_r27_c51_B9 TOP B9 mim_unit
XXN_r10_c15_B11 TOP B11 mim_unit
XXN_r13_c46_B11 TOP B11 mim_unit
XXN_r32_c22_B5 TOP B5 mim_unit
XXN_r25_c55_B9 TOP B9 mim_unit
XXN_r10_c06_B11 TOP B11 mim_unit
XXN_r13_c37_B11 TOP B11 mim_unit
XXN_r18_c36_B10 TOP B10 mim_unit
XXN_r46_c38_B10 TOP B10 mim_unit
XXN_r43_c07_B10 TOP B10 mim_unit
XXN_r33_c00_EDGE EDGE_BIAS EDGE_BIAS mim_unit
XXN_r43_c65_EDGE EDGE_BIAS EDGE_BIAS mim_unit
XXN_r18_c27_B10 TOP B10 mim_unit
XXN_r57_c60_B11 TOP B11 mim_unit
XXN_r46_c29_B10 TOP B10 mim_unit
XXN_r13_c28_B11 TOP B11 mim_unit
XXN_r16_c59_B11 TOP B11 mim_unit
XXN_r37_c22_B9 TOP B9 mim_unit
XXN_r56_c64_B10 TOP B10 mim_unit
XXN_r27_c46_B9 TOP B9 mim_unit
XXN_r13_c19_B11 TOP B11 mim_unit
XXN_r18_c18_B10 TOP B10 mim_unit
XXN_r57_c51_B11 TOP B11 mim_unit
XXN_r54_c20_B11 TOP B11 mim_unit
XXN_r35_c42_B8 TOP B8 mim_unit
XXN_r32_c17_B5 TOP B5 mim_unit
XXN_r51_c56_B11 TOP B11 mim_unit
XXN_r22_c58_B10 TOP B10 mim_unit
XXN_r18_c09_B10 TOP B10 mim_unit
XXN_r57_c42_B11 TOP B11 mim_unit
XXN_r54_c11_B11 TOP B11 mim_unit
XXN_r39_c13_B9 TOP B9 mim_unit
XXN_r51_c47_B11 TOP B11 mim_unit
XXN_r29_c53_B8 TOP B8 mim_unit
XXN_r22_c49_B10 TOP B10 mim_unit
XXN_r57_c33_B11 TOP B11 mim_unit
XXN_r54_c02_B11 TOP B11 mim_unit
XXN_r37_c17_B9 TOP B9 mim_unit
XXN_r51_c38_B11 TOP B11 mim_unit
XXN_r57_c24_B11 TOP B11 mim_unit
XXN_r35_c37_B8 TOP B8 mim_unit
XXN_r51_c29_B11 TOP B11 mim_unit
XXN_r00_c02_EDGE EDGE_BIAS EDGE_BIAS mim_unit
XXN_r05_c60_B11 TOP B11 mim_unit
XXN_r39_c08_B9 TOP B9 mim_unit
XXN_r57_c15_B11 TOP B11 mim_unit
XXN_r29_c48_B8 TOP B8 mim_unit
XXN_r05_c51_B11 TOP B11 mim_unit
XXN_r02_c20_B11 TOP B11 mim_unit
XXN_r61_c55_B11 TOP B11 mim_unit
XXN_r57_c06_B11 TOP B11 mim_unit
XXN_r64_c10_B11 TOP B11 mim_unit
XXN_r05_c42_B11 TOP B11 mim_unit
XXN_r02_c11_B11 TOP B11 mim_unit
XXN_r00_c25_EDGE EDGE_BIAS EDGE_BIAS mim_unit
XXN_r32_c30_B5 TOP B5 mim_unit
XXN_r25_c63_B9 TOP B9 mim_unit
XXN_r61_c46_B11 TOP B11 mim_unit
XXN_r64_c01_B11 TOP B11 mim_unit
XXN_r05_c33_B11 TOP B11 mim_unit
XXN_r02_c02_B11 TOP B11 mim_unit
XXN_r08_c64_B11 TOP B11 mim_unit
XXN_r61_c37_B11 TOP B11 mim_unit
XXN_r00_c48_EDGE EDGE_BIAS EDGE_BIAS mim_unit
XXN_r37_c30_B9 TOP B9 mim_unit
XXN_r05_c24_B11 TOP B11 mim_unit
XXN_r08_c55_B11 TOP B11 mim_unit
XXN_r27_c54_B9 TOP B9 mim_unit
XXN_r64_c59_B11 TOP B11 mim_unit
XXN_r61_c28_B11 TOP B11 mim_unit
XXN_r48_c60_B10 TOP B10 mim_unit
XXN_r58_c00_EDGE EDGE_BIAS EDGE_BIAS mim_unit
XXN_r35_c50_B8 TOP B8 mim_unit
XXN_r32_c25_B5 TOP B5 mim_unit
XXN_r25_c58_B9 TOP B9 mim_unit
XXN_r05_c15_B11 TOP B11 mim_unit
XXN_r08_c46_B11 TOP B11 mim_unit
XXN_r61_c19_B11 TOP B11 mim_unit
XXN_r30_c04_B8 TOP B8 mim_unit
XXN_r15_c50_B11 TOP B11 mim_unit
XXN_r48_c51_B10 TOP B10 mim_unit
XXN_r45_c20_B10 TOP B10 mim_unit
XXN_r39_c21_B9 TOP B9 mim_unit
XXN_r05_c06_B11 TOP B11 mim_unit
XXN_r08_c37_B11 TOP B11 mim_unit
XXN_r65_c12_EDGE EDGE_BIAS EDGE_BIAS mim_unit
XXN_r42_c56_B10 TOP B10 mim_unit
XXN_r29_c61_B8 TOP B8 mim_unit
XXN_r48_c42_B10 TOP B10 mim_unit
XXN_r45_c11_B10 TOP B10 mim_unit
XXN_r12_c10_B11 TOP B11 mim_unit
XXN_r15_c41_B11 TOP B11 mim_unit
XXN_r37_c25_B9 TOP B9 mim_unit
XXN_r27_c49_B9 TOP B9 mim_unit
XXN_r42_c47_B10 TOP B10 mim_unit
XXN_r08_c28_B11 TOP B11 mim_unit
XXN_r15_c32_B11 TOP B11 mim_unit
XXN_r48_c33_B10 TOP B10 mim_unit
XXN_r45_c02_B10 TOP B10 mim_unit
XXN_r35_c45_B8 TOP B8 mim_unit
XXN_r65_c35_EDGE EDGE_BIAS EDGE_BIAS mim_unit
XXN_r08_c19_B11 TOP B11 mim_unit
XXN_r49_c20_B11 TOP B11 mim_unit
XXN_r42_c38_B10 TOP B10 mim_unit
XXN_r21_c40_B10 TOP B10 mim_unit
XXN_r48_c24_B10 TOP B10 mim_unit
XXN_r39_c16_B9 TOP B9 mim_unit
XXN_r15_c23_B11 TOP B11 mim_unit
XXN_r12_c59_B11 TOP B11 mim_unit
XXN_r17_c58_B10 TOP B10 mim_unit
XXN_r53_c60_B11 TOP B11 mim_unit
XXN_r49_c11_B11 TOP B11 mim_unit
XXN_r42_c29_B10 TOP B10 mim_unit
XXN_r29_c56_B8 TOP B8 mim_unit
XXN_r34_c02_B7 TOP B7 mim_unit
XXN_r24_c62_B10 TOP B10 mim_unit
XXN_r15_c14_B11 TOP B11 mim_unit
XXN_r21_c31_B10 TOP B10 mim_unit
XXN_r65_c58_EDGE EDGE_BIAS EDGE_BIAS mim_unit
XXN_r52_c64_B10 TOP B10 mim_unit
XXN_r48_c15_B10 TOP B10 mim_unit
XXN_r17_c49_B10 TOP B10 mim_unit
XXN_r53_c51_B11 TOP B11 mim_unit
XXN_r50_c20_B11 TOP B11 mim_unit
XXN_r49_c02_B11 TOP B11 mim_unit
XXN_r24_c53_B10 TOP B10 mim_unit
XXN_r48_c06_B10 TOP B10 mim_unit
XXN_r15_c05_B11 TOP B11 mim_unit
XXN_r21_c22_B10 TOP B10 mim_unit
XXN_r02_c00_EDGE EDGE_BIAS EDGE_BIAS mim_unit
XXN_r53_c42_B11 TOP B11 mim_unit
XXN_r50_c11_B11 TOP B11 mim_unit
XXN_r24_c44_B10 TOP B10 mim_unit
XXN_r12_c65_EDGE EDGE_BIAS EDGE_BIAS mim_unit
XXN_r21_c13_B10 TOP B10 mim_unit
XXN_r53_c33_B11 TOP B11 mim_unit
XXN_r50_c02_B11 TOP B11 mim_unit
XXN_r24_c35_B10 TOP B10 mim_unit
XXN_r27_c62_B9 TOP B9 mim_unit
XXN_r21_c04_B10 TOP B10 mim_unit
XXN_r56_c55_B11 TOP B11 mim_unit
XXN_r53_c24_B11 TOP B11 mim_unit
XXN_r30_c12_B8 TOP B8 mim_unit
XXN_r24_c26_B10 TOP B10 mim_unit
XXN_r59_c10_B11 TOP B11 mim_unit
XXN_r26_c03_B9 TOP B9 mim_unit
XXN_r01_c60_B11 TOP B11 mim_unit
XXN_r56_c46_B11 TOP B11 mim_unit
XXN_r53_c15_B11 TOP B11 mim_unit
XXN_r63_c50_B11 TOP B11 mim_unit
XXN_r59_c01_B11 TOP B11 mim_unit
XXN_r24_c17_B10 TOP B10 mim_unit
XXN_r01_c51_B11 TOP B11 mim_unit
XXN_r37_c33_B9 TOP B9 mim_unit
XXN_r56_c37_B11 TOP B11 mim_unit
XXN_r53_c06_B11 TOP B11 mim_unit
XXN_r27_c57_B9 TOP B9 mim_unit
XXN_r24_c08_B10 TOP B10 mim_unit
XXN_r63_c41_B11 TOP B11 mim_unit
XXN_r60_c10_B11 TOP B11 mim_unit
XXN_r01_c42_B11 TOP B11 mim_unit
XXN_r35_c53_B8 TOP B8 mim_unit
XXN_r32_c28_B5 TOP B5 mim_unit
XXN_r59_c59_B11 TOP B11 mim_unit
XXN_r56_c28_B11 TOP B11 mim_unit
XXN_r30_c07_B8 TOP B8 mim_unit
XXN_r63_c32_B11 TOP B11 mim_unit
XXN_r04_c64_B11 TOP B11 mim_unit
XXN_r60_c01_B11 TOP B11 mim_unit
XXN_r39_c24_B9 TOP B9 mim_unit
XXN_r01_c33_B11 TOP B11 mim_unit
XXN_r56_c19_B11 TOP B11 mim_unit
XXN_r29_c64_B8 TOP B8 mim_unit
XXN_r34_c10_B7 TOP B7 mim_unit
XXN_r63_c23_B11 TOP B11 mim_unit
XXN_r37_c28_B9 TOP B9 mim_unit
XXN_r04_c55_B11 TOP B11 mim_unit
XXN_r01_c24_B11 TOP B11 mim_unit
XXN_r60_c59_B11 TOP B11 mim_unit
XXN_r44_c60_B10 TOP B10 mim_unit
XXN_r07_c10_B11 TOP B11 mim_unit
XXN_r63_c14_B11 TOP B11 mim_unit
XXN_r35_c48_B8 TOP B8 mim_unit
XXN_r04_c46_B11 TOP B11 mim_unit
XXN_r01_c15_B11 TOP B11 mim_unit
XXN_r11_c50_B11 TOP B11 mim_unit
XXN_r44_c51_B10 TOP B10 mim_unit
XXN_r41_c20_B10 TOP B10 mim_unit
XXN_r39_c19_B9 TOP B9 mim_unit
XXN_r63_c05_B11 TOP B11 mim_unit
XXN_r04_c37_B11 TOP B11 mim_unit
XXN_r01_c06_B11 TOP B11 mim_unit
XXN_r29_c59_B8 TOP B8 mim_unit
XXN_r44_c42_B10 TOP B10 mim_unit
XXN_r41_c11_B10 TOP B10 mim_unit
XXN_r34_c05_B7 TOP B7 mim_unit
XXN_r07_c01_B9 TOP B9 mim_unit
XXN_r11_c41_B11 TOP B11 mim_unit
XXN_r04_c28_B11 TOP B11 mim_unit
XXN_r07_c59_B11 TOP B11 mim_unit
XXN_r11_c32_B11 TOP B11 mim_unit
XXN_r14_c63_B11 TOP B11 mim_unit
XXN_r19_c62_B10 TOP B10 mim_unit
XXN_r44_c33_B10 TOP B10 mim_unit
XXN_r41_c02_B10 TOP B10 mim_unit
XXN_r27_c00_EDGE EDGE_BIAS EDGE_BIAS mim_unit
XXN_r30_c20_B8 TOP B8 mim_unit
XXN_r04_c19_B11 TOP B11 mim_unit
XXN_r37_c65_EDGE EDGE_BIAS EDGE_BIAS mim_unit
XXN_r26_c11_B9 TOP B9 mim_unit
XXN_r19_c53_B10 TOP B10 mim_unit
XXN_r47_c55_B10 TOP B10 mim_unit
XXN_r44_c24_B10 TOP B10 mim_unit
XXN_r11_c23_B11 TOP B11 mim_unit
XXN_r14_c54_B11 TOP B11 mim_unit
XXN_r00_c15_EDGE EDGE_BIAS EDGE_BIAS mim_unit
XXN_r37_c41_B9 TOP B9 mim_unit
XXN_r11_c14_B11 TOP B11 mim_unit
XXN_r14_c45_B11 TOP B11 mim_unit
XXN_r19_c44_B10 TOP B10 mim_unit
XXN_r20_c62_B10 TOP B10 mim_unit
XXN_r47_c46_B10 TOP B10 mim_unit
XXN_r44_c15_B10 TOP B10 mim_unit
XXN_r28_c02_B9 TOP B9 mim_unit
XXN_r19_c35_B10 TOP B10 mim_unit
XXN_r20_c53_B10 TOP B10 mim_unit
XXN_r47_c37_B10 TOP B10 mim_unit
XXN_r44_c06_B10 TOP B10 mim_unit
XXN_r35_c61_B8 TOP B8 mim_unit
XXN_r11_c05_B11 TOP B11 mim_unit
XXN_r14_c36_B11 TOP B11 mim_unit
XXN_r30_c15_B8 TOP B8 mim_unit
XXN_r26_c06_B9 TOP B9 mim_unit
XXN_r00_c38_EDGE EDGE_BIAS EDGE_BIAS mim_unit
XXN_r39_c32_B9 TOP B9 mim_unit
XXN_r14_c27_B11 TOP B11 mim_unit
XXN_r19_c26_B10 TOP B10 mim_unit
XXN_r20_c44_B10 TOP B10 mim_unit
XXN_r47_c28_B10 TOP B10 mim_unit
XXN_r37_c36_B9 TOP B9 mim_unit
XXN_r19_c17_B10 TOP B10 mim_unit
XXN_r20_c35_B10 TOP B10 mim_unit
XXN_r58_c50_B11 TOP B11 mim_unit
XXN_r47_c19_B10 TOP B10 mim_unit
XXN_r14_c18_B11 TOP B11 mim_unit
XXN_r65_c02_EDGE EDGE_BIAS EDGE_BIAS mim_unit
XXN_r52_c55_B11 TOP B11 mim_unit
XXN_r35_c56_B8 TOP B8 mim_unit
XXN_r23_c57_B10 TOP B10 mim_unit
XXN_r14_c09_B11 TOP B11 mim_unit
XXN_r19_c08_B10 TOP B10 mim_unit
XXN_r20_c26_B10 TOP B10 mim_unit
XXN_r58_c41_B11 TOP B11 mim_unit
XXN_r55_c10_B11 TOP B11 mim_unit
XXN_r42_c00_EDGE EDGE_BIAS EDGE_BIAS mim_unit
XXN_r52_c65_EDGE EDGE_BIAS EDGE_BIAS mim_unit
XXN_r39_c27_B9 TOP B9 mim_unit
XXN_r52_c46_B11 TOP B11 mim_unit
XXN_r23_c48_B10 TOP B10 mim_unit
XXN_r20_c17_B10 TOP B10 mim_unit
XXN_r58_c32_B11 TOP B11 mim_unit
XXN_r55_c01_B11 TOP B11 mim_unit
XXN_r34_c13_B7 TOP B7 mim_unit
XXN_r65_c25_EDGE EDGE_BIAS EDGE_BIAS mim_unit
XXN_r52_c37_B11 TOP B11 mim_unit
XXN_r20_c08_B10 TOP B10 mim_unit
XXN_r23_c39_B10 TOP B10 mim_unit
XXN_r58_c23_B11 TOP B11 mim_unit
XXN_r55_c59_B11 TOP B11 mim_unit
XXN_r52_c28_B11 TOP B11 mim_unit
XXN_r62_c63_B11 TOP B11 mim_unit
XXN_r58_c14_B11 TOP B11 mim_unit
XXN_r65_c48_EDGE EDGE_BIAS EDGE_BIAS mim_unit
XXN_r52_c19_B11 TOP B11 mim_unit
XXN_r06_c50_B11 TOP B11 mim_unit
XXN_r34_c08_B7 TOP B7 mim_unit
XXN_r62_c54_B11 TOP B11 mim_unit
XXN_r58_c05_B11 TOP B11 mim_unit
XXN_r28_c10_B9 TOP B9 mim_unit
XXN_r03_c10_B11 TOP B11 mim_unit
XXN_r06_c41_B11 TOP B11 mim_unit
XXN_r62_c45_B11 TOP B11 mim_unit
XXN_r30_c23_B8 TOP B8 mim_unit
XXN_r26_c14_B9 TOP B9 mim_unit
XXN_r06_c32_B11 TOP B11 mim_unit
XXN_r09_c63_B11 TOP B11 mim_unit
XXN_r62_c36_B11 TOP B11 mim_unit
XXN_r39_c40_B9 TOP B9 mim_unit
XXN_r09_c54_B11 TOP B11 mim_unit
XXN_r37_c44_B9 TOP B9 mim_unit
XXN_r06_c23_B11 TOP B11 mim_unit
XXN_r64_c64_B6 TOP B6 mim_unit
XXN_r62_c27_B11 TOP B11 mim_unit
XXN_r03_c59_B11 TOP B11 mim_unit
XXN_r28_c05_B9 TOP B9 mim_unit
XXN_r06_c14_B11 TOP B11 mim_unit
XXN_r09_c45_B11 TOP B11 mim_unit
XXN_r10_c63_B11 TOP B11 mim_unit
XXN_r62_c18_B11 TOP B11 mim_unit
XXN_r30_c18_B8 TOP B8 mim_unit
XXN_r26_c09_B9 TOP B9 mim_unit
XXN_r36_c01_B8 TOP B8 mim_unit
XXN_r10_c54_B11 TOP B11 mim_unit
XXN_r43_c55_B10 TOP B10 mim_unit
XXN_r39_c35_B9 TOP B9 mim_unit
XXN_r06_c05_B11 TOP B11 mim_unit
XXN_r09_c36_B11 TOP B11 mim_unit
XXN_r62_c09_B11 TOP B11 mim_unit
XXN_r16_c40_B11 TOP B11 mim_unit
XXN_r46_c10_B10 TOP B10 mim_unit
XXN_r34_c21_B7 TOP B7 mim_unit
XXN_r37_c39_B9 TOP B9 mim_unit
XXN_r09_c27_B11 TOP B11 mim_unit
XXN_r10_c45_B11 TOP B11 mim_unit
XXN_r43_c46_B10 TOP B10 mim_unit
XXN_r47_c64_B11 TOP B11 mim_unit
XXN_r46_c01_B10 TOP B10 mim_unit
XXN_r16_c31_B11 TOP B11 mim_unit
XXN_r35_c59_B8 TOP B8 mim_unit
XXN_r32_c41_B6 TOP B6 mim_unit
XXN_r43_c37_B10 TOP B10 mim_unit
XXN_r09_c18_B11 TOP B11 mim_unit
XXN_r10_c36_B11 TOP B11 mim_unit
XXN_r06_c65_EDGE EDGE_BIAS EDGE_BIAS mim_unit
XXN_r16_c22_B11 TOP B11 mim_unit
XXN_r09_c09_B11 TOP B11 mim_unit
XXN_r10_c27_B11 TOP B11 mim_unit
XXN_r13_c58_B11 TOP B11 mim_unit
XXN_r18_c57_B10 TOP B10 mim_unit
XXN_r46_c59_B10 TOP B10 mim_unit
XXN_r43_c28_B10 TOP B10 mim_unit
XXN_r22_c30_B10 TOP B10 mim_unit
XXN_r34_c16_B7 TOP B7 mim_unit
XXN_r16_c13_B11 TOP B11 mim_unit
XXN_r13_c49_B11 TOP B11 mim_unit
XXN_r18_c48_B10 TOP B10 mim_unit
XXN_r54_c50_B11 TOP B11 mim_unit
XXN_r43_c19_B10 TOP B10 mim_unit
XXN_r10_c18_B11 TOP B11 mim_unit
XXN_r32_c36_B6 TOP B6 mim_unit
XXN_r16_c04_B11 TOP B11 mim_unit
XXN_r22_c21_B10 TOP B10 mim_unit
XXN_r30_c31_B8 TOP B8 mim_unit
XXN_r10_c09_B11 TOP B11 mim_unit
XXN_r18_c39_B10 TOP B10 mim_unit
XXN_r54_c41_B11 TOP B11 mim_unit
XXN_r51_c10_B11 TOP B11 mim_unit
XXN_r26_c22_B9 TOP B9 mim_unit
XXN_r22_c12_B10 TOP B10 mim_unit
XXN_r57_c63_B11 TOP B11 mim_unit
XXN_r54_c32_B11 TOP B11 mim_unit
XXN_r51_c01_B11 TOP B11 mim_unit
XXN_r37_c52_B9 TOP B9 mim_unit
XXN_r22_c03_B10 TOP B10 mim_unit
XXN_r57_c54_B11 TOP B11 mim_unit
XXN_r54_c23_B11 TOP B11 mim_unit
XXN_r28_c13_B9 TOP B9 mim_unit
XXN_r51_c59_B11 TOP B11 mim_unit
XXN_r00_c05_EDGE EDGE_BIAS EDGE_BIAS mim_unit
XXN_r30_c26_B8 TOP B8 mim_unit
XXN_r26_c17_B9 TOP B9 mim_unit
XXN_r57_c45_B11 TOP B11 mim_unit
XXN_r54_c14_B11 TOP B11 mim_unit
XXN_r11_c00_EDGE EDGE_BIAS EDGE_BIAS mim_unit
XXN_r39_c43_B9 TOP B9 mim_unit
XXN_r21_c65_EDGE EDGE_BIAS EDGE_BIAS mim_unit
XXN_r02_c50_B11 TOP B11 mim_unit
XXN_r37_c47_B9 TOP B9 mim_unit
XXN_r57_c36_B11 TOP B11 mim_unit
XXN_r54_c05_B11 TOP B11 mim_unit
XXN_r64_c40_B11 TOP B11 mim_unit
XXN_r02_c41_B11 TOP B11 mim_unit
XXN_r00_c28_EDGE EDGE_BIAS EDGE_BIAS mim_unit
XXN_r28_c08_B9 TOP B9 mim_unit
XXN_r57_c27_B11 TOP B11 mim_unit
XXN_r64_c31_B11 TOP B11 mim_unit
XXN_r36_c04_B8 TOP B8 mim_unit
XXN_r02_c32_B11 TOP B11 mim_unit
XXN_r05_c63_B11 TOP B11 mim_unit
XXN_r39_c38_B9 TOP B9 mim_unit
XXN_r57_c18_B11 TOP B11 mim_unit
XXN_r64_c22_B11 TOP B11 mim_unit
XXN_r34_c24_B7 TOP B7 mim_unit
XXN_r05_c54_B11 TOP B11 mim_unit
XXN_r02_c23_B11 TOP B11 mim_unit
XXN_r61_c58_B11 TOP B11 mim_unit
XXN_r57_c09_B11 TOP B11 mim_unit
XXN_r64_c13_B11 TOP B11 mim_unit
XXN_r32_c44_B6 TOP B6 mim_unit
XXN_r05_c45_B11 TOP B11 mim_unit
XXN_r02_c14_B11 TOP B11 mim_unit
XXN_r61_c49_B11 TOP B11 mim_unit
XXN_r45_c50_B10 TOP B10 mim_unit
XXN_r64_c04_B11 TOP B11 mim_unit
XXN_r26_c30_B9 TOP B9 mim_unit
XXN_r05_c36_B11 TOP B11 mim_unit
XXN_r65_c15_EDGE EDGE_BIAS EDGE_BIAS mim_unit
XXN_r02_c05_B11 TOP B11 mim_unit
XXN_r12_c40_B11 TOP B11 mim_unit
XXN_r45_c41_B10 TOP B10 mim_unit
XXN_r42_c10_B10 TOP B10 mim_unit
XXN_r34_c19_B7 TOP B7 mim_unit
XXN_r37_c60_B9 TOP B9 mim_unit
XXN_r05_c27_B11 TOP B11 mim_unit
XXN_r08_c58_B11 TOP B11 mim_unit
XXN_r02_c01_B7 TOP B7 mim_unit
XXN_r15_c62_B11 TOP B11 mim_unit
XXN_r17_c30_B10 TOP B10 mim_unit
XXN_r48_c63_B10 TOP B10 mim_unit
XXN_r45_c32_B10 TOP B10 mim_unit
XXN_r43_c64_B11 TOP B11 mim_unit
XXN_r42_c01_B10 TOP B10 mim_unit
XXN_r32_c39_B6 TOP B6 mim_unit
XXN_r28_c21_B9 TOP B9 mim_unit
XXN_r12_c31_B11 TOP B11 mim_unit
XXN_r65_c38_EDGE EDGE_BIAS EDGE_BIAS mim_unit
XXN_r05_c18_B11 TOP B11 mim_unit
XXN_r08_c49_B11 TOP B11 mim_unit
XXN_r49_c50_B11 TOP B11 mim_unit
XXN_r30_c34_B8 TOP B8 mim_unit
XXN_r26_c25_B9 TOP B9 mim_unit
XXN_r12_c22_B11 TOP B11 mim_unit
XXN_r15_c53_B11 TOP B11 mim_unit
XXN_r17_c21_B10 TOP B10 mim_unit
XXN_r48_c54_B10 TOP B10 mim_unit
XXN_r45_c23_B10 TOP B10 mim_unit
XXN_r39_c51_B9 TOP B9 mim_unit
XXN_r42_c59_B10 TOP B10 mim_unit
XXN_r05_c09_B11 TOP B11 mim_unit
XXN_r49_c41_B11 TOP B11 mim_unit
XXN_r17_c12_B10 TOP B10 mim_unit
XXN_r21_c61_B10 TOP B10 mim_unit
XXN_r48_c45_B10 TOP B10 mim_unit
XXN_r45_c14_B10 TOP B10 mim_unit
XXN_r37_c55_B9 TOP B9 mim_unit
XXN_r12_c13_B11 TOP B11 mim_unit
XXN_r15_c44_B11 TOP B11 mim_unit
XXN_r50_c50_B11 TOP B11 mim_unit
XXN_r49_c32_B11 TOP B11 mim_unit
XXN_r28_c16_B9 TOP B9 mim_unit
XXN_r12_c04_B11 TOP B11 mim_unit
XXN_r15_c35_B11 TOP B11 mim_unit
XXN_r17_c03_B10 TOP B10 mim_unit
XXN_r21_c52_B10 TOP B10 mim_unit
XXN_r48_c36_B10 TOP B10 mim_unit
XXN_r45_c05_B10 TOP B10 mim_unit
XXN_r36_c00_EDGE EDGE_BIAS EDGE_BIAS mim_unit
XXN_r30_c29_B8 TOP B8 mim_unit
XXN_r50_c41_B11 TOP B11 mim_unit
XXN_r49_c23_B11 TOP B11 mim_unit
XXN_r46_c65_EDGE EDGE_BIAS EDGE_BIAS mim_unit
XXN_r36_c12_B8 TOP B8 mim_unit
XXN_r21_c43_B10 TOP B10 mim_unit
XXN_r48_c27_B10 TOP B10 mim_unit
XXN_r39_c46_B9 TOP B9 mim_unit
XXN_r15_c26_B11 TOP B11 mim_unit
XXN_r53_c63_B11 TOP B11 mim_unit
XXN_r50_c32_B11 TOP B11 mim_unit
XXN_r49_c14_B11 TOP B11 mim_unit
XXN_r34_c32_B7 TOP B7 mim_unit
XXN_r00_c61_EDGE EDGE_BIAS EDGE_BIAS mim_unit
XXN_r15_c17_B11 TOP B11 mim_unit
XXN_r21_c34_B10 TOP B10 mim_unit
XXN_r48_c18_B10 TOP B10 mim_unit
XXN_r53_c54_B11 TOP B11 mim_unit
XXN_r50_c23_B11 TOP B11 mim_unit
XXN_r49_c05_B11 TOP B11 mim_unit
XXN_r32_c52_B6 TOP B6 mim_unit
XXN_r24_c56_B10 TOP B10 mim_unit
XXN_r21_c25_B10 TOP B10 mim_unit
XXN_r59_c40_B11 TOP B11 mim_unit
XXN_r48_c09_B10 TOP B10 mim_unit
XXN_r15_c08_B11 TOP B11 mim_unit
XXN_r36_c07_B8 TOP B8 mim_unit
XXN_r53_c45_B11 TOP B11 mim_unit
XXN_r50_c14_B11 TOP B11 mim_unit
XXN_r24_c47_B10 TOP B10 mim_unit
XXN_r21_c16_B10 TOP B10 mim_unit
XXN_r59_c31_B11 TOP B11 mim_unit
XXN_r34_c27_B7 TOP B7 mim_unit
XXN_r53_c36_B11 TOP B11 mim_unit
XXN_r50_c05_B11 TOP B11 mim_unit
XXN_r24_c38_B10 TOP B10 mim_unit
XXN_r21_c07_B10 TOP B10 mim_unit
XXN_r60_c40_B11 TOP B11 mim_unit
XXN_r59_c22_B11 TOP B11 mim_unit
XXN_r32_c47_B6 TOP B6 mim_unit
XXN_r56_c58_B11 TOP B11 mim_unit
XXN_r53_c27_B11 TOP B11 mim_unit
XXN_r40_c02_B9 TOP B9 mim_unit
XXN_r30_c42_B8 TOP B8 mim_unit
XXN_r24_c29_B10 TOP B10 mim_unit
XXN_r63_c62_B11 TOP B11 mim_unit
XXN_r60_c31_B11 TOP B11 mim_unit
XXN_r59_c13_B11 TOP B11 mim_unit
XXN_r51_c00_EDGE EDGE_BIAS EDGE_BIAS mim_unit
XXN_r26_c33_B9 TOP B9 mim_unit
XXN_r01_c63_B11 TOP B11 mim_unit
XXN_r61_c65_EDGE EDGE_BIAS EDGE_BIAS mim_unit
XXN_r56_c49_B11 TOP B11 mim_unit
XXN_r53_c18_B11 TOP B11 mim_unit
XXN_r63_c53_B11 TOP B11 mim_unit
XXN_r60_c22_B11 TOP B11 mim_unit
XXN_r59_c04_B11 TOP B11 mim_unit
XXN_r01_c54_B11 TOP B11 mim_unit
XXN_r37_c63_B9 TOP B9 mim_unit
XXN_r53_c09_B11 TOP B11 mim_unit
XXN_r07_c40_B11 TOP B11 mim_unit
XXN_r28_c24_B9 TOP B9 mim_unit
XXN_r63_c44_B11 TOP B11 mim_unit
XXN_r60_c13_B11 TOP B11 mim_unit
XXN_r01_c45_B11 TOP B11 mim_unit
XXN_r07_c31_B11 TOP B11 mim_unit
XXN_r41_c50_B10 TOP B10 mim_unit
XXN_r38_c64_B11 TOP B11 mim_unit
XXN_r36_c20_B8 TOP B8 mim_unit
XXN_r30_c37_B8 TOP B8 mim_unit
XXN_r26_c28_B9 TOP B9 mim_unit
XXN_r63_c35_B11 TOP B11 mim_unit
XXN_r60_c04_B11 TOP B11 mim_unit
XXN_r01_c36_B11 TOP B11 mim_unit
XXN_r39_c54_B9 TOP B9 mim_unit
XXN_r07_c22_B11 TOP B11 mim_unit
XXN_r41_c41_B10 TOP B10 mim_unit
XXN_r37_c58_B9 TOP B9 mim_unit
XXN_r34_c40_B7 TOP B7 mim_unit
XXN_r63_c26_B11 TOP B11 mim_unit
XXN_r04_c58_B11 TOP B11 mim_unit
XXN_r01_c27_B11 TOP B11 mim_unit
XXN_r11_c62_B11 TOP B11 mim_unit
XXN_r44_c63_B10 TOP B10 mim_unit
XXN_r41_c32_B10 TOP B10 mim_unit
XXN_r28_c19_B9 TOP B9 mim_unit
XXN_r07_c13_B11 TOP B11 mim_unit
XXN_r63_c17_B11 TOP B11 mim_unit
XXN_r58_c64_B9 TOP B9 mim_unit
XXN_r32_c60_B6 TOP B6 mim_unit
XXN_r04_c49_B11 TOP B11 mim_unit
XXN_r01_c18_B11 TOP B11 mim_unit
XXN_r44_c54_B10 TOP B10 mim_unit
XXN_r36_c15_B8 TOP B8 mim_unit
XXN_r07_c04_B11 TOP B11 mim_unit
XXN_r11_c53_B11 TOP B11 mim_unit
XXN_r41_c23_B10 TOP B10 mim_unit
XXN_r39_c49_B9 TOP B9 mim_unit
XXN_r63_c08_B11 TOP B11 mim_unit
XXN_r01_c09_B11 TOP B11 mim_unit
XXN_r00_c18_EDGE EDGE_BIAS EDGE_BIAS mim_unit
XXN_r34_c35_B7 TOP B7 mim_unit
XXN_r11_c44_B11 TOP B11 mim_unit
XXN_r44_c45_B10 TOP B10 mim_unit
XXN_r41_c14_B10 TOP B10 mim_unit
XXN_r32_c55_B6 TOP B6 mim_unit
XXN_r11_c35_B11 TOP B11 mim_unit
XXN_r44_c36_B10 TOP B10 mim_unit
XXN_r40_c10_B9 TOP B9 mim_unit
XXN_r41_c05_B10 TOP B10 mim_unit
XXN_r30_c50_B8 TOP B8 mim_unit
XXN_r26_c41_B9 TOP B9 mim_unit
XXN_r11_c26_B11 TOP B11 mim_unit
XXN_r14_c57_B11 TOP B11 mim_unit
XXN_r19_c56_B10 TOP B10 mim_unit
XXN_r47_c58_B10 TOP B10 mim_unit
XXN_r44_c27_B10 TOP B10 mim_unit
XXN_r47_c49_B10 TOP B10 mim_unit
XXN_r11_c17_B11 TOP B11 mim_unit
XXN_r14_c48_B11 TOP B11 mim_unit
XXN_r19_c47_B10 TOP B10 mim_unit
XXN_r44_c18_B10 TOP B10 mim_unit
XXN_r23_c20_B10 TOP B10 mim_unit
XXN_r28_c32_B9 TOP B9 mim_unit
XXN_r65_c05_EDGE EDGE_BIAS EDGE_BIAS mim_unit
XXN_r40_c05_B9 TOP B9 mim_unit
XXN_r11_c08_B11 TOP B11 mim_unit
XXN_r14_c39_B11 TOP B11 mim_unit
XXN_r19_c38_B10 TOP B10 mim_unit
XXN_r20_c56_B10 TOP B10 mim_unit
XXN_r55_c40_B11 TOP B11 mim_unit
XXN_r44_c09_B10 TOP B10 mim_unit
XXN_r30_c45_B8 TOP B8 mim_unit
XXN_r05_c00_EDGE EDGE_BIAS EDGE_BIAS mim_unit
XXN_r26_c36_B9 TOP B9 mim_unit
XXN_r23_c11_B10 TOP B10 mim_unit
XXN_r39_c62_B9 TOP B9 mim_unit
XXN_r15_c65_EDGE EDGE_BIAS EDGE_BIAS mim_unit
XXN_r19_c29_B10 TOP B10 mim_unit
XXN_r20_c47_B10 TOP B10 mim_unit
XXN_r58_c62_B11 TOP B11 mim_unit
XXN_r55_c31_B11 TOP B11 mim_unit
XXN_r23_c02_B10 TOP B10 mim_unit
XXN_r65_c28_EDGE EDGE_BIAS EDGE_BIAS mim_unit
XXN_r20_c38_B10 TOP B10 mim_unit
XXN_r58_c53_B11 TOP B11 mim_unit
XXN_r55_c22_B11 TOP B11 mim_unit
XXN_r38_c03_B9 TOP B9 mim_unit
XXN_r28_c27_B9 TOP B9 mim_unit
XXN_r52_c58_B11 TOP B11 mim_unit
XXN_r20_c29_B10 TOP B10 mim_unit
XXN_r58_c44_B11 TOP B11 mim_unit
XXN_r55_c13_B11 TOP B11 mim_unit
XXN_r36_c23_B8 TOP B8 mim_unit
XXN_r52_c49_B11 TOP B11 mim_unit
XXN_r39_c57_B9 TOP B9 mim_unit
XXN_r58_c35_B11 TOP B11 mim_unit
XXN_r55_c04_B11 TOP B11 mim_unit
XXN_r34_c43_B7 TOP B7 mim_unit
XXN_r03_c40_B11 TOP B11 mim_unit
XXN_r58_c26_B11 TOP B11 mim_unit
XXN_r32_c63_B6 TOP B6 mim_unit
XXN_r03_c31_B11 TOP B11 mim_unit
XXN_r06_c62_B11 TOP B11 mim_unit
XXN_r36_c18_B8 TOP B8 mim_unit
XXN_r34_c64_B11 TOP B11 mim_unit
XXN_r00_c51_EDGE EDGE_BIAS EDGE_BIAS mim_unit
XXN_r58_c17_B11 TOP B11 mim_unit
XXN_r20_c00_EDGE EDGE_BIAS EDGE_BIAS mim_unit
XXN_r30_c65_EDGE EDGE_BIAS EDGE_BIAS mim_unit
XXN_r03_c22_B11 TOP B11 mim_unit
XXN_r06_c53_B11 TOP B11 mim_unit
XXN_r62_c57_B11 TOP B11 mim_unit
XXN_r34_c38_B7 TOP B7 mim_unit
XXN_r58_c08_B11 TOP B11 mim_unit
XXN_r03_c13_B11 TOP B11 mim_unit
XXN_r06_c44_B11 TOP B11 mim_unit
XXN_r32_c58_B6 TOP B6 mim_unit
XXN_r28_c40_B9 TOP B9 mim_unit
XXN_r62_c48_B11 TOP B11 mim_unit
XXN_r40_c13_B9 TOP B9 mim_unit
XXN_r30_c53_B8 TOP B8 mim_unit
XXN_r26_c44_B9 TOP B9 mim_unit
XXN_r03_c04_B11 TOP B11 mim_unit
XXN_r06_c35_B11 TOP B11 mim_unit
XXN_r62_c39_B11 TOP B11 mim_unit
XXN_r46_c40_B10 TOP B10 mim_unit
XXN_r06_c26_B11 TOP B11 mim_unit
XXN_r09_c57_B11 TOP B11 mim_unit
XXN_r13_c30_B11 TOP B11 mim_unit
XXN_r16_c61_B11 TOP B11 mim_unit
XXN_r46_c31_B10 TOP B10 mim_unit
XXN_r38_c11_B9 TOP B9 mim_unit
XXN_r28_c35_B9 TOP B9 mim_unit
XXN_r40_c08_B9 TOP B9 mim_unit
XXN_r06_c17_B11 TOP B11 mim_unit
XXN_r09_c48_B11 TOP B11 mim_unit
XXN_r16_c52_B11 TOP B11 mim_unit
XXN_r18_c20_B10 TOP B10 mim_unit
XXN_r46_c22_B10 TOP B10 mim_unit
XXN_r36_c31_B8 TOP B8 mim_unit
XXN_r30_c48_B8 TOP B8 mim_unit
XXN_r26_c39_B9 TOP B9 mim_unit
XXN_r13_c21_B11 TOP B11 mim_unit
XXN_r06_c08_B11 TOP B11 mim_unit
XXN_r09_c39_B11 TOP B11 mim_unit
XXN_r10_c57_B11 TOP B11 mim_unit
XXN_r65_c61_EDGE EDGE_BIAS EDGE_BIAS mim_unit
XXN_r43_c58_B10 TOP B10 mim_unit
XXN_r22_c60_B10 TOP B10 mim_unit
XXN_r13_c12_B11 TOP B11 mim_unit
XXN_r16_c43_B11 TOP B11 mim_unit
XXN_r18_c11_B10 TOP B10 mim_unit
XXN_r46_c13_B10 TOP B10 mim_unit
XXN_r34_c51_B7 TOP B7 mim_unit
XXN_r43_c49_B10 TOP B10 mim_unit
XXN_r10_c48_B11 TOP B11 mim_unit
XXN_r38_c06_B9 TOP B9 mim_unit
XXN_r22_c51_B10 TOP B10 mim_unit
XXN_r16_c34_B11 TOP B11 mim_unit
XXN_r18_c02_B10 TOP B10 mim_unit
XXN_r46_c04_B10 TOP B10 mim_unit
XXN_r13_c03_B11 TOP B11 mim_unit
XXN_r10_c39_B11 TOP B11 mim_unit
XXN_r51_c40_B11 TOP B11 mim_unit
XXN_r36_c26_B8 TOP B8 mim_unit
XXN_r22_c42_B10 TOP B10 mim_unit
XXN_r16_c25_B11 TOP B11 mim_unit
XXN_r54_c62_B11 TOP B11 mim_unit
XXN_r51_c31_B11 TOP B11 mim_unit
XXN_r34_c46_B7 TOP B7 mim_unit
XXN_r22_c33_B10 TOP B10 mim_unit
XXN_r16_c16_B11 TOP B11 mim_unit
XXN_r54_c53_B11 TOP B11 mim_unit
XXN_r51_c22_B11 TOP B11 mim_unit
XXN_r16_c07_B11 TOP B11 mim_unit
XXN_r22_c24_B10 TOP B10 mim_unit
XXN_r40_c21_B9 TOP B9 mim_unit
XXN_r00_c08_EDGE EDGE_BIAS EDGE_BIAS mim_unit
XXN_r54_c44_B11 TOP B11 mim_unit
XXN_r45_c00_EDGE EDGE_BIAS EDGE_BIAS mim_unit
XXN_r33_c03_B6 TOP B6 mim_unit
XXN_r30_c61_B8 TOP B8 mim_unit
XXN_r55_c65_EDGE EDGE_BIAS EDGE_BIAS mim_unit
XXN_r51_c13_B11 TOP B11 mim_unit
XXN_r26_c52_B9 TOP B9 mim_unit
XXN_r22_c15_B10 TOP B10 mim_unit
XXN_r54_c35_B11 TOP B11 mim_unit
XXN_r51_c04_B11 TOP B11 mim_unit
XXN_r22_c06_B10 TOP B10 mim_unit
XXN_r57_c57_B11 TOP B11 mim_unit
XXN_r54_c26_B11 TOP B11 mim_unit
XXN_r28_c43_B9 TOP B9 mim_unit
XXN_r40_c16_B9 TOP B9 mim_unit
XXN_r64_c61_B11 TOP B11 mim_unit
XXN_r61_c30_B11 TOP B11 mim_unit
XXN_r30_c56_B8 TOP B8 mim_unit
XXN_r02_c62_B11 TOP B11 mim_unit
XXN_r26_c47_B9 TOP B9 mim_unit
XXN_r57_c48_B11 TOP B11 mim_unit
XXN_r54_c17_B11 TOP B11 mim_unit
XXN_r64_c52_B11 TOP B11 mim_unit
XXN_r61_c21_B11 TOP B11 mim_unit
XXN_r02_c53_B11 TOP B11 mim_unit
XXN_r57_c39_B11 TOP B11 mim_unit
XXN_r54_c08_B11 TOP B11 mim_unit
XXN_r64_c43_B11 TOP B11 mim_unit
XXN_r61_c12_B11 TOP B11 mim_unit
XXN_r38_c14_B9 TOP B9 mim_unit
XXN_r02_c44_B11 TOP B11 mim_unit
XXN_r28_c38_B9 TOP B9 mim_unit
XXN_r08_c30_B11 TOP B11 mim_unit
XXN_r64_c34_B11 TOP B11 mim_unit
XXN_r65_c18_EDGE EDGE_BIAS EDGE_BIAS mim_unit
XXN_r61_c03_B11 TOP B11 mim_unit
XXN_r60_c00_EDGE EDGE_BIAS EDGE_BIAS mim_unit
XXN_r36_c34_B8 TOP B8 mim_unit
XXN_r02_c35_B11 TOP B11 mim_unit
XXN_r31_c04_B7 TOP B7 mim_unit
XXN_r08_c21_B11 TOP B11 mim_unit
XXN_r42_c40_B10 TOP B10 mim_unit
XXN_r64_c25_B11 TOP B11 mim_unit
XXN_r34_c54_B7 TOP B7 mim_unit
XXN_r05_c57_B11 TOP B11 mim_unit
XXN_r02_c26_B11 TOP B11 mim_unit
XXN_r45_c62_B10 TOP B10 mim_unit
XXN_r38_c09_B9 TOP B9 mim_unit
XXN_r08_c12_B11 TOP B11 mim_unit
XXN_r12_c61_B11 TOP B11 mim_unit
XXN_r17_c60_B10 TOP B10 mim_unit
XXN_r42_c31_B10 TOP B10 mim_unit
XXN_r64_c16_B11 TOP B11 mim_unit
XXN_r05_c48_B11 TOP B11 mim_unit
XXN_r02_c17_B11 TOP B11 mim_unit
XXN_r08_c03_B11 TOP B11 mim_unit
XXN_r12_c52_B11 TOP B11 mim_unit
XXN_r17_c51_B10 TOP B10 mim_unit
XXN_r45_c53_B10 TOP B10 mim_unit
XXN_r42_c22_B10 TOP B10 mim_unit
XXN_r36_c29_B8 TOP B8 mim_unit
XXN_r33_c11_B6 TOP B6 mim_unit
XXN_r64_c07_B11 TOP B11 mim_unit
XXN_r26_c60_B9 TOP B9 mim_unit
XXN_r05_c39_B11 TOP B11 mim_unit
XXN_r02_c08_B11 TOP B11 mim_unit
XXN_r45_c44_B10 TOP B10 mim_unit
XXN_r12_c43_B11 TOP B11 mim_unit
XXN_r17_c42_B10 TOP B10 mim_unit
XXN_r42_c13_B10 TOP B10 mim_unit
XXN_r34_c49_B7 TOP B7 mim_unit
XXN_r49_c62_B11 TOP B11 mim_unit
XXN_r00_c41_EDGE EDGE_BIAS EDGE_BIAS mim_unit
XXN_r12_c34_B11 TOP B11 mim_unit
XXN_r17_c33_B10 TOP B10 mim_unit
XXN_r45_c35_B10 TOP B10 mim_unit
XXN_r42_c04_B10 TOP B10 mim_unit
XXN_r28_c51_B9 TOP B9 mim_unit
XXN_r40_c24_B9 TOP B9 mim_unit
XXN_r49_c53_B11 TOP B11 mim_unit
XXN_r33_c06_B6 TOP B6 mim_unit
XXN_r30_c64_B8 TOP B8 mim_unit
XXN_r09_c65_EDGE EDGE_BIAS EDGE_BIAS mim_unit
XXN_r48_c57_B10 TOP B10 mim_unit
XXN_r45_c26_B10 TOP B10 mim_unit
XXN_r26_c55_B9 TOP B9 mim_unit
XXN_r12_c25_B11 TOP B11 mim_unit
XXN_r15_c56_B11 TOP B11 mim_unit
XXN_r17_c24_B10 TOP B10 mim_unit
XXN_r50_c62_B11 TOP B11 mim_unit
XXN_r49_c44_B11 TOP B11 mim_unit
XXN_r33_c63_B1 TOP B1 mim_unit
XXN_r00_c64_EDGE EDGE_BIAS EDGE_BIAS mim_unit
XXN_r12_c16_B11 TOP B11 mim_unit
XXN_r15_c47_B11 TOP B11 mim_unit
XXN_r17_c15_B10 TOP B10 mim_unit
XXN_r21_c64_B10 TOP B10 mim_unit
XXN_r48_c48_B10 TOP B10 mim_unit
XXN_r45_c17_B10 TOP B10 mim_unit
XXN_r50_c53_B11 TOP B11 mim_unit
XXN_r49_c35_B11 TOP B11 mim_unit
XXN_r38_c22_B9 TOP B9 mim_unit
XXN_r28_c46_B9 TOP B9 mim_unit
XXN_r48_c39_B10 TOP B10 mim_unit
XXN_r40_c19_B9 TOP B9 mim_unit
XXN_r12_c07_B11 TOP B11 mim_unit
XXN_r15_c38_B11 TOP B11 mim_unit
XXN_r17_c06_B10 TOP B10 mim_unit
XXN_r21_c55_B10 TOP B10 mim_unit
XXN_r45_c08_B10 TOP B10 mim_unit
XXN_r24_c10_B10 TOP B10 mim_unit
XXN_r50_c44_B11 TOP B11 mim_unit
XXN_r49_c26_B11 TOP B11 mim_unit
XXN_r36_c42_B8 TOP B8 mim_unit
XXN_r30_c59_B8 TOP B8 mim_unit
XXN_r15_c29_B11 TOP B11 mim_unit
XXN_r21_c46_B10 TOP B10 mim_unit
XXN_r59_c61_B11 TOP B11 mim_unit
XXN_r56_c30_B11 TOP B11 mim_unit
XXN_r31_c12_B7 TOP B7 mim_unit
XXN_r50_c35_B11 TOP B11 mim_unit
XXN_r49_c17_B11 TOP B11 mim_unit
XXN_r34_c62_B7 TOP B7 mim_unit
XXN_r59_c52_B11 TOP B11 mim_unit
XXN_r21_c37_B10 TOP B10 mim_unit
XXN_r56_c21_B11 TOP B11 mim_unit
XXN_r38_c17_B9 TOP B9 mim_unit
XXN_r53_c57_B11 TOP B11 mim_unit
XXN_r50_c26_B11 TOP B11 mim_unit
XXN_r49_c08_B11 TOP B11 mim_unit
XXN_r65_c51_EDGE EDGE_BIAS EDGE_BIAS mim_unit
XXN_r24_c59_B10 TOP B10 mim_unit
XXN_r21_c28_B10 TOP B10 mim_unit
XXN_r60_c61_B11 TOP B11 mim_unit
XXN_r59_c43_B11 TOP B11 mim_unit
XXN_r56_c12_B11 TOP B11 mim_unit
XXN_r14_c00_EDGE EDGE_BIAS EDGE_BIAS mim_unit
XXN_r36_c37_B8 TOP B8 mim_unit
XXN_r53_c48_B11 TOP B11 mim_unit
XXN_r50_c17_B11 TOP B11 mim_unit
XXN_r31_c07_B7 TOP B7 mim_unit
XXN_r24_c65_EDGE EDGE_BIAS EDGE_BIAS mim_unit
XXN_r60_c52_B11 TOP B11 mim_unit
XXN_r28_c01_B11 TOP B11 mim_unit
XXN_r21_c19_B10 TOP B10 mim_unit
XXN_r59_c34_B11 TOP B11 mim_unit
XXN_r56_c03_B11 TOP B11 mim_unit
XXN_r34_c57_B7 TOP B7 mim_unit
XXN_r53_c39_B11 TOP B11 mim_unit
XXN_r50_c08_B11 TOP B11 mim_unit
XXN_r60_c43_B11 TOP B11 mim_unit
XXN_r59_c25_B11 TOP B11 mim_unit
XXN_r40_c32_B9 TOP B9 mim_unit
XXN_r04_c30_B11 TOP B11 mim_unit
XXN_r07_c61_B11 TOP B11 mim_unit
XXN_r33_c14_B6 TOP B6 mim_unit
XXN_r60_c34_B11 TOP B11 mim_unit
XXN_r59_c16_B11 TOP B11 mim_unit
XXN_r26_c63_B9 TOP B9 mim_unit
XXN_r04_c21_B11 TOP B11 mim_unit
XXN_r07_c52_B11 TOP B11 mim_unit
XXN_r63_c56_B11 TOP B11 mim_unit
XXN_r60_c25_B11 TOP B11 mim_unit
XXN_r59_c07_B11 TOP B11 mim_unit
XXN_r01_c57_B11 TOP B11 mim_unit
XXN_r25_c04_B9 TOP B9 mim_unit
XXN_r41_c62_B10 TOP B10 mim_unit
XXN_r04_c12_B11 TOP B11 mim_unit
XXN_r07_c43_B11 TOP B11 mim_unit
XXN_r63_c47_B11 TOP B11 mim_unit
XXN_r38_c30_B9 TOP B9 mim_unit
XXN_r28_c54_B9 TOP B9 mim_unit
XXN_r60_c16_B11 TOP B11 mim_unit
XXN_r40_c27_B9 TOP B9 mim_unit
XXN_r01_c48_B11 TOP B11 mim_unit
XXN_r33_c09_B6 TOP B6 mim_unit
XXN_r04_c03_B11 TOP B11 mim_unit
XXN_r07_c34_B11 TOP B11 mim_unit
XXN_r41_c53_B10 TOP B10 mim_unit
XXN_r36_c50_B8 TOP B8 mim_unit
XXN_r26_c58_B9 TOP B9 mim_unit
XXN_r63_c38_B11 TOP B11 mim_unit
XXN_r60_c07_B11 TOP B11 mim_unit
XXN_r01_c39_B11 TOP B11 mim_unit
XXN_r31_c20_B7 TOP B7 mim_unit
XXN_r41_c44_B10 TOP B10 mim_unit
XXN_r07_c25_B11 TOP B11 mim_unit
XXN_r63_c29_B11 TOP B11 mim_unit
XXN_r47_c30_B10 TOP B10 mim_unit
XXN_r38_c25_B9 TOP B9 mim_unit
XXN_r07_c16_B11 TOP B11 mim_unit
XXN_r41_c35_B10 TOP B10 mim_unit
XXN_r28_c49_B9 TOP B9 mim_unit
XXN_r14_c20_B11 TOP B11 mim_unit
XXN_r47_c21_B10 TOP B10 mim_unit
XXN_r29_c02_B8 TOP B8 mim_unit
XXN_r44_c57_B10 TOP B10 mim_unit
XXN_r41_c26_B10 TOP B10 mim_unit
XXN_r36_c45_B8 TOP B8 mim_unit
XXN_r07_c07_B11 TOP B11 mim_unit
XXN_r11_c56_B11 TOP B11 mim_unit
XXN_r31_c15_B7 TOP B7 mim_unit
XXN_r14_c11_B11 TOP B11 mim_unit
XXN_r19_c10_B10 TOP B10 mim_unit
XXN_r47_c12_B10 TOP B10 mim_unit
XXN_r11_c47_B11 TOP B11 mim_unit
XXN_r44_c48_B10 TOP B10 mim_unit
XXN_r41_c17_B10 TOP B10 mim_unit
XXN_r23_c50_B10 TOP B10 mim_unit
XXN_r14_c02_B11 TOP B11 mim_unit
XXN_r65_c08_EDGE EDGE_BIAS EDGE_BIAS mim_unit
XXN_r47_c03_B10 TOP B10 mim_unit
XXN_r44_c39_B10 TOP B10 mim_unit
XXN_r40_c40_B9 TOP B9 mim_unit
XXN_r41_c08_B10 TOP B10 mim_unit
XXN_r39_c00_EDGE EDGE_BIAS EDGE_BIAS mim_unit
XXN_r11_c38_B11 TOP B11 mim_unit
XXN_r20_c10_B10 TOP B10 mim_unit
XXN_r23_c41_B10 TOP B10 mim_unit
XXN_r49_c65_EDGE EDGE_BIAS EDGE_BIAS mim_unit
XXN_r33_c22_B6 TOP B6 mim_unit
XXN_r11_c29_B11 TOP B11 mim_unit
XXN_r19_c59_B10 TOP B10 mim_unit
XXN_r55_c61_B11 TOP B11 mim_unit
XXN_r52_c30_B11 TOP B11 mim_unit
XXN_r23_c32_B10 TOP B10 mim_unit
XXN_r55_c52_B11 TOP B11 mim_unit
XXN_r52_c21_B11 TOP B11 mim_unit
XXN_r25_c12_B9 TOP B9 mim_unit
XXN_r23_c23_B10 TOP B10 mim_unit
XXN_r32_c04_B2 TOP B2 mim_unit
XXN_r28_c62_B9 TOP B9 mim_unit
XXN_r40_c35_B9 TOP B9 mim_unit
XXN_r20_c59_B10 TOP B10 mim_unit
XXN_r55_c43_B11 TOP B11 mim_unit
XXN_r52_c12_B11 TOP B11 mim_unit
XXN_r33_c17_B6 TOP B6 mim_unit
XXN_r33_c33_B5 TOP B5 mim_unit
XXN_r23_c14_B10 TOP B10 mim_unit
XXN_r00_c31_EDGE EDGE_BIAS EDGE_BIAS mim_unit
XXN_r55_c34_B11 TOP B11 mim_unit
XXN_r27_c03_B9 TOP B9 mim_unit
XXN_r24_c01_B11 TOP B11 mim_unit
XXN_r52_c03_B11 TOP B11 mim_unit
XXN_r23_c05_B10 TOP B10 mim_unit
XXN_r25_c07_B9 TOP B9 mim_unit
XXN_r58_c56_B11 TOP B11 mim_unit
XXN_r55_c25_B11 TOP B11 mim_unit
XXN_r38_c33_B9 TOP B9 mim_unit
XXN_r28_c57_B9 TOP B9 mim_unit
XXN_r03_c61_B11 TOP B11 mim_unit
XXN_r00_c54_EDGE EDGE_BIAS EDGE_BIAS mim_unit
XXN_r58_c47_B11 TOP B11 mim_unit
XXN_r55_c16_B11 TOP B11 mim_unit
XXN_r54_c00_EDGE EDGE_BIAS EDGE_BIAS mim_unit
XXN_r36_c53_B8 TOP B8 mim_unit
XXN_r29_c10_B8 TOP B8 mim_unit
XXN_r64_c65_EDGE EDGE_BIAS EDGE_BIAS mim_unit
XXN_r62_c20_B11 TOP B11 mim_unit
XXN_r33_c60_B3 TOP B3 mim_unit
XXN_r31_c23_B7 TOP B7 mim_unit
XXN_r03_c52_B11 TOP B11 mim_unit
XXN_r58_c38_B11 TOP B11 mim_unit
XXN_r55_c07_B11 TOP B11 mim_unit
XXN_r62_c11_B11 TOP B11 mim_unit
XXN_r38_c28_B9 TOP B9 mim_unit
XXN_r03_c43_B11 TOP B11 mim_unit
XXN_r58_c29_B11 TOP B11 mim_unit
XXN_r62_c02_B11 TOP B11 mim_unit
XXN_r33_c30_B6 TOP B6 mim_unit
XXN_r29_c05_B8 TOP B8 mim_unit
XXN_r03_c34_B11 TOP B11 mim_unit
XXN_r36_c48_B8 TOP B8 mim_unit
XXN_r31_c18_B7 TOP B7 mim_unit
XXN_r09_c20_B11 TOP B11 mim_unit
XXN_r03_c25_B11 TOP B11 mim_unit
XXN_r06_c56_B11 TOP B11 mim_unit
XXN_r65_c41_EDGE EDGE_BIAS EDGE_BIAS mim_unit
XXN_r09_c11_B11 TOP B11 mim_unit
XXN_r13_c60_B11 TOP B11 mim_unit
XXN_r46_c61_B10 TOP B10 mim_unit
XXN_r43_c30_B10 TOP B10 mim_unit
XXN_r25_c20_B9 TOP B9 mim_unit
XXN_r08_c01_B9 TOP B9 mim_unit
XXN_r03_c16_B11 TOP B11 mim_unit
XXN_r06_c47_B11 TOP B11 mim_unit
XXN_r40_c43_B9 TOP B9 mim_unit
XXN_r46_c52_B10 TOP B10 mim_unit
XXN_r43_c21_B10 TOP B10 mim_unit
XXN_r09_c02_B11 TOP B11 mim_unit
XXN_r10_c20_B11 TOP B11 mim_unit
XXN_r13_c51_B11 TOP B11 mim_unit
XXN_r18_c50_B10 TOP B10 mim_unit
XXN_r33_c25_B6 TOP B6 mim_unit
XXN_r65_c64_EDGE EDGE_BIAS EDGE_BIAS mim_unit
XXN_r33_c41_B5 TOP B5 mim_unit
XXN_r03_c07_B11 TOP B11 mim_unit
XXN_r06_c38_B11 TOP B11 mim_unit
XXN_r27_c11_B9 TOP B9 mim_unit
XXN_r10_c11_B11 TOP B11 mim_unit
XXN_r13_c42_B11 TOP B11 mim_unit
XXN_r18_c41_B10 TOP B10 mim_unit
XXN_r46_c43_B10 TOP B10 mim_unit
XXN_r43_c12_B10 TOP B10 mim_unit
XXN_r06_c29_B11 TOP B11 mim_unit
XXN_r25_c15_B9 TOP B9 mim_unit
XXN_r46_c34_B10 TOP B10 mim_unit
XXN_r10_c02_B11 TOP B11 mim_unit
XXN_r13_c33_B11 TOP B11 mim_unit
XXN_r15_c01_B10 TOP B10 mim_unit
XXN_r16_c64_B11 TOP B11 mim_unit
XXN_r18_c32_B10 TOP B10 mim_unit
XXN_r43_c03_B10 TOP B10 mim_unit
XXN_r38_c41_B9 TOP B9 mim_unit
XXN_r40_c38_B9 TOP B9 mim_unit
XXN_r13_c24_B11 TOP B11 mim_unit
XXN_r16_c55_B11 TOP B11 mim_unit
XXN_r18_c23_B10 TOP B10 mim_unit
XXN_r46_c25_B10 TOP B10 mim_unit
XXN_r36_c61_B8 TOP B8 mim_unit
XXN_r33_c36_B5 TOP B5 mim_unit
XXN_r33_c52_B4 TOP B4 mim_unit
XXN_r51_c61_B11 TOP B11 mim_unit
XXN_r31_c31_B7 TOP B7 mim_unit
XXN_r27_c06_B9 TOP B9 mim_unit
XXN_r22_c63_B10 TOP B10 mim_unit
XXN_r46_c16_B10 TOP B10 mim_unit
XXN_r13_c15_B11 TOP B11 mim_unit
XXN_r16_c46_B11 TOP B11 mim_unit
XXN_r18_c14_B10 TOP B10 mim_unit
XXN_r51_c52_B11 TOP B11 mim_unit
XXN_r35_c02_B8 TOP B8 mim_unit
XXN_r19_c01_B11 TOP B11 mim_unit
XXN_r38_c36_B9 TOP B9 mim_unit
XXN_r22_c54_B10 TOP B10 mim_unit
XXN_r13_c06_B11 TOP B11 mim_unit
XXN_r16_c37_B11 TOP B11 mim_unit
XXN_r18_c05_B10 TOP B10 mim_unit
XXN_r46_c07_B10 TOP B10 mim_unit
XXN_r08_c00_EDGE EDGE_BIAS EDGE_BIAS mim_unit
XXN_r51_c43_B11 TOP B11 mim_unit
XXN_r29_c13_B8 TOP B8 mim_unit
XXN_r22_c45_B10 TOP B10 mim_unit
XXN_r18_c65_EDGE EDGE_BIAS EDGE_BIAS mim_unit
XXN_r36_c56_B8 TOP B8 mim_unit
XXN_r16_c28_B11 TOP B11 mim_unit
XXN_r31_c26_B7 TOP B7 mim_unit
XXN_r51_c34_B11 TOP B11 mim_unit
XXN_r20_c01_B11 TOP B11 mim_unit
XXN_r16_c19_B11 TOP B11 mim_unit
XXN_r22_c36_B10 TOP B10 mim_unit
XXN_r57_c20_B11 TOP B11 mim_unit
XXN_r54_c56_B11 TOP B11 mim_unit
XXN_r51_c25_B11 TOP B11 mim_unit
XXN_r61_c60_B11 TOP B11 mim_unit
XXN_r40_c51_B9 TOP B9 mim_unit
XXN_r22_c27_B10 TOP B10 mim_unit
XXN_r57_c11_B11 TOP B11 mim_unit
XXN_r29_c08_B8 TOP B8 mim_unit
XXN_r54_c47_B11 TOP B11 mim_unit
XXN_r51_c16_B11 TOP B11 mim_unit
XXN_r33_c58_B3 TOP B3 mim_unit
XXN_r22_c18_B10 TOP B10 mim_unit
XXN_r61_c51_B11 TOP B11 mim_unit
XXN_r57_c02_B11 TOP B11 mim_unit
XXN_r54_c38_B11 TOP B11 mim_unit
XXN_r51_c07_B11 TOP B11 mim_unit
XXN_r61_c42_B11 TOP B11 mim_unit
XXN_r25_c23_B9 TOP B9 mim_unit
XXN_r22_c09_B10 TOP B10 mim_unit
XXN_r54_c29_B11 TOP B11 mim_unit
XXN_r08_c60_B11 TOP B11 mim_unit
XXN_r40_c46_B9 TOP B9 mim_unit
XXN_r61_c33_B11 TOP B11 mim_unit
XXN_r33_c28_B6 TOP B6 mim_unit
XXN_r23_c00_EDGE EDGE_BIAS EDGE_BIAS mim_unit
XXN_r33_c44_B5 TOP B5 mim_unit
XXN_r33_c65_EDGE EDGE_BIAS EDGE_BIAS mim_unit
XXN_r05_c20_B11 TOP B11 mim_unit
XXN_r08_c51_B11 TOP B11 mim_unit
XXN_r64_c55_B11 TOP B11 mim_unit
XXN_r61_c24_B11 TOP B11 mim_unit
XXN_r27_c14_B9 TOP B9 mim_unit
XXN_r02_c56_B11 TOP B11 mim_unit
XXN_r25_c18_B9 TOP B9 mim_unit
XXN_r05_c11_B11 TOP B11 mim_unit
XXN_r08_c42_B11 TOP B11 mim_unit
XXN_r42_c61_B10 TOP B10 mim_unit
XXN_r35_c10_B8 TOP B8 mim_unit
XXN_r64_c46_B11 TOP B11 mim_unit
XXN_r61_c15_B11 TOP B11 mim_unit
XXN_r38_c44_B9 TOP B9 mim_unit
XXN_r02_c47_B11 TOP B11 mim_unit
XXN_r00_c21_EDGE EDGE_BIAS EDGE_BIAS mim_unit
XXN_r42_c52_B10 TOP B10 mim_unit
XXN_r05_c02_B11 TOP B11 mim_unit
XXN_r08_c33_B11 TOP B11 mim_unit
XXN_r64_c37_B11 TOP B11 mim_unit
XXN_r61_c06_B11 TOP B11 mim_unit
XXN_r33_c39_B5 TOP B5 mim_unit
XXN_r29_c21_B8 TOP B8 mim_unit
XXN_r33_c55_B4 TOP B4 mim_unit
XXN_r02_c38_B11 TOP B11 mim_unit
XXN_r31_c34_B7 TOP B7 mim_unit
XXN_r27_c09_B9 TOP B9 mim_unit
XXN_r08_c24_B11 TOP B11 mim_unit
XXN_r42_c43_B10 TOP B10 mim_unit
XXN_r64_c28_B11 TOP B11 mim_unit
XXN_r02_c29_B11 TOP B11 mim_unit
XXN_r35_c05_B8 TOP B8 mim_unit
XXN_r00_c44_EDGE EDGE_BIAS EDGE_BIAS mim_unit
XXN_r17_c63_B10 TOP B10 mim_unit
XXN_r42_c34_B10 TOP B10 mim_unit
XXN_r38_c39_B9 TOP B9 mim_unit
XXN_r08_c15_B11 TOP B11 mim_unit
XXN_r11_c01_B10 TOP B10 mim_unit
XXN_r12_c64_B11 TOP B11 mim_unit
XXN_r64_c19_B11 TOP B11 mim_unit
XXN_r48_c20_B10 TOP B10 mim_unit
XXN_r29_c16_B8 TOP B8 mim_unit
XXN_r08_c06_B11 TOP B11 mim_unit
XXN_r12_c55_B11 TOP B11 mim_unit
XXN_r17_c54_B10 TOP B10 mim_unit
XXN_r45_c56_B10 TOP B10 mim_unit
XXN_r42_c25_B10 TOP B10 mim_unit
XXN_r36_c59_B8 TOP B8 mim_unit
XXN_r31_c29_B7 TOP B7 mim_unit
XXN_r15_c10_B11 TOP B11 mim_unit
XXN_r48_c11_B10 TOP B10 mim_unit
XXN_r17_c45_B10 TOP B10 mim_unit
XXN_r45_c47_B10 TOP B10 mim_unit
XXN_r42_c16_B10 TOP B10 mim_unit
XXN_r12_c46_B11 TOP B11 mim_unit
XXN_r48_c02_B10 TOP B10 mim_unit
XXN_r25_c31_B9 TOP B9 mim_unit
XXN_r32_c07_B3 TOP B3 mim_unit
XXN_r12_c37_B11 TOP B11 mim_unit
XXN_r17_c36_B10 TOP B10 mim_unit
XXN_r45_c38_B10 TOP B10 mim_unit
XXN_r42_c07_B10 TOP B10 mim_unit
XXN_r40_c54_B9 TOP B9 mim_unit
XXN_r24_c40_B10 TOP B10 mim_unit
XXN_r49_c56_B11 TOP B11 mim_unit
XXN_r17_c27_B10 TOP B10 mim_unit
XXN_r65_c31_EDGE EDGE_BIAS EDGE_BIAS mim_unit
XXN_r56_c60_B11 TOP B11 mim_unit
XXN_r45_c29_B10 TOP B10 mim_unit
XXN_r12_c28_B11 TOP B11 mim_unit
XXN_r15_c59_B11 TOP B11 mim_unit
XXN_r27_c22_B9 TOP B9 mim_unit
XXN_r24_c31_B10 TOP B10 mim_unit
XXN_r55_c64_B10 TOP B10 mim_unit
XXN_r49_c47_B11 TOP B11 mim_unit
XXN_r12_c19_B11 TOP B11 mim_unit
XXN_r17_c18_B10 TOP B10 mim_unit
XXN_r56_c51_B11 TOP B11 mim_unit
XXN_r53_c20_B11 TOP B11 mim_unit
XXN_r25_c26_B9 TOP B9 mim_unit
XXN_r24_c22_B10 TOP B10 mim_unit
XXN_r65_c54_EDGE EDGE_BIAS EDGE_BIAS mim_unit
XXN_r50_c56_B11 TOP B11 mim_unit
XXN_r49_c38_B11 TOP B11 mim_unit
XXN_r38_c52_B9 TOP B9 mim_unit
XXN_r17_c09_B10 TOP B10 mim_unit
XXN_r21_c58_B10 TOP B10 mim_unit
XXN_r56_c42_B11 TOP B11 mim_unit
XXN_r53_c11_B11 TOP B11 mim_unit
XXN_r48_c00_EDGE EDGE_BIAS EDGE_BIAS mim_unit
XXN_r40_c49_B9 TOP B9 mim_unit
XXN_r24_c13_B10 TOP B10 mim_unit
XXN_r58_c65_EDGE EDGE_BIAS EDGE_BIAS mim_unit
XXN_r50_c47_B11 TOP B11 mim_unit
XXN_r49_c29_B11 TOP B11 mim_unit
XXN_r33_c47_B5 TOP B5 mim_unit
XXN_r21_c49_B10 TOP B10 mim_unit
XXN_r56_c33_B11 TOP B11 mim_unit
XXN_r53_c02_B11 TOP B11 mim_unit
XXN_r31_c42_B7 TOP B7 mim_unit
XXN_r27_c17_B9 TOP B9 mim_unit
XXN_r24_c04_B10 TOP B10 mim_unit
XXN_r50_c38_B11 TOP B11 mim_unit
XXN_r59_c55_B11 TOP B11 mim_unit
XXN_r56_c24_B11 TOP B11 mim_unit
XXN_r35_c13_B8 TOP B8 mim_unit
XXN_r38_c47_B9 TOP B9 mim_unit
XXN_r50_c29_B11 TOP B11 mim_unit
XXN_r04_c60_B11 TOP B11 mim_unit
XXN_r59_c46_B11 TOP B11 mim_unit
XXN_r56_c15_B11 TOP B11 mim_unit
XXN_r29_c24_B8 TOP B8 mim_unit
XXN_r31_c37_B7 TOP B7 mim_unit
XXN_r04_c51_B11 TOP B11 mim_unit
XXN_r01_c20_B11 TOP B11 mim_unit
XXN_r60_c55_B11 TOP B11 mim_unit
XXN_r59_c37_B11 TOP B11 mim_unit
XXN_r56_c06_B11 TOP B11 mim_unit
XXN_r63_c10_B11 TOP B11 mim_unit
XXN_r35_c08_B8 TOP B8 mim_unit
XXN_r04_c42_B11 TOP B11 mim_unit
XXN_r01_c11_B11 TOP B11 mim_unit
XXN_r60_c46_B11 TOP B11 mim_unit
XXN_r59_c28_B11 TOP B11 mim_unit
XXN_r40_c62_B9 TOP B9 mim_unit
XXN_r07_c64_B11 TOP B11 mim_unit
XXN_r63_c01_B11 TOP B11 mim_unit
XXN_r29_c19_B8 TOP B8 mim_unit
XXN_r04_c33_B11 TOP B11 mim_unit
XXN_r01_c02_B11 TOP B11 mim_unit
XXN_r63_c00_EDGE EDGE_BIAS EDGE_BIAS mim_unit
XXN_r60_c37_B11 TOP B11 mim_unit
XXN_r59_c19_B11 TOP B11 mim_unit
XXN_r02_c65_EDGE EDGE_BIAS EDGE_BIAS mim_unit
XXN_r27_c30_B9 TOP B9 mim_unit
XXN_r04_c24_B11 TOP B11 mim_unit
XXN_r07_c55_B11 TOP B11 mim_unit
XXN_r63_c59_B11 TOP B11 mim_unit
XXN_r60_c28_B11 TOP B11 mim_unit
XXN_r47_c60_B10 TOP B10 mim_unit
XXN_r25_c34_B9 TOP B9 mim_unit
XXN_r38_c60_B9 TOP B9 mim_unit
XXN_r04_c15_B11 TOP B11 mim_unit
XXN_r07_c46_B11 TOP B11 mim_unit
XXN_r60_c19_B11 TOP B11 mim_unit
XXN_r14_c50_B11 TOP B11 mim_unit
XXN_r47_c51_B10 TOP B10 mim_unit
XXN_r44_c20_B10 TOP B10 mim_unit
XXN_r40_c57_B9 TOP B9 mim_unit
XXN_r04_c06_B11 TOP B11 mim_unit
XXN_r07_c37_B11 TOP B11 mim_unit
XXN_r41_c56_B10 TOP B10 mim_unit
XXN_r19_c40_B10 TOP B10 mim_unit
XXN_r47_c42_B10 TOP B10 mim_unit
XXN_r44_c11_B10 TOP B10 mim_unit
XXN_r37_c01_B9 TOP B9 mim_unit
XXN_r11_c10_B11 TOP B11 mim_unit
XXN_r14_c41_B11 TOP B11 mim_unit
XXN_r31_c50_B7 TOP B7 mim_unit
XXN_r27_c25_B9 TOP B9 mim_unit
XXN_r41_c47_B10 TOP B10 mim_unit
XXN_r07_c28_B11 TOP B11 mim_unit
XXN_r35_c21_B8 TOP B8 mim_unit
XXN_r25_c29_B9 TOP B9 mim_unit
XXN_r14_c32_B11 TOP B11 mim_unit
XXN_r19_c31_B10 TOP B10 mim_unit
XXN_r47_c33_B10 TOP B10 mim_unit
XXN_r44_c02_B10 TOP B10 mim_unit
XXN_r32_c12_B4 TOP B4 mim_unit
XXN_r38_c55_B9 TOP B9 mim_unit
XXN_r07_c19_B11 TOP B11 mim_unit
XXN_r41_c38_B10 TOP B10 mim_unit
XXN_r19_c22_B10 TOP B10 mim_unit
XXN_r20_c40_B10 TOP B10 mim_unit
XXN_r47_c24_B10 TOP B10 mim_unit
XXN_r14_c23_B11 TOP B11 mim_unit
XXN_r29_c32_B8 TOP B8 mim_unit
XXN_r11_c59_B11 TOP B11 mim_unit
XXN_r52_c60_B11 TOP B11 mim_unit
XXN_r41_c29_B10 TOP B10 mim_unit
XXN_r31_c45_B7 TOP B7 mim_unit
XXN_r23_c62_B10 TOP B10 mim_unit
XXN_r14_c14_B11 TOP B11 mim_unit
XXN_r19_c13_B10 TOP B10 mim_unit
XXN_r20_c31_B10 TOP B10 mim_unit
XXN_r51_c64_B10 TOP B10 mim_unit
XXN_r47_c15_B10 TOP B10 mim_unit
XXN_r00_c11_EDGE EDGE_BIAS EDGE_BIAS mim_unit
XXN_r52_c51_B11 TOP B11 mim_unit
XXN_r35_c16_B8 TOP B8 mim_unit
XXN_r23_c53_B10 TOP B10 mim_unit
XXN_r47_c06_B10 TOP B10 mim_unit
XXN_r14_c05_B11 TOP B11 mim_unit
XXN_r19_c04_B10 TOP B10 mim_unit
XXN_r20_c22_B10 TOP B10 mim_unit
XXN_r52_c42_B11 TOP B11 mim_unit
XXN_r29_c27_B8 TOP B8 mim_unit
XXN_r23_c44_B10 TOP B10 mim_unit
XXN_r20_c13_B10 TOP B10 mim_unit
XXN_r00_c34_EDGE EDGE_BIAS EDGE_BIAS mim_unit
XXN_r52_c33_B11 TOP B11 mim_unit
XXN_r23_c35_B10 TOP B10 mim_unit
XXN_r20_c04_B10 TOP B10 mim_unit
XXN_r55_c55_B11 TOP B11 mim_unit
XXN_r52_c24_B11 TOP B11 mim_unit
XXN_r25_c42_B9 TOP B9 mim_unit
XXN_r23_c26_B10 TOP B10 mim_unit
XXN_r58_c10_B11 TOP B11 mim_unit
XXN_r00_c57_EDGE EDGE_BIAS EDGE_BIAS mim_unit
XXN_r17_c00_EDGE EDGE_BIAS EDGE_BIAS mim_unit
XXN_r55_c46_B11 TOP B11 mim_unit
XXN_r52_c15_B11 TOP B11 mim_unit
XXN_r27_c65_EDGE EDGE_BIAS EDGE_BIAS mim_unit
XXN_r23_c17_B10 TOP B10 mim_unit
XXN_r62_c50_B11 TOP B11 mim_unit
XXN_r58_c01_B11 TOP B11 mim_unit
XXN_r27_c33_B9 TOP B9 mim_unit
XXN_r55_c37_B11 TOP B11 mim_unit
XXN_r52_c06_B11 TOP B11 mim_unit
XXN_r23_c08_B10 TOP B10 mim_unit
XXN_r62_c41_B11 TOP B11 mim_unit
XXN_r25_c37_B9 TOP B9 mim_unit
XXN_r38_c63_B9 TOP B9 mim_unit
XXN_r65_c21_EDGE EDGE_BIAS EDGE_BIAS mim_unit
XXN_r58_c59_B11 TOP B11 mim_unit
XXN_r55_c28_B11 TOP B11 mim_unit
XXN_r62_c32_B11 TOP B11 mim_unit
XXN_r03_c64_B11 TOP B11 mim_unit
XXN_r55_c19_B11 TOP B11 mim_unit
XXN_r29_c40_B8 TOP B8 mim_unit
XXN_r09_c50_B11 TOP B11 mim_unit
XXN_r37_c04_B9 TOP B9 mim_unit
XXN_r62_c23_B11 TOP B11 mim_unit
XXN_r31_c53_B7 TOP B7 mim_unit
XXN_r27_c28_B9 TOP B9 mim_unit
XXN_r03_c55_B11 TOP B11 mim_unit
XXN_r65_c44_EDGE EDGE_BIAS EDGE_BIAS mim_unit
XXN_r43_c60_B10 TOP B10 mim_unit
XXN_r06_c10_B11 TOP B11 mim_unit
XXN_r09_c41_B11 TOP B11 mim_unit
XXN_r62_c14_B11 TOP B11 mim_unit
XXN_r35_c24_B8 TOP B8 mim_unit
XXN_r32_c15_B4 TOP B4 mim_unit
XXN_r03_c46_B11 TOP B11 mim_unit
XXN_r38_c58_B9 TOP B9 mim_unit
XXN_r09_c32_B11 TOP B11 mim_unit
XXN_r10_c50_B11 TOP B11 mim_unit
XXN_r43_c51_B10 TOP B10 mim_unit
XXN_r62_c05_B11 TOP B11 mim_unit
XXN_r59_c64_B9 TOP B9 mim_unit
XXN_r32_c00_EDGE EDGE_BIAS EDGE_BIAS mim_unit
XXN_r29_c35_B8 TOP B8 mim_unit
XXN_r03_c37_B11 TOP B11 mim_unit
XXN_r42_c65_EDGE EDGE_BIAS EDGE_BIAS mim_unit
XXN_r43_c42_B10 TOP B10 mim_unit
XXN_r31_c48_B7 TOP B7 mim_unit
XXN_r09_c23_B11 TOP B11 mim_unit
XXN_r10_c41_B11 TOP B11 mim_unit
XXN_r03_c28_B11 TOP B11 mim_unit
XXN_r06_c59_B11 TOP B11 mim_unit
XXN_r35_c19_B8 TOP B8 mim_unit
XXN_r09_c14_B11 TOP B11 mim_unit
XXN_r10_c32_B11 TOP B11 mim_unit
XXN_r13_c63_B11 TOP B11 mim_unit
XXN_r18_c62_B10 TOP B10 mim_unit
XXN_r43_c33_B10 TOP B10 mim_unit
XXN_r25_c50_B9 TOP B9 mim_unit
XXN_r03_c19_B11 TOP B11 mim_unit
XXN_r03_c01_B8 TOP B8 mim_unit
XXN_r18_c53_B10 TOP B10 mim_unit
XXN_r46_c55_B10 TOP B10 mim_unit
XXN_r43_c24_B10 TOP B10 mim_unit
XXN_r09_c05_B11 TOP B11 mim_unit
XXN_r10_c23_B11 TOP B11 mim_unit
XXN_r13_c54_B11 TOP B11 mim_unit
XXN_r27_c41_B9 TOP B9 mim_unit
XXN_r10_c14_B11 TOP B11 mim_unit
XXN_r13_c45_B11 TOP B11 mim_unit
XXN_r18_c44_B10 TOP B10 mim_unit
XXN_r46_c46_B10 TOP B10 mim_unit
XXN_r43_c15_B10 TOP B10 mim_unit
XXN_r25_c45_B9 TOP B9 mim_unit
XXN_r18_c35_B10 TOP B10 mim_unit
XXN_r46_c37_B10 TOP B10 mim_unit
XXN_r43_c06_B10 TOP B10 mim_unit
XXN_r10_c05_B11 TOP B11 mim_unit
XXN_r13_c36_B11 TOP B11 mim_unit
XXN_r13_c27_B11 TOP B11 mim_unit
XXN_r16_c58_B11 TOP B11 mim_unit
XXN_r18_c26_B10 TOP B10 mim_unit
XXN_r46_c28_B10 TOP B10 mim_unit
XXN_r37_c12_B9 TOP B9 mim_unit
XXN_r27_c36_B9 TOP B9 mim_unit
XXN_r31_c61_B7 TOP B7 mim_unit
XXN_r18_c17_B10 TOP B10 mim_unit
XXN_r57_c50_B11 TOP B11 mim_unit
XXN_r46_c19_B10 TOP B10 mim_unit
XXN_r13_c18_B11 TOP B11 mim_unit
XXN_r16_c49_B11 TOP B11 mim_unit
XXN_r35_c32_B8 TOP B8 mim_unit
XXN_r51_c55_B11 TOP B11 mim_unit
XXN_r22_c57_B10 TOP B10 mim_unit
XXN_r13_c09_B11 TOP B11 mim_unit
XXN_r18_c08_B10 TOP B10 mim_unit
XXN_r57_c41_B11 TOP B11 mim_unit
XXN_r54_c10_B11 TOP B11 mim_unit
XXN_r39_c03_B9 TOP B9 mim_unit
XXN_r51_c46_B11 TOP B11 mim_unit
XXN_r29_c43_B8 TOP B8 mim_unit
XXN_r22_c48_B10 TOP B10 mim_unit
XXN_r57_c32_B11 TOP B11 mim_unit
XXN_r54_c01_B11 TOP B11 mim_unit
XXN_r37_c07_B9 TOP B9 mim_unit
XXN_r31_c56_B7 TOP B7 mim_unit
XXN_r51_c37_B11 TOP B11 mim_unit
XXN_r22_c39_B10 TOP B10 mim_unit
XXN_r57_c23_B11 TOP B11 mim_unit
XXN_r35_c27_B8 TOP B8 mim_unit
XXN_r54_c59_B11 TOP B11 mim_unit
XXN_r51_c28_B11 TOP B11 mim_unit
XXN_r61_c63_B11 TOP B11 mim_unit
XXN_r57_c14_B11 TOP B11 mim_unit
XXN_r57_c00_EDGE EDGE_BIAS EDGE_BIAS mim_unit
XXN_r29_c38_B8 TOP B8 mim_unit
XXN_r51_c19_B11 TOP B11 mim_unit
XXN_r05_c50_B11 TOP B11 mim_unit
XXN_r00_c01_EDGE EDGE_BIAS EDGE_BIAS mim_unit
XXN_r61_c54_B11 TOP B11 mim_unit
XXN_r57_c05_B11 TOP B11 mim_unit
XXN_r05_c41_B11 TOP B11 mim_unit
XXN_r02_c10_B11 TOP B11 mim_unit
XXN_r61_c45_B11 TOP B11 mim_unit
XXN_r32_c20_B5 TOP B5 mim_unit
XXN_r25_c53_B9 TOP B9 mim_unit
XXN_r00_c24_EDGE EDGE_BIAS EDGE_BIAS mim_unit
XXN_r05_c32_B11 TOP B11 mim_unit
XXN_r08_c63_B11 TOP B11 mim_unit
XXN_r61_c36_B11 TOP B11 mim_unit
XXN_r08_c54_B11 TOP B11 mim_unit
XXN_r37_c20_B9 TOP B9 mim_unit
XXN_r27_c44_B9 TOP B9 mim_unit
XXN_r05_c23_B11 TOP B11 mim_unit
XXN_r64_c58_B11 TOP B11 mim_unit
XXN_r61_c27_B11 TOP B11 mim_unit
XXN_r02_c59_B11 TOP B11 mim_unit
XXN_r00_c47_EDGE EDGE_BIAS EDGE_BIAS mim_unit
XXN_r35_c40_B8 TOP B8 mim_unit
XXN_r25_c48_B9 TOP B9 mim_unit
XXN_r05_c14_B11 TOP B11 mim_unit
XXN_r08_c45_B11 TOP B11 mim_unit
XXN_r64_c49_B11 TOP B11 mim_unit
XXN_r61_c18_B11 TOP B11 mim_unit
XXN_r48_c50_B10 TOP B10 mim_unit
XXN_r39_c11_B9 TOP B9 mim_unit
XXN_r08_c36_B11 TOP B11 mim_unit
XXN_r42_c55_B10 TOP B10 mim_unit
XXN_r05_c05_B11 TOP B11 mim_unit
XXN_r61_c09_B11 TOP B11 mim_unit
XXN_r29_c51_B8 TOP B8 mim_unit
XXN_r01_c00_EDGE EDGE_BIAS EDGE_BIAS mim_unit
XXN_r15_c40_B11 TOP B11 mim_unit
XXN_r48_c41_B10 TOP B10 mim_unit
XXN_r45_c10_B10 TOP B10 mim_unit
XXN_r37_c15_B9 TOP B9 mim_unit
XXN_r65_c11_EDGE EDGE_BIAS EDGE_BIAS mim_unit
XXN_r31_c64_B7 TOP B7 mim_unit
XXN_r27_c39_B9 TOP B9 mim_unit
XXN_r08_c27_B11 TOP B11 mim_unit
XXN_r11_c65_EDGE EDGE_BIAS EDGE_BIAS mim_unit
XXN_r42_c46_B10 TOP B10 mim_unit
XXN_r48_c32_B10 TOP B10 mim_unit
XXN_r46_c64_B11 TOP B11 mim_unit
XXN_r45_c01_B10 TOP B10 mim_unit
XXN_r15_c31_B11 TOP B11 mim_unit
XXN_r35_c35_B8 TOP B8 mim_unit
XXN_r42_c37_B10 TOP B10 mim_unit
XXN_r08_c18_B11 TOP B11 mim_unit
XXN_r39_c06_B9 TOP B9 mim_unit
XXN_r15_c22_B11 TOP B11 mim_unit
XXN_r48_c23_B10 TOP B10 mim_unit
XXN_r65_c34_EDGE EDGE_BIAS EDGE_BIAS mim_unit
XXN_r45_c59_B10 TOP B10 mim_unit
XXN_r29_c46_B8 TOP B8 mim_unit
XXN_r08_c09_B11 TOP B11 mim_unit
XXN_r12_c58_B11 TOP B11 mim_unit
XXN_r17_c57_B10 TOP B10 mim_unit
XXN_r49_c10_B11 TOP B11 mim_unit
XXN_r42_c28_B10 TOP B10 mim_unit
XXN_r24_c61_B10 TOP B10 mim_unit
XXN_r21_c30_B10 TOP B10 mim_unit
XXN_r48_c14_B10 TOP B10 mim_unit
XXN_r31_c59_B7 TOP B7 mim_unit
XXN_r15_c13_B11 TOP B11 mim_unit
XXN_r12_c49_B11 TOP B11 mim_unit
XXN_r17_c48_B10 TOP B10 mim_unit
XXN_r53_c50_B11 TOP B11 mim_unit
XXN_r49_c01_B11 TOP B11 mim_unit
XXN_r42_c19_B10 TOP B10 mim_unit
XXN_r24_c52_B10 TOP B10 mim_unit
XXN_r15_c04_B11 TOP B11 mim_unit
XXN_r21_c21_B10 TOP B10 mim_unit
XXN_r65_c57_EDGE EDGE_BIAS EDGE_BIAS mim_unit
XXN_r48_c05_B10 TOP B10 mim_unit
XXN_r25_c61_B9 TOP B9 mim_unit
XXN_r17_c39_B10 TOP B10 mim_unit
XXN_r53_c41_B11 TOP B11 mim_unit
XXN_r50_c10_B11 TOP B11 mim_unit
XXN_r24_c43_B10 TOP B10 mim_unit
XXN_r21_c12_B10 TOP B10 mim_unit
XXN_r49_c59_B11 TOP B11 mim_unit
XXN_r56_c63_B11 TOP B11 mim_unit
XXN_r53_c32_B11 TOP B11 mim_unit
XXN_r50_c01_B11 TOP B11 mim_unit
XXN_r27_c52_B9 TOP B9 mim_unit
XXN_r24_c34_B10 TOP B10 mim_unit
XXN_r21_c03_B10 TOP B10 mim_unit
XXN_r56_c54_B11 TOP B11 mim_unit
XXN_r53_c23_B11 TOP B11 mim_unit
XXN_r32_c23_B5 TOP B5 mim_unit
XXN_r25_c56_B9 TOP B9 mim_unit
XXN_r24_c25_B10 TOP B10 mim_unit
XXN_r50_c59_B11 TOP B11 mim_unit
XXN_r30_c02_B8 TOP B8 mim_unit
XXN_r56_c45_B11 TOP B11 mim_unit
XXN_r53_c14_B11 TOP B11 mim_unit
XXN_r24_c16_B10 TOP B10 mim_unit
XXN_r01_c50_B11 TOP B11 mim_unit
XXN_r37_c23_B9 TOP B9 mim_unit
XXN_r27_c47_B9 TOP B9 mim_unit
XXN_r56_c36_B11 TOP B11 mim_unit
XXN_r53_c05_B11 TOP B11 mim_unit
XXN_r24_c07_B10 TOP B10 mim_unit
XXN_r63_c40_B11 TOP B11 mim_unit
XXN_r01_c41_B11 TOP B11 mim_unit
XXN_r35_c43_B8 TOP B8 mim_unit
XXN_r32_c18_B5 TOP B5 mim_unit
XXN_r59_c58_B11 TOP B11 mim_unit
XXN_r56_c27_B11 TOP B11 mim_unit
XXN_r63_c31_B11 TOP B11 mim_unit
XXN_r39_c14_B9 TOP B9 mim_unit
XXN_r01_c32_B11 TOP B11 mim_unit
XXN_r04_c63_B11 TOP B11 mim_unit
XXN_r26_c00_EDGE EDGE_BIAS EDGE_BIAS mim_unit
XXN_r59_c49_B11 TOP B11 mim_unit
XXN_r56_c18_B11 TOP B11 mim_unit
XXN_r36_c65_EDGE EDGE_BIAS EDGE_BIAS mim_unit
XXN_r29_c54_B8 TOP B8 mim_unit
XXN_r63_c22_B11 TOP B11 mim_unit
XXN_r37_c18_B9 TOP B9 mim_unit
XXN_r04_c54_B11 TOP B11 mim_unit
XXN_r01_c23_B11 TOP B11 mim_unit
XXN_r60_c58_B11 TOP B11 mim_unit
XXN_r56_c09_B11 TOP B11 mim_unit
XXN_r63_c13_B11 TOP B11 mim_unit
XXN_r35_c38_B8 TOP B8 mim_unit
XXN_r04_c45_B11 TOP B11 mim_unit
XXN_r01_c14_B11 TOP B11 mim_unit
XXN_r60_c49_B11 TOP B11 mim_unit
XXN_r44_c50_B10 TOP B10 mim_unit
XXN_r63_c04_B11 TOP B11 mim_unit
XXN_r39_c09_B9 TOP B9 mim_unit
XXN_r04_c36_B11 TOP B11 mim_unit
XXN_r01_c05_B11 TOP B11 mim_unit
XXN_r29_c49_B8 TOP B8 mim_unit
XXN_r11_c40_B11 TOP B11 mim_unit
XXN_r44_c41_B10 TOP B10 mim_unit
XXN_r41_c10_B10 TOP B10 mim_unit
XXN_r27_c60_B9 TOP B9 mim_unit
XXN_r04_c27_B11 TOP B11 mim_unit
XXN_r07_c58_B11 TOP B11 mim_unit
XXN_r14_c62_B11 TOP B11 mim_unit
XXN_r19_c61_B10 TOP B10 mim_unit
XXN_r47_c63_B10 TOP B10 mim_unit
XXN_r44_c32_B10 TOP B10 mim_unit
XXN_r42_c64_B11 TOP B11 mim_unit
XXN_r41_c01_B10 TOP B10 mim_unit
XXN_r11_c31_B11 TOP B11 mim_unit
XXN_r32_c31_B5 TOP B5 mim_unit
XXN_r25_c64_B9 TOP B9 mim_unit
XXN_r04_c18_B11 TOP B11 mim_unit
XXN_r07_c49_B11 TOP B11 mim_unit
XXN_r30_c10_B8 TOP B8 mim_unit
XXN_r11_c22_B11 TOP B11 mim_unit
XXN_r14_c53_B11 TOP B11 mim_unit
XXN_r19_c52_B10 TOP B10 mim_unit
XXN_r47_c54_B10 TOP B10 mim_unit
XXN_r44_c23_B10 TOP B10 mim_unit
XXN_r41_c59_B10 TOP B10 mim_unit
XXN_r04_c09_B11 TOP B11 mim_unit
XXN_r41_c00_EDGE EDGE_BIAS EDGE_BIAS mim_unit
XXN_r14_c44_B11 TOP B11 mim_unit
XXN_r19_c43_B10 TOP B10 mim_unit
XXN_r20_c61_B10 TOP B10 mim_unit
XXN_r51_c65_EDGE EDGE_BIAS EDGE_BIAS mim_unit
XXN_r47_c45_B10 TOP B10 mim_unit
XXN_r44_c14_B10 TOP B10 mim_unit
XXN_r37_c31_B9 TOP B9 mim_unit
XXN_r27_c55_B9 TOP B9 mim_unit
XXN_r11_c13_B11 TOP B11 mim_unit
XXN_r00_c14_EDGE EDGE_BIAS EDGE_BIAS mim_unit
XXN_r35_c51_B8 TOP B8 mim_unit
XXN_r32_c26_B5 TOP B5 mim_unit
XXN_r25_c59_B9 TOP B9 mim_unit
XXN_r11_c04_B11 TOP B11 mim_unit
XXN_r14_c35_B11 TOP B11 mim_unit
XXN_r19_c34_B10 TOP B10 mim_unit
XXN_r20_c52_B10 TOP B10 mim_unit
XXN_r47_c36_B10 TOP B10 mim_unit
XXN_r44_c05_B10 TOP B10 mim_unit
XXN_r30_c05_B8 TOP B8 mim_unit
XXN_r39_c22_B9 TOP B9 mim_unit
XXN_r19_c25_B10 TOP B10 mim_unit
XXN_r20_c43_B10 TOP B10 mim_unit
XXN_r47_c27_B10 TOP B10 mim_unit
XXN_r14_c26_B11 TOP B11 mim_unit
XXN_r29_c62_B8 TOP B8 mim_unit
XXN_r00_c37_EDGE EDGE_BIAS EDGE_BIAS mim_unit
XXN_r52_c63_B11 TOP B11 mim_unit
XXN_r37_c26_B9 TOP B9 mim_unit
XXN_r14_c17_B11 TOP B11 mim_unit
XXN_r19_c16_B10 TOP B10 mim_unit
XXN_r20_c34_B10 TOP B10 mim_unit
XXN_r47_c18_B10 TOP B10 mim_unit
XXN_r52_c54_B11 TOP B11 mim_unit
XXN_r35_c46_B8 TOP B8 mim_unit
XXN_r23_c56_B10 TOP B10 mim_unit
XXN_r19_c07_B10 TOP B10 mim_unit
XXN_r20_c25_B10 TOP B10 mim_unit
XXN_r58_c40_B11 TOP B11 mim_unit
XXN_r47_c09_B10 TOP B10 mim_unit
XXN_r14_c08_B11 TOP B11 mim_unit
XXN_r39_c17_B9 TOP B9 mim_unit
XXN_r65_c01_EDGE EDGE_BIAS EDGE_BIAS mim_unit
XXN_r52_c45_B11 TOP B11 mim_unit
XXN_r29_c57_B8 TOP B8 mim_unit
XXN_r23_c47_B10 TOP B10 mim_unit
XXN_r20_c16_B10 TOP B10 mim_unit
XXN_r58_c31_B11 TOP B11 mim_unit
XXN_r34_c03_B7 TOP B7 mim_unit
XXN_r52_c36_B11 TOP B11 mim_unit
XXN_r20_c07_B10 TOP B10 mim_unit
XXN_r23_c38_B10 TOP B10 mim_unit
XXN_r58_c22_B11 TOP B11 mim_unit
XXN_r65_c24_EDGE EDGE_BIAS EDGE_BIAS mim_unit
XXN_r55_c58_B11 TOP B11 mim_unit
XXN_r52_c27_B11 TOP B11 mim_unit
XXN_r23_c29_B10 TOP B10 mim_unit
XXN_r62_c62_B11 TOP B11 mim_unit
XXN_r58_c13_B11 TOP B11 mim_unit
XXN_r55_c49_B11 TOP B11 mim_unit
XXN_r52_c18_B11 TOP B11 mim_unit
XXN_r62_c53_B11 TOP B11 mim_unit
XXN_r58_c04_B11 TOP B11 mim_unit
XXN_r65_c47_EDGE EDGE_BIAS EDGE_BIAS mim_unit
XXN_r27_c63_B9 TOP B9 mim_unit
XXN_r52_c09_B11 TOP B11 mim_unit
XXN_r06_c40_B11 TOP B11 mim_unit
XXN_r62_c44_B11 TOP B11 mim_unit
XXN_r30_c13_B8 TOP B8 mim_unit
XXN_r06_c31_B11 TOP B11 mim_unit
XXN_r09_c62_B11 TOP B11 mim_unit
XXN_r37_c64_B11 TOP B11 mim_unit
XXN_r26_c04_B9 TOP B9 mim_unit
XXN_r62_c35_B11 TOP B11 mim_unit
XXN_r39_c30_B9 TOP B9 mim_unit
XXN_r05_c65_EDGE EDGE_BIAS EDGE_BIAS mim_unit
XXN_r06_c22_B11 TOP B11 mim_unit
XXN_r09_c53_B11 TOP B11 mim_unit
XXN_r37_c34_B9 TOP B9 mim_unit
XXN_r27_c58_B9 TOP B9 mim_unit
XXN_r62_c26_B11 TOP B11 mim_unit
XXN_r03_c58_B11 TOP B11 mim_unit
XXN_r06_c13_B11 TOP B11 mim_unit
XXN_r09_c44_B11 TOP B11 mim_unit
XXN_r10_c62_B11 TOP B11 mim_unit
XXN_r43_c63_B10 TOP B10 mim_unit
XXN_r35_c54_B8 TOP B8 mim_unit
XXN_r32_c29_B5 TOP B5 mim_unit
XXN_r62_c17_B11 TOP B11 mim_unit
XXN_r30_c08_B8 TOP B8 mim_unit
XXN_r03_c49_B11 TOP B11 mim_unit
XXN_r43_c54_B10 TOP B10 mim_unit
XXN_r39_c25_B9 TOP B9 mim_unit
XXN_r06_c04_B11 TOP B11 mim_unit
XXN_r09_c35_B11 TOP B11 mim_unit
XXN_r10_c53_B11 TOP B11 mim_unit
XXN_r62_c08_B11 TOP B11 mim_unit
XXN_r37_c29_B9 TOP B9 mim_unit
XXN_r34_c11_B7 TOP B7 mim_unit
XXN_r09_c26_B11 TOP B11 mim_unit
XXN_r10_c44_B11 TOP B11 mim_unit
XXN_r43_c45_B10 TOP B10 mim_unit
XXN_r16_c30_B11 TOP B11 mim_unit
XXN_r35_c49_B8 TOP B8 mim_unit
XXN_r09_c17_B11 TOP B11 mim_unit
XXN_r10_c35_B11 TOP B11 mim_unit
XXN_r43_c36_B10 TOP B10 mim_unit
XXN_r16_c21_B11 TOP B11 mim_unit
XXN_r09_c08_B11 TOP B11 mim_unit
XXN_r10_c26_B11 TOP B11 mim_unit
XXN_r13_c57_B11 TOP B11 mim_unit
XXN_r18_c56_B10 TOP B10 mim_unit
XXN_r46_c58_B10 TOP B10 mim_unit
XXN_r43_c27_B10 TOP B10 mim_unit
XXN_r34_c06_B7 TOP B7 mim_unit
XXN_r10_c00_EDGE EDGE_BIAS EDGE_BIAS mim_unit
XXN_r16_c12_B11 TOP B11 mim_unit
XXN_r46_c49_B10 TOP B10 mim_unit
XXN_r10_c17_B11 TOP B11 mim_unit
XXN_r13_c48_B11 TOP B11 mim_unit
XXN_r18_c47_B10 TOP B10 mim_unit
XXN_r20_c65_EDGE EDGE_BIAS EDGE_BIAS mim_unit
XXN_r43_c18_B10 TOP B10 mim_unit
XXN_r22_c20_B10 TOP B10 mim_unit
XXN_r16_c03_B11 TOP B11 mim_unit
XXN_r10_c08_B11 TOP B11 mim_unit
XXN_r13_c39_B11 TOP B11 mim_unit
XXN_r18_c38_B10 TOP B10 mim_unit
XXN_r54_c40_B11 TOP B11 mim_unit
XXN_r43_c09_B10 TOP B10 mim_unit
XXN_r30_c21_B8 TOP B8 mim_unit
XXN_r26_c12_B9 TOP B9 mim_unit
XXN_r22_c11_B10 TOP B10 mim_unit
XXN_r57_c62_B11 TOP B11 mim_unit
XXN_r18_c29_B10 TOP B10 mim_unit
XXN_r54_c31_B11 TOP B11 mim_unit
XXN_r22_c02_B10 TOP B10 mim_unit
XXN_r37_c42_B9 TOP B9 mim_unit
XXN_r57_c53_B11 TOP B11 mim_unit
XXN_r54_c22_B11 TOP B11 mim_unit
XXN_r28_c03_B9 TOP B9 mim_unit
XXN_r35_c62_B8 TOP B8 mim_unit
XXN_r51_c58_B11 TOP B11 mim_unit
XXN_r30_c16_B8 TOP B8 mim_unit
XXN_r26_c07_B9 TOP B9 mim_unit
XXN_r57_c44_B11 TOP B11 mim_unit
XXN_r54_c13_B11 TOP B11 mim_unit
XXN_r39_c33_B9 TOP B9 mim_unit
XXN_r51_c49_B11 TOP B11 mim_unit
XXN_r00_c04_EDGE EDGE_BIAS EDGE_BIAS mim_unit
XXN_r57_c35_B11 TOP B11 mim_unit
XXN_r54_c04_B11 TOP B11 mim_unit
XXN_r37_c37_B9 TOP B9 mim_unit
XXN_r02_c40_B11 TOP B11 mim_unit
XXN_r57_c26_B11 TOP B11 mim_unit
XXN_r35_c57_B8 TOP B8 mim_unit
XXN_r64_c30_B11 TOP B11 mim_unit
XXN_r02_c31_B11 TOP B11 mim_unit
XXN_r00_c27_EDGE EDGE_BIAS EDGE_BIAS mim_unit
XXN_r05_c62_B11 TOP B11 mim_unit
XXN_r39_c28_B9 TOP B9 mim_unit
XXN_r33_c64_B11 TOP B11 mim_unit
XXN_r57_c17_B11 TOP B11 mim_unit
XXN_r64_c21_B11 TOP B11 mim_unit
XXN_r34_c14_B7 TOP B7 mim_unit
XXN_r05_c53_B11 TOP B11 mim_unit
XXN_r02_c22_B11 TOP B11 mim_unit
XXN_r61_c57_B11 TOP B11 mim_unit
XXN_r57_c08_B11 TOP B11 mim_unit
XXN_r64_c12_B11 TOP B11 mim_unit
XXN_r05_c44_B11 TOP B11 mim_unit
XXN_r02_c13_B11 TOP B11 mim_unit
XXN_r32_c34_B6 TOP B6 mim_unit
XXN_r61_c48_B11 TOP B11 mim_unit
XXN_r26_c20_B9 TOP B9 mim_unit
XXN_r64_c03_B11 TOP B11 mim_unit
XXN_r05_c35_B11 TOP B11 mim_unit
XXN_r02_c04_B11 TOP B11 mim_unit
XXN_r35_c00_EDGE EDGE_BIAS EDGE_BIAS mim_unit
XXN_r61_c39_B11 TOP B11 mim_unit
XXN_r45_c40_B10 TOP B10 mim_unit
XXN_r34_c09_B7 TOP B7 mim_unit
XXN_r45_c65_EDGE EDGE_BIAS EDGE_BIAS mim_unit
XXN_r37_c50_B9 TOP B9 mim_unit
XXN_r05_c26_B11 TOP B11 mim_unit
XXN_r08_c57_B11 TOP B11 mim_unit
XXN_r65_c14_EDGE EDGE_BIAS EDGE_BIAS mim_unit
XXN_r48_c62_B10 TOP B10 mim_unit
XXN_r12_c30_B11 TOP B11 mim_unit
XXN_r15_c61_B11 TOP B11 mim_unit
XXN_r45_c31_B10 TOP B10 mim_unit
XXN_r28_c11_B9 TOP B9 mim_unit
XXN_r05_c17_B11 TOP B11 mim_unit
XXN_r08_c48_B11 TOP B11 mim_unit
XXN_r30_c24_B8 TOP B8 mim_unit
XXN_r15_c52_B11 TOP B11 mim_unit
XXN_r17_c20_B10 TOP B10 mim_unit
XXN_r48_c53_B10 TOP B10 mim_unit
XXN_r45_c22_B10 TOP B10 mim_unit
XXN_r26_c15_B9 TOP B9 mim_unit
XXN_r12_c21_B11 TOP B11 mim_unit
XXN_r65_c37_EDGE EDGE_BIAS EDGE_BIAS mim_unit
XXN_r39_c41_B9 TOP B9 mim_unit
XXN_r05_c08_B11 TOP B11 mim_unit
XXN_r08_c39_B11 TOP B11 mim_unit
XXN_r49_c40_B11 TOP B11 mim_unit
XXN_r42_c58_B10 TOP B10 mim_unit
XXN_r12_c12_B11 TOP B11 mim_unit
XXN_r15_c43_B11 TOP B11 mim_unit
XXN_r17_c11_B10 TOP B10 mim_unit
XXN_r21_c60_B10 TOP B10 mim_unit
XXN_r48_c44_B10 TOP B10 mim_unit
XXN_r45_c13_B10 TOP B10 mim_unit
XXN_r37_c45_B9 TOP B9 mim_unit
XXN_r49_c31_B11 TOP B11 mim_unit
XXN_r42_c49_B10 TOP B10 mim_unit
XXN_r28_c06_B9 TOP B9 mim_unit
XXN_r15_c34_B11 TOP B11 mim_unit
XXN_r17_c02_B10 TOP B10 mim_unit
XXN_r21_c51_B10 TOP B10 mim_unit
XXN_r48_c35_B10 TOP B10 mim_unit
XXN_r45_c04_B10 TOP B10 mim_unit
XXN_r12_c03_B11 TOP B11 mim_unit
XXN_r30_c19_B8 TOP B8 mim_unit
XXN_r50_c40_B11 TOP B11 mim_unit
XXN_r49_c22_B11 TOP B11 mim_unit
XXN_r36_c02_B8 TOP B8 mim_unit
XXN_r39_c36_B9 TOP B9 mim_unit
XXN_r15_c25_B11 TOP B11 mim_unit
XXN_r21_c42_B10 TOP B10 mim_unit
XXN_r48_c26_B10 TOP B10 mim_unit
XXN_r53_c62_B11 TOP B11 mim_unit
XXN_r50_c31_B11 TOP B11 mim_unit
XXN_r50_c00_EDGE EDGE_BIAS EDGE_BIAS mim_unit
XXN_r49_c13_B11 TOP B11 mim_unit
XXN_r34_c22_B7 TOP B7 mim_unit
XXN_r24_c64_B10 TOP B10 mim_unit
XXN_r15_c16_B11 TOP B11 mim_unit
XXN_r21_c33_B10 TOP B10 mim_unit
XXN_r60_c65_EDGE EDGE_BIAS EDGE_BIAS mim_unit
XXN_r48_c17_B10 TOP B10 mim_unit
XXN_r53_c53_B11 TOP B11 mim_unit
XXN_r50_c22_B11 TOP B11 mim_unit
XXN_r49_c04_B11 TOP B11 mim_unit
XXN_r32_c42_B6 TOP B6 mim_unit
XXN_r00_c60_EDGE EDGE_BIAS EDGE_BIAS mim_unit
XXN_r24_c55_B10 TOP B10 mim_unit
XXN_r15_c07_B11 TOP B11 mim_unit
XXN_r21_c24_B10 TOP B10 mim_unit
XXN_r48_c08_B10 TOP B10 mim_unit
XXN_r53_c44_B11 TOP B11 mim_unit
XXN_r50_c13_B11 TOP B11 mim_unit
XXN_r24_c46_B10 TOP B10 mim_unit
XXN_r21_c15_B10 TOP B10 mim_unit
XXN_r59_c30_B11 TOP B11 mim_unit
XXN_r34_c17_B7 TOP B7 mim_unit
XXN_r53_c35_B11 TOP B11 mim_unit
XXN_r50_c04_B11 TOP B11 mim_unit
XXN_r24_c37_B10 TOP B10 mim_unit
XXN_r21_c06_B10 TOP B10 mim_unit
XXN_r59_c21_B11 TOP B11 mim_unit
XXN_r56_c57_B11 TOP B11 mim_unit
XXN_r53_c26_B11 TOP B11 mim_unit
XXN_r32_c37_B6 TOP B6 mim_unit
XXN_r24_c28_B10 TOP B10 mim_unit
XXN_r63_c61_B11 TOP B11 mim_unit
XXN_r60_c30_B11 TOP B11 mim_unit
XXN_r59_c12_B11 TOP B11 mim_unit
XXN_r30_c32_B8 TOP B8 mim_unit
XXN_r26_c23_B9 TOP B9 mim_unit
XXN_r01_c62_B11 TOP B11 mim_unit
XXN_r56_c48_B11 TOP B11 mim_unit
XXN_r53_c17_B11 TOP B11 mim_unit
XXN_r24_c19_B10 TOP B10 mim_unit
XXN_r63_c52_B11 TOP B11 mim_unit
XXN_r60_c21_B11 TOP B11 mim_unit
XXN_r59_c03_B11 TOP B11 mim_unit
XXN_r01_c53_B11 TOP B11 mim_unit
XXN_r56_c39_B11 TOP B11 mim_unit
XXN_r37_c53_B9 TOP B9 mim_unit
XXN_r53_c08_B11 TOP B11 mim_unit
XXN_r63_c43_B11 TOP B11 mim_unit
XXN_r60_c12_B11 TOP B11 mim_unit
XXN_r28_c14_B9 TOP B9 mim_unit
XXN_r01_c44_B11 TOP B11 mim_unit
XXN_r30_c27_B8 TOP B8 mim_unit
XXN_r07_c30_B11 TOP B11 mim_unit
XXN_r36_c10_B8 TOP B8 mim_unit
XXN_r32_c01_B11 TOP B11 mim_unit
XXN_r26_c18_B9 TOP B9 mim_unit
XXN_r63_c34_B11 TOP B11 mim_unit
XXN_r60_c03_B11 TOP B11 mim_unit
XXN_r39_c44_B9 TOP B9 mim_unit
XXN_r01_c35_B11 TOP B11 mim_unit
XXN_r07_c21_B11 TOP B11 mim_unit
XXN_r41_c40_B10 TOP B10 mim_unit
XXN_r63_c25_B11 TOP B11 mim_unit
XXN_r37_c48_B9 TOP B9 mim_unit
XXN_r34_c30_B7 TOP B7 mim_unit
XXN_r04_c57_B11 TOP B11 mim_unit
XXN_r01_c26_B11 TOP B11 mim_unit
XXN_r44_c62_B10 TOP B10 mim_unit
XXN_r41_c31_B10 TOP B10 mim_unit
XXN_r28_c09_B9 TOP B9 mim_unit
XXN_r07_c12_B11 TOP B11 mim_unit
XXN_r11_c61_B11 TOP B11 mim_unit
XXN_r32_c50_B6 TOP B6 mim_unit
XXN_r63_c16_B11 TOP B11 mim_unit
XXN_r04_c48_B11 TOP B11 mim_unit
XXN_r01_c17_B11 TOP B11 mim_unit
XXN_r36_c05_B8 TOP B8 mim_unit
XXN_r07_c03_B11 TOP B11 mim_unit
XXN_r11_c52_B11 TOP B11 mim_unit
XXN_r44_c53_B10 TOP B10 mim_unit
XXN_r41_c22_B10 TOP B10 mim_unit
XXN_r39_c39_B9 TOP B9 mim_unit
XXN_r63_c07_B11 TOP B11 mim_unit
XXN_r04_c39_B11 TOP B11 mim_unit
XXN_r01_c08_B11 TOP B11 mim_unit
XXN_r04_c00_EDGE EDGE_BIAS EDGE_BIAS mim_unit
XXN_r44_c44_B10 TOP B10 mim_unit
XXN_r34_c25_B7 TOP B7 mim_unit
XXN_r11_c43_B11 TOP B11 mim_unit
XXN_r14_c65_EDGE EDGE_BIAS EDGE_BIAS mim_unit
XXN_r41_c13_B10 TOP B10 mim_unit
XXN_r00_c17_EDGE EDGE_BIAS EDGE_BIAS mim_unit
XXN_r11_c34_B11 TOP B11 mim_unit
XXN_r19_c64_B10 TOP B10 mim_unit
XXN_r44_c35_B10 TOP B10 mim_unit
XXN_r41_c04_B10 TOP B10 mim_unit
XXN_r32_c45_B6 TOP B6 mim_unit
XXN_r30_c40_B8 TOP B8 mim_unit
XXN_r26_c31_B9 TOP B9 mim_unit
XXN_r47_c57_B10 TOP B10 mim_unit
XXN_r44_c26_B10 TOP B10 mim_unit
XXN_r11_c25_B11 TOP B11 mim_unit
XXN_r14_c56_B11 TOP B11 mim_unit
XXN_r19_c55_B10 TOP B10 mim_unit
XXN_r37_c61_B9 TOP B9 mim_unit
XXN_r11_c16_B11 TOP B11 mim_unit
XXN_r14_c47_B11 TOP B11 mim_unit
XXN_r19_c46_B10 TOP B10 mim_unit
XXN_r20_c64_B10 TOP B10 mim_unit
XXN_r47_c48_B10 TOP B10 mim_unit
XXN_r44_c17_B10 TOP B10 mim_unit
XXN_r28_c22_B9 TOP B9 mim_unit
XXN_r47_c39_B10 TOP B10 mim_unit
XXN_r11_c07_B11 TOP B11 mim_unit
XXN_r14_c38_B11 TOP B11 mim_unit
XXN_r19_c37_B10 TOP B10 mim_unit
XXN_r20_c55_B10 TOP B10 mim_unit
XXN_r60_c64_B9 TOP B9 mim_unit
XXN_r44_c08_B10 TOP B10 mim_unit
XXN_r30_c35_B8 TOP B8 mim_unit
XXN_r23_c10_B10 TOP B10 mim_unit
XXN_r26_c26_B9 TOP B9 mim_unit
XXN_r65_c04_EDGE EDGE_BIAS EDGE_BIAS mim_unit
XXN_r39_c52_B9 TOP B9 mim_unit
XXN_r14_c29_B11 TOP B11 mim_unit
XXN_r19_c28_B10 TOP B10 mim_unit
XXN_r20_c46_B10 TOP B10 mim_unit
XXN_r58_c61_B11 TOP B11 mim_unit
XXN_r55_c30_B11 TOP B11 mim_unit
XXN_r37_c56_B9 TOP B9 mim_unit
XXN_r58_c52_B11 TOP B11 mim_unit
XXN_r19_c19_B10 TOP B10 mim_unit
XXN_r20_c37_B10 TOP B10 mim_unit
XXN_r55_c21_B11 TOP B11 mim_unit
XXN_r28_c17_B9 TOP B9 mim_unit
XXN_r65_c27_EDGE EDGE_BIAS EDGE_BIAS mim_unit
XXN_r52_c57_B11 TOP B11 mim_unit
XXN_r23_c59_B10 TOP B10 mim_unit
XXN_r20_c28_B10 TOP B10 mim_unit
XXN_r58_c43_B11 TOP B11 mim_unit
XXN_r55_c12_B11 TOP B11 mim_unit
XXN_r36_c13_B8 TOP B8 mim_unit
XXN_r39_c47_B9 TOP B9 mim_unit
XXN_r52_c48_B11 TOP B11 mim_unit
XXN_r58_c34_B11 TOP B11 mim_unit
XXN_r27_c01_B11 TOP B11 mim_unit
XXN_r20_c19_B10 TOP B10 mim_unit
XXN_r55_c03_B11 TOP B11 mim_unit
XXN_r34_c33_B7 TOP B7 mim_unit
XXN_r52_c39_B11 TOP B11 mim_unit
XXN_r58_c25_B11 TOP B11 mim_unit
XXN_r32_c53_B6 TOP B6 mim_unit
XXN_r36_c08_B8 TOP B8 mim_unit
XXN_r03_c30_B11 TOP B11 mim_unit
XXN_r06_c61_B11 TOP B11 mim_unit
XXN_r58_c16_B11 TOP B11 mim_unit
XXN_r29_c00_EDGE EDGE_BIAS EDGE_BIAS mim_unit
XXN_r39_c65_EDGE EDGE_BIAS EDGE_BIAS mim_unit
XXN_r03_c21_B11 TOP B11 mim_unit
XXN_r00_c50_EDGE EDGE_BIAS EDGE_BIAS mim_unit
XXN_r06_c52_B11 TOP B11 mim_unit
XXN_r34_c28_B7 TOP B7 mim_unit
XXN_r62_c56_B11 TOP B11 mim_unit
XXN_r58_c07_B11 TOP B11 mim_unit
XXN_r03_c12_B11 TOP B11 mim_unit
XXN_r06_c43_B11 TOP B11 mim_unit
XXN_r62_c47_B11 TOP B11 mim_unit
XXN_r40_c03_B9 TOP B9 mim_unit
XXN_r32_c48_B6 TOP B6 mim_unit
XXN_r28_c30_B9 TOP B9 mim_unit
XXN_r30_c43_B8 TOP B8 mim_unit
XXN_r26_c34_B9 TOP B9 mim_unit
XXN_r03_c03_B11 TOP B11 mim_unit
XXN_r06_c34_B11 TOP B11 mim_unit
XXN_r62_c38_B11 TOP B11 mim_unit
XXN_r39_c60_B9 TOP B9 mim_unit
XXN_r06_c25_B11 TOP B11 mim_unit
XXN_r09_c56_B11 TOP B11 mim_unit
XXN_r62_c29_B11 TOP B11 mim_unit
XXN_r16_c60_B11 TOP B11 mim_unit
XXN_r46_c30_B10 TOP B10 mim_unit
XXN_r38_c01_B9 TOP B9 mim_unit
XXN_r28_c25_B9 TOP B9 mim_unit
XXN_r06_c16_B11 TOP B11 mim_unit
XXN_r09_c47_B11 TOP B11 mim_unit
XXN_r30_c38_B8 TOP B8 mim_unit
XXN_r13_c20_B11 TOP B11 mim_unit
XXN_r16_c51_B11 TOP B11 mim_unit
XXN_r46_c21_B10 TOP B10 mim_unit
XXN_r36_c21_B8 TOP B8 mim_unit
XXN_r26_c29_B9 TOP B9 mim_unit
XXN_r43_c57_B10 TOP B10 mim_unit
XXN_r39_c55_B9 TOP B9 mim_unit
XXN_r06_c07_B11 TOP B11 mim_unit
XXN_r09_c38_B11 TOP B11 mim_unit
XXN_r10_c56_B11 TOP B11 mim_unit
XXN_r44_c00_EDGE EDGE_BIAS EDGE_BIAS mim_unit
XXN_r13_c11_B11 TOP B11 mim_unit
XXN_r16_c42_B11 TOP B11 mim_unit
XXN_r18_c10_B10 TOP B10 mim_unit
XXN_r46_c12_B10 TOP B10 mim_unit
XXN_r54_c65_EDGE EDGE_BIAS EDGE_BIAS mim_unit
XXN_r37_c59_B9 TOP B9 mim_unit
XXN_r34_c41_B7 TOP B7 mim_unit
XXN_r09_c29_B11 TOP B11 mim_unit
XXN_r10_c47_B11 TOP B11 mim_unit
XXN_r65_c60_EDGE EDGE_BIAS EDGE_BIAS mim_unit
XXN_r43_c48_B10 TOP B10 mim_unit
XXN_r22_c50_B10 TOP B10 mim_unit
XXN_r13_c02_B11 TOP B11 mim_unit
XXN_r16_c33_B11 TOP B11 mim_unit
XXN_r46_c03_B10 TOP B10 mim_unit
XXN_r32_c61_B6 TOP B6 mim_unit
XXN_r43_c39_B10 TOP B10 mim_unit
XXN_r10_c38_B11 TOP B11 mim_unit
XXN_r36_c16_B8 TOP B8 mim_unit
XXN_r16_c24_B11 TOP B11 mim_unit
XXN_r22_c41_B10 TOP B10 mim_unit
XXN_r10_c29_B11 TOP B11 mim_unit
XXN_r18_c59_B10 TOP B10 mim_unit
XXN_r54_c61_B11 TOP B11 mim_unit
XXN_r51_c30_B11 TOP B11 mim_unit
XXN_r34_c36_B7 TOP B7 mim_unit
XXN_r16_c15_B11 TOP B11 mim_unit
XXN_r22_c32_B10 TOP B10 mim_unit
XXN_r54_c52_B11 TOP B11 mim_unit
XXN_r51_c21_B11 TOP B11 mim_unit
XXN_r16_c06_B11 TOP B11 mim_unit
XXN_r22_c23_B10 TOP B10 mim_unit
XXN_r40_c11_B9 TOP B9 mim_unit
XXN_r32_c56_B6 TOP B6 mim_unit
XXN_r30_c51_B8 TOP B8 mim_unit
XXN_r54_c43_B11 TOP B11 mim_unit
XXN_r51_c12_B11 TOP B11 mim_unit
XXN_r26_c42_B9 TOP B9 mim_unit
XXN_r00_c07_EDGE EDGE_BIAS EDGE_BIAS mim_unit
XXN_r22_c14_B10 TOP B10 mim_unit
XXN_r54_c34_B11 TOP B11 mim_unit
XXN_r51_c03_B11 TOP B11 mim_unit
XXN_r23_c01_B11 TOP B11 mim_unit
XXN_r22_c05_B10 TOP B10 mim_unit
XXN_r57_c56_B11 TOP B11 mim_unit
XXN_r54_c25_B11 TOP B11 mim_unit
XXN_r40_c06_B9 TOP B9 mim_unit
XXN_r28_c33_B9 TOP B9 mim_unit
XXN_r64_c60_B11 TOP B11 mim_unit
XXN_r30_c46_B8 TOP B8 mim_unit
XXN_r02_c61_B11 TOP B11 mim_unit
XXN_r57_c47_B11 TOP B11 mim_unit
XXN_r54_c16_B11 TOP B11 mim_unit
XXN_r26_c37_B9 TOP B9 mim_unit
XXN_r39_c63_B9 TOP B9 mim_unit
XXN_r64_c51_B11 TOP B11 mim_unit
XXN_r61_c20_B11 TOP B11 mim_unit
XXN_r02_c52_B11 TOP B11 mim_unit
XXN_r57_c38_B11 TOP B11 mim_unit
XXN_r54_c07_B11 TOP B11 mim_unit
XXN_r64_c42_B11 TOP B11 mim_unit
XXN_r38_c04_B9 TOP B9 mim_unit
XXN_r61_c11_B11 TOP B11 mim_unit
XXN_r28_c28_B9 TOP B9 mim_unit
XXN_r02_c43_B11 TOP B11 mim_unit
XXN_r57_c29_B11 TOP B11 mim_unit
XXN_r64_c33_B11 TOP B11 mim_unit
XXN_r61_c02_B11 TOP B11 mim_unit
XXN_r36_c24_B8 TOP B8 mim_unit
XXN_r02_c34_B11 TOP B11 mim_unit
XXN_r39_c58_B9 TOP B9 mim_unit
XXN_r08_c20_B11 TOP B11 mim_unit
XXN_r08_c65_EDGE EDGE_BIAS EDGE_BIAS mim_unit
XXN_r64_c24_B11 TOP B11 mim_unit
XXN_r65_c17_EDGE EDGE_BIAS EDGE_BIAS mim_unit
XXN_r34_c44_B7 TOP B7 mim_unit
XXN_r05_c56_B11 TOP B11 mim_unit
XXN_r02_c25_B11 TOP B11 mim_unit
XXN_r08_c11_B11 TOP B11 mim_unit
XXN_r12_c60_B11 TOP B11 mim_unit
XXN_r45_c61_B10 TOP B10 mim_unit
XXN_r42_c30_B10 TOP B10 mim_unit
XXN_r64_c15_B11 TOP B11 mim_unit
XXN_r32_c64_B6 TOP B6 mim_unit
XXN_r05_c47_B11 TOP B11 mim_unit
XXN_r02_c16_B11 TOP B11 mim_unit
XXN_r17_c50_B10 TOP B10 mim_unit
XXN_r45_c52_B10 TOP B10 mim_unit
XXN_r42_c21_B10 TOP B10 mim_unit
XXN_r36_c19_B8 TOP B8 mim_unit
XXN_r33_c01_B6 TOP B6 mim_unit
XXN_r08_c02_B11 TOP B11 mim_unit
XXN_r12_c51_B11 TOP B11 mim_unit
XXN_r26_c50_B9 TOP B9 mim_unit
XXN_r64_c06_B11 TOP B11 mim_unit
XXN_r05_c38_B11 TOP B11 mim_unit
XXN_r02_c07_B11 TOP B11 mim_unit
XXN_r04_c01_B8 TOP B8 mim_unit
XXN_r12_c42_B11 TOP B11 mim_unit
XXN_r17_c41_B10 TOP B10 mim_unit
XXN_r45_c43_B10 TOP B10 mim_unit
XXN_r42_c12_B10 TOP B10 mim_unit
XXN_r34_c39_B7 TOP B7 mim_unit
XXN_r05_c29_B11 TOP B11 mim_unit
XXN_r49_c61_B11 TOP B11 mim_unit
XXN_r45_c34_B10 TOP B10 mim_unit
XXN_r42_c03_B10 TOP B10 mim_unit
XXN_r12_c33_B11 TOP B11 mim_unit
XXN_r14_c01_B10 TOP B10 mim_unit
XXN_r15_c64_B11 TOP B11 mim_unit
XXN_r17_c32_B10 TOP B10 mim_unit
XXN_r40_c14_B9 TOP B9 mim_unit
XXN_r32_c59_B6 TOP B6 mim_unit
XXN_r28_c41_B9 TOP B9 mim_unit
XXN_r49_c52_B11 TOP B11 mim_unit
XXN_r00_c40_EDGE EDGE_BIAS EDGE_BIAS mim_unit
XXN_r30_c54_B8 TOP B8 mim_unit
XXN_r26_c45_B9 TOP B9 mim_unit
XXN_r12_c24_B11 TOP B11 mim_unit
XXN_r15_c55_B11 TOP B11 mim_unit
XXN_r17_c23_B10 TOP B10 mim_unit
XXN_r48_c56_B10 TOP B10 mim_unit
XXN_r45_c25_B10 TOP B10 mim_unit
XXN_r50_c61_B11 TOP B11 mim_unit
XXN_r49_c43_B11 TOP B11 mim_unit
XXN_r13_c00_EDGE EDGE_BIAS EDGE_BIAS mim_unit
XXN_r21_c63_B10 TOP B10 mim_unit
XXN_r48_c47_B10 TOP B10 mim_unit
XXN_r45_c16_B10 TOP B10 mim_unit
XXN_r23_c65_EDGE EDGE_BIAS EDGE_BIAS mim_unit
XXN_r12_c15_B11 TOP B11 mim_unit
XXN_r15_c46_B11 TOP B11 mim_unit
XXN_r17_c14_B10 TOP B10 mim_unit
XXN_r50_c52_B11 TOP B11 mim_unit
XXN_r49_c34_B11 TOP B11 mim_unit
XXN_r38_c12_B9 TOP B9 mim_unit
XXN_r00_c63_EDGE EDGE_BIAS EDGE_BIAS mim_unit
XXN_r18_c01_B11 TOP B11 mim_unit
XXN_r40_c09_B9 TOP B9 mim_unit
XXN_r28_c36_B9 TOP B9 mim_unit
XXN_r12_c06_B11 TOP B11 mim_unit
XXN_r15_c37_B11 TOP B11 mim_unit
XXN_r17_c05_B10 TOP B10 mim_unit
XXN_r21_c54_B10 TOP B10 mim_unit
XXN_r48_c38_B10 TOP B10 mim_unit
XXN_r45_c07_B10 TOP B10 mim_unit
XXN_r30_c49_B8 TOP B8 mim_unit
XXN_r50_c43_B11 TOP B11 mim_unit
XXN_r49_c25_B11 TOP B11 mim_unit
XXN_r36_c32_B8 TOP B8 mim_unit
XXN_r21_c45_B10 TOP B10 mim_unit
XXN_r59_c60_B11 TOP B11 mim_unit
XXN_r48_c29_B10 TOP B10 mim_unit
XXN_r31_c02_B7 TOP B7 mim_unit
XXN_r15_c28_B11 TOP B11 mim_unit
XXN_r50_c34_B11 TOP B11 mim_unit
XXN_r49_c16_B11 TOP B11 mim_unit
XXN_r34_c52_B7 TOP B7 mim_unit
XXN_r15_c19_B11 TOP B11 mim_unit
XXN_r21_c36_B10 TOP B10 mim_unit
XXN_r59_c51_B11 TOP B11 mim_unit
XXN_r56_c20_B11 TOP B11 mim_unit
XXN_r38_c07_B9 TOP B9 mim_unit
XXN_r53_c56_B11 TOP B11 mim_unit
XXN_r50_c25_B11 TOP B11 mim_unit
XXN_r49_c07_B11 TOP B11 mim_unit
XXN_r24_c58_B10 TOP B10 mim_unit
XXN_r60_c60_B11 TOP B11 mim_unit
XXN_r59_c42_B11 TOP B11 mim_unit
XXN_r56_c11_B11 TOP B11 mim_unit
XXN_r21_c27_B10 TOP B10 mim_unit
XXN_r36_c27_B8 TOP B8 mim_unit
XXN_r53_c47_B11 TOP B11 mim_unit
XXN_r50_c16_B11 TOP B11 mim_unit
XXN_r65_c50_EDGE EDGE_BIAS EDGE_BIAS mim_unit
XXN_r24_c49_B10 TOP B10 mim_unit
XXN_r21_c18_B10 TOP B10 mim_unit
XXN_r60_c51_B11 TOP B11 mim_unit
XXN_r59_c33_B11 TOP B11 mim_unit
XXN_r56_c02_B11 TOP B11 mim_unit
XXN_r34_c47_B7 TOP B7 mim_unit
XXN_r53_c38_B11 TOP B11 mim_unit
XXN_r50_c07_B11 TOP B11 mim_unit
XXN_r60_c42_B11 TOP B11 mim_unit
XXN_r59_c24_B11 TOP B11 mim_unit
XXN_r21_c09_B10 TOP B10 mim_unit
XXN_r53_c29_B11 TOP B11 mim_unit
XXN_r40_c22_B9 TOP B9 mim_unit
XXN_r07_c60_B11 TOP B11 mim_unit
XXN_r33_c04_B6 TOP B6 mim_unit
XXN_r30_c62_B8 TOP B8 mim_unit
XXN_r60_c33_B11 TOP B11 mim_unit
XXN_r59_c15_B11 TOP B11 mim_unit
XXN_r26_c53_B9 TOP B9 mim_unit
XXN_r04_c20_B11 TOP B11 mim_unit
XXN_r07_c51_B11 TOP B11 mim_unit
XXN_r63_c55_B11 TOP B11 mim_unit
XXN_r60_c24_B11 TOP B11 mim_unit
XXN_r59_c06_B11 TOP B11 mim_unit
XXN_r01_c56_B11 TOP B11 mim_unit
XXN_r04_c11_B11 TOP B11 mim_unit
XXN_r07_c42_B11 TOP B11 mim_unit
XXN_r41_c61_B10 TOP B10 mim_unit
XXN_r38_c20_B9 TOP B9 mim_unit
XXN_r63_c46_B11 TOP B11 mim_unit
XXN_r60_c15_B11 TOP B11 mim_unit
XXN_r40_c17_B9 TOP B9 mim_unit
XXN_r32_c02_B1 TOP B1 mim_unit
XXN_r28_c44_B9 TOP B9 mim_unit
XXN_r01_c47_B11 TOP B11 mim_unit
XXN_r41_c52_B10 TOP B10 mim_unit
XXN_r30_c57_B8 TOP B8 mim_unit
XXN_r26_c48_B9 TOP B9 mim_unit
XXN_r04_c02_B11 TOP B11 mim_unit
XXN_r07_c33_B11 TOP B11 mim_unit
XXN_r09_c01_B10 TOP B10 mim_unit
XXN_r63_c37_B11 TOP B11 mim_unit
XXN_r60_c06_B11 TOP B11 mim_unit
XXN_r36_c40_B8 TOP B8 mim_unit
XXN_r01_c38_B11 TOP B11 mim_unit
XXN_r38_c00_EDGE EDGE_BIAS EDGE_BIAS mim_unit
XXN_r31_c10_B7 TOP B7 mim_unit
XXN_r48_c65_EDGE EDGE_BIAS EDGE_BIAS mim_unit
XXN_r07_c24_B11 TOP B11 mim_unit
XXN_r41_c43_B10 TOP B10 mim_unit
XXN_r34_c60_B7 TOP B7 mim_unit
XXN_r63_c28_B11 TOP B11 mim_unit
XXN_r01_c29_B11 TOP B11 mim_unit
XXN_r38_c15_B9 TOP B9 mim_unit
XXN_r41_c34_B10 TOP B10 mim_unit
XXN_r28_c39_B9 TOP B9 mim_unit
XXN_r07_c15_B11 TOP B11 mim_unit
XXN_r10_c01_B10 TOP B10 mim_unit
XXN_r11_c64_B11 TOP B11 mim_unit
XXN_r63_c19_B11 TOP B11 mim_unit
XXN_r47_c20_B10 TOP B10 mim_unit
XXN_r36_c35_B8 TOP B8 mim_unit
XXN_r07_c06_B11 TOP B11 mim_unit
XXN_r11_c55_B11 TOP B11 mim_unit
XXN_r44_c56_B10 TOP B10 mim_unit
XXN_r41_c25_B10 TOP B10 mim_unit
XXN_r47_c11_B10 TOP B10 mim_unit
XXN_r31_c05_B7 TOP B7 mim_unit
XXN_r14_c10_B11 TOP B11 mim_unit
XXN_r44_c47_B10 TOP B10 mim_unit
XXN_r41_c16_B10 TOP B10 mim_unit
XXN_r34_c55_B7 TOP B7 mim_unit
XXN_r11_c46_B11 TOP B11 mim_unit
XXN_r47_c02_B10 TOP B10 mim_unit
XXN_r11_c37_B11 TOP B11 mim_unit
XXN_r44_c38_B10 TOP B10 mim_unit
XXN_r40_c30_B9 TOP B9 mim_unit
XXN_r41_c07_B10 TOP B10 mim_unit
XXN_r33_c12_B6 TOP B6 mim_unit
XXN_r23_c40_B10 TOP B10 mim_unit
XXN_r65_c07_EDGE EDGE_BIAS EDGE_BIAS mim_unit
XXN_r26_c61_B9 TOP B9 mim_unit
XXN_r19_c58_B10 TOP B10 mim_unit
XXN_r55_c60_B11 TOP B11 mim_unit
XXN_r44_c29_B10 TOP B10 mim_unit
XXN_r11_c28_B11 TOP B11 mim_unit
XXN_r14_c59_B11 TOP B11 mim_unit
XXN_r53_c00_EDGE EDGE_BIAS EDGE_BIAS mim_unit
XXN_r23_c31_B10 TOP B10 mim_unit
XXN_r54_c64_B10 TOP B10 mim_unit
XXN_r63_c65_EDGE EDGE_BIAS EDGE_BIAS mim_unit
XXN_r25_c02_B9 TOP B9 mim_unit
XXN_r11_c19_B11 TOP B11 mim_unit
XXN_r19_c49_B10 TOP B10 mim_unit
XXN_r55_c51_B11 TOP B11 mim_unit
XXN_r52_c20_B11 TOP B11 mim_unit
XXN_r28_c52_B9 TOP B9 mim_unit
XXN_r23_c22_B10 TOP B10 mim_unit
XXN_r40_c25_B9 TOP B9 mim_unit
XXN_r20_c58_B10 TOP B10 mim_unit
XXN_r55_c42_B11 TOP B11 mim_unit
XXN_r52_c11_B11 TOP B11 mim_unit
XXN_r33_c07_B6 TOP B6 mim_unit
XXN_r26_c56_B9 TOP B9 mim_unit
XXN_r23_c13_B10 TOP B10 mim_unit
XXN_r20_c49_B10 TOP B10 mim_unit
XXN_r55_c33_B11 TOP B11 mim_unit
XXN_r52_c02_B11 TOP B11 mim_unit
XXN_r23_c04_B10 TOP B10 mim_unit
XXN_r00_c30_EDGE EDGE_BIAS EDGE_BIAS mim_unit
XXN_r58_c55_B11 TOP B11 mim_unit
XXN_r55_c24_B11 TOP B11 mim_unit
XXN_r38_c23_B9 TOP B9 mim_unit
XXN_r28_c47_B9 TOP B9 mim_unit
XXN_r03_c60_B11 TOP B11 mim_unit
XXN_r58_c46_B11 TOP B11 mim_unit
XXN_r55_c15_B11 TOP B11 mim_unit
XXN_r36_c43_B8 TOP B8 mim_unit
XXN_r31_c13_B7 TOP B7 mim_unit
XXN_r03_c51_B11 TOP B11 mim_unit
XXN_r00_c53_EDGE EDGE_BIAS EDGE_BIAS mim_unit
XXN_r58_c37_B11 TOP B11 mim_unit
XXN_r55_c06_B11 TOP B11 mim_unit
XXN_r34_c63_B7 TOP B7 mim_unit
XXN_r62_c10_B11 TOP B11 mim_unit
XXN_r38_c18_B9 TOP B9 mim_unit
XXN_r03_c42_B11 TOP B11 mim_unit
XXN_r58_c28_B11 TOP B11 mim_unit
XXN_r06_c64_B11 TOP B11 mim_unit
XXN_r62_c01_B11 TOP B11 mim_unit
XXN_r36_c38_B8 TOP B8 mim_unit
XXN_r33_c20_B6 TOP B6 mim_unit
XXN_r03_c33_B11 TOP B11 mim_unit
XXN_r58_c19_B11 TOP B11 mim_unit
XXN_r33_c61_B2 TOP B2 mim_unit
XXN_r31_c08_B7 TOP B7 mim_unit
XXN_r03_c24_B11 TOP B11 mim_unit
XXN_r06_c55_B11 TOP B11 mim_unit
XXN_r34_c58_B7 TOP B7 mim_unit
XXN_r62_c59_B11 TOP B11 mim_unit
XXN_r46_c60_B10 TOP B10 mim_unit
XXN_r25_c10_B9 TOP B9 mim_unit
XXN_r09_c10_B11 TOP B11 mim_unit
XXN_r28_c60_B9 TOP B9 mim_unit
XXN_r03_c15_B11 TOP B11 mim_unit
XXN_r06_c46_B11 TOP B11 mim_unit
XXN_r65_c40_EDGE EDGE_BIAS EDGE_BIAS mim_unit
XXN_r40_c33_B9 TOP B9 mim_unit
XXN_r13_c50_B11 TOP B11 mim_unit
XXN_r46_c51_B10 TOP B10 mim_unit
XXN_r43_c20_B10 TOP B10 mim_unit
XXN_r33_c15_B6 TOP B6 mim_unit
XXN_r26_c64_B9 TOP B9 mim_unit
XXN_r03_c06_B11 TOP B11 mim_unit
XXN_r06_c37_B11 TOP B11 mim_unit
XXN_r18_c40_B10 TOP B10 mim_unit
XXN_r46_c42_B10 TOP B10 mim_unit
XXN_r43_c11_B10 TOP B10 mim_unit
XXN_r07_c00_EDGE EDGE_BIAS EDGE_BIAS mim_unit
XXN_r10_c10_B11 TOP B11 mim_unit
XXN_r13_c41_B11 TOP B11 mim_unit
XXN_r09_c59_B11 TOP B11 mim_unit
XXN_r17_c65_EDGE EDGE_BIAS EDGE_BIAS mim_unit
XXN_r65_c63_EDGE EDGE_BIAS EDGE_BIAS mim_unit
XXN_r06_c28_B11 TOP B11 mim_unit
XXN_r25_c05_B9 TOP B9 mim_unit
XXN_r13_c32_B11 TOP B11 mim_unit
XXN_r16_c63_B11 TOP B11 mim_unit
XXN_r18_c31_B10 TOP B10 mim_unit
XXN_r49_c64_B10 TOP B10 mim_unit
XXN_r46_c33_B10 TOP B10 mim_unit
XXN_r43_c02_B10 TOP B10 mim_unit
XXN_r38_c31_B9 TOP B9 mim_unit
XXN_r40_c28_B9 TOP B9 mim_unit
XXN_r28_c55_B9 TOP B9 mim_unit
XXN_r06_c19_B11 TOP B11 mim_unit
XXN_r18_c22_B10 TOP B10 mim_unit
XXN_r46_c24_B10 TOP B10 mim_unit
XXN_r26_c59_B9 TOP B9 mim_unit
XXN_r13_c23_B11 TOP B11 mim_unit
XXN_r16_c54_B11 TOP B11 mim_unit
XXN_r36_c51_B8 TOP B8 mim_unit
XXN_r10_c59_B11 TOP B11 mim_unit
XXN_r51_c60_B11 TOP B11 mim_unit
XXN_r31_c21_B7 TOP B7 mim_unit
XXN_r22_c62_B10 TOP B10 mim_unit
XXN_r13_c14_B11 TOP B11 mim_unit
XXN_r16_c45_B11 TOP B11 mim_unit
XXN_r18_c13_B10 TOP B10 mim_unit
XXN_r50_c64_B10 TOP B10 mim_unit
XXN_r46_c15_B10 TOP B10 mim_unit
XXN_r51_c51_B11 TOP B11 mim_unit
XXN_r38_c26_B9 TOP B9 mim_unit
XXN_r22_c53_B10 TOP B10 mim_unit
XXN_r46_c06_B10 TOP B10 mim_unit
XXN_r13_c05_B11 TOP B11 mim_unit
XXN_r16_c36_B11 TOP B11 mim_unit
XXN_r18_c04_B10 TOP B10 mim_unit
XXN_r51_c42_B11 TOP B11 mim_unit
XXN_r29_c03_B8 TOP B8 mim_unit
XXN_r36_c46_B8 TOP B8 mim_unit
XXN_r22_c44_B10 TOP B10 mim_unit
XXN_r16_c27_B11 TOP B11 mim_unit
XXN_r31_c16_B7 TOP B7 mim_unit
XXN_r51_c33_B11 TOP B11 mim_unit
XXN_r22_c00_EDGE EDGE_BIAS EDGE_BIAS mim_unit
XXN_r22_c35_B10 TOP B10 mim_unit
XXN_r32_c65_EDGE EDGE_BIAS EDGE_BIAS mim_unit
XXN_r16_c18_B11 TOP B11 mim_unit
XXN_r54_c55_B11 TOP B11 mim_unit
XXN_r51_c24_B11 TOP B11 mim_unit
XXN_r16_c09_B11 TOP B11 mim_unit
XXN_r22_c26_B10 TOP B10 mim_unit
XXN_r57_c10_B11 TOP B11 mim_unit
XXN_r40_c41_B9 TOP B9 mim_unit
XXN_r33_c23_B6 TOP B6 mim_unit
XXN_r54_c46_B11 TOP B11 mim_unit
XXN_r51_c15_B11 TOP B11 mim_unit
XXN_r22_c17_B10 TOP B10 mim_unit
XXN_r61_c50_B11 TOP B11 mim_unit
XXN_r57_c01_B11 TOP B11 mim_unit
XXN_r54_c37_B11 TOP B11 mim_unit
XXN_r51_c06_B11 TOP B11 mim_unit
XXN_r25_c13_B9 TOP B9 mim_unit
XXN_r22_c08_B10 TOP B10 mim_unit
XXN_r61_c41_B11 TOP B11 mim_unit
XXN_r28_c63_B9 TOP B9 mim_unit
XXN_r57_c59_B11 TOP B11 mim_unit
XXN_r54_c28_B11 TOP B11 mim_unit
XXN_r40_c36_B9 TOP B9 mim_unit
XXN_r64_c63_B11 TOP B11 mim_unit
XXN_r61_c32_B11 TOP B11 mim_unit
XXN_r33_c18_B6 TOP B6 mim_unit
XXN_r02_c64_B11 TOP B11 mim_unit
XXN_r33_c34_B5 TOP B5 mim_unit
XXN_r54_c19_B11 TOP B11 mim_unit
XXN_r33_c50_B4 TOP B4 mim_unit
XXN_r08_c50_B11 TOP B11 mim_unit
XXN_r27_c04_B9 TOP B9 mim_unit
XXN_r64_c54_B11 TOP B11 mim_unit
XXN_r61_c23_B11 TOP B11 mim_unit
XXN_r02_c55_B11 TOP B11 mim_unit
XXN_r42_c60_B10 TOP B10 mim_unit
XXN_r25_c08_B9 TOP B9 mim_unit
XXN_r05_c10_B11 TOP B11 mim_unit
XXN_r08_c41_B11 TOP B11 mim_unit
XXN_r64_c45_B11 TOP B11 mim_unit
XXN_r61_c14_B11 TOP B11 mim_unit
XXN_r38_c34_B9 TOP B9 mim_unit
XXN_r02_c46_B11 TOP B11 mim_unit
XXN_r28_c58_B9 TOP B9 mim_unit
XXN_r08_c32_B11 TOP B11 mim_unit
XXN_r42_c51_B10 TOP B10 mim_unit
XXN_r29_c11_B8 TOP B8 mim_unit
XXN_r64_c36_B11 TOP B11 mim_unit
XXN_r61_c05_B11 TOP B11 mim_unit
XXN_r36_c54_B8 TOP B8 mim_unit
XXN_r02_c37_B11 TOP B11 mim_unit
XXN_r31_c24_B7 TOP B7 mim_unit
XXN_r00_c20_EDGE EDGE_BIAS EDGE_BIAS mim_unit
XXN_r42_c42_B10 TOP B10 mim_unit
XXN_r08_c23_B11 TOP B11 mim_unit
XXN_r64_c27_B11 TOP B11 mim_unit
XXN_r05_c59_B11 TOP B11 mim_unit
XXN_r02_c28_B11 TOP B11 mim_unit
XXN_r38_c29_B9 TOP B9 mim_unit
XXN_r08_c14_B11 TOP B11 mim_unit
XXN_r12_c63_B11 TOP B11 mim_unit
XXN_r17_c62_B10 TOP B10 mim_unit
XXN_r42_c33_B10 TOP B10 mim_unit
XXN_r64_c18_B11 TOP B11 mim_unit
XXN_r02_c19_B11 TOP B11 mim_unit
XXN_r00_c43_EDGE EDGE_BIAS EDGE_BIAS mim_unit
XXN_r17_c53_B10 TOP B10 mim_unit
XXN_r45_c55_B10 TOP B10 mim_unit
XXN_r42_c24_B10 TOP B10 mim_unit
XXN_r36_c49_B8 TOP B8 mim_unit
XXN_r33_c31_B6 TOP B6 mim_unit
XXN_r29_c06_B8 TOP B8 mim_unit
XXN_r08_c05_B11 TOP B11 mim_unit
XXN_r12_c54_B11 TOP B11 mim_unit
XXN_r64_c09_B11 TOP B11 mim_unit
XXN_r48_c10_B10 TOP B10 mim_unit
XXN_r47_c00_EDGE EDGE_BIAS EDGE_BIAS mim_unit
XXN_r31_c19_B7 TOP B7 mim_unit
XXN_r57_c65_EDGE EDGE_BIAS EDGE_BIAS mim_unit
XXN_r12_c45_B11 TOP B11 mim_unit
XXN_r17_c44_B10 TOP B10 mim_unit
XXN_r45_c46_B10 TOP B10 mim_unit
XXN_r42_c15_B10 TOP B10 mim_unit
XXN_r48_c01_B10 TOP B10 mim_unit
XXN_r25_c21_B9 TOP B9 mim_unit
XXN_r17_c35_B10 TOP B10 mim_unit
XXN_r45_c37_B10 TOP B10 mim_unit
XXN_r42_c06_B10 TOP B10 mim_unit
XXN_r12_c36_B11 TOP B11 mim_unit
XXN_r40_c44_B9 TOP B9 mim_unit
XXN_r49_c55_B11 TOP B11 mim_unit
XXN_r33_c26_B6 TOP B6 mim_unit
XXN_r33_c42_B5 TOP B5 mim_unit
XXN_r12_c27_B11 TOP B11 mim_unit
XXN_r15_c58_B11 TOP B11 mim_unit
XXN_r17_c26_B10 TOP B10 mim_unit
XXN_r48_c59_B10 TOP B10 mim_unit
XXN_r45_c28_B10 TOP B10 mim_unit
XXN_r24_c30_B10 TOP B10 mim_unit
XXN_r27_c12_B9 TOP B9 mim_unit
XXN_r49_c46_B11 TOP B11 mim_unit
XXN_r15_c49_B11 TOP B11 mim_unit
XXN_r17_c17_B10 TOP B10 mim_unit
XXN_r65_c30_EDGE EDGE_BIAS EDGE_BIAS mim_unit
XXN_r56_c50_B11 TOP B11 mim_unit
XXN_r45_c19_B10 TOP B10 mim_unit
XXN_r12_c18_B11 TOP B11 mim_unit
XXN_r24_c21_B10 TOP B10 mim_unit
XXN_r25_c16_B9 TOP B9 mim_unit
XXN_r50_c55_B11 TOP B11 mim_unit
XXN_r49_c37_B11 TOP B11 mim_unit
XXN_r38_c42_B9 TOP B9 mim_unit
XXN_r40_c39_B9 TOP B9 mim_unit
XXN_r12_c09_B11 TOP B11 mim_unit
XXN_r17_c08_B10 TOP B10 mim_unit
XXN_r21_c57_B10 TOP B10 mim_unit
XXN_r56_c41_B11 TOP B11 mim_unit
XXN_r53_c10_B11 TOP B11 mim_unit
XXN_r33_c37_B5 TOP B5 mim_unit
XXN_r24_c12_B10 TOP B10 mim_unit
XXN_r65_c53_EDGE EDGE_BIAS EDGE_BIAS mim_unit
XXN_r50_c46_B11 TOP B11 mim_unit
XXN_r49_c28_B11 TOP B11 mim_unit
XXN_r36_c62_B8 TOP B8 mim_unit
XXN_r33_c53_B4 TOP B4 mim_unit
XXN_r21_c48_B10 TOP B10 mim_unit
XXN_r59_c63_B11 TOP B11 mim_unit
XXN_r56_c32_B11 TOP B11 mim_unit
XXN_r53_c01_B11 TOP B11 mim_unit
XXN_r31_c32_B7 TOP B7 mim_unit
XXN_r27_c07_B9 TOP B9 mim_unit
XXN_r24_c03_B10 TOP B10 mim_unit
XXN_r62_c00_EDGE EDGE_BIAS EDGE_BIAS mim_unit
XXN_r50_c37_B11 TOP B11 mim_unit
XXN_r49_c19_B11 TOP B11 mim_unit
XXN_r35_c03_B8 TOP B8 mim_unit
XXN_r01_c65_EDGE EDGE_BIAS EDGE_BIAS mim_unit
XXN_r21_c39_B10 TOP B10 mim_unit
XXN_r59_c54_B11 TOP B11 mim_unit
XXN_r56_c23_B11 TOP B11 mim_unit
XXN_r38_c37_B9 TOP B9 mim_unit
XXN_r53_c59_B11 TOP B11 mim_unit
XXN_r50_c28_B11 TOP B11 mim_unit
XXN_r60_c63_B11 TOP B11 mim_unit
XXN_r59_c45_B11 TOP B11 mim_unit
XXN_r56_c14_B11 TOP B11 mim_unit
XXN_r29_c14_B8 TOP B8 mim_unit
XXN_r36_c57_B8 TOP B8 mim_unit
XXN_r50_c19_B11 TOP B11 mim_unit
XXN_r04_c50_B11 TOP B11 mim_unit
XXN_r31_c27_B7 TOP B7 mim_unit
XXN_r60_c54_B11 TOP B11 mim_unit
XXN_r59_c36_B11 TOP B11 mim_unit
XXN_r56_c05_B11 TOP B11 mim_unit
XXN_r04_c41_B11 TOP B11 mim_unit
XXN_r01_c10_B11 TOP B11 mim_unit
XXN_r60_c45_B11 TOP B11 mim_unit
XXN_r59_c27_B11 TOP B11 mim_unit
XXN_r32_c05_B3 TOP B3 mim_unit
XXN_r40_c52_B9 TOP B9 mim_unit
XXN_r04_c32_B11 TOP B11 mim_unit
XXN_r07_c63_B11 TOP B11 mim_unit
XXN_r29_c09_B8 TOP B8 mim_unit
XXN_r60_c36_B11 TOP B11 mim_unit
XXN_r59_c18_B11 TOP B11 mim_unit
XXN_r33_c59_B3 TOP B3 mim_unit
XXN_r07_c54_B11 TOP B11 mim_unit
XXN_r27_c20_B9 TOP B9 mim_unit
XXN_r04_c23_B11 TOP B11 mim_unit
XXN_r63_c58_B11 TOP B11 mim_unit
XXN_r60_c27_B11 TOP B11 mim_unit
XXN_r59_c09_B11 TOP B11 mim_unit
XXN_r01_c59_B11 TOP B11 mim_unit
XXN_r25_c24_B9 TOP B9 mim_unit
XXN_r04_c14_B11 TOP B11 mim_unit
XXN_r07_c45_B11 TOP B11 mim_unit
XXN_r38_c50_B9 TOP B9 mim_unit
XXN_r63_c49_B11 TOP B11 mim_unit
XXN_r60_c18_B11 TOP B11 mim_unit
XXN_r47_c50_B10 TOP B10 mim_unit
XXN_r40_c47_B9 TOP B9 mim_unit
XXN_r33_c29_B6 TOP B6 mim_unit
XXN_r07_c36_B11 TOP B11 mim_unit
XXN_r41_c55_B10 TOP B10 mim_unit
XXN_r33_c45_B5 TOP B5 mim_unit
XXN_r04_c05_B11 TOP B11 mim_unit
XXN_r60_c09_B11 TOP B11 mim_unit
XXN_r14_c40_B11 TOP B11 mim_unit
XXN_r47_c41_B10 TOP B10 mim_unit
XXN_r44_c10_B10 TOP B10 mim_unit
XXN_r31_c40_B7 TOP B7 mim_unit
XXN_r27_c15_B9 TOP B9 mim_unit
XXN_r07_c27_B11 TOP B11 mim_unit
XXN_r41_c46_B10 TOP B10 mim_unit
XXN_r19_c30_B10 TOP B10 mim_unit
XXN_r47_c32_B10 TOP B10 mim_unit
XXN_r45_c64_B11 TOP B11 mim_unit
XXN_r44_c01_B10 TOP B10 mim_unit
XXN_r35_c11_B8 TOP B8 mim_unit
XXN_r25_c19_B9 TOP B9 mim_unit
XXN_r14_c31_B11 TOP B11 mim_unit
XXN_r38_c45_B9 TOP B9 mim_unit
XXN_r07_c18_B11 TOP B11 mim_unit
XXN_r41_c37_B10 TOP B10 mim_unit
XXN_r14_c22_B11 TOP B11 mim_unit
XXN_r19_c21_B10 TOP B10 mim_unit
XXN_r47_c23_B10 TOP B10 mim_unit
XXN_r29_c22_B8 TOP B8 mim_unit
XXN_r44_c59_B10 TOP B10 mim_unit
XXN_r33_c56_B4 TOP B4 mim_unit
XXN_r07_c09_B11 TOP B11 mim_unit
XXN_r11_c58_B11 TOP B11 mim_unit
XXN_r41_c28_B10 TOP B10 mim_unit
XXN_r31_c35_B7 TOP B7 mim_unit
XXN_r23_c61_B10 TOP B10 mim_unit
XXN_r19_c12_B10 TOP B10 mim_unit
XXN_r20_c30_B10 TOP B10 mim_unit
XXN_r61_c64_B8 TOP B8 mim_unit
XXN_r47_c14_B10 TOP B10 mim_unit
XXN_r14_c13_B11 TOP B11 mim_unit
XXN_r16_c00_EDGE EDGE_BIAS EDGE_BIAS mim_unit
XXN_r26_c65_EDGE EDGE_BIAS EDGE_BIAS mim_unit
XXN_r11_c49_B11 TOP B11 mim_unit
XXN_r52_c50_B11 TOP B11 mim_unit
XXN_r41_c19_B10 TOP B10 mim_unit
XXN_r35_c06_B8 TOP B8 mim_unit
XXN_r23_c52_B10 TOP B10 mim_unit
XXN_r14_c04_B11 TOP B11 mim_unit
XXN_r19_c03_B10 TOP B10 mim_unit
XXN_r20_c21_B10 TOP B10 mim_unit
XXN_r47_c05_B10 TOP B10 mim_unit
XXN_r40_c60_B9 TOP B9 mim_unit
XXN_r00_c10_EDGE EDGE_BIAS EDGE_BIAS mim_unit
XXN_r52_c41_B11 TOP B11 mim_unit
XXN_r23_c43_B10 TOP B10 mim_unit
XXN_r20_c12_B10 TOP B10 mim_unit
XXN_r29_c17_B8 TOP B8 mim_unit
XXN_r55_c63_B11 TOP B11 mim_unit
XXN_r52_c32_B11 TOP B11 mim_unit
XXN_r20_c03_B10 TOP B10 mim_unit
XXN_r23_c34_B10 TOP B10 mim_unit
XXN_r25_c32_B9 TOP B9 mim_unit
XXN_r00_c33_EDGE EDGE_BIAS EDGE_BIAS mim_unit
XXN_r55_c54_B11 TOP B11 mim_unit
XXN_r52_c23_B11 TOP B11 mim_unit
XXN_r32_c08_B3 TOP B3 mim_unit
XXN_r23_c25_B10 TOP B10 mim_unit
XXN_r40_c55_B9 TOP B9 mim_unit
XXN_r55_c45_B11 TOP B11 mim_unit
XXN_r52_c14_B11 TOP B11 mim_unit
XXN_r23_c16_B10 TOP B10 mim_unit
XXN_r00_c56_EDGE EDGE_BIAS EDGE_BIAS mim_unit
XXN_r27_c23_B9 TOP B9 mim_unit
XXN_r55_c36_B11 TOP B11 mim_unit
XXN_r52_c05_B11 TOP B11 mim_unit
XXN_r31_c00_EDGE EDGE_BIAS EDGE_BIAS mim_unit
XXN_r23_c07_B10 TOP B10 mim_unit
XXN_r62_c40_B11 TOP B11 mim_unit
XXN_r41_c65_EDGE EDGE_BIAS EDGE_BIAS mim_unit
XXN_r32_c10_B4 TOP B4 mim_unit
XXN_r25_c27_B9 TOP B9 mim_unit
XXN_r58_c58_B11 TOP B11 mim_unit
XXN_r55_c27_B11 TOP B11 mim_unit
XXN_r38_c53_B9 TOP B9 mim_unit
XXN_r62_c31_B11 TOP B11 mim_unit
XXN_r03_c63_B11 TOP B11 mim_unit
XXN_r65_c20_EDGE EDGE_BIAS EDGE_BIAS mim_unit
XXN_r33_c48_B5 TOP B5 mim_unit
XXN_r29_c30_B8 TOP B8 mim_unit
XXN_r58_c49_B11 TOP B11 mim_unit
XXN_r55_c18_B11 TOP B11 mim_unit
XXN_r62_c22_B11 TOP B11 mim_unit
XXN_r31_c43_B7 TOP B7 mim_unit
XXN_r27_c18_B9 TOP B9 mim_unit
XXN_r03_c54_B11 TOP B11 mim_unit
XXN_r55_c09_B11 TOP B11 mim_unit
XXN_r09_c40_B11 TOP B11 mim_unit
XXN_r35_c14_B8 TOP B8 mim_unit
XXN_r62_c13_B11 TOP B11 mim_unit
XXN_r38_c48_B9 TOP B9 mim_unit
XXN_r03_c45_B11 TOP B11 mim_unit
XXN_r65_c43_EDGE EDGE_BIAS EDGE_BIAS mim_unit
XXN_r43_c50_B10 TOP B10 mim_unit
XXN_r09_c31_B11 TOP B11 mim_unit
XXN_r62_c04_B11 TOP B11 mim_unit
XXN_r29_c25_B8 TOP B8 mim_unit
XXN_r03_c36_B11 TOP B11 mim_unit
XXN_r09_c22_B11 TOP B11 mim_unit
XXN_r10_c40_B11 TOP B11 mim_unit
XXN_r43_c41_B10 TOP B10 mim_unit
XXN_r31_c38_B7 TOP B7 mim_unit
XXN_r03_c27_B11 TOP B11 mim_unit
XXN_r06_c58_B11 TOP B11 mim_unit
XXN_r35_c09_B8 TOP B8 mim_unit
XXN_r13_c62_B11 TOP B11 mim_unit
XXN_r18_c61_B10 TOP B10 mim_unit
XXN_r46_c63_B10 TOP B10 mim_unit
XXN_r43_c32_B10 TOP B10 mim_unit
XXN_r41_c64_B11 TOP B11 mim_unit
XXN_r25_c40_B9 TOP B9 mim_unit
XXN_r09_c13_B11 TOP B11 mim_unit
XXN_r10_c31_B11 TOP B11 mim_unit
XXN_r03_c18_B11 TOP B11 mim_unit
XXN_r06_c49_B11 TOP B11 mim_unit
XXN_r40_c63_B9 TOP B9 mim_unit
XXN_r09_c04_B11 TOP B11 mim_unit
XXN_r10_c22_B11 TOP B11 mim_unit
XXN_r13_c53_B11 TOP B11 mim_unit
XXN_r18_c52_B10 TOP B10 mim_unit
XXN_r46_c54_B10 TOP B10 mim_unit
XXN_r43_c23_B10 TOP B10 mim_unit
XXN_r03_c09_B11 TOP B11 mim_unit
XXN_r13_c44_B11 TOP B11 mim_unit
XXN_r18_c43_B10 TOP B10 mim_unit
XXN_r46_c45_B10 TOP B10 mim_unit
XXN_r43_c14_B10 TOP B10 mim_unit
XXN_r27_c31_B9 TOP B9 mim_unit
XXN_r10_c13_B11 TOP B11 mim_unit
XXN_r25_c35_B9 TOP B9 mim_unit
XXN_r10_c04_B11 TOP B11 mim_unit
XXN_r13_c35_B11 TOP B11 mim_unit
XXN_r18_c34_B10 TOP B10 mim_unit
XXN_r46_c36_B10 TOP B10 mim_unit
XXN_r43_c05_B10 TOP B10 mim_unit
XXN_r38_c61_B9 TOP B9 mim_unit
XXN_r40_c58_B9 TOP B9 mim_unit
XXN_r16_c57_B11 TOP B11 mim_unit
XXN_r18_c25_B10 TOP B10 mim_unit
XXN_r46_c27_B10 TOP B10 mim_unit
XXN_r13_c26_B11 TOP B11 mim_unit
XXN_r37_c02_B9 TOP B9 mim_unit
XXN_r56_c00_EDGE EDGE_BIAS EDGE_BIAS mim_unit
XXN_r51_c63_B11 TOP B11 mim_unit
XXN_r31_c51_B7 TOP B7 mim_unit
XXN_r27_c26_B9 TOP B9 mim_unit
XXN_r13_c17_B11 TOP B11 mim_unit
XXN_r16_c48_B11 TOP B11 mim_unit
XXN_r18_c16_B10 TOP B10 mim_unit
XXN_r46_c18_B10 TOP B10 mim_unit
XXN_r51_c54_B11 TOP B11 mim_unit
XXN_r35_c22_B8 TOP B8 mim_unit
XXN_r32_c13_B4 TOP B4 mim_unit
XXN_r38_c56_B9 TOP B9 mim_unit
XXN_r22_c56_B10 TOP B10 mim_unit
XXN_r16_c39_B11 TOP B11 mim_unit
XXN_r18_c07_B10 TOP B10 mim_unit
XXN_r57_c40_B11 TOP B11 mim_unit
XXN_r46_c09_B10 TOP B10 mim_unit
XXN_r13_c08_B11 TOP B11 mim_unit
XXN_r51_c45_B11 TOP B11 mim_unit
XXN_r29_c33_B8 TOP B8 mim_unit
XXN_r22_c47_B10 TOP B10 mim_unit
XXN_r57_c31_B11 TOP B11 mim_unit
XXN_r31_c46_B7 TOP B7 mim_unit
XXN_r51_c36_B11 TOP B11 mim_unit
XXN_r22_c38_B10 TOP B10 mim_unit
XXN_r57_c22_B11 TOP B11 mim_unit
XXN_r35_c17_B8 TOP B8 mim_unit
XXN_r54_c58_B11 TOP B11 mim_unit
XXN_r51_c27_B11 TOP B11 mim_unit
XXN_r22_c29_B10 TOP B10 mim_unit
XXN_r61_c62_B11 TOP B11 mim_unit
XXN_r57_c13_B11 TOP B11 mim_unit
XXN_r54_c49_B11 TOP B11 mim_unit
XXN_r29_c28_B8 TOP B8 mim_unit
XXN_r51_c18_B11 TOP B11 mim_unit
XXN_r61_c53_B11 TOP B11 mim_unit
XXN_r57_c04_B11 TOP B11 mim_unit
XXN_r51_c09_B11 TOP B11 mim_unit
XXN_r05_c40_B11 TOP B11 mim_unit
XXN_r00_c00_EDGE EDGE_BIAS EDGE_BIAS mim_unit
XXN_r25_c43_B9 TOP B9 mim_unit
XXN_r10_c65_EDGE EDGE_BIAS EDGE_BIAS mim_unit
XXN_r61_c44_B11 TOP B11 mim_unit
XXN_r05_c31_B11 TOP B11 mim_unit
XXN_r08_c62_B11 TOP B11 mim_unit
XXN_r36_c64_B11 TOP B11 mim_unit
XXN_r61_c35_B11 TOP B11 mim_unit
XXN_r00_c23_EDGE EDGE_BIAS EDGE_BIAS mim_unit
XXN_r37_c10_B9 TOP B9 mim_unit
XXN_r05_c22_B11 TOP B11 mim_unit
XXN_r08_c53_B11 TOP B11 mim_unit
XXN_r27_c34_B9 TOP B9 mim_unit
XXN_r64_c57_B11 TOP B11 mim_unit
XXN_r61_c26_B11 TOP B11 mim_unit
XXN_r02_c58_B11 TOP B11 mim_unit
XXN_r05_c13_B11 TOP B11 mim_unit
XXN_r08_c44_B11 TOP B11 mim_unit
XXN_r42_c63_B10 TOP B10 mim_unit
XXN_r35_c30_B8 TOP B8 mim_unit
XXN_r25_c38_B9 TOP B9 mim_unit
XXN_r64_c48_B11 TOP B11 mim_unit
XXN_r61_c17_B11 TOP B11 mim_unit
XXN_r02_c49_B11 TOP B11 mim_unit
XXN_r00_c46_EDGE EDGE_BIAS EDGE_BIAS mim_unit
XXN_r42_c54_B10 TOP B10 mim_unit
XXN_r39_c01_B9 TOP B9 mim_unit
XXN_r05_c04_B11 TOP B11 mim_unit
XXN_r08_c35_B11 TOP B11 mim_unit
XXN_r29_c41_B8 TOP B8 mim_unit
XXN_r64_c39_B11 TOP B11 mim_unit
XXN_r61_c08_B11 TOP B11 mim_unit
XXN_r48_c40_B10 TOP B10 mim_unit
XXN_r37_c05_B9 TOP B9 mim_unit
XXN_r31_c54_B7 TOP B7 mim_unit
XXN_r27_c29_B9 TOP B9 mim_unit
XXN_r08_c26_B11 TOP B11 mim_unit
XXN_r42_c45_B10 TOP B10 mim_unit
XXN_r15_c30_B11 TOP B11 mim_unit
XXN_r48_c31_B10 TOP B10 mim_unit
XXN_r35_c25_B8 TOP B8 mim_unit
XXN_r65_c10_EDGE EDGE_BIAS EDGE_BIAS mim_unit
XXN_r42_c36_B10 TOP B10 mim_unit
XXN_r38_c59_B9 TOP B9 mim_unit
XXN_r32_c16_B4 TOP B4 mim_unit
XXN_r08_c17_B11 TOP B11 mim_unit
XXN_r48_c22_B10 TOP B10 mim_unit
XXN_r15_c21_B11 TOP B11 mim_unit
XXN_r29_c36_B8 TOP B8 mim_unit
XXN_r08_c08_B11 TOP B11 mim_unit
XXN_r12_c57_B11 TOP B11 mim_unit
XXN_r17_c56_B10 TOP B10 mim_unit
XXN_r45_c58_B10 TOP B10 mim_unit
XXN_r42_c27_B10 TOP B10 mim_unit
XXN_r24_c60_B10 TOP B10 mim_unit
XXN_r15_c12_B11 TOP B11 mim_unit
XXN_r48_c13_B10 TOP B10 mim_unit
XXN_r31_c49_B7 TOP B7 mim_unit
XXN_r65_c33_EDGE EDGE_BIAS EDGE_BIAS mim_unit
XXN_r45_c49_B10 TOP B10 mim_unit
XXN_r12_c48_B11 TOP B11 mim_unit
XXN_r17_c47_B10 TOP B10 mim_unit
XXN_r42_c18_B10 TOP B10 mim_unit
XXN_r24_c51_B10 TOP B10 mim_unit
XXN_r21_c20_B10 TOP B10 mim_unit
XXN_r48_c04_B10 TOP B10 mim_unit
XXN_r25_c51_B9 TOP B9 mim_unit
XXN_r15_c03_B11 TOP B11 mim_unit
XXN_r12_c39_B11 TOP B11 mim_unit
XXN_r17_c38_B10 TOP B10 mim_unit
XXN_r53_c40_B11 TOP B11 mim_unit
XXN_r42_c09_B10 TOP B10 mim_unit
XXN_r24_c42_B10 TOP B10 mim_unit
XXN_r21_c11_B10 TOP B10 mim_unit
XXN_r65_c56_EDGE EDGE_BIAS EDGE_BIAS mim_unit
XXN_r49_c58_B11 TOP B11 mim_unit
XXN_r56_c62_B11 TOP B11 mim_unit
XXN_r17_c29_B10 TOP B10 mim_unit
XXN_r53_c31_B11 TOP B11 mim_unit
XXN_r24_c33_B10 TOP B10 mim_unit
XXN_r21_c02_B10 TOP B10 mim_unit
XXN_r49_c49_B11 TOP B11 mim_unit
XXN_r27_c42_B9 TOP B9 mim_unit
XXN_r25_c00_EDGE EDGE_BIAS EDGE_BIAS mim_unit
XXN_r35_c65_EDGE EDGE_BIAS EDGE_BIAS mim_unit
XXN_r56_c53_B11 TOP B11 mim_unit
XXN_r53_c22_B11 TOP B11 mim_unit
XXN_r25_c46_B9 TOP B9 mim_unit
XXN_r24_c24_B10 TOP B10 mim_unit
XXN_r50_c58_B11 TOP B11 mim_unit
XXN_r56_c44_B11 TOP B11 mim_unit
XXN_r53_c13_B11 TOP B11 mim_unit
XXN_r24_c15_B10 TOP B10 mim_unit
XXN_r50_c49_B11 TOP B11 mim_unit
XXN_r37_c13_B9 TOP B9 mim_unit
XXN_r56_c35_B11 TOP B11 mim_unit
XXN_r53_c04_B11 TOP B11 mim_unit
XXN_r31_c62_B7 TOP B7 mim_unit
XXN_r27_c37_B9 TOP B9 mim_unit
XXN_r24_c06_B10 TOP B10 mim_unit
XXN_r01_c40_B11 TOP B11 mim_unit
XXN_r59_c57_B11 TOP B11 mim_unit
XXN_r35_c33_B8 TOP B8 mim_unit
XXN_r56_c26_B11 TOP B11 mim_unit
XXN_r63_c30_B11 TOP B11 mim_unit
XXN_r01_c31_B11 TOP B11 mim_unit
XXN_r04_c62_B11 TOP B11 mim_unit
XXN_r39_c04_B9 TOP B9 mim_unit
XXN_r59_c48_B11 TOP B11 mim_unit
XXN_r56_c17_B11 TOP B11 mim_unit
XXN_r29_c44_B8 TOP B8 mim_unit
XXN_r37_c08_B9 TOP B9 mim_unit
XXN_r63_c21_B11 TOP B11 mim_unit
XXN_r31_c57_B7 TOP B7 mim_unit
XXN_r04_c53_B11 TOP B11 mim_unit
XXN_r01_c22_B11 TOP B11 mim_unit
XXN_r60_c57_B11 TOP B11 mim_unit
XXN_r59_c39_B11 TOP B11 mim_unit
XXN_r56_c08_B11 TOP B11 mim_unit
XXN_r40_c00_EDGE EDGE_BIAS EDGE_BIAS mim_unit
XXN_r63_c12_B11 TOP B11 mim_unit
XXN_r35_c28_B8 TOP B8 mim_unit
XXN_r04_c44_B11 TOP B11 mim_unit
XXN_r01_c13_B11 TOP B11 mim_unit
XXN_r50_c65_EDGE EDGE_BIAS EDGE_BIAS mim_unit
XXN_r60_c48_B11 TOP B11 mim_unit
XXN_r63_c03_B11 TOP B11 mim_unit
XXN_r04_c35_B11 TOP B11 mim_unit
XXN_r01_c04_B11 TOP B11 mim_unit
XXN_r60_c39_B11 TOP B11 mim_unit
XXN_r29_c39_B8 TOP B8 mim_unit
XXN_r44_c40_B10 TOP B10 mim_unit
XXN_r27_c50_B9 TOP B9 mim_unit
XXN_r04_c26_B11 TOP B11 mim_unit
XXN_r07_c57_B11 TOP B11 mim_unit
XXN_r47_c62_B10 TOP B10 mim_unit
XXN_r11_c30_B11 TOP B11 mim_unit
XXN_r14_c61_B11 TOP B11 mim_unit
XXN_r19_c60_B10 TOP B10 mim_unit
XXN_r44_c31_B10 TOP B10 mim_unit
XXN_r32_c21_B5 TOP B5 mim_unit
XXN_r25_c54_B9 TOP B9 mim_unit
XXN_r04_c17_B11 TOP B11 mim_unit
XXN_r07_c48_B11 TOP B11 mim_unit
XXN_r11_c21_B11 TOP B11 mim_unit
XXN_r14_c52_B11 TOP B11 mim_unit
XXN_r19_c51_B10 TOP B10 mim_unit
XXN_r47_c53_B10 TOP B10 mim_unit
XXN_r44_c22_B10 TOP B10 mim_unit
XXN_r04_c08_B11 TOP B11 mim_unit
XXN_r07_c39_B11 TOP B11 mim_unit
XXN_r41_c58_B10 TOP B10 mim_unit
XXN_r37_c21_B9 TOP B9 mim_unit
XXN_r11_c12_B11 TOP B11 mim_unit
XXN_r14_c43_B11 TOP B11 mim_unit
XXN_r19_c42_B10 TOP B10 mim_unit
XXN_r20_c60_B10 TOP B10 mim_unit
XXN_r47_c44_B10 TOP B10 mim_unit
XXN_r44_c13_B10 TOP B10 mim_unit
XXN_r27_c45_B9 TOP B9 mim_unit
XXN_r41_c49_B10 TOP B10 mim_unit
XXN_r14_c34_B11 TOP B11 mim_unit
XXN_r19_c33_B10 TOP B10 mim_unit
XXN_r20_c51_B10 TOP B10 mim_unit
XXN_r47_c35_B10 TOP B10 mim_unit
XXN_r44_c04_B10 TOP B10 mim_unit
XXN_r35_c41_B8 TOP B8 mim_unit
XXN_r25_c49_B9 TOP B9 mim_unit
XXN_r11_c03_B11 TOP B11 mim_unit
XXN_r00_c13_EDGE EDGE_BIAS EDGE_BIAS mim_unit
XXN_r39_c12_B9 TOP B9 mim_unit
XXN_r14_c25_B11 TOP B11 mim_unit
XXN_r19_c24_B10 TOP B10 mim_unit
XXN_r20_c42_B10 TOP B10 mim_unit
XXN_r47_c26_B10 TOP B10 mim_unit
XXN_r29_c52_B8 TOP B8 mim_unit
XXN_r52_c62_B11 TOP B11 mim_unit
XXN_r37_c16_B9 TOP B9 mim_unit
XXN_r23_c64_B10 TOP B10 mim_unit
XXN_r14_c16_B11 TOP B11 mim_unit
XXN_r19_c15_B10 TOP B10 mim_unit
XXN_r20_c33_B10 TOP B10 mim_unit
XXN_r47_c17_B10 TOP B10 mim_unit
XXN_r00_c36_EDGE EDGE_BIAS EDGE_BIAS mim_unit
XXN_r52_c53_B11 TOP B11 mim_unit
XXN_r35_c36_B8 TOP B8 mim_unit
XXN_r23_c55_B10 TOP B10 mim_unit
XXN_r14_c07_B11 TOP B11 mim_unit
XXN_r19_c06_B10 TOP B10 mim_unit
XXN_r20_c24_B10 TOP B10 mim_unit
XXN_r47_c08_B10 TOP B10 mim_unit
XXN_r52_c44_B11 TOP B11 mim_unit
XXN_r39_c07_B9 TOP B9 mim_unit
XXN_r29_c47_B8 TOP B8 mim_unit
XXN_r23_c46_B10 TOP B10 mim_unit
XXN_r20_c15_B10 TOP B10 mim_unit
XXN_r58_c30_B11 TOP B11 mim_unit
XXN_r00_c59_EDGE EDGE_BIAS EDGE_BIAS mim_unit
XXN_r65_c00_EDGE EDGE_BIAS EDGE_BIAS mim_unit
XXN_r52_c35_B11 TOP B11 mim_unit
XXN_r20_c06_B10 TOP B10 mim_unit
XXN_r23_c37_B10 TOP B10 mim_unit
XXN_r58_c21_B11 TOP B11 mim_unit
XXN_r04_c65_EDGE EDGE_BIAS EDGE_BIAS mim_unit
XXN_r55_c57_B11 TOP B11 mim_unit
XXN_r52_c26_B11 TOP B11 mim_unit
XXN_r25_c62_B9 TOP B9 mim_unit
XXN_r23_c28_B10 TOP B10 mim_unit
XXN_r62_c61_B11 TOP B11 mim_unit
XXN_r58_c12_B11 TOP B11 mim_unit
XXN_r65_c23_EDGE EDGE_BIAS EDGE_BIAS mim_unit
XXN_r55_c48_B11 TOP B11 mim_unit
XXN_r52_c17_B11 TOP B11 mim_unit
XXN_r23_c19_B10 TOP B10 mim_unit
XXN_r62_c52_B11 TOP B11 mim_unit
XXN_r58_c03_B11 TOP B11 mim_unit
XXN_r55_c39_B11 TOP B11 mim_unit
XXN_r52_c08_B11 TOP B11 mim_unit
XXN_r27_c53_B9 TOP B9 mim_unit
XXN_r62_c43_B11 TOP B11 mim_unit
XXN_r32_c24_B5 TOP B5 mim_unit
XXN_r25_c57_B9 TOP B9 mim_unit
XXN_r65_c46_EDGE EDGE_BIAS EDGE_BIAS mim_unit
XXN_r30_c03_B8 TOP B8 mim_unit
XXN_r06_c30_B11 TOP B11 mim_unit
XXN_r09_c61_B11 TOP B11 mim_unit
XXN_r39_c20_B9 TOP B9 mim_unit
XXN_r31_c01_B11 TOP B11 mim_unit
XXN_r62_c34_B11 TOP B11 mim_unit
XXN_r29_c60_B8 TOP B8 mim_unit
XXN_r06_c21_B11 TOP B11 mim_unit
XXN_r09_c52_B11 TOP B11 mim_unit
XXN_r37_c24_B9 TOP B9 mim_unit
XXN_r62_c25_B11 TOP B11 mim_unit
XXN_r27_c48_B9 TOP B9 mim_unit
XXN_r03_c57_B11 TOP B11 mim_unit
XXN_r43_c62_B10 TOP B10 mim_unit
XXN_r06_c12_B11 TOP B11 mim_unit
XXN_r09_c43_B11 TOP B11 mim_unit
XXN_r10_c61_B11 TOP B11 mim_unit
XXN_r35_c44_B8 TOP B8 mim_unit
XXN_r32_c19_B5 TOP B5 mim_unit
XXN_r62_c16_B11 TOP B11 mim_unit
XXN_r03_c48_B11 TOP B11 mim_unit
XXN_r06_c03_B11 TOP B11 mim_unit
XXN_r09_c34_B11 TOP B11 mim_unit
XXN_r10_c52_B11 TOP B11 mim_unit
XXN_r43_c53_B10 TOP B10 mim_unit
XXN_r39_c15_B9 TOP B9 mim_unit
XXN_r62_c07_B11 TOP B11 mim_unit
XXN_r29_c55_B8 TOP B8 mim_unit
XXN_r03_c39_B11 TOP B11 mim_unit
XXN_r37_c19_B9 TOP B9 mim_unit
XXN_r34_c01_B7 TOP B7 mim_unit
XXN_r43_c44_B10 TOP B10 mim_unit
XXN_r09_c25_B11 TOP B11 mim_unit
XXN_r10_c43_B11 TOP B11 mim_unit
XXN_r05_c01_B9 TOP B9 mim_unit
XXN_r35_c39_B8 TOP B8 mim_unit
XXN_r09_c16_B11 TOP B11 mim_unit
XXN_r10_c34_B11 TOP B11 mim_unit
XXN_r18_c64_B10 TOP B10 mim_unit
XXN_r43_c35_B10 TOP B10 mim_unit
XXN_r16_c20_B11 TOP B11 mim_unit
XXN_r18_c55_B10 TOP B10 mim_unit
XXN_r46_c57_B10 TOP B10 mim_unit
XXN_r43_c26_B10 TOP B10 mim_unit
XXN_r09_c07_B11 TOP B11 mim_unit
XXN_r10_c25_B11 TOP B11 mim_unit
XXN_r13_c56_B11 TOP B11 mim_unit
XXN_r16_c11_B11 TOP B11 mim_unit
XXN_r19_c00_EDGE EDGE_BIAS EDGE_BIAS mim_unit
XXN_r27_c61_B9 TOP B9 mim_unit
XXN_r10_c16_B11 TOP B11 mim_unit
XXN_r13_c47_B11 TOP B11 mim_unit
XXN_r18_c46_B10 TOP B10 mim_unit
XXN_r46_c48_B10 TOP B10 mim_unit
XXN_r43_c17_B10 TOP B10 mim_unit
XXN_r29_c65_EDGE EDGE_BIAS EDGE_BIAS mim_unit
XXN_r16_c02_B11 TOP B11 mim_unit
XXN_r32_c32_B5 TOP B5 mim_unit
XXN_r46_c39_B10 TOP B10 mim_unit
XXN_r43_c08_B10 TOP B10 mim_unit
XXN_r30_c11_B8 TOP B8 mim_unit
XXN_r10_c07_B11 TOP B11 mim_unit
XXN_r13_c38_B11 TOP B11 mim_unit
XXN_r18_c37_B10 TOP B10 mim_unit
XXN_r26_c02_B9 TOP B9 mim_unit
XXN_r22_c10_B10 TOP B10 mim_unit
XXN_r13_c29_B11 TOP B11 mim_unit
XXN_r18_c28_B10 TOP B10 mim_unit
XXN_r57_c61_B11 TOP B11 mim_unit
XXN_r54_c30_B11 TOP B11 mim_unit
XXN_r37_c32_B9 TOP B9 mim_unit
XXN_r27_c56_B9 TOP B9 mim_unit
XXN_r57_c52_B11 TOP B11 mim_unit
XXN_r18_c19_B10 TOP B10 mim_unit
XXN_r54_c21_B11 TOP B11 mim_unit
XXN_r32_c27_B5 TOP B5 mim_unit
XXN_r51_c57_B11 TOP B11 mim_unit
XXN_r35_c52_B8 TOP B8 mim_unit
XXN_r30_c06_B8 TOP B8 mim_unit
XXN_r22_c59_B10 TOP B10 mim_unit
XXN_r57_c43_B11 TOP B11 mim_unit
XXN_r54_c12_B11 TOP B11 mim_unit
XXN_r39_c23_B9 TOP B9 mim_unit
XXN_r51_c48_B11 TOP B11 mim_unit
XXN_r29_c63_B8 TOP B8 mim_unit
XXN_r57_c34_B11 TOP B11 mim_unit
XXN_r37_c27_B9 TOP B9 mim_unit
XXN_r26_c01_B11 TOP B11 mim_unit
XXN_r54_c03_B11 TOP B11 mim_unit
XXN_r51_c39_B11 TOP B11 mim_unit
XXN_r34_c00_EDGE EDGE_BIAS EDGE_BIAS mim_unit
XXN_r00_c03_EDGE EDGE_BIAS EDGE_BIAS mim_unit
XXN_r44_c65_EDGE EDGE_BIAS EDGE_BIAS mim_unit
XXN_r57_c25_B11 TOP B11 mim_unit
XXN_r35_c47_B8 TOP B8 mim_unit
XXN_r02_c30_B11 TOP B11 mim_unit
XXN_r05_c61_B11 TOP B11 mim_unit
XXN_r57_c16_B11 TOP B11 mim_unit
XXN_r39_c18_B9 TOP B9 mim_unit
XXN_r29_c58_B8 TOP B8 mim_unit
XXN_r64_c20_B11 TOP B11 mim_unit
XXN_r34_c04_B7 TOP B7 mim_unit
XXN_r05_c52_B11 TOP B11 mim_unit
XXN_r02_c21_B11 TOP B11 mim_unit
XXN_r00_c26_EDGE EDGE_BIAS EDGE_BIAS mim_unit
XXN_r61_c56_B11 TOP B11 mim_unit
XXN_r57_c07_B11 TOP B11 mim_unit
XXN_r64_c11_B11 TOP B11 mim_unit
XXN_r05_c43_B11 TOP B11 mim_unit
XXN_r02_c12_B11 TOP B11 mim_unit
XXN_r61_c47_B11 TOP B11 mim_unit
XXN_r00_c49_EDGE EDGE_BIAS EDGE_BIAS mim_unit
XXN_r64_c02_B11 TOP B11 mim_unit
XXN_r26_c10_B9 TOP B9 mim_unit
XXN_r05_c34_B11 TOP B11 mim_unit
XXN_r02_c03_B11 TOP B11 mim_unit
XXN_r61_c38_B11 TOP B11 mim_unit
XXN_r37_c40_B9 TOP B9 mim_unit
XXN_r27_c64_B9 TOP B9 mim_unit
XXN_r05_c25_B11 TOP B11 mim_unit
XXN_r08_c56_B11 TOP B11 mim_unit
XXN_r61_c29_B11 TOP B11 mim_unit
XXN_r15_c60_B11 TOP B11 mim_unit
XXN_r48_c61_B10 TOP B10 mim_unit
XXN_r45_c30_B10 TOP B10 mim_unit
XXN_r35_c60_B8 TOP B8 mim_unit
XXN_r05_c16_B11 TOP B11 mim_unit
XXN_r08_c47_B11 TOP B11 mim_unit
XXN_r65_c13_EDGE EDGE_BIAS EDGE_BIAS mim_unit
XXN_r30_c14_B8 TOP B8 mim_unit
XXN_r48_c52_B10 TOP B10 mim_unit
XXN_r26_c05_B9 TOP B9 mim_unit
XXN_r12_c20_B11 TOP B11 mim_unit
XXN_r15_c51_B11 TOP B11 mim_unit
XXN_r45_c21_B10 TOP B10 mim_unit
XXN_r39_c31_B9 TOP B9 mim_unit
XXN_r42_c57_B10 TOP B10 mim_unit
XXN_r05_c07_B11 TOP B11 mim_unit
XXN_r08_c38_B11 TOP B11 mim_unit
XXN_r12_c11_B11 TOP B11 mim_unit
XXN_r15_c42_B11 TOP B11 mim_unit
XXN_r17_c10_B10 TOP B10 mim_unit
XXN_r48_c43_B10 TOP B10 mim_unit
XXN_r45_c12_B10 TOP B10 mim_unit
XXN_r37_c35_B9 TOP B9 mim_unit
XXN_r65_c36_EDGE EDGE_BIAS EDGE_BIAS mim_unit
XXN_r27_c59_B9 TOP B9 mim_unit
XXN_r08_c29_B11 TOP B11 mim_unit
XXN_r49_c30_B11 TOP B11 mim_unit
XXN_r42_c48_B10 TOP B10 mim_unit
XXN_r48_c34_B10 TOP B10 mim_unit
XXN_r12_c02_B11 TOP B11 mim_unit
XXN_r15_c33_B11 TOP B11 mim_unit
XXN_r21_c50_B10 TOP B10 mim_unit
XXN_r45_c03_B10 TOP B10 mim_unit
XXN_r35_c55_B8 TOP B8 mim_unit
XXN_r49_c21_B11 TOP B11 mim_unit
XXN_r42_c39_B10 TOP B10 mim_unit
XXN_r30_c09_B8 TOP B8 mim_unit
XXN_r15_c24_B11 TOP B11 mim_unit
XXN_r21_c41_B10 TOP B10 mim_unit
XXN_r65_c59_EDGE EDGE_BIAS EDGE_BIAS mim_unit
XXN_r48_c25_B10 TOP B10 mim_unit
XXN_r39_c26_B9 TOP B9 mim_unit
XXN_r17_c59_B10 TOP B10 mim_unit
XXN_r53_c61_B11 TOP B11 mim_unit
XXN_r50_c30_B11 TOP B11 mim_unit
XXN_r49_c12_B11 TOP B11 mim_unit
XXN_r34_c12_B7 TOP B7 mim_unit
XXN_r59_c00_EDGE EDGE_BIAS EDGE_BIAS mim_unit
XXN_r48_c16_B10 TOP B10 mim_unit
XXN_r24_c63_B10 TOP B10 mim_unit
XXN_r15_c15_B11 TOP B11 mim_unit
XXN_r21_c32_B10 TOP B10 mim_unit
XXN_r53_c52_B11 TOP B11 mim_unit
XXN_r50_c21_B11 TOP B11 mim_unit
XXN_r49_c03_B11 TOP B11 mim_unit
XXN_r24_c54_B10 TOP B10 mim_unit
XXN_r15_c06_B11 TOP B11 mim_unit
XXN_r21_c23_B10 TOP B10 mim_unit
XXN_r48_c07_B10 TOP B10 mim_unit
XXN_r53_c43_B11 TOP B11 mim_unit
XXN_r50_c12_B11 TOP B11 mim_unit
XXN_r24_c45_B10 TOP B10 mim_unit
XXN_r21_c14_B10 TOP B10 mim_unit
XXN_r34_c07_B7 TOP B7 mim_unit
XXN_r53_c34_B11 TOP B11 mim_unit
XXN_r50_c03_B11 TOP B11 mim_unit
XXN_r22_c01_B11 TOP B11 mim_unit
XXN_r24_c36_B10 TOP B10 mim_unit
XXN_r21_c05_B10 TOP B10 mim_unit
XXN_r59_c20_B11 TOP B11 mim_unit
XXN_r56_c56_B11 TOP B11 mim_unit
XXN_r53_c25_B11 TOP B11 mim_unit
XXN_r63_c60_B11 TOP B11 mim_unit
XXN_r30_c22_B8 TOP B8 mim_unit
XXN_r24_c27_B10 TOP B10 mim_unit
XXN_r59_c11_B11 TOP B11 mim_unit
XXN_r26_c13_B9 TOP B9 mim_unit
XXN_r01_c61_B11 TOP B11 mim_unit
XXN_r56_c47_B11 TOP B11 mim_unit
XXN_r53_c16_B11 TOP B11 mim_unit
XXN_r24_c18_B10 TOP B10 mim_unit
XXN_r63_c51_B11 TOP B11 mim_unit
XXN_r60_c20_B11 TOP B11 mim_unit
XXN_r59_c02_B11 TOP B11 mim_unit
XXN_r01_c52_B11 TOP B11 mim_unit
XXN_r37_c43_B9 TOP B9 mim_unit
XXN_r56_c38_B11 TOP B11 mim_unit
XXN_r53_c07_B11 TOP B11 mim_unit
XXN_r63_c42_B11 TOP B11 mim_unit
XXN_r28_c04_B9 TOP B9 mim_unit
XXN_r24_c09_B10 TOP B10 mim_unit
XXN_r03_c00_EDGE EDGE_BIAS EDGE_BIAS mim_unit
XXN_r60_c11_B11 TOP B11 mim_unit
XXN_r01_c43_B11 TOP B11 mim_unit
XXN_r13_c65_EDGE EDGE_BIAS EDGE_BIAS mim_unit
XXN_r56_c29_B11 TOP B11 mim_unit
XXN_r35_c63_B8 TOP B8 mim_unit
XXN_r30_c17_B8 TOP B8 mim_unit
XXN_r26_c08_B9 TOP B9 mim_unit
XXN_r63_c33_B11 TOP B11 mim_unit
XXN_r60_c02_B11 TOP B11 mim_unit
XXN_r39_c34_B9 TOP B9 mim_unit
XXN_r01_c34_B11 TOP B11 mim_unit
XXN_r07_c20_B11 TOP B11 mim_unit
XXN_r37_c38_B9 TOP B9 mim_unit
XXN_r34_c20_B7 TOP B7 mim_unit
XXN_r63_c24_B11 TOP B11 mim_unit
XXN_r04_c56_B11 TOP B11 mim_unit
XXN_r01_c25_B11 TOP B11 mim_unit
XXN_r07_c11_B11 TOP B11 mim_unit
XXN_r11_c60_B11 TOP B11 mim_unit
XXN_r44_c61_B10 TOP B10 mim_unit
XXN_r41_c30_B10 TOP B10 mim_unit
XXN_r63_c15_B11 TOP B11 mim_unit
XXN_r35_c58_B8 TOP B8 mim_unit
XXN_r32_c40_B6 TOP B6 mim_unit
XXN_r04_c47_B11 TOP B11 mim_unit
XXN_r01_c16_B11 TOP B11 mim_unit
XXN_r44_c52_B10 TOP B10 mim_unit
XXN_r41_c21_B10 TOP B10 mim_unit
XXN_r07_c02_B11 TOP B11 mim_unit
XXN_r11_c51_B11 TOP B11 mim_unit
XXN_r39_c29_B9 TOP B9 mim_unit
XXN_r63_c06_B11 TOP B11 mim_unit
XXN_r04_c38_B11 TOP B11 mim_unit
XXN_r01_c07_B11 TOP B11 mim_unit
XXN_r34_c15_B7 TOP B7 mim_unit
XXN_r11_c42_B11 TOP B11 mim_unit
XXN_r44_c43_B10 TOP B10 mim_unit
XXN_r41_c12_B10 TOP B10 mim_unit
XXN_r04_c29_B11 TOP B11 mim_unit
XXN_r19_c63_B10 TOP B10 mim_unit
.ends

.subckt cdac_side_p_routed TOP B11 B10 B9 B8 B7 B6 B5 B4 B3 B2 B1 B0 DUMMY EDGE_BIAS
XXP_r64_c23_B11 TOP B11 mim_unit
XXP_r38_c51_B9 TOP B9 mim_unit
XXP_r05_c55_B11 TOP B11 mim_unit
XXP_r02_c24_B11 TOP B11 mim_unit
XXP_r40_c48_B9 TOP B9 mim_unit
XXP_r61_c59_B11 TOP B11 mim_unit
XXP_r45_c60_B10 TOP B10 mim_unit
XXP_r08_c10_B11 TOP B11 mim_unit
XXP_r64_c14_B11 TOP B11 mim_unit
XXP_r05_c46_B11 TOP B11 mim_unit
XXP_r02_c15_B11 TOP B11 mim_unit
XXP_r31_c41_B7 TOP B7 mim_unit
XXP_r27_c16_B9 TOP B9 mim_unit
XXP_r08_c01_B11 TOP B11 mim_unit
XXP_r12_c50_B11 TOP B11 mim_unit
XXP_r65_c57_EDGE EDGE_BIAS EDGE_BIAS mim_unit
XXP_r45_c51_B10 TOP B10 mim_unit
XXP_r42_c20_B10 TOP B10 mim_unit
XXP_r64_c05_B11 TOP B11 mim_unit
XXP_r05_c37_B11 TOP B11 mim_unit
XXP_r02_c06_B11 TOP B11 mim_unit
XXP_r35_c12_B8 TOP B8 mim_unit
XXP_r45_c42_B10 TOP B10 mim_unit
XXP_r38_c46_B9 TOP B9 mim_unit
XXP_r12_c41_B11 TOP B11 mim_unit
XXP_r17_c40_B10 TOP B10 mim_unit
XXP_r42_c11_B10 TOP B10 mim_unit
XXP_r49_c60_B11 TOP B11 mim_unit
XXP_r05_c28_B11 TOP B11 mim_unit
XXP_r08_c59_B11 TOP B11 mim_unit
XXP_r29_c23_B8 TOP B8 mim_unit
XXP_r12_c32_B11 TOP B11 mim_unit
XXP_r15_c63_B11 TOP B11 mim_unit
XXP_r17_c31_B10 TOP B10 mim_unit
XXP_r48_c64_B10 TOP B10 mim_unit
XXP_r45_c33_B10 TOP B10 mim_unit
XXP_r42_c02_B10 TOP B10 mim_unit
XXP_r31_c36_B7 TOP B7 mim_unit
XXP_r05_c19_B11 TOP B11 mim_unit
XXP_r49_c51_B11 TOP B11 mim_unit
XXP_r48_c55_B10 TOP B10 mim_unit
XXP_r45_c24_B10 TOP B10 mim_unit
XXP_r12_c23_B11 TOP B11 mim_unit
XXP_r15_c54_B11 TOP B11 mim_unit
XXP_r17_c22_B10 TOP B10 mim_unit
XXP_r35_c07_B8 TOP B8 mim_unit
XXP_r50_c60_B11 TOP B11 mim_unit
XXP_r49_c42_B11 TOP B11 mim_unit
XXP_r12_c14_B11 TOP B11 mim_unit
XXP_r15_c45_B11 TOP B11 mim_unit
XXP_r17_c13_B10 TOP B10 mim_unit
XXP_r21_c62_B10 TOP B10 mim_unit
XXP_r48_c46_B10 TOP B10 mim_unit
XXP_r45_c15_B10 TOP B10 mim_unit
XXP_r40_c61_B9 TOP B9 mim_unit
XXP_r29_c18_B8 TOP B8 mim_unit
XXP_r50_c51_B11 TOP B11 mim_unit
XXP_r49_c33_B11 TOP B11 mim_unit
XXP_r33_c43_B6 TOP B6 mim_unit
XXP_r48_c37_B10 TOP B10 mim_unit
XXP_r12_c05_B11 TOP B11 mim_unit
XXP_r15_c36_B11 TOP B11 mim_unit
XXP_r17_c04_B10 TOP B10 mim_unit
XXP_r21_c53_B10 TOP B10 mim_unit
XXP_r45_c06_B10 TOP B10 mim_unit
XXP_r50_c42_B11 TOP B11 mim_unit
XXP_r49_c24_B11 TOP B11 mim_unit
XXP_r15_c27_B11 TOP B11 mim_unit
XXP_r21_c44_B10 TOP B10 mim_unit
XXP_r48_c28_B10 TOP B10 mim_unit
XXP_r25_c33_B9 TOP B9 mim_unit
XXP_r26_c00_EDGE EDGE_BIAS EDGE_BIAS mim_unit
XXP_r53_c64_B11 TOP B11 mim_unit
XXP_r52_c01_B10 TOP B10 mim_unit
XXP_r50_c33_B11 TOP B11 mim_unit
XXP_r49_c15_B11 TOP B11 mim_unit
XXP_r36_c65_EDGE EDGE_BIAS EDGE_BIAS mim_unit
XXP_r59_c50_B11 TOP B11 mim_unit
XXP_r48_c19_B10 TOP B10 mim_unit
XXP_r40_c56_B9 TOP B9 mim_unit
XXP_r15_c18_B11 TOP B11 mim_unit
XXP_r21_c35_B10 TOP B10 mim_unit
XXP_r33_c38_B6 TOP B6 mim_unit
XXP_r53_c55_B11 TOP B11 mim_unit
XXP_r50_c24_B11 TOP B11 mim_unit
XXP_r49_c06_B11 TOP B11 mim_unit
XXP_r24_c57_B10 TOP B10 mim_unit
XXP_r15_c09_B11 TOP B11 mim_unit
XXP_r21_c26_B10 TOP B10 mim_unit
XXP_r59_c41_B11 TOP B11 mim_unit
XXP_r56_c10_B11 TOP B11 mim_unit
XXP_r27_c24_B9 TOP B9 mim_unit
XXP_r53_c46_B11 TOP B11 mim_unit
XXP_r50_c15_B11 TOP B11 mim_unit
XXP_r24_c48_B10 TOP B10 mim_unit
XXP_r25_c28_B9 TOP B9 mim_unit
XXP_r60_c50_B11 TOP B11 mim_unit
XXP_r59_c32_B11 TOP B11 mim_unit
XXP_r35_c20_B8 TOP B8 mim_unit
XXP_r21_c17_B10 TOP B10 mim_unit
XXP_r38_c54_B9 TOP B9 mim_unit
XXP_r53_c37_B11 TOP B11 mim_unit
XXP_r50_c06_B11 TOP B11 mim_unit
XXP_r24_c39_B10 TOP B10 mim_unit
XXP_r21_c08_B10 TOP B10 mim_unit
XXP_r60_c41_B11 TOP B11 mim_unit
XXP_r59_c23_B11 TOP B11 mim_unit
XXP_r29_c31_B8 TOP B8 mim_unit
XXP_r56_c59_B11 TOP B11 mim_unit
XXP_r53_c28_B11 TOP B11 mim_unit
XXP_r31_c44_B7 TOP B7 mim_unit
XXP_r27_c19_B9 TOP B9 mim_unit
XXP_r63_c63_B11 TOP B11 mim_unit
XXP_r60_c32_B11 TOP B11 mim_unit
XXP_r59_c14_B11 TOP B11 mim_unit
XXP_r58_c01_B9 TOP B9 mim_unit
XXP_r53_c19_B11 TOP B11 mim_unit
XXP_r35_c15_B8 TOP B8 mim_unit
XXP_r07_c50_B11 TOP B11 mim_unit
XXP_r38_c49_B9 TOP B9 mim_unit
XXP_r63_c54_B11 TOP B11 mim_unit
XXP_r60_c23_B11 TOP B11 mim_unit
XXP_r59_c05_B11 TOP B11 mim_unit
XXP_r41_c00_EDGE EDGE_BIAS EDGE_BIAS mim_unit
XXP_r01_c55_B11 TOP B11 mim_unit
XXP_r51_c65_EDGE EDGE_BIAS EDGE_BIAS mim_unit
XXP_r41_c60_B10 TOP B10 mim_unit
XXP_r33_c51_B6 TOP B6 mim_unit
XXP_r29_c26_B8 TOP B8 mim_unit
XXP_r04_c10_B11 TOP B11 mim_unit
XXP_r07_c41_B11 TOP B11 mim_unit
XXP_r63_c45_B11 TOP B11 mim_unit
XXP_r00_c14_EDGE EDGE_BIAS EDGE_BIAS mim_unit
XXP_r60_c14_B11 TOP B11 mim_unit
XXP_r31_c39_B7 TOP B7 mim_unit
XXP_r01_c46_B11 TOP B11 mim_unit
XXP_r04_c01_B11 TOP B11 mim_unit
XXP_r07_c32_B11 TOP B11 mim_unit
XXP_r41_c51_B10 TOP B10 mim_unit
XXP_r63_c36_B11 TOP B11 mim_unit
XXP_r60_c05_B11 TOP B11 mim_unit
XXP_r01_c37_B11 TOP B11 mim_unit
XXP_r25_c41_B9 TOP B9 mim_unit
XXP_r41_c42_B10 TOP B10 mim_unit
XXP_r00_c37_EDGE EDGE_BIAS EDGE_BIAS mim_unit
XXP_r07_c23_B11 TOP B11 mim_unit
XXP_r63_c27_B11 TOP B11 mim_unit
XXP_r40_c64_B9 TOP B9 mim_unit
XXP_r04_c59_B11 TOP B11 mim_unit
XXP_r01_c28_B11 TOP B11 mim_unit
XXP_r33_c46_B6 TOP B6 mim_unit
XXP_r07_c14_B11 TOP B11 mim_unit
XXP_r11_c63_B11 TOP B11 mim_unit
XXP_r44_c64_B10 TOP B10 mim_unit
XXP_r41_c33_B10 TOP B10 mim_unit
XXP_r63_c18_B11 TOP B11 mim_unit
XXP_r27_c32_B9 TOP B9 mim_unit
XXP_r01_c19_B11 TOP B11 mim_unit
XXP_r44_c55_B10 TOP B10 mim_unit
XXP_r41_c24_B10 TOP B10 mim_unit
XXP_r07_c05_B11 TOP B11 mim_unit
XXP_r11_c54_B11 TOP B11 mim_unit
XXP_r63_c09_B11 TOP B11 mim_unit
XXP_r25_c36_B9 TOP B9 mim_unit
XXP_r65_c01_EDGE EDGE_BIAS EDGE_BIAS mim_unit
XXP_r47_c10_B10 TOP B10 mim_unit
XXP_r38_c62_B9 TOP B9 mim_unit
XXP_r11_c45_B11 TOP B11 mim_unit
XXP_r44_c46_B10 TOP B10 mim_unit
XXP_r40_c59_B9 TOP B9 mim_unit
XXP_r41_c15_B10 TOP B10 mim_unit
XXP_r44_c37_B10 TOP B10 mim_unit
XXP_r41_c06_B10 TOP B10 mim_unit
XXP_r37_c03_B9 TOP B9 mim_unit
XXP_r11_c36_B11 TOP B11 mim_unit
XXP_r65_c24_EDGE EDGE_BIAS EDGE_BIAS mim_unit
XXP_r31_c52_B7 TOP B7 mim_unit
XXP_r27_c27_B9 TOP B9 mim_unit
XXP_r11_c27_B11 TOP B11 mim_unit
XXP_r14_c58_B11 TOP B11 mim_unit
XXP_r19_c57_B10 TOP B10 mim_unit
XXP_r47_c59_B10 TOP B10 mim_unit
XXP_r44_c28_B10 TOP B10 mim_unit
XXP_r35_c23_B8 TOP B8 mim_unit
XXP_r38_c57_B9 TOP B9 mim_unit
XXP_r23_c30_B10 TOP B10 mim_unit
XXP_r19_c48_B10 TOP B10 mim_unit
XXP_r55_c50_B11 TOP B11 mim_unit
XXP_r44_c19_B10 TOP B10 mim_unit
XXP_r11_c18_B11 TOP B11 mim_unit
XXP_r14_c49_B11 TOP B11 mim_unit
XXP_r65_c47_EDGE EDGE_BIAS EDGE_BIAS mim_unit
XXP_r29_c34_B8 TOP B8 mim_unit
XXP_r23_c21_B10 TOP B10 mim_unit
XXP_r31_c47_B7 TOP B7 mim_unit
XXP_r11_c09_B11 TOP B11 mim_unit
XXP_r19_c39_B10 TOP B10 mim_unit
XXP_r20_c57_B10 TOP B10 mim_unit
XXP_r55_c41_B11 TOP B11 mim_unit
XXP_r52_c10_B11 TOP B11 mim_unit
XXP_r23_c12_B10 TOP B10 mim_unit
XXP_r35_c18_B8 TOP B8 mim_unit
XXP_r20_c48_B10 TOP B10 mim_unit
XXP_r58_c63_B11 TOP B11 mim_unit
XXP_r55_c32_B11 TOP B11 mim_unit
XXP_r23_c03_B10 TOP B10 mim_unit
XXP_r05_c65_EDGE EDGE_BIAS EDGE_BIAS mim_unit
XXP_r29_c29_B8 TOP B8 mim_unit
XXP_r20_c39_B10 TOP B10 mim_unit
XXP_r58_c54_B11 TOP B11 mim_unit
XXP_r55_c23_B11 TOP B11 mim_unit
XXP_r33_c54_B6 TOP B6 mim_unit
XXP_r52_c59_B11 TOP B11 mim_unit
XXP_r27_c40_B9 TOP B9 mim_unit
XXP_r58_c45_B11 TOP B11 mim_unit
XXP_r55_c14_B11 TOP B11 mim_unit
XXP_r25_c44_B9 TOP B9 mim_unit
XXP_r03_c50_B11 TOP B11 mim_unit
XXP_r58_c36_B11 TOP B11 mim_unit
XXP_r55_c05_B11 TOP B11 mim_unit
XXP_r33_c49_B6 TOP B6 mim_unit
XXP_r03_c41_B11 TOP B11 mim_unit
XXP_r58_c27_B11 TOP B11 mim_unit
XXP_r37_c11_B9 TOP B9 mim_unit
XXP_r31_c60_B7 TOP B7 mim_unit
XXP_r27_c35_B9 TOP B9 mim_unit
XXP_r03_c32_B11 TOP B11 mim_unit
XXP_r06_c63_B11 TOP B11 mim_unit
XXP_r58_c18_B11 TOP B11 mim_unit
XXP_r35_c31_B8 TOP B8 mim_unit
XXP_r25_c39_B9 TOP B9 mim_unit
XXP_r03_c23_B11 TOP B11 mim_unit
XXP_r06_c54_B11 TOP B11 mim_unit
XXP_r62_c58_B11 TOP B11 mim_unit
XXP_r58_c09_B11 TOP B11 mim_unit
XXP_r39_c02_B9 TOP B9 mim_unit
XXP_r10_c00_EDGE EDGE_BIAS EDGE_BIAS mim_unit
XXP_r20_c65_EDGE EDGE_BIAS EDGE_BIAS mim_unit
XXP_r29_c42_B8 TOP B8 mim_unit
XXP_r03_c14_B11 TOP B11 mim_unit
XXP_r06_c45_B11 TOP B11 mim_unit
XXP_r37_c06_B9 TOP B9 mim_unit
XXP_r62_c49_B11 TOP B11 mim_unit
XXP_r46_c50_B10 TOP B10 mim_unit
XXP_r31_c55_B7 TOP B7 mim_unit
XXP_r03_c05_B11 TOP B11 mim_unit
XXP_r06_c36_B11 TOP B11 mim_unit
XXP_r35_c26_B8 TOP B8 mim_unit
XXP_r13_c40_B11 TOP B11 mim_unit
XXP_r46_c41_B10 TOP B10 mim_unit
XXP_r43_c10_B10 TOP B10 mim_unit
XXP_r06_c27_B11 TOP B11 mim_unit
XXP_r09_c58_B11 TOP B11 mim_unit
XXP_r46_c32_B10 TOP B10 mim_unit
XXP_r33_c62_B6 TOP B6 mim_unit
XXP_r29_c37_B8 TOP B8 mim_unit
XXP_r13_c31_B11 TOP B11 mim_unit
XXP_r16_c62_B11 TOP B11 mim_unit
XXP_r18_c30_B10 TOP B10 mim_unit
XXP_r06_c18_B11 TOP B11 mim_unit
XXP_r09_c49_B11 TOP B11 mim_unit
XXP_r13_c22_B11 TOP B11 mim_unit
XXP_r16_c53_B11 TOP B11 mim_unit
XXP_r18_c21_B10 TOP B10 mim_unit
XXP_r46_c23_B10 TOP B10 mim_unit
XXP_r32_c03_B6 TOP B6 mim_unit
XXP_r06_c09_B11 TOP B11 mim_unit
XXP_r10_c58_B11 TOP B11 mim_unit
XXP_r43_c59_B10 TOP B10 mim_unit
XXP_r25_c52_B9 TOP B9 mim_unit
XXP_r22_c61_B10 TOP B10 mim_unit
XXP_r46_c14_B10 TOP B10 mim_unit
XXP_r00_c04_EDGE EDGE_BIAS EDGE_BIAS mim_unit
XXP_r13_c13_B11 TOP B11 mim_unit
XXP_r16_c44_B11 TOP B11 mim_unit
XXP_r18_c12_B10 TOP B10 mim_unit
XXP_r51_c50_B11 TOP B11 mim_unit
XXP_r47_c01_B11 TOP B11 mim_unit
XXP_r10_c49_B11 TOP B11 mim_unit
XXP_r33_c57_B6 TOP B6 mim_unit
XXP_r22_c52_B10 TOP B10 mim_unit
XXP_r13_c04_B11 TOP B11 mim_unit
XXP_r16_c35_B11 TOP B11 mim_unit
XXP_r18_c03_B10 TOP B10 mim_unit
XXP_r46_c05_B10 TOP B10 mim_unit
XXP_r27_c43_B9 TOP B9 mim_unit
XXP_r51_c41_B11 TOP B11 mim_unit
XXP_r22_c43_B10 TOP B10 mim_unit
XXP_r00_c27_EDGE EDGE_BIAS EDGE_BIAS mim_unit
XXP_r16_c26_B11 TOP B11 mim_unit
XXP_r25_c47_B9 TOP B9 mim_unit
XXP_r54_c63_B11 TOP B11 mim_unit
XXP_r51_c32_B11 TOP B11 mim_unit
XXP_r16_c17_B11 TOP B11 mim_unit
XXP_r22_c34_B10 TOP B10 mim_unit
XXP_r39_c10_B9 TOP B9 mim_unit
XXP_r54_c54_B11 TOP B11 mim_unit
XXP_r51_c23_B11 TOP B11 mim_unit
XXP_r29_c50_B8 TOP B8 mim_unit
XXP_r37_c14_B9 TOP B9 mim_unit
XXP_r16_c08_B11 TOP B11 mim_unit
XXP_r22_c25_B10 TOP B10 mim_unit
XXP_r31_c63_B7 TOP B7 mim_unit
XXP_r27_c38_B9 TOP B9 mim_unit
XXP_r54_c45_B11 TOP B11 mim_unit
XXP_r51_c14_B11 TOP B11 mim_unit
XXP_r22_c16_B10 TOP B10 mim_unit
XXP_r35_c34_B8 TOP B8 mim_unit
XXP_r35_c00_EDGE EDGE_BIAS EDGE_BIAS mim_unit
XXP_r54_c36_B11 TOP B11 mim_unit
XXP_r51_c05_B11 TOP B11 mim_unit
XXP_r45_c65_EDGE EDGE_BIAS EDGE_BIAS mim_unit
XXP_r39_c05_B9 TOP B9 mim_unit
XXP_r65_c14_EDGE EDGE_BIAS EDGE_BIAS mim_unit
XXP_r61_c40_B11 TOP B11 mim_unit
XXP_r22_c07_B10 TOP B10 mim_unit
XXP_r29_c45_B8 TOP B8 mim_unit
XXP_r57_c58_B11 TOP B11 mim_unit
XXP_r54_c27_B11 TOP B11 mim_unit
XXP_r37_c09_B9 TOP B9 mim_unit
XXP_r31_c58_B7 TOP B7 mim_unit
XXP_r64_c62_B11 TOP B11 mim_unit
XXP_r61_c31_B11 TOP B11 mim_unit
XXP_r02_c63_B11 TOP B11 mim_unit
XXP_r57_c49_B11 TOP B11 mim_unit
XXP_r54_c18_B11 TOP B11 mim_unit
XXP_r35_c29_B8 TOP B8 mim_unit
XXP_r32_c11_B6 TOP B6 mim_unit
XXP_r64_c53_B11 TOP B11 mim_unit
XXP_r65_c37_EDGE EDGE_BIAS EDGE_BIAS mim_unit
XXP_r61_c22_B11 TOP B11 mim_unit
XXP_r25_c60_B9 TOP B9 mim_unit
XXP_r02_c54_B11 TOP B11 mim_unit
XXP_r54_c09_B11 TOP B11 mim_unit
XXP_r08_c40_B11 TOP B11 mim_unit
XXP_r64_c44_B11 TOP B11 mim_unit
XXP_r61_c13_B11 TOP B11 mim_unit
XXP_r02_c45_B11 TOP B11 mim_unit
XXP_r42_c50_B10 TOP B10 mim_unit
XXP_r27_c51_B9 TOP B9 mim_unit
XXP_r08_c31_B11 TOP B11 mim_unit
XXP_r64_c35_B11 TOP B11 mim_unit
XXP_r61_c04_B11 TOP B11 mim_unit
XXP_r02_c36_B11 TOP B11 mim_unit
XXP_r32_c06_B6 TOP B6 mim_unit
XXP_r25_c55_B9 TOP B9 mim_unit
XXP_r08_c22_B11 TOP B11 mim_unit
XXP_r42_c41_B10 TOP B10 mim_unit
XXP_r30_c01_B8 TOP B8 mim_unit
XXP_r64_c26_B11 TOP B11 mim_unit
XXP_r50_c00_EDGE EDGE_BIAS EDGE_BIAS mim_unit
XXP_r32_c63_B1 TOP B1 mim_unit
XXP_r05_c58_B11 TOP B11 mim_unit
XXP_r02_c27_B11 TOP B11 mim_unit
XXP_r17_c61_B10 TOP B10 mim_unit
XXP_r60_c65_EDGE EDGE_BIAS EDGE_BIAS mim_unit
XXP_r45_c63_B10 TOP B10 mim_unit
XXP_r42_c32_B10 TOP B10 mim_unit
XXP_r08_c13_B11 TOP B11 mim_unit
XXP_r12_c62_B11 TOP B11 mim_unit
XXP_r64_c17_B11 TOP B11 mim_unit
XXP_r05_c49_B11 TOP B11 mim_unit
XXP_r00_c60_EDGE EDGE_BIAS EDGE_BIAS mim_unit
XXP_r37_c22_B9 TOP B9 mim_unit
XXP_r27_c46_B9 TOP B9 mim_unit
XXP_r02_c18_B11 TOP B11 mim_unit
XXP_r08_c04_B11 TOP B11 mim_unit
XXP_r12_c53_B11 TOP B11 mim_unit
XXP_r17_c52_B10 TOP B10 mim_unit
XXP_r45_c54_B10 TOP B10 mim_unit
XXP_r42_c23_B10 TOP B10 mim_unit
XXP_r64_c08_B11 TOP B11 mim_unit
XXP_r35_c42_B8 TOP B8 mim_unit
XXP_r02_c09_B11 TOP B11 mim_unit
XXP_r17_c43_B10 TOP B10 mim_unit
XXP_r45_c45_B10 TOP B10 mim_unit
XXP_r42_c14_B10 TOP B10 mim_unit
XXP_r12_c44_B11 TOP B11 mim_unit
XXP_r39_c13_B9 TOP B9 mim_unit
XXP_r49_c63_B11 TOP B11 mim_unit
XXP_r43_c01_B11 TOP B11 mim_unit
XXP_r29_c53_B8 TOP B8 mim_unit
XXP_r12_c35_B11 TOP B11 mim_unit
XXP_r17_c34_B10 TOP B10 mim_unit
XXP_r45_c36_B10 TOP B10 mim_unit
XXP_r42_c05_B10 TOP B10 mim_unit
XXP_r37_c17_B9 TOP B9 mim_unit
XXP_r49_c54_B11 TOP B11 mim_unit
XXP_r17_c25_B10 TOP B10 mim_unit
XXP_r48_c58_B10 TOP B10 mim_unit
XXP_r45_c27_B10 TOP B10 mim_unit
XXP_r12_c26_B11 TOP B11 mim_unit
XXP_r15_c57_B11 TOP B11 mim_unit
XXP_r35_c37_B8 TOP B8 mim_unit
XXP_r50_c63_B11 TOP B11 mim_unit
XXP_r49_c45_B11 TOP B11 mim_unit
XXP_r12_c17_B11 TOP B11 mim_unit
XXP_r15_c48_B11 TOP B11 mim_unit
XXP_r17_c16_B10 TOP B10 mim_unit
XXP_r48_c49_B10 TOP B10 mim_unit
XXP_r45_c18_B10 TOP B10 mim_unit
XXP_r39_c08_B9 TOP B9 mim_unit
XXP_r29_c48_B8 TOP B8 mim_unit
XXP_r24_c20_B10 TOP B10 mim_unit
XXP_r50_c54_B11 TOP B11 mim_unit
XXP_r49_c36_B11 TOP B11 mim_unit
XXP_r17_c07_B10 TOP B10 mim_unit
XXP_r21_c56_B10 TOP B10 mim_unit
XXP_r56_c40_B11 TOP B11 mim_unit
XXP_r45_c09_B10 TOP B10 mim_unit
XXP_r12_c08_B11 TOP B11 mim_unit
XXP_r15_c39_B11 TOP B11 mim_unit
XXP_r24_c11_B10 TOP B10 mim_unit
XXP_r50_c45_B11 TOP B11 mim_unit
XXP_r49_c27_B11 TOP B11 mim_unit
XXP_r32_c14_B6 TOP B6 mim_unit
XXP_r21_c47_B10 TOP B10 mim_unit
XXP_r59_c62_B11 TOP B11 mim_unit
XXP_r56_c31_B11 TOP B11 mim_unit
XXP_r25_c63_B9 TOP B9 mim_unit
XXP_r24_c02_B10 TOP B10 mim_unit
XXP_r50_c36_B11 TOP B11 mim_unit
XXP_r49_c18_B11 TOP B11 mim_unit
XXP_r21_c38_B10 TOP B10 mim_unit
XXP_r59_c53_B11 TOP B11 mim_unit
XXP_r56_c22_B11 TOP B11 mim_unit
XXP_r53_c58_B11 TOP B11 mim_unit
XXP_r50_c27_B11 TOP B11 mim_unit
XXP_r49_c09_B11 TOP B11 mim_unit
XXP_r37_c30_B9 TOP B9 mim_unit
XXP_r27_c54_B9 TOP B9 mim_unit
XXP_r21_c29_B10 TOP B10 mim_unit
XXP_r60_c62_B11 TOP B11 mim_unit
XXP_r59_c44_B11 TOP B11 mim_unit
XXP_r56_c13_B11 TOP B11 mim_unit
XXP_r32_c09_B6 TOP B6 mim_unit
XXP_r53_c49_B11 TOP B11 mim_unit
XXP_r50_c18_B11 TOP B11 mim_unit
XXP_r35_c50_B8 TOP B8 mim_unit
XXP_r25_c58_B9 TOP B9 mim_unit
XXP_r60_c53_B11 TOP B11 mim_unit
XXP_r59_c35_B11 TOP B11 mim_unit
XXP_r56_c04_B11 TOP B11 mim_unit
XXP_r30_c04_B8 TOP B8 mim_unit
XXP_r04_c00_EDGE EDGE_BIAS EDGE_BIAS mim_unit
XXP_r50_c09_B11 TOP B11 mim_unit
XXP_r39_c21_B9 TOP B9 mim_unit
XXP_r04_c40_B11 TOP B11 mim_unit
XXP_r14_c65_EDGE EDGE_BIAS EDGE_BIAS mim_unit
XXP_r00_c17_EDGE EDGE_BIAS EDGE_BIAS mim_unit
XXP_r60_c44_B11 TOP B11 mim_unit
XXP_r59_c26_B11 TOP B11 mim_unit
XXP_r29_c61_B8 TOP B8 mim_unit
XXP_r37_c25_B9 TOP B9 mim_unit
XXP_r07_c62_B11 TOP B11 mim_unit
XXP_r27_c49_B9 TOP B9 mim_unit
XXP_r04_c31_B11 TOP B11 mim_unit
XXP_r60_c35_B11 TOP B11 mim_unit
XXP_r59_c17_B11 TOP B11 mim_unit
XXP_r35_c45_B8 TOP B8 mim_unit
XXP_r04_c22_B11 TOP B11 mim_unit
XXP_r07_c53_B11 TOP B11 mim_unit
XXP_r63_c57_B11 TOP B11 mim_unit
XXP_r60_c26_B11 TOP B11 mim_unit
XXP_r59_c08_B11 TOP B11 mim_unit
XXP_r39_c16_B9 TOP B9 mim_unit
XXP_r01_c58_B11 TOP B11 mim_unit
XXP_r41_c63_B10 TOP B10 mim_unit
XXP_r29_c56_B8 TOP B8 mim_unit
XXP_r04_c13_B11 TOP B11 mim_unit
XXP_r07_c44_B11 TOP B11 mim_unit
XXP_r63_c48_B11 TOP B11 mim_unit
XXP_r60_c17_B11 TOP B11 mim_unit
XXP_r34_c02_B7 TOP B7 mim_unit
XXP_r01_c49_B11 TOP B11 mim_unit
XXP_r38_c01_B11 TOP B11 mim_unit
XXP_r04_c04_B11 TOP B11 mim_unit
XXP_r07_c35_B11 TOP B11 mim_unit
XXP_r41_c54_B10 TOP B10 mim_unit
XXP_r65_c04_EDGE EDGE_BIAS EDGE_BIAS mim_unit
XXP_r63_c39_B11 TOP B11 mim_unit
XXP_r60_c08_B11 TOP B11 mim_unit
XXP_r47_c40_B10 TOP B10 mim_unit
XXP_r32_c22_B6 TOP B6 mim_unit
XXP_r41_c45_B10 TOP B10 mim_unit
XXP_r07_c26_B11 TOP B11 mim_unit
XXP_r14_c30_B11 TOP B11 mim_unit
XXP_r47_c31_B10 TOP B10 mim_unit
XXP_r07_c17_B11 TOP B11 mim_unit
XXP_r41_c36_B10 TOP B10 mim_unit
XXP_r19_c20_B10 TOP B10 mim_unit
XXP_r65_c27_EDGE EDGE_BIAS EDGE_BIAS mim_unit
XXP_r47_c22_B10 TOP B10 mim_unit
XXP_r27_c62_B9 TOP B9 mim_unit
XXP_r14_c21_B11 TOP B11 mim_unit
XXP_r11_c57_B11 TOP B11 mim_unit
XXP_r44_c58_B10 TOP B10 mim_unit
XXP_r41_c27_B10 TOP B10 mim_unit
XXP_r32_c17_B6 TOP B6 mim_unit
XXP_r07_c08_B11 TOP B11 mim_unit
XXP_r32_c33_B5 TOP B5 mim_unit
XXP_r23_c60_B10 TOP B10 mim_unit
XXP_r14_c12_B11 TOP B11 mim_unit
XXP_r19_c11_B10 TOP B10 mim_unit
XXP_r47_c13_B10 TOP B10 mim_unit
XXP_r30_c12_B8 TOP B8 mim_unit
XXP_r26_c03_B9 TOP B9 mim_unit
XXP_r11_c48_B11 TOP B11 mim_unit
XXP_r44_c49_B10 TOP B10 mim_unit
XXP_r41_c18_B10 TOP B10 mim_unit
XXP_r23_c51_B10 TOP B10 mim_unit
XXP_r20_c20_B10 TOP B10 mim_unit
XXP_r47_c04_B10 TOP B10 mim_unit
XXP_r14_c03_B11 TOP B11 mim_unit
XXP_r19_c02_B10 TOP B10 mim_unit
XXP_r11_c39_B11 TOP B11 mim_unit
XXP_r52_c40_B11 TOP B11 mim_unit
XXP_r41_c09_B10 TOP B10 mim_unit
XXP_r37_c33_B9 TOP B9 mim_unit
XXP_r27_c57_B9 TOP B9 mim_unit
XXP_r23_c42_B10 TOP B10 mim_unit
XXP_r20_c11_B10 TOP B10 mim_unit
XXP_r35_c53_B8 TOP B8 mim_unit
XXP_r29_c00_EDGE EDGE_BIAS EDGE_BIAS mim_unit
XXP_r55_c62_B11 TOP B11 mim_unit
XXP_r52_c31_B11 TOP B11 mim_unit
XXP_r30_c07_B8 TOP B8 mim_unit
XXP_r23_c33_B10 TOP B10 mim_unit
XXP_r39_c65_EDGE EDGE_BIAS EDGE_BIAS mim_unit
XXP_r32_c60_B3 TOP B3 mim_unit
XXP_r00_c50_EDGE EDGE_BIAS EDGE_BIAS mim_unit
XXP_r20_c02_B10 TOP B10 mim_unit
XXP_r39_c24_B9 TOP B9 mim_unit
XXP_r55_c53_B11 TOP B11 mim_unit
XXP_r52_c22_B11 TOP B11 mim_unit
XXP_r23_c24_B10 TOP B10 mim_unit
XXP_r37_c28_B9 TOP B9 mim_unit
XXP_r34_c10_B7 TOP B7 mim_unit
XXP_r55_c44_B11 TOP B11 mim_unit
XXP_r52_c13_B11 TOP B11 mim_unit
XXP_r23_c15_B10 TOP B10 mim_unit
XXP_r32_c30_B6 TOP B6 mim_unit
XXP_r35_c48_B8 TOP B8 mim_unit
XXP_r55_c35_B11 TOP B11 mim_unit
XXP_r52_c04_B11 TOP B11 mim_unit
XXP_r23_c06_B10 TOP B10 mim_unit
XXP_r39_c19_B9 TOP B9 mim_unit
XXP_r29_c59_B8 TOP B8 mim_unit
XXP_r06_c64_B9 TOP B9 mim_unit
XXP_r58_c57_B11 TOP B11 mim_unit
XXP_r55_c26_B11 TOP B11 mim_unit
XXP_r34_c05_B7 TOP B7 mim_unit
XXP_r62_c30_B11 TOP B11 mim_unit
XXP_r03_c62_B11 TOP B11 mim_unit
XXP_r31_c64_B11 TOP B11 mim_unit
XXP_r58_c48_B11 TOP B11 mim_unit
XXP_r55_c17_B11 TOP B11 mim_unit
XXP_r32_c25_B6 TOP B6 mim_unit
XXP_r62_c21_B11 TOP B11 mim_unit
XXP_r32_c41_B5 TOP B5 mim_unit
XXP_r03_c53_B11 TOP B11 mim_unit
XXP_r44_c00_EDGE EDGE_BIAS EDGE_BIAS mim_unit
XXP_r30_c20_B8 TOP B8 mim_unit
XXP_r26_c11_B9 TOP B9 mim_unit
XXP_r58_c39_B11 TOP B11 mim_unit
XXP_r54_c65_EDGE EDGE_BIAS EDGE_BIAS mim_unit
XXP_r55_c08_B11 TOP B11 mim_unit
XXP_r65_c60_EDGE EDGE_BIAS EDGE_BIAS mim_unit
XXP_r62_c12_B11 TOP B11 mim_unit
XXP_r33_c03_B2 TOP B2 mim_unit
XXP_r03_c44_B11 TOP B11 mim_unit
XXP_r09_c30_B11 TOP B11 mim_unit
XXP_r37_c41_B9 TOP B9 mim_unit
XXP_r34_c01_B11 TOP B11 mim_unit
XXP_r62_c03_B11 TOP B11 mim_unit
XXP_r03_c35_B11 TOP B11 mim_unit
XXP_r28_c02_B9 TOP B9 mim_unit
XXP_r43_c40_B10 TOP B10 mim_unit
XXP_r35_c61_B8 TOP B8 mim_unit
XXP_r32_c36_B5 TOP B5 mim_unit
XXP_r09_c21_B11 TOP B11 mim_unit
XXP_r32_c52_B4 TOP B4 mim_unit
XXP_r30_c15_B8 TOP B8 mim_unit
XXP_r03_c26_B11 TOP B11 mim_unit
XXP_r06_c57_B11 TOP B11 mim_unit
XXP_r26_c06_B9 TOP B9 mim_unit
XXP_r39_c32_B9 TOP B9 mim_unit
XXP_r09_c12_B11 TOP B11 mim_unit
XXP_r10_c30_B11 TOP B11 mim_unit
XXP_r13_c61_B11 TOP B11 mim_unit
XXP_r18_c60_B10 TOP B10 mim_unit
XXP_r46_c62_B10 TOP B10 mim_unit
XXP_r43_c31_B10 TOP B10 mim_unit
XXP_r03_c17_B11 TOP B11 mim_unit
XXP_r06_c48_B11 TOP B11 mim_unit
XXP_r37_c36_B9 TOP B9 mim_unit
XXP_r18_c51_B10 TOP B10 mim_unit
XXP_r46_c53_B10 TOP B10 mim_unit
XXP_r43_c22_B10 TOP B10 mim_unit
XXP_r09_c03_B11 TOP B11 mim_unit
XXP_r10_c21_B11 TOP B11 mim_unit
XXP_r13_c52_B11 TOP B11 mim_unit
XXP_r03_c08_B11 TOP B11 mim_unit
XXP_r06_c39_B11 TOP B11 mim_unit
XXP_r35_c56_B8 TOP B8 mim_unit
XXP_r00_c07_EDGE EDGE_BIAS EDGE_BIAS mim_unit
XXP_r10_c12_B11 TOP B11 mim_unit
XXP_r13_c43_B11 TOP B11 mim_unit
XXP_r18_c42_B10 TOP B10 mim_unit
XXP_r46_c44_B10 TOP B10 mim_unit
XXP_r43_c13_B10 TOP B10 mim_unit
XXP_r39_c27_B9 TOP B9 mim_unit
XXP_r18_c33_B10 TOP B10 mim_unit
XXP_r46_c35_B10 TOP B10 mim_unit
XXP_r43_c04_B10 TOP B10 mim_unit
XXP_r10_c03_B11 TOP B11 mim_unit
XXP_r13_c34_B11 TOP B11 mim_unit
XXP_r34_c13_B7 TOP B7 mim_unit
XXP_r13_c25_B11 TOP B11 mim_unit
XXP_r16_c56_B11 TOP B11 mim_unit
XXP_r18_c24_B10 TOP B10 mim_unit
XXP_r46_c26_B10 TOP B10 mim_unit
XXP_r51_c62_B11 TOP B11 mim_unit
XXP_r32_c58_B3 TOP B3 mim_unit
XXP_r16_c47_B11 TOP B11 mim_unit
XXP_r18_c15_B10 TOP B10 mim_unit
XXP_r46_c17_B10 TOP B10 mim_unit
XXP_r13_c16_B11 TOP B11 mim_unit
XXP_r51_c53_B11 TOP B11 mim_unit
XXP_r34_c08_B7 TOP B7 mim_unit
XXP_r22_c55_B10 TOP B10 mim_unit
XXP_r13_c07_B11 TOP B11 mim_unit
XXP_r16_c38_B11 TOP B11 mim_unit
XXP_r18_c06_B10 TOP B10 mim_unit
XXP_r46_c08_B10 TOP B10 mim_unit
XXP_r51_c44_B11 TOP B11 mim_unit
XXP_r22_c46_B10 TOP B10 mim_unit
XXP_r57_c30_B11 TOP B11 mim_unit
XXP_r32_c28_B6 TOP B6 mim_unit
XXP_r28_c10_B9 TOP B9 mim_unit
XXP_r16_c29_B11 TOP B11 mim_unit
XXP_r32_c44_B5 TOP B5 mim_unit
XXP_r26_c64_B11 TOP B11 mim_unit
XXP_r51_c35_B11 TOP B11 mim_unit
XXP_r30_c23_B8 TOP B8 mim_unit
XXP_r08_c65_EDGE EDGE_BIAS EDGE_BIAS mim_unit
XXP_r65_c17_EDGE EDGE_BIAS EDGE_BIAS mim_unit
XXP_r26_c14_B9 TOP B9 mim_unit
XXP_r22_c37_B10 TOP B10 mim_unit
XXP_r57_c21_B11 TOP B11 mim_unit
XXP_r39_c40_B9 TOP B9 mim_unit
XXP_r54_c57_B11 TOP B11 mim_unit
XXP_r51_c26_B11 TOP B11 mim_unit
XXP_r22_c28_B10 TOP B10 mim_unit
XXP_r61_c61_B11 TOP B11 mim_unit
XXP_r57_c12_B11 TOP B11 mim_unit
XXP_r37_c44_B9 TOP B9 mim_unit
XXP_r01_c64_B6 TOP B6 mim_unit
XXP_r54_c48_B11 TOP B11 mim_unit
XXP_r51_c17_B11 TOP B11 mim_unit
XXP_r28_c05_B9 TOP B9 mim_unit
XXP_r35_c64_B8 TOP B8 mim_unit
XXP_r32_c39_B5 TOP B5 mim_unit
XXP_r22_c19_B10 TOP B10 mim_unit
XXP_r61_c52_B11 TOP B11 mim_unit
XXP_r57_c03_B11 TOP B11 mim_unit
XXP_r32_c55_B4 TOP B4 mim_unit
XXP_r30_c18_B8 TOP B8 mim_unit
XXP_r26_c09_B9 TOP B9 mim_unit
XXP_r54_c39_B11 TOP B11 mim_unit
XXP_r51_c08_B11 TOP B11 mim_unit
XXP_r39_c35_B9 TOP B9 mim_unit
XXP_r61_c43_B11 TOP B11 mim_unit
XXP_r37_c39_B9 TOP B9 mim_unit
XXP_r34_c21_B7 TOP B7 mim_unit
XXP_r05_c30_B11 TOP B11 mim_unit
XXP_r08_c61_B11 TOP B11 mim_unit
XXP_r61_c34_B11 TOP B11 mim_unit
XXP_r00_c40_EDGE EDGE_BIAS EDGE_BIAS mim_unit
XXP_r08_c52_B11 TOP B11 mim_unit
XXP_r35_c59_B8 TOP B8 mim_unit
XXP_r05_c21_B11 TOP B11 mim_unit
XXP_r64_c56_B11 TOP B11 mim_unit
XXP_r61_c25_B11 TOP B11 mim_unit
XXP_r02_c57_B11 TOP B11 mim_unit
XXP_r13_c00_EDGE EDGE_BIAS EDGE_BIAS mim_unit
XXP_r42_c62_B10 TOP B10 mim_unit
XXP_r23_c65_EDGE EDGE_BIAS EDGE_BIAS mim_unit
XXP_r05_c12_B11 TOP B11 mim_unit
XXP_r08_c43_B11 TOP B11 mim_unit
XXP_r00_c63_EDGE EDGE_BIAS EDGE_BIAS mim_unit
XXP_r64_c47_B11 TOP B11 mim_unit
XXP_r61_c16_B11 TOP B11 mim_unit
XXP_r34_c16_B7 TOP B7 mim_unit
XXP_r02_c48_B11 TOP B11 mim_unit
XXP_r08_c34_B11 TOP B11 mim_unit
XXP_r42_c53_B10 TOP B10 mim_unit
XXP_r05_c03_B11 TOP B11 mim_unit
XXP_r64_c38_B11 TOP B11 mim_unit
XXP_r61_c07_B11 TOP B11 mim_unit
XXP_r02_c39_B11 TOP B11 mim_unit
XXP_r08_c25_B11 TOP B11 mim_unit
XXP_r42_c44_B10 TOP B10 mim_unit
XXP_r30_c31_B8 TOP B8 mim_unit
XXP_r26_c22_B9 TOP B9 mim_unit
XXP_r64_c29_B11 TOP B11 mim_unit
XXP_r48_c30_B10 TOP B10 mim_unit
XXP_r08_c16_B11 TOP B11 mim_unit
XXP_r42_c35_B10 TOP B10 mim_unit
XXP_r15_c20_B11 TOP B11 mim_unit
XXP_r48_c21_B10 TOP B10 mim_unit
XXP_r37_c52_B9 TOP B9 mim_unit
XXP_r45_c57_B10 TOP B10 mim_unit
XXP_r08_c07_B11 TOP B11 mim_unit
XXP_r12_c56_B11 TOP B11 mim_unit
XXP_r17_c55_B10 TOP B10 mim_unit
XXP_r42_c26_B10 TOP B10 mim_unit
XXP_r28_c13_B9 TOP B9 mim_unit
XXP_r65_c50_EDGE EDGE_BIAS EDGE_BIAS mim_unit
XXP_r48_c12_B10 TOP B10 mim_unit
XXP_r32_c47_B5 TOP B5 mim_unit
XXP_r15_c11_B11 TOP B11 mim_unit
XXP_r30_c26_B8 TOP B8 mim_unit
XXP_r12_c47_B11 TOP B11 mim_unit
XXP_r17_c46_B10 TOP B10 mim_unit
XXP_r45_c48_B10 TOP B10 mim_unit
XXP_r42_c17_B10 TOP B10 mim_unit
XXP_r26_c17_B9 TOP B9 mim_unit
XXP_r39_c43_B9 TOP B9 mim_unit
XXP_r24_c50_B10 TOP B10 mim_unit
XXP_r15_c02_B11 TOP B11 mim_unit
XXP_r48_c03_B10 TOP B10 mim_unit
XXP_r12_c38_B11 TOP B11 mim_unit
XXP_r17_c37_B10 TOP B10 mim_unit
XXP_r45_c39_B10 TOP B10 mim_unit
XXP_r42_c08_B10 TOP B10 mim_unit
XXP_r37_c47_B9 TOP B9 mim_unit
XXP_r24_c41_B10 TOP B10 mim_unit
XXP_r21_c10_B10 TOP B10 mim_unit
XXP_r49_c57_B11 TOP B11 mim_unit
XXP_r28_c08_B9 TOP B9 mim_unit
XXP_r12_c29_B11 TOP B11 mim_unit
XXP_r17_c28_B10 TOP B10 mim_unit
XXP_r56_c61_B11 TOP B11 mim_unit
XXP_r53_c30_B11 TOP B11 mim_unit
XXP_r24_c32_B10 TOP B10 mim_unit
XXP_r22_c64_B11 TOP B11 mim_unit
XXP_r21_c01_B10 TOP B10 mim_unit
XXP_r49_c48_B11 TOP B11 mim_unit
XXP_r36_c04_B8 TOP B8 mim_unit
XXP_r39_c38_B9 TOP B9 mim_unit
XXP_r17_c19_B10 TOP B10 mim_unit
XXP_r56_c52_B11 TOP B11 mim_unit
XXP_r53_c21_B11 TOP B11 mim_unit
XXP_r24_c23_B10 TOP B10 mim_unit
XXP_r50_c57_B11 TOP B11 mim_unit
XXP_r49_c39_B11 TOP B11 mim_unit
XXP_r34_c24_B7 TOP B7 mim_unit
XXP_r21_c59_B10 TOP B10 mim_unit
XXP_r56_c43_B11 TOP B11 mim_unit
XXP_r53_c12_B11 TOP B11 mim_unit
XXP_r24_c14_B10 TOP B10 mim_unit
XXP_r50_c48_B11 TOP B11 mim_unit
XXP_r38_c00_EDGE EDGE_BIAS EDGE_BIAS mim_unit
XXP_r56_c34_B11 TOP B11 mim_unit
XXP_r53_c03_B11 TOP B11 mim_unit
XXP_r24_c05_B10 TOP B10 mim_unit
XXP_r50_c39_B11 TOP B11 mim_unit
XXP_r48_c65_EDGE EDGE_BIAS EDGE_BIAS mim_unit
XXP_r26_c30_B9 TOP B9 mim_unit
XXP_r33_c06_B3 TOP B3 mim_unit
XXP_r59_c56_B11 TOP B11 mim_unit
XXP_r56_c25_B11 TOP B11 mim_unit
XXP_r34_c19_B7 TOP B7 mim_unit
XXP_r37_c60_B9 TOP B9 mim_unit
XXP_r01_c30_B11 TOP B11 mim_unit
XXP_r04_c61_B11 TOP B11 mim_unit
XXP_r59_c47_B11 TOP B11 mim_unit
XXP_r56_c16_B11 TOP B11 mim_unit
XXP_r63_c20_B11 TOP B11 mim_unit
XXP_r28_c21_B9 TOP B9 mim_unit
XXP_r04_c52_B11 TOP B11 mim_unit
XXP_r01_c21_B11 TOP B11 mim_unit
XXP_r60_c56_B11 TOP B11 mim_unit
XXP_r59_c38_B11 TOP B11 mim_unit
XXP_r56_c07_B11 TOP B11 mim_unit
XXP_r30_c34_B8 TOP B8 mim_unit
XXP_r26_c25_B9 TOP B9 mim_unit
XXP_r63_c11_B11 TOP B11 mim_unit
XXP_r39_c51_B9 TOP B9 mim_unit
XXP_r04_c43_B11 TOP B11 mim_unit
XXP_r01_c12_B11 TOP B11 mim_unit
XXP_r60_c47_B11 TOP B11 mim_unit
XXP_r59_c29_B11 TOP B11 mim_unit
XXP_r63_c02_B11 TOP B11 mim_unit
XXP_r37_c55_B9 TOP B9 mim_unit
XXP_r04_c34_B11 TOP B11 mim_unit
XXP_r01_c03_B11 TOP B11 mim_unit
XXP_r65_c07_EDGE EDGE_BIAS EDGE_BIAS mim_unit
XXP_r60_c38_B11 TOP B11 mim_unit
XXP_r28_c16_B9 TOP B9 mim_unit
XXP_r30_c29_B8 TOP B8 mim_unit
XXP_r04_c25_B11 TOP B11 mim_unit
XXP_r07_c56_B11 TOP B11 mim_unit
XXP_r53_c00_EDGE EDGE_BIAS EDGE_BIAS mim_unit
XXP_r36_c12_B8 TOP B8 mim_unit
XXP_r14_c60_B11 TOP B11 mim_unit
XXP_r63_c65_EDGE EDGE_BIAS EDGE_BIAS mim_unit
XXP_r60_c29_B11 TOP B11 mim_unit
XXP_r47_c61_B10 TOP B10 mim_unit
XXP_r44_c30_B10 TOP B10 mim_unit
XXP_r39_c46_B9 TOP B9 mim_unit
XXP_r04_c16_B11 TOP B11 mim_unit
XXP_r07_c47_B11 TOP B11 mim_unit
XXP_r13_c64_B10 TOP B10 mim_unit
XXP_r34_c32_B7 TOP B7 mim_unit
XXP_r11_c20_B11 TOP B11 mim_unit
XXP_r14_c51_B11 TOP B11 mim_unit
XXP_r19_c50_B10 TOP B10 mim_unit
XXP_r47_c52_B10 TOP B10 mim_unit
XXP_r44_c21_B10 TOP B10 mim_unit
XXP_r41_c57_B10 TOP B10 mim_unit
XXP_r04_c07_B11 TOP B11 mim_unit
XXP_r07_c38_B11 TOP B11 mim_unit
XXP_r14_c42_B11 TOP B11 mim_unit
XXP_r19_c41_B10 TOP B10 mim_unit
XXP_r47_c43_B10 TOP B10 mim_unit
XXP_r44_c12_B10 TOP B10 mim_unit
XXP_r11_c11_B11 TOP B11 mim_unit
XXP_r36_c07_B8 TOP B8 mim_unit
XXP_r07_c29_B11 TOP B11 mim_unit
XXP_r41_c48_B10 TOP B10 mim_unit
XXP_r11_c02_B11 TOP B11 mim_unit
XXP_r14_c33_B11 TOP B11 mim_unit
XXP_r17_c64_B11 TOP B11 mim_unit
XXP_r19_c32_B10 TOP B10 mim_unit
XXP_r20_c50_B10 TOP B10 mim_unit
XXP_r47_c34_B10 TOP B10 mim_unit
XXP_r44_c03_B10 TOP B10 mim_unit
XXP_r00_c30_EDGE EDGE_BIAS EDGE_BIAS mim_unit
XXP_r41_c39_B10 TOP B10 mim_unit
XXP_r34_c27_B7 TOP B7 mim_unit
XXP_r19_c23_B10 TOP B10 mim_unit
XXP_r20_c41_B10 TOP B10 mim_unit
XXP_r47_c25_B10 TOP B10 mim_unit
XXP_r14_c24_B11 TOP B11 mim_unit
XXP_r52_c61_B11 TOP B11 mim_unit
XXP_r40_c02_B9 TOP B9 mim_unit
XXP_r23_c63_B10 TOP B10 mim_unit
XXP_r00_c53_EDGE EDGE_BIAS EDGE_BIAS mim_unit
XXP_r14_c15_B11 TOP B11 mim_unit
XXP_r19_c14_B10 TOP B10 mim_unit
XXP_r20_c32_B10 TOP B10 mim_unit
XXP_r47_c16_B10 TOP B10 mim_unit
XXP_r30_c42_B8 TOP B8 mim_unit
XXP_r26_c33_B9 TOP B9 mim_unit
XXP_r52_c52_B11 TOP B11 mim_unit
XXP_r23_c54_B10 TOP B10 mim_unit
XXP_r19_c05_B10 TOP B10 mim_unit
XXP_r20_c23_B10 TOP B10 mim_unit
XXP_r47_c07_B10 TOP B10 mim_unit
XXP_r14_c06_B11 TOP B11 mim_unit
XXP_r52_c43_B11 TOP B11 mim_unit
XXP_r37_c63_B9 TOP B9 mim_unit
XXP_r23_c45_B10 TOP B10 mim_unit
XXP_r20_c14_B10 TOP B10 mim_unit
XXP_r28_c24_B9 TOP B9 mim_unit
XXP_r52_c34_B11 TOP B11 mim_unit
XXP_r30_c37_B8 TOP B8 mim_unit
XXP_r20_c05_B10 TOP B10 mim_unit
XXP_r23_c36_B10 TOP B10 mim_unit
XXP_r58_c20_B11 TOP B11 mim_unit
XXP_r36_c20_B8 TOP B8 mim_unit
XXP_r33_c11_B4 TOP B4 mim_unit
XXP_r26_c28_B9 TOP B9 mim_unit
XXP_r39_c54_B9 TOP B9 mim_unit
XXP_r55_c56_B11 TOP B11 mim_unit
XXP_r52_c25_B11 TOP B11 mim_unit
XXP_r23_c27_B10 TOP B10 mim_unit
XXP_r65_c40_EDGE EDGE_BIAS EDGE_BIAS mim_unit
XXP_r62_c60_B11 TOP B11 mim_unit
XXP_r58_c11_B11 TOP B11 mim_unit
XXP_r37_c58_B9 TOP B9 mim_unit
XXP_r34_c40_B7 TOP B7 mim_unit
XXP_r55_c47_B11 TOP B11 mim_unit
XXP_r52_c16_B11 TOP B11 mim_unit
XXP_r28_c19_B9 TOP B9 mim_unit
XXP_r23_c18_B10 TOP B10 mim_unit
XXP_r62_c51_B11 TOP B11 mim_unit
XXP_r58_c02_B11 TOP B11 mim_unit
XXP_r07_c00_EDGE EDGE_BIAS EDGE_BIAS mim_unit
XXP_r59_c01_B9 TOP B9 mim_unit
XXP_r55_c38_B11 TOP B11 mim_unit
XXP_r52_c07_B11 TOP B11 mim_unit
XXP_r36_c15_B8 TOP B8 mim_unit
XXP_r39_c49_B9 TOP B9 mim_unit
XXP_r17_c65_EDGE EDGE_BIAS EDGE_BIAS mim_unit
XXP_r23_c09_B10 TOP B10 mim_unit
XXP_r65_c63_EDGE EDGE_BIAS EDGE_BIAS mim_unit
XXP_r62_c42_B11 TOP B11 mim_unit
XXP_r55_c29_B11 TOP B11 mim_unit
XXP_r09_c60_B11 TOP B11 mim_unit
XXP_r34_c35_B7 TOP B7 mim_unit
XXP_r62_c33_B11 TOP B11 mim_unit
XXP_r06_c20_B11 TOP B11 mim_unit
XXP_r09_c51_B11 TOP B11 mim_unit
XXP_r40_c10_B9 TOP B9 mim_unit
XXP_r62_c24_B11 TOP B11 mim_unit
XXP_r03_c56_B11 TOP B11 mim_unit
XXP_r30_c50_B8 TOP B8 mim_unit
XXP_r26_c41_B9 TOP B9 mim_unit
XXP_r06_c11_B11 TOP B11 mim_unit
XXP_r09_c42_B11 TOP B11 mim_unit
XXP_r10_c60_B11 TOP B11 mim_unit
XXP_r43_c61_B10 TOP B10 mim_unit
XXP_r62_c15_B11 TOP B11 mim_unit
XXP_r03_c47_B11 TOP B11 mim_unit
XXP_r43_c52_B10 TOP B10 mim_unit
XXP_r06_c02_B11 TOP B11 mim_unit
XXP_r09_c33_B11 TOP B11 mim_unit
XXP_r10_c51_B11 TOP B11 mim_unit
XXP_r62_c06_B11 TOP B11 mim_unit
XXP_r03_c38_B11 TOP B11 mim_unit
XXP_r40_c05_B9 TOP B9 mim_unit
XXP_r28_c32_B9 TOP B9 mim_unit
XXP_r09_c24_B11 TOP B11 mim_unit
XXP_r10_c42_B11 TOP B11 mim_unit
XXP_r43_c43_B10 TOP B10 mim_unit
XXP_r30_c45_B8 TOP B8 mim_unit
XXP_r03_c29_B11 TOP B11 mim_unit
XXP_r26_c36_B9 TOP B9 mim_unit
XXP_r22_c00_EDGE EDGE_BIAS EDGE_BIAS mim_unit
XXP_r43_c34_B10 TOP B10 mim_unit
XXP_r39_c62_B9 TOP B9 mim_unit
XXP_r32_c65_EDGE EDGE_BIAS EDGE_BIAS mim_unit
XXP_r09_c15_B11 TOP B11 mim_unit
XXP_r10_c33_B11 TOP B11 mim_unit
XXP_r18_c63_B10 TOP B10 mim_unit
XXP_r09_c06_B11 TOP B11 mim_unit
XXP_r10_c24_B11 TOP B11 mim_unit
XXP_r13_c55_B11 TOP B11 mim_unit
XXP_r18_c54_B10 TOP B10 mim_unit
XXP_r46_c56_B10 TOP B10 mim_unit
XXP_r43_c25_B10 TOP B10 mim_unit
XXP_r38_c03_B9 TOP B9 mim_unit
XXP_r28_c27_B9 TOP B9 mim_unit
XXP_r16_c10_B11 TOP B11 mim_unit
XXP_r46_c47_B10 TOP B10 mim_unit
XXP_r10_c15_B11 TOP B11 mim_unit
XXP_r13_c46_B11 TOP B11 mim_unit
XXP_r18_c45_B10 TOP B10 mim_unit
XXP_r43_c16_B10 TOP B10 mim_unit
XXP_r36_c23_B8 TOP B8 mim_unit
XXP_r39_c57_B9 TOP B9 mim_unit
XXP_r33_c14_B4 TOP B4 mim_unit
XXP_r16_c01_B11 TOP B11 mim_unit
XXP_r10_c06_B11 TOP B11 mim_unit
XXP_r13_c37_B11 TOP B11 mim_unit
XXP_r18_c36_B10 TOP B10 mim_unit
XXP_r46_c38_B10 TOP B10 mim_unit
XXP_r43_c07_B10 TOP B10 mim_unit
XXP_r34_c43_B7 TOP B7 mim_unit
XXP_r57_c60_B11 TOP B11 mim_unit
XXP_r46_c29_B10 TOP B10 mim_unit
XXP_r13_c28_B11 TOP B11 mim_unit
XXP_r16_c59_B11 TOP B11 mim_unit
XXP_r18_c27_B10 TOP B10 mim_unit
XXP_r36_c18_B8 TOP B8 mim_unit
XXP_r13_c19_B11 TOP B11 mim_unit
XXP_r18_c18_B10 TOP B10 mim_unit
XXP_r57_c51_B11 TOP B11 mim_unit
XXP_r54_c20_B11 TOP B11 mim_unit
XXP_r33_c09_B4 TOP B4 mim_unit
XXP_r51_c56_B11 TOP B11 mim_unit
XXP_r34_c38_B7 TOP B7 mim_unit
XXP_r22_c58_B10 TOP B10 mim_unit
XXP_r18_c09_B10 TOP B10 mim_unit
XXP_r57_c42_B11 TOP B11 mim_unit
XXP_r54_c11_B11 TOP B11 mim_unit
XXP_r51_c47_B11 TOP B11 mim_unit
XXP_r22_c49_B10 TOP B10 mim_unit
XXP_r57_c33_B11 TOP B11 mim_unit
XXP_r54_c02_B11 TOP B11 mim_unit
XXP_r40_c13_B9 TOP B9 mim_unit
XXP_r28_c40_B9 TOP B9 mim_unit
XXP_r00_c20_EDGE EDGE_BIAS EDGE_BIAS mim_unit
XXP_r51_c38_B11 TOP B11 mim_unit
XXP_r30_c53_B8 TOP B8 mim_unit
XXP_r26_c44_B9 TOP B9 mim_unit
XXP_r57_c24_B11 TOP B11 mim_unit
XXP_r51_c29_B11 TOP B11 mim_unit
XXP_r05_c60_B11 TOP B11 mim_unit
XXP_r61_c64_B11 TOP B11 mim_unit
XXP_r57_c15_B11 TOP B11 mim_unit
XXP_r00_c43_EDGE EDGE_BIAS EDGE_BIAS mim_unit
XXP_r38_c11_B9 TOP B9 mim_unit
XXP_r40_c08_B9 TOP B9 mim_unit
XXP_r28_c35_B9 TOP B9 mim_unit
XXP_r05_c51_B11 TOP B11 mim_unit
XXP_r02_c20_B11 TOP B11 mim_unit
XXP_r61_c55_B11 TOP B11 mim_unit
XXP_r57_c06_B11 TOP B11 mim_unit
XXP_r47_c00_EDGE EDGE_BIAS EDGE_BIAS mim_unit
XXP_r30_c48_B8 TOP B8 mim_unit
XXP_r64_c10_B11 TOP B11 mim_unit
XXP_r57_c65_EDGE EDGE_BIAS EDGE_BIAS mim_unit
XXP_r36_c31_B8 TOP B8 mim_unit
XXP_r26_c39_B9 TOP B9 mim_unit
XXP_r05_c42_B11 TOP B11 mim_unit
XXP_r02_c11_B11 TOP B11 mim_unit
XXP_r31_c01_B7 TOP B7 mim_unit
XXP_r61_c46_B11 TOP B11 mim_unit
XXP_r34_c51_B7 TOP B7 mim_unit
XXP_r05_c33_B11 TOP B11 mim_unit
XXP_r02_c02_B11 TOP B11 mim_unit
XXP_r61_c37_B11 TOP B11 mim_unit
XXP_r38_c06_B9 TOP B9 mim_unit
XXP_r05_c24_B11 TOP B11 mim_unit
XXP_r08_c55_B11 TOP B11 mim_unit
XXP_r64_c59_B11 TOP B11 mim_unit
XXP_r61_c28_B11 TOP B11 mim_unit
XXP_r48_c60_B10 TOP B10 mim_unit
XXP_r36_c26_B8 TOP B8 mim_unit
XXP_r65_c30_EDGE EDGE_BIAS EDGE_BIAS mim_unit
XXP_r05_c15_B11 TOP B11 mim_unit
XXP_r08_c46_B11 TOP B11 mim_unit
XXP_r15_c50_B11 TOP B11 mim_unit
XXP_r61_c19_B11 TOP B11 mim_unit
XXP_r48_c51_B10 TOP B10 mim_unit
XXP_r45_c20_B10 TOP B10 mim_unit
XXP_r34_c46_B7 TOP B7 mim_unit
XXP_r05_c06_B11 TOP B11 mim_unit
XXP_r08_c37_B11 TOP B11 mim_unit
XXP_r42_c56_B10 TOP B10 mim_unit
XXP_r12_c10_B11 TOP B11 mim_unit
XXP_r15_c41_B11 TOP B11 mim_unit
XXP_r65_c53_EDGE EDGE_BIAS EDGE_BIAS mim_unit
XXP_r48_c42_B10 TOP B10 mim_unit
XXP_r45_c11_B10 TOP B10 mim_unit
XXP_r40_c21_B9 TOP B9 mim_unit
XXP_r42_c47_B10 TOP B10 mim_unit
XXP_r30_c61_B8 TOP B8 mim_unit
XXP_r08_c28_B11 TOP B11 mim_unit
XXP_r62_c00_EDGE EDGE_BIAS EDGE_BIAS mim_unit
XXP_r26_c52_B9 TOP B9 mim_unit
XXP_r15_c32_B11 TOP B11 mim_unit
XXP_r48_c33_B10 TOP B10 mim_unit
XXP_r45_c02_B10 TOP B10 mim_unit
XXP_r12_c01_B11 TOP B11 mim_unit
XXP_r01_c65_EDGE EDGE_BIAS EDGE_BIAS mim_unit
XXP_r08_c19_B11 TOP B11 mim_unit
XXP_r49_c20_B11 TOP B11 mim_unit
XXP_r42_c38_B10 TOP B10 mim_unit
XXP_r15_c23_B11 TOP B11 mim_unit
XXP_r21_c40_B10 TOP B10 mim_unit
XXP_r48_c24_B10 TOP B10 mim_unit
XXP_r17_c58_B10 TOP B10 mim_unit
XXP_r53_c60_B11 TOP B11 mim_unit
XXP_r49_c11_B11 TOP B11 mim_unit
XXP_r42_c29_B10 TOP B10 mim_unit
XXP_r12_c59_B11 TOP B11 mim_unit
XXP_r40_c16_B9 TOP B9 mim_unit
XXP_r28_c43_B9 TOP B9 mim_unit
XXP_r24_c62_B10 TOP B10 mim_unit
XXP_r15_c14_B11 TOP B11 mim_unit
XXP_r21_c31_B10 TOP B10 mim_unit
XXP_r48_c15_B10 TOP B10 mim_unit
XXP_r30_c56_B8 TOP B8 mim_unit
XXP_r17_c49_B10 TOP B10 mim_unit
XXP_r53_c51_B11 TOP B11 mim_unit
XXP_r50_c20_B11 TOP B11 mim_unit
XXP_r49_c02_B11 TOP B11 mim_unit
XXP_r26_c47_B9 TOP B9 mim_unit
XXP_r24_c53_B10 TOP B10 mim_unit
XXP_r15_c05_B11 TOP B11 mim_unit
XXP_r21_c22_B10 TOP B10 mim_unit
XXP_r48_c06_B10 TOP B10 mim_unit
XXP_r53_c42_B11 TOP B11 mim_unit
XXP_r50_c11_B11 TOP B11 mim_unit
XXP_r24_c44_B10 TOP B10 mim_unit
XXP_r21_c13_B10 TOP B10 mim_unit
XXP_r38_c14_B9 TOP B9 mim_unit
XXP_r28_c38_B9 TOP B9 mim_unit
XXP_r56_c64_B11 TOP B11 mim_unit
XXP_r55_c01_B10 TOP B10 mim_unit
XXP_r53_c33_B11 TOP B11 mim_unit
XXP_r50_c02_B11 TOP B11 mim_unit
XXP_r24_c35_B10 TOP B10 mim_unit
XXP_r21_c04_B10 TOP B10 mim_unit
XXP_r36_c34_B8 TOP B8 mim_unit
XXP_r56_c55_B11 TOP B11 mim_unit
XXP_r53_c24_B11 TOP B11 mim_unit
XXP_r31_c04_B7 TOP B7 mim_unit
XXP_r24_c26_B10 TOP B10 mim_unit
XXP_r59_c10_B11 TOP B11 mim_unit
XXP_r01_c60_B11 TOP B11 mim_unit
XXP_r34_c54_B7 TOP B7 mim_unit
XXP_r56_c46_B11 TOP B11 mim_unit
XXP_r53_c15_B11 TOP B11 mim_unit
XXP_r38_c09_B9 TOP B9 mim_unit
XXP_r24_c17_B10 TOP B10 mim_unit
XXP_r63_c50_B11 TOP B11 mim_unit
XXP_r01_c51_B11 TOP B11 mim_unit
XXP_r56_c37_B11 TOP B11 mim_unit
XXP_r53_c06_B11 TOP B11 mim_unit
XXP_r36_c29_B8 TOP B8 mim_unit
XXP_r24_c08_B10 TOP B10 mim_unit
XXP_r63_c41_B11 TOP B11 mim_unit
XXP_r60_c10_B11 TOP B11 mim_unit
XXP_r26_c60_B9 TOP B9 mim_unit
XXP_r01_c42_B11 TOP B11 mim_unit
XXP_r59_c59_B11 TOP B11 mim_unit
XXP_r56_c28_B11 TOP B11 mim_unit
XXP_r34_c49_B7 TOP B7 mim_unit
XXP_r63_c32_B11 TOP B11 mim_unit
XXP_r25_c01_B9 TOP B9 mim_unit
XXP_r01_c33_B11 TOP B11 mim_unit
XXP_r56_c19_B11 TOP B11 mim_unit
XXP_r63_c23_B11 TOP B11 mim_unit
XXP_r40_c24_B9 TOP B9 mim_unit
XXP_r28_c51_B9 TOP B9 mim_unit
XXP_r04_c55_B11 TOP B11 mim_unit
XXP_r01_c24_B11 TOP B11 mim_unit
XXP_r16_c00_EDGE EDGE_BIAS EDGE_BIAS mim_unit
XXP_r60_c59_B11 TOP B11 mim_unit
XXP_r44_c60_B10 TOP B10 mim_unit
XXP_r33_c22_B5 TOP B5 mim_unit
XXP_r26_c55_B9 TOP B9 mim_unit
XXP_r07_c10_B11 TOP B11 mim_unit
XXP_r26_c65_EDGE EDGE_BIAS EDGE_BIAS mim_unit
XXP_r63_c14_B11 TOP B11 mim_unit
XXP_r04_c46_B11 TOP B11 mim_unit
XXP_r01_c15_B11 TOP B11 mim_unit
XXP_r07_c01_B11 TOP B11 mim_unit
XXP_r11_c50_B11 TOP B11 mim_unit
XXP_r44_c51_B10 TOP B10 mim_unit
XXP_r41_c20_B10 TOP B10 mim_unit
XXP_r63_c05_B11 TOP B11 mim_unit
XXP_r04_c37_B11 TOP B11 mim_unit
XXP_r01_c06_B11 TOP B11 mim_unit
XXP_r00_c10_EDGE EDGE_BIAS EDGE_BIAS mim_unit
XXP_r38_c22_B9 TOP B9 mim_unit
XXP_r44_c42_B10 TOP B10 mim_unit
XXP_r40_c19_B9 TOP B9 mim_unit
XXP_r28_c46_B9 TOP B9 mim_unit
XXP_r11_c41_B11 TOP B11 mim_unit
XXP_r41_c11_B10 TOP B10 mim_unit
XXP_r30_c59_B8 TOP B8 mim_unit
XXP_r04_c28_B11 TOP B11 mim_unit
XXP_r07_c59_B11 TOP B11 mim_unit
XXP_r36_c42_B8 TOP B8 mim_unit
XXP_r33_c17_B5 TOP B5 mim_unit
XXP_r11_c32_B11 TOP B11 mim_unit
XXP_r14_c63_B11 TOP B11 mim_unit
XXP_r19_c62_B10 TOP B10 mim_unit
XXP_r47_c64_B10 TOP B10 mim_unit
XXP_r44_c33_B10 TOP B10 mim_unit
XXP_r41_c02_B10 TOP B10 mim_unit
XXP_r31_c12_B7 TOP B7 mim_unit
XXP_r00_c33_EDGE EDGE_BIAS EDGE_BIAS mim_unit
XXP_r04_c19_B11 TOP B11 mim_unit
XXP_r19_c53_B10 TOP B10 mim_unit
XXP_r47_c55_B10 TOP B10 mim_unit
XXP_r44_c24_B10 TOP B10 mim_unit
XXP_r34_c62_B7 TOP B7 mim_unit
XXP_r11_c23_B11 TOP B11 mim_unit
XXP_r14_c54_B11 TOP B11 mim_unit
XXP_r38_c17_B9 TOP B9 mim_unit
XXP_r00_c56_EDGE EDGE_BIAS EDGE_BIAS mim_unit
XXP_r11_c14_B11 TOP B11 mim_unit
XXP_r14_c45_B11 TOP B11 mim_unit
XXP_r19_c44_B10 TOP B10 mim_unit
XXP_r20_c62_B10 TOP B10 mim_unit
XXP_r47_c46_B10 TOP B10 mim_unit
XXP_r44_c15_B10 TOP B10 mim_unit
XXP_r36_c37_B8 TOP B8 mim_unit
XXP_r31_c00_EDGE EDGE_BIAS EDGE_BIAS mim_unit
XXP_r20_c53_B10 TOP B10 mim_unit
XXP_r47_c37_B10 TOP B10 mim_unit
XXP_r44_c06_B10 TOP B10 mim_unit
XXP_r41_c65_EDGE EDGE_BIAS EDGE_BIAS mim_unit
XXP_r31_c07_B7 TOP B7 mim_unit
XXP_r11_c05_B11 TOP B11 mim_unit
XXP_r14_c36_B11 TOP B11 mim_unit
XXP_r19_c35_B10 TOP B10 mim_unit
XXP_r34_c57_B7 TOP B7 mim_unit
XXP_r14_c27_B11 TOP B11 mim_unit
XXP_r19_c26_B10 TOP B10 mim_unit
XXP_r20_c44_B10 TOP B10 mim_unit
XXP_r47_c28_B10 TOP B10 mim_unit
XXP_r65_c20_EDGE EDGE_BIAS EDGE_BIAS mim_unit
XXP_r52_c64_B11 TOP B11 mim_unit
XXP_r51_c01_B10 TOP B10 mim_unit
XXP_r40_c32_B9 TOP B9 mim_unit
XXP_r58_c50_B11 TOP B11 mim_unit
XXP_r47_c19_B10 TOP B10 mim_unit
XXP_r14_c18_B11 TOP B11 mim_unit
XXP_r19_c17_B10 TOP B10 mim_unit
XXP_r20_c35_B10 TOP B10 mim_unit
XXP_r33_c30_B5 TOP B5 mim_unit
XXP_r26_c63_B9 TOP B9 mim_unit
XXP_r52_c55_B11 TOP B11 mim_unit
XXP_r23_c57_B10 TOP B10 mim_unit
XXP_r14_c09_B11 TOP B11 mim_unit
XXP_r19_c08_B10 TOP B10 mim_unit
XXP_r20_c26_B10 TOP B10 mim_unit
XXP_r65_c43_EDGE EDGE_BIAS EDGE_BIAS mim_unit
XXP_r58_c41_B11 TOP B11 mim_unit
XXP_r55_c10_B11 TOP B11 mim_unit
XXP_r52_c46_B11 TOP B11 mim_unit
XXP_r25_c04_B9 TOP B9 mim_unit
XXP_r23_c48_B10 TOP B10 mim_unit
XXP_r58_c32_B11 TOP B11 mim_unit
XXP_r38_c30_B9 TOP B9 mim_unit
XXP_r20_c17_B10 TOP B10 mim_unit
XXP_r40_c27_B9 TOP B9 mim_unit
XXP_r28_c54_B9 TOP B9 mim_unit
XXP_r52_c37_B11 TOP B11 mim_unit
XXP_r33_c25_B5 TOP B5 mim_unit
XXP_r20_c08_B10 TOP B10 mim_unit
XXP_r23_c39_B10 TOP B10 mim_unit
XXP_r58_c23_B11 TOP B11 mim_unit
XXP_r36_c50_B8 TOP B8 mim_unit
XXP_r26_c58_B9 TOP B9 mim_unit
XXP_r31_c20_B7 TOP B7 mim_unit
XXP_r55_c59_B11 TOP B11 mim_unit
XXP_r52_c28_B11 TOP B11 mim_unit
XXP_r62_c63_B11 TOP B11 mim_unit
XXP_r58_c14_B11 TOP B11 mim_unit
XXP_r52_c19_B11 TOP B11 mim_unit
XXP_r38_c25_B9 TOP B9 mim_unit
XXP_r06_c50_B11 TOP B11 mim_unit
XXP_r28_c49_B9 TOP B9 mim_unit
XXP_r62_c54_B11 TOP B11 mim_unit
XXP_r58_c05_B11 TOP B11 mim_unit
XXP_r36_c45_B8 TOP B8 mim_unit
XXP_r29_c02_B8 TOP B8 mim_unit
XXP_r03_c10_B11 TOP B11 mim_unit
XXP_r06_c41_B11 TOP B11 mim_unit
XXP_r62_c45_B11 TOP B11 mim_unit
XXP_r31_c15_B7 TOP B7 mim_unit
XXP_r03_c01_B11 TOP B11 mim_unit
XXP_r06_c32_B11 TOP B11 mim_unit
XXP_r09_c63_B11 TOP B11 mim_unit
XXP_r62_c36_B11 TOP B11 mim_unit
XXP_r06_c23_B11 TOP B11 mim_unit
XXP_r09_c54_B11 TOP B11 mim_unit
XXP_r62_c27_B11 TOP B11 mim_unit
XXP_r40_c40_B9 TOP B9 mim_unit
XXP_r03_c59_B11 TOP B11 mim_unit
XXP_r56_c00_EDGE EDGE_BIAS EDGE_BIAS mim_unit
XXP_r06_c14_B11 TOP B11 mim_unit
XXP_r09_c45_B11 TOP B11 mim_unit
XXP_r10_c63_B11 TOP B11 mim_unit
XXP_r43_c64_B10 TOP B10 mim_unit
XXP_r62_c18_B11 TOP B11 mim_unit
XXP_r43_c55_B10 TOP B10 mim_unit
XXP_r25_c12_B9 TOP B9 mim_unit
XXP_r06_c05_B11 TOP B11 mim_unit
XXP_r09_c36_B11 TOP B11 mim_unit
XXP_r10_c54_B11 TOP B11 mim_unit
XXP_r62_c09_B11 TOP B11 mim_unit
XXP_r16_c40_B11 TOP B11 mim_unit
XXP_r46_c10_B10 TOP B10 mim_unit
XXP_r40_c35_B9 TOP B9 mim_unit
XXP_r28_c62_B9 TOP B9 mim_unit
XXP_r09_c27_B11 TOP B11 mim_unit
XXP_r10_c45_B11 TOP B11 mim_unit
XXP_r43_c46_B10 TOP B10 mim_unit
XXP_r16_c31_B11 TOP B11 mim_unit
XXP_r43_c37_B10 TOP B10 mim_unit
XXP_r27_c03_B9 TOP B9 mim_unit
XXP_r09_c18_B11 TOP B11 mim_unit
XXP_r10_c36_B11 TOP B11 mim_unit
XXP_r16_c22_B11 TOP B11 mim_unit
XXP_r25_c07_B9 TOP B9 mim_unit
XXP_r09_c09_B11 TOP B11 mim_unit
XXP_r10_c27_B11 TOP B11 mim_unit
XXP_r13_c58_B11 TOP B11 mim_unit
XXP_r18_c57_B10 TOP B10 mim_unit
XXP_r46_c59_B10 TOP B10 mim_unit
XXP_r43_c28_B10 TOP B10 mim_unit
XXP_r38_c33_B9 TOP B9 mim_unit
XXP_r28_c57_B9 TOP B9 mim_unit
XXP_r16_c13_B11 TOP B11 mim_unit
XXP_r22_c30_B10 TOP B10 mim_unit
XXP_r18_c48_B10 TOP B10 mim_unit
XXP_r54_c50_B11 TOP B11 mim_unit
XXP_r43_c19_B10 TOP B10 mim_unit
XXP_r29_c10_B8 TOP B8 mim_unit
XXP_r10_c18_B11 TOP B11 mim_unit
XXP_r13_c49_B11 TOP B11 mim_unit
XXP_r36_c53_B8 TOP B8 mim_unit
XXP_r33_c28_B5 TOP B5 mim_unit
XXP_r16_c04_B11 TOP B11 mim_unit
XXP_r22_c21_B10 TOP B10 mim_unit
XXP_r31_c23_B7 TOP B7 mim_unit
XXP_r00_c00_EDGE EDGE_BIAS EDGE_BIAS mim_unit
XXP_r10_c09_B11 TOP B11 mim_unit
XXP_r10_c65_EDGE EDGE_BIAS EDGE_BIAS mim_unit
XXP_r18_c39_B10 TOP B10 mim_unit
XXP_r54_c41_B11 TOP B11 mim_unit
XXP_r51_c10_B11 TOP B11 mim_unit
XXP_r22_c12_B10 TOP B10 mim_unit
XXP_r38_c28_B9 TOP B9 mim_unit
XXP_r57_c63_B11 TOP B11 mim_unit
XXP_r54_c32_B11 TOP B11 mim_unit
XXP_r00_c23_EDGE EDGE_BIAS EDGE_BIAS mim_unit
XXP_r22_c03_B10 TOP B10 mim_unit
XXP_r36_c48_B8 TOP B8 mim_unit
XXP_r29_c05_B8 TOP B8 mim_unit
XXP_r57_c54_B11 TOP B11 mim_unit
XXP_r54_c23_B11 TOP B11 mim_unit
XXP_r31_c18_B7 TOP B7 mim_unit
XXP_r51_c59_B11 TOP B11 mim_unit
XXP_r57_c45_B11 TOP B11 mim_unit
XXP_r54_c14_B11 TOP B11 mim_unit
XXP_r00_c46_EDGE EDGE_BIAS EDGE_BIAS mim_unit
XXP_r07_c64_B9 TOP B9 mim_unit
XXP_r25_c20_B9 TOP B9 mim_unit
XXP_r02_c50_B11 TOP B11 mim_unit
XXP_r57_c36_B11 TOP B11 mim_unit
XXP_r54_c05_B11 TOP B11 mim_unit
XXP_r40_c43_B9 TOP B9 mim_unit
XXP_r64_c40_B11 TOP B11 mim_unit
XXP_r02_c41_B11 TOP B11 mim_unit
XXP_r57_c27_B11 TOP B11 mim_unit
XXP_r27_c11_B9 TOP B9 mim_unit
XXP_r64_c31_B11 TOP B11 mim_unit
XXP_r65_c10_EDGE EDGE_BIAS EDGE_BIAS mim_unit
XXP_r02_c32_B11 TOP B11 mim_unit
XXP_r05_c63_B11 TOP B11 mim_unit
XXP_r57_c18_B11 TOP B11 mim_unit
XXP_r25_c15_B9 TOP B9 mim_unit
XXP_r38_c41_B9 TOP B9 mim_unit
XXP_r64_c22_B11 TOP B11 mim_unit
XXP_r40_c38_B9 TOP B9 mim_unit
XXP_r05_c54_B11 TOP B11 mim_unit
XXP_r02_c23_B11 TOP B11 mim_unit
XXP_r61_c58_B11 TOP B11 mim_unit
XXP_r57_c09_B11 TOP B11 mim_unit
XXP_r65_c33_EDGE EDGE_BIAS EDGE_BIAS mim_unit
XXP_r64_c13_B11 TOP B11 mim_unit
XXP_r36_c61_B8 TOP B8 mim_unit
XXP_r05_c45_B11 TOP B11 mim_unit
XXP_r02_c14_B11 TOP B11 mim_unit
XXP_r31_c31_B7 TOP B7 mim_unit
XXP_r27_c06_B9 TOP B9 mim_unit
XXP_r61_c49_B11 TOP B11 mim_unit
XXP_r45_c50_B10 TOP B10 mim_unit
XXP_r64_c04_B11 TOP B11 mim_unit
XXP_r35_c02_B8 TOP B8 mim_unit
XXP_r05_c36_B11 TOP B11 mim_unit
XXP_r02_c05_B11 TOP B11 mim_unit
XXP_r38_c36_B9 TOP B9 mim_unit
XXP_r12_c40_B11 TOP B11 mim_unit
XXP_r65_c56_EDGE EDGE_BIAS EDGE_BIAS mim_unit
XXP_r45_c41_B10 TOP B10 mim_unit
XXP_r42_c10_B10 TOP B10 mim_unit
XXP_r05_c27_B11 TOP B11 mim_unit
XXP_r08_c58_B11 TOP B11 mim_unit
XXP_r29_c13_B8 TOP B8 mim_unit
XXP_r25_c00_EDGE EDGE_BIAS EDGE_BIAS mim_unit
XXP_r17_c30_B10 TOP B10 mim_unit
XXP_r48_c63_B10 TOP B10 mim_unit
XXP_r45_c32_B10 TOP B10 mim_unit
XXP_r36_c56_B8 TOP B8 mim_unit
XXP_r12_c31_B11 TOP B11 mim_unit
XXP_r15_c62_B11 TOP B11 mim_unit
XXP_r35_c65_EDGE EDGE_BIAS EDGE_BIAS mim_unit
XXP_r08_c49_B11 TOP B11 mim_unit
XXP_r49_c50_B11 TOP B11 mim_unit
XXP_r31_c26_B7 TOP B7 mim_unit
XXP_r05_c18_B11 TOP B11 mim_unit
XXP_r12_c22_B11 TOP B11 mim_unit
XXP_r15_c53_B11 TOP B11 mim_unit
XXP_r17_c21_B10 TOP B10 mim_unit
XXP_r48_c54_B10 TOP B10 mim_unit
XXP_r45_c23_B10 TOP B10 mim_unit
XXP_r05_c09_B11 TOP B11 mim_unit
XXP_r49_c41_B11 TOP B11 mim_unit
XXP_r42_c59_B10 TOP B10 mim_unit
XXP_r21_c61_B10 TOP B10 mim_unit
XXP_r48_c45_B10 TOP B10 mim_unit
XXP_r45_c14_B10 TOP B10 mim_unit
XXP_r12_c13_B11 TOP B11 mim_unit
XXP_r15_c44_B11 TOP B11 mim_unit
XXP_r17_c12_B10 TOP B10 mim_unit
XXP_r40_c51_B9 TOP B9 mim_unit
XXP_r50_c50_B11 TOP B11 mim_unit
XXP_r49_c32_B11 TOP B11 mim_unit
XXP_r46_c01_B11 TOP B11 mim_unit
XXP_r29_c08_B8 TOP B8 mim_unit
XXP_r12_c04_B11 TOP B11 mim_unit
XXP_r15_c35_B11 TOP B11 mim_unit
XXP_r17_c03_B10 TOP B10 mim_unit
XXP_r21_c52_B10 TOP B10 mim_unit
XXP_r48_c36_B10 TOP B10 mim_unit
XXP_r45_c05_B10 TOP B10 mim_unit
XXP_r50_c41_B11 TOP B11 mim_unit
XXP_r49_c23_B11 TOP B11 mim_unit
XXP_r21_c43_B10 TOP B10 mim_unit
XXP_r48_c27_B10 TOP B10 mim_unit
XXP_r25_c23_B9 TOP B9 mim_unit
XXP_r15_c26_B11 TOP B11 mim_unit
XXP_r53_c63_B11 TOP B11 mim_unit
XXP_r50_c32_B11 TOP B11 mim_unit
XXP_r49_c14_B11 TOP B11 mim_unit
XXP_r40_c46_B9 TOP B9 mim_unit
XXP_r15_c17_B11 TOP B11 mim_unit
XXP_r21_c34_B10 TOP B10 mim_unit
XXP_r48_c18_B10 TOP B10 mim_unit
XXP_r53_c54_B11 TOP B11 mim_unit
XXP_r50_c23_B11 TOP B11 mim_unit
XXP_r49_c05_B11 TOP B11 mim_unit
XXP_r40_c00_EDGE EDGE_BIAS EDGE_BIAS mim_unit
XXP_r24_c56_B10 TOP B10 mim_unit
XXP_r21_c25_B10 TOP B10 mim_unit
XXP_r59_c40_B11 TOP B11 mim_unit
XXP_r50_c65_EDGE EDGE_BIAS EDGE_BIAS mim_unit
XXP_r48_c09_B10 TOP B10 mim_unit
XXP_r27_c14_B9 TOP B9 mim_unit
XXP_r15_c08_B11 TOP B11 mim_unit
XXP_r53_c45_B11 TOP B11 mim_unit
XXP_r50_c14_B11 TOP B11 mim_unit
XXP_r35_c10_B8 TOP B8 mim_unit
XXP_r24_c47_B10 TOP B10 mim_unit
XXP_r25_c18_B9 TOP B9 mim_unit
XXP_r21_c16_B10 TOP B10 mim_unit
XXP_r59_c31_B11 TOP B11 mim_unit
XXP_r38_c44_B9 TOP B9 mim_unit
XXP_r53_c36_B11 TOP B11 mim_unit
XXP_r50_c05_B11 TOP B11 mim_unit
XXP_r24_c38_B10 TOP B10 mim_unit
XXP_r60_c40_B11 TOP B11 mim_unit
XXP_r59_c22_B11 TOP B11 mim_unit
XXP_r29_c21_B8 TOP B8 mim_unit
XXP_r21_c07_B10 TOP B10 mim_unit
XXP_r36_c64_B8 TOP B8 mim_unit
XXP_r56_c58_B11 TOP B11 mim_unit
XXP_r53_c27_B11 TOP B11 mim_unit
XXP_r31_c34_B7 TOP B7 mim_unit
XXP_r27_c09_B9 TOP B9 mim_unit
XXP_r24_c29_B10 TOP B10 mim_unit
XXP_r63_c62_B11 TOP B11 mim_unit
XXP_r60_c31_B11 TOP B11 mim_unit
XXP_r59_c13_B11 TOP B11 mim_unit
XXP_r01_c63_B11 TOP B11 mim_unit
XXP_r35_c05_B8 TOP B8 mim_unit
XXP_r56_c49_B11 TOP B11 mim_unit
XXP_r53_c18_B11 TOP B11 mim_unit
XXP_r38_c39_B9 TOP B9 mim_unit
XXP_r63_c53_B11 TOP B11 mim_unit
XXP_r60_c22_B11 TOP B11 mim_unit
XXP_r59_c04_B11 TOP B11 mim_unit
XXP_r01_c54_B11 TOP B11 mim_unit
XXP_r53_c09_B11 TOP B11 mim_unit
XXP_r07_c40_B11 TOP B11 mim_unit
XXP_r36_c59_B8 TOP B8 mim_unit
XXP_r33_c41_B6 TOP B6 mim_unit
XXP_r29_c16_B8 TOP B8 mim_unit
XXP_r63_c44_B11 TOP B11 mim_unit
XXP_r60_c13_B11 TOP B11 mim_unit
XXP_r01_c45_B11 TOP B11 mim_unit
XXP_r31_c29_B7 TOP B7 mim_unit
XXP_r41_c50_B10 TOP B10 mim_unit
XXP_r07_c31_B11 TOP B11 mim_unit
XXP_r63_c35_B11 TOP B11 mim_unit
XXP_r60_c04_B11 TOP B11 mim_unit
XXP_r00_c13_EDGE EDGE_BIAS EDGE_BIAS mim_unit
XXP_r01_c36_B11 TOP B11 mim_unit
XXP_r25_c31_B9 TOP B9 mim_unit
XXP_r07_c22_B11 TOP B11 mim_unit
XXP_r41_c41_B10 TOP B10 mim_unit
XXP_r63_c26_B11 TOP B11 mim_unit
XXP_r40_c54_B9 TOP B9 mim_unit
XXP_r04_c58_B11 TOP B11 mim_unit
XXP_r01_c27_B11 TOP B11 mim_unit
XXP_r33_c36_B6 TOP B6 mim_unit
XXP_r44_c63_B10 TOP B10 mim_unit
XXP_r41_c32_B10 TOP B10 mim_unit
XXP_r00_c36_EDGE EDGE_BIAS EDGE_BIAS mim_unit
XXP_r07_c13_B11 TOP B11 mim_unit
XXP_r11_c62_B11 TOP B11 mim_unit
XXP_r63_c17_B11 TOP B11 mim_unit
XXP_r04_c49_B11 TOP B11 mim_unit
XXP_r27_c22_B9 TOP B9 mim_unit
XXP_r01_c18_B11 TOP B11 mim_unit
XXP_r07_c04_B11 TOP B11 mim_unit
XXP_r11_c53_B11 TOP B11 mim_unit
XXP_r44_c54_B10 TOP B10 mim_unit
XXP_r41_c23_B10 TOP B10 mim_unit
XXP_r63_c08_B11 TOP B11 mim_unit
XXP_r25_c26_B9 TOP B9 mim_unit
XXP_r01_c09_B11 TOP B11 mim_unit
XXP_r60_c01_B9 TOP B9 mim_unit
XXP_r38_c52_B9 TOP B9 mim_unit
XXP_r44_c45_B10 TOP B10 mim_unit
XXP_r40_c49_B9 TOP B9 mim_unit
XXP_r41_c14_B10 TOP B10 mim_unit
XXP_r00_c59_EDGE EDGE_BIAS EDGE_BIAS mim_unit
XXP_r11_c44_B11 TOP B11 mim_unit
XXP_r65_c00_EDGE EDGE_BIAS EDGE_BIAS mim_unit
XXP_r42_c01_B11 TOP B11 mim_unit
XXP_r04_c65_EDGE EDGE_BIAS EDGE_BIAS mim_unit
XXP_r11_c35_B11 TOP B11 mim_unit
XXP_r44_c36_B10 TOP B10 mim_unit
XXP_r41_c05_B10 TOP B10 mim_unit
XXP_r31_c42_B7 TOP B7 mim_unit
XXP_r27_c17_B9 TOP B9 mim_unit
XXP_r19_c56_B10 TOP B10 mim_unit
XXP_r47_c58_B10 TOP B10 mim_unit
XXP_r44_c27_B10 TOP B10 mim_unit
XXP_r35_c13_B8 TOP B8 mim_unit
XXP_r11_c26_B11 TOP B11 mim_unit
XXP_r14_c57_B11 TOP B11 mim_unit
XXP_r65_c23_EDGE EDGE_BIAS EDGE_BIAS mim_unit
XXP_r38_c47_B9 TOP B9 mim_unit
XXP_r11_c17_B11 TOP B11 mim_unit
XXP_r14_c48_B11 TOP B11 mim_unit
XXP_r19_c47_B10 TOP B10 mim_unit
XXP_r47_c49_B10 TOP B10 mim_unit
XXP_r44_c18_B10 TOP B10 mim_unit
XXP_r29_c24_B8 TOP B8 mim_unit
XXP_r23_c20_B10 TOP B10 mim_unit
XXP_r19_c38_B10 TOP B10 mim_unit
XXP_r20_c56_B10 TOP B10 mim_unit
XXP_r55_c40_B11 TOP B11 mim_unit
XXP_r44_c09_B10 TOP B10 mim_unit
XXP_r31_c37_B7 TOP B7 mim_unit
XXP_r11_c08_B11 TOP B11 mim_unit
XXP_r14_c39_B11 TOP B11 mim_unit
XXP_r65_c46_EDGE EDGE_BIAS EDGE_BIAS mim_unit
XXP_r23_c11_B10 TOP B10 mim_unit
XXP_r35_c08_B8 TOP B8 mim_unit
XXP_r19_c29_B10 TOP B10 mim_unit
XXP_r20_c47_B10 TOP B10 mim_unit
XXP_r58_c62_B11 TOP B11 mim_unit
XXP_r55_c31_B11 TOP B11 mim_unit
XXP_r23_c02_B10 TOP B10 mim_unit
XXP_r40_c62_B9 TOP B9 mim_unit
XXP_r20_c38_B10 TOP B10 mim_unit
XXP_r58_c53_B11 TOP B11 mim_unit
XXP_r55_c22_B11 TOP B11 mim_unit
XXP_r33_c44_B6 TOP B6 mim_unit
XXP_r29_c19_B8 TOP B8 mim_unit
XXP_r52_c58_B11 TOP B11 mim_unit
XXP_r27_c30_B9 TOP B9 mim_unit
XXP_r20_c29_B10 TOP B10 mim_unit
XXP_r58_c44_B11 TOP B11 mim_unit
XXP_r55_c13_B11 TOP B11 mim_unit
XXP_r25_c34_B9 TOP B9 mim_unit
XXP_r52_c49_B11 TOP B11 mim_unit
XXP_r02_c64_B7 TOP B7 mim_unit
XXP_r58_c35_B11 TOP B11 mim_unit
XXP_r55_c04_B11 TOP B11 mim_unit
XXP_r38_c60_B9 TOP B9 mim_unit
XXP_r40_c57_B9 TOP B9 mim_unit
XXP_r33_c39_B6 TOP B6 mim_unit
XXP_r03_c40_B11 TOP B11 mim_unit
XXP_r58_c26_B11 TOP B11 mim_unit
XXP_r31_c50_B7 TOP B7 mim_unit
XXP_r27_c25_B9 TOP B9 mim_unit
XXP_r06_c62_B11 TOP B11 mim_unit
XXP_r03_c31_B11 TOP B11 mim_unit
XXP_r58_c17_B11 TOP B11 mim_unit
XXP_r35_c21_B8 TOP B8 mim_unit
XXP_r25_c29_B9 TOP B9 mim_unit
XXP_r38_c55_B9 TOP B9 mim_unit
XXP_r03_c22_B11 TOP B11 mim_unit
XXP_r06_c53_B11 TOP B11 mim_unit
XXP_r62_c57_B11 TOP B11 mim_unit
XXP_r58_c08_B11 TOP B11 mim_unit
XXP_r19_c00_EDGE EDGE_BIAS EDGE_BIAS mim_unit
XXP_r29_c65_EDGE EDGE_BIAS EDGE_BIAS mim_unit
XXP_r29_c32_B8 TOP B8 mim_unit
XXP_r06_c44_B11 TOP B11 mim_unit
XXP_r03_c13_B11 TOP B11 mim_unit
XXP_r62_c48_B11 TOP B11 mim_unit
XXP_r31_c45_B7 TOP B7 mim_unit
XXP_r37_c01_B11 TOP B11 mim_unit
XXP_r03_c04_B11 TOP B11 mim_unit
XXP_r06_c35_B11 TOP B11 mim_unit
XXP_r35_c16_B8 TOP B8 mim_unit
XXP_r62_c39_B11 TOP B11 mim_unit
XXP_r46_c40_B10 TOP B10 mim_unit
XXP_r09_c57_B11 TOP B11 mim_unit
XXP_r06_c26_B11 TOP B11 mim_unit
XXP_r13_c30_B11 TOP B11 mim_unit
XXP_r16_c61_B11 TOP B11 mim_unit
XXP_r46_c31_B10 TOP B10 mim_unit
XXP_r33_c52_B6 TOP B6 mim_unit
XXP_r29_c27_B8 TOP B8 mim_unit
XXP_r06_c17_B11 TOP B11 mim_unit
XXP_r09_c48_B11 TOP B11 mim_unit
XXP_r18_c20_B10 TOP B10 mim_unit
XXP_r46_c22_B10 TOP B10 mim_unit
XXP_r13_c21_B11 TOP B11 mim_unit
XXP_r16_c52_B11 TOP B11 mim_unit
XXP_r09_c39_B11 TOP B11 mim_unit
XXP_r10_c57_B11 TOP B11 mim_unit
XXP_r43_c58_B10 TOP B10 mim_unit
XXP_r25_c42_B9 TOP B9 mim_unit
XXP_r06_c08_B11 TOP B11 mim_unit
XXP_r22_c60_B10 TOP B10 mim_unit
XXP_r13_c12_B11 TOP B11 mim_unit
XXP_r16_c43_B11 TOP B11 mim_unit
XXP_r18_c11_B10 TOP B10 mim_unit
XXP_r46_c13_B10 TOP B10 mim_unit
XXP_r10_c48_B11 TOP B11 mim_unit
XXP_r43_c49_B10 TOP B10 mim_unit
XXP_r33_c47_B6 TOP B6 mim_unit
XXP_r22_c51_B10 TOP B10 mim_unit
XXP_r18_c02_B10 TOP B10 mim_unit
XXP_r46_c04_B10 TOP B10 mim_unit
XXP_r34_c00_EDGE EDGE_BIAS EDGE_BIAS mim_unit
XXP_r00_c03_EDGE EDGE_BIAS EDGE_BIAS mim_unit
XXP_r13_c03_B11 TOP B11 mim_unit
XXP_r16_c34_B11 TOP B11 mim_unit
XXP_r44_c65_EDGE EDGE_BIAS EDGE_BIAS mim_unit
XXP_r10_c39_B11 TOP B11 mim_unit
XXP_r51_c40_B11 TOP B11 mim_unit
XXP_r27_c33_B9 TOP B9 mim_unit
XXP_r22_c42_B10 TOP B10 mim_unit
XXP_r16_c25_B11 TOP B11 mim_unit
XXP_r25_c37_B9 TOP B9 mim_unit
XXP_r54_c62_B11 TOP B11 mim_unit
XXP_r51_c31_B11 TOP B11 mim_unit
XXP_r38_c63_B9 TOP B9 mim_unit
XXP_r00_c26_EDGE EDGE_BIAS EDGE_BIAS mim_unit
XXP_r22_c33_B10 TOP B10 mim_unit
XXP_r16_c16_B11 TOP B11 mim_unit
XXP_r54_c53_B11 TOP B11 mim_unit
XXP_r51_c22_B11 TOP B11 mim_unit
XXP_r29_c40_B8 TOP B8 mim_unit
XXP_r37_c04_B9 TOP B9 mim_unit
XXP_r16_c07_B11 TOP B11 mim_unit
XXP_r22_c24_B10 TOP B10 mim_unit
XXP_r31_c53_B7 TOP B7 mim_unit
XXP_r27_c28_B9 TOP B9 mim_unit
XXP_r54_c44_B11 TOP B11 mim_unit
XXP_r51_c13_B11 TOP B11 mim_unit
XXP_r00_c49_EDGE EDGE_BIAS EDGE_BIAS mim_unit
XXP_r22_c15_B10 TOP B10 mim_unit
XXP_r35_c24_B8 TOP B8 mim_unit
XXP_r38_c58_B9 TOP B9 mim_unit
XXP_r29_c64_B11 TOP B11 mim_unit
XXP_r54_c35_B11 TOP B11 mim_unit
XXP_r51_c04_B11 TOP B11 mim_unit
XXP_r22_c06_B10 TOP B10 mim_unit
XXP_r29_c35_B8 TOP B8 mim_unit
XXP_r33_c60_B6 TOP B6 mim_unit
XXP_r57_c57_B11 TOP B11 mim_unit
XXP_r54_c26_B11 TOP B11 mim_unit
XXP_r64_c61_B11 TOP B11 mim_unit
XXP_r65_c13_EDGE EDGE_BIAS EDGE_BIAS mim_unit
XXP_r61_c30_B11 TOP B11 mim_unit
XXP_r31_c48_B7 TOP B7 mim_unit
XXP_r02_c62_B11 TOP B11 mim_unit
XXP_r30_c64_B11 TOP B11 mim_unit
XXP_r57_c48_B11 TOP B11 mim_unit
XXP_r54_c17_B11 TOP B11 mim_unit
XXP_r35_c19_B8 TOP B8 mim_unit
XXP_r32_c01_B6 TOP B6 mim_unit
XXP_r25_c50_B9 TOP B9 mim_unit
XXP_r64_c52_B11 TOP B11 mim_unit
XXP_r61_c21_B11 TOP B11 mim_unit
XXP_r02_c53_B11 TOP B11 mim_unit
XXP_r57_c39_B11 TOP B11 mim_unit
XXP_r54_c08_B11 TOP B11 mim_unit
XXP_r64_c43_B11 TOP B11 mim_unit
XXP_r65_c36_EDGE EDGE_BIAS EDGE_BIAS mim_unit
XXP_r61_c12_B11 TOP B11 mim_unit
XXP_r33_c55_B6 TOP B6 mim_unit
XXP_r02_c44_B11 TOP B11 mim_unit
XXP_r08_c30_B11 TOP B11 mim_unit
XXP_r33_c01_B11 TOP B11 mim_unit
XXP_r27_c41_B9 TOP B9 mim_unit
XXP_r64_c34_B11 TOP B11 mim_unit
XXP_r61_c03_B11 TOP B11 mim_unit
XXP_r02_c35_B11 TOP B11 mim_unit
XXP_r25_c45_B9 TOP B9 mim_unit
XXP_r65_c59_EDGE EDGE_BIAS EDGE_BIAS mim_unit
XXP_r42_c40_B10 TOP B10 mim_unit
XXP_r08_c21_B11 TOP B11 mim_unit
XXP_r64_c25_B11 TOP B11 mim_unit
XXP_r05_c57_B11 TOP B11 mim_unit
XXP_r02_c26_B11 TOP B11 mim_unit
XXP_r59_c00_EDGE EDGE_BIAS EDGE_BIAS mim_unit
XXP_r08_c12_B11 TOP B11 mim_unit
XXP_r12_c61_B11 TOP B11 mim_unit
XXP_r17_c60_B10 TOP B10 mim_unit
XXP_r45_c62_B10 TOP B10 mim_unit
XXP_r42_c31_B10 TOP B10 mim_unit
XXP_r64_c16_B11 TOP B11 mim_unit
XXP_r37_c12_B9 TOP B9 mim_unit
XXP_r05_c48_B11 TOP B11 mim_unit
XXP_r02_c17_B11 TOP B11 mim_unit
XXP_r31_c61_B7 TOP B7 mim_unit
XXP_r27_c36_B9 TOP B9 mim_unit
XXP_r12_c52_B11 TOP B11 mim_unit
XXP_r17_c51_B10 TOP B10 mim_unit
XXP_r45_c53_B10 TOP B10 mim_unit
XXP_r42_c22_B10 TOP B10 mim_unit
XXP_r08_c03_B11 TOP B11 mim_unit
XXP_r64_c07_B11 TOP B11 mim_unit
XXP_r05_c39_B11 TOP B11 mim_unit
XXP_r02_c08_B11 TOP B11 mim_unit
XXP_r35_c32_B8 TOP B8 mim_unit
XXP_r12_c43_B11 TOP B11 mim_unit
XXP_r17_c42_B10 TOP B10 mim_unit
XXP_r45_c44_B10 TOP B10 mim_unit
XXP_r42_c13_B10 TOP B10 mim_unit
XXP_r49_c62_B11 TOP B11 mim_unit
XXP_r39_c03_B9 TOP B9 mim_unit
XXP_r29_c43_B8 TOP B8 mim_unit
XXP_r17_c33_B10 TOP B10 mim_unit
XXP_r45_c35_B10 TOP B10 mim_unit
XXP_r42_c04_B10 TOP B10 mim_unit
XXP_r12_c34_B11 TOP B11 mim_unit
XXP_r37_c07_B9 TOP B9 mim_unit
XXP_r31_c56_B7 TOP B7 mim_unit
XXP_r49_c53_B11 TOP B11 mim_unit
XXP_r12_c25_B11 TOP B11 mim_unit
XXP_r15_c56_B11 TOP B11 mim_unit
XXP_r17_c24_B10 TOP B10 mim_unit
XXP_r48_c57_B10 TOP B10 mim_unit
XXP_r45_c26_B10 TOP B10 mim_unit
XXP_r35_c27_B8 TOP B8 mim_unit
XXP_r50_c62_B11 TOP B11 mim_unit
XXP_r49_c44_B11 TOP B11 mim_unit
XXP_r15_c47_B11 TOP B11 mim_unit
XXP_r17_c15_B10 TOP B10 mim_unit
XXP_r48_c48_B10 TOP B10 mim_unit
XXP_r45_c17_B10 TOP B10 mim_unit
XXP_r12_c16_B11 TOP B11 mim_unit
XXP_r50_c53_B11 TOP B11 mim_unit
XXP_r49_c35_B11 TOP B11 mim_unit
XXP_r33_c63_B6 TOP B6 mim_unit
XXP_r29_c38_B8 TOP B8 mim_unit
XXP_r03_c00_EDGE EDGE_BIAS EDGE_BIAS mim_unit
XXP_r12_c07_B11 TOP B11 mim_unit
XXP_r15_c38_B11 TOP B11 mim_unit
XXP_r17_c06_B10 TOP B10 mim_unit
XXP_r21_c55_B10 TOP B10 mim_unit
XXP_r48_c39_B10 TOP B10 mim_unit
XXP_r45_c08_B10 TOP B10 mim_unit
XXP_r13_c65_EDGE EDGE_BIAS EDGE_BIAS mim_unit
XXP_r24_c10_B10 TOP B10 mim_unit
XXP_r50_c44_B11 TOP B11 mim_unit
XXP_r49_c26_B11 TOP B11 mim_unit
XXP_r32_c04_B6 TOP B6 mim_unit
XXP_r21_c46_B10 TOP B10 mim_unit
XXP_r59_c61_B11 TOP B11 mim_unit
XXP_r56_c30_B11 TOP B11 mim_unit
XXP_r25_c53_B9 TOP B9 mim_unit
XXP_r15_c29_B11 TOP B11 mim_unit
XXP_r25_c64_B11 TOP B11 mim_unit
XXP_r24_c01_B10 TOP B10 mim_unit
XXP_r50_c35_B11 TOP B11 mim_unit
XXP_r49_c17_B11 TOP B11 mim_unit
XXP_r21_c37_B10 TOP B10 mim_unit
XXP_r59_c52_B11 TOP B11 mim_unit
XXP_r56_c21_B11 TOP B11 mim_unit
XXP_r33_c58_B6 TOP B6 mim_unit
XXP_r53_c57_B11 TOP B11 mim_unit
XXP_r50_c26_B11 TOP B11 mim_unit
XXP_r49_c08_B11 TOP B11 mim_unit
XXP_r37_c20_B9 TOP B9 mim_unit
XXP_r24_c59_B10 TOP B10 mim_unit
XXP_r21_c28_B10 TOP B10 mim_unit
XXP_r60_c61_B11 TOP B11 mim_unit
XXP_r59_c43_B11 TOP B11 mim_unit
XXP_r56_c12_B11 TOP B11 mim_unit
XXP_r27_c44_B9 TOP B9 mim_unit
XXP_r53_c48_B11 TOP B11 mim_unit
XXP_r50_c17_B11 TOP B11 mim_unit
XXP_r35_c40_B8 TOP B8 mim_unit
XXP_r25_c48_B9 TOP B9 mim_unit
XXP_r21_c19_B10 TOP B10 mim_unit
XXP_r60_c52_B11 TOP B11 mim_unit
XXP_r59_c34_B11 TOP B11 mim_unit
XXP_r56_c03_B11 TOP B11 mim_unit
XXP_r53_c39_B11 TOP B11 mim_unit
XXP_r50_c08_B11 TOP B11 mim_unit
XXP_r39_c11_B9 TOP B9 mim_unit
XXP_r60_c43_B11 TOP B11 mim_unit
XXP_r59_c25_B11 TOP B11 mim_unit
XXP_r29_c51_B8 TOP B8 mim_unit
XXP_r37_c15_B9 TOP B9 mim_unit
XXP_r27_c39_B9 TOP B9 mim_unit
XXP_r04_c30_B11 TOP B11 mim_unit
XXP_r07_c61_B11 TOP B11 mim_unit
XXP_r00_c16_EDGE EDGE_BIAS EDGE_BIAS mim_unit
XXP_r60_c34_B11 TOP B11 mim_unit
XXP_r59_c16_B11 TOP B11 mim_unit
XXP_r35_c35_B8 TOP B8 mim_unit
XXP_r04_c21_B11 TOP B11 mim_unit
XXP_r07_c52_B11 TOP B11 mim_unit
XXP_r63_c56_B11 TOP B11 mim_unit
XXP_r60_c25_B11 TOP B11 mim_unit
XXP_r59_c07_B11 TOP B11 mim_unit
XXP_r01_c57_B11 TOP B11 mim_unit
XXP_r39_c06_B9 TOP B9 mim_unit
XXP_r41_c62_B10 TOP B10 mim_unit
XXP_r29_c46_B8 TOP B8 mim_unit
XXP_r04_c12_B11 TOP B11 mim_unit
XXP_r07_c43_B11 TOP B11 mim_unit
XXP_r00_c39_EDGE EDGE_BIAS EDGE_BIAS mim_unit
XXP_r63_c47_B11 TOP B11 mim_unit
XXP_r60_c16_B11 TOP B11 mim_unit
XXP_r01_c48_B11 TOP B11 mim_unit
XXP_r31_c59_B7 TOP B7 mim_unit
XXP_r07_c34_B11 TOP B11 mim_unit
XXP_r41_c53_B10 TOP B10 mim_unit
XXP_r04_c03_B11 TOP B11 mim_unit
XXP_r63_c38_B11 TOP B11 mim_unit
XXP_r60_c07_B11 TOP B11 mim_unit
XXP_r32_c12_B6 TOP B6 mim_unit
XXP_r01_c39_B11 TOP B11 mim_unit
XXP_r25_c61_B9 TOP B9 mim_unit
XXP_r07_c25_B11 TOP B11 mim_unit
XXP_r41_c44_B10 TOP B10 mim_unit
XXP_r65_c03_EDGE EDGE_BIAS EDGE_BIAS mim_unit
XXP_r63_c29_B11 TOP B11 mim_unit
XXP_r47_c30_B10 TOP B10 mim_unit
XXP_r28_c00_EDGE EDGE_BIAS EDGE_BIAS mim_unit
XXP_r38_c65_EDGE EDGE_BIAS EDGE_BIAS mim_unit
XXP_r07_c16_B11 TOP B11 mim_unit
XXP_r16_c64_B10 TOP B10 mim_unit
XXP_r41_c35_B10 TOP B10 mim_unit
XXP_r14_c20_B11 TOP B11 mim_unit
XXP_r47_c21_B10 TOP B10 mim_unit
XXP_r27_c52_B9 TOP B9 mim_unit
XXP_r44_c57_B10 TOP B10 mim_unit
XXP_r32_c07_B6 TOP B6 mim_unit
XXP_r07_c07_B11 TOP B11 mim_unit
XXP_r11_c56_B11 TOP B11 mim_unit
XXP_r65_c26_EDGE EDGE_BIAS EDGE_BIAS mim_unit
XXP_r41_c26_B10 TOP B10 mim_unit
XXP_r25_c56_B9 TOP B9 mim_unit
XXP_r19_c10_B10 TOP B10 mim_unit
XXP_r47_c12_B10 TOP B10 mim_unit
XXP_r30_c02_B8 TOP B8 mim_unit
XXP_r14_c11_B11 TOP B11 mim_unit
XXP_r11_c47_B11 TOP B11 mim_unit
XXP_r44_c48_B10 TOP B10 mim_unit
XXP_r41_c17_B10 TOP B10 mim_unit
XXP_r23_c50_B10 TOP B10 mim_unit
XXP_r14_c02_B11 TOP B11 mim_unit
XXP_r19_c01_B10 TOP B10 mim_unit
XXP_r47_c03_B10 TOP B10 mim_unit
XXP_r44_c39_B10 TOP B10 mim_unit
XXP_r37_c23_B9 TOP B9 mim_unit
XXP_r11_c38_B11 TOP B11 mim_unit
XXP_r65_c49_EDGE EDGE_BIAS EDGE_BIAS mim_unit
XXP_r41_c08_B10 TOP B10 mim_unit
XXP_r27_c47_B9 TOP B9 mim_unit
XXP_r20_c10_B10 TOP B10 mim_unit
XXP_r23_c41_B10 TOP B10 mim_unit
XXP_r11_c29_B11 TOP B11 mim_unit
XXP_r19_c59_B10 TOP B10 mim_unit
XXP_r55_c61_B11 TOP B11 mim_unit
XXP_r52_c30_B11 TOP B11 mim_unit
XXP_r35_c43_B8 TOP B8 mim_unit
XXP_r20_c01_B10 TOP B10 mim_unit
XXP_r21_c64_B11 TOP B11 mim_unit
XXP_r23_c32_B10 TOP B10 mim_unit
XXP_r39_c14_B9 TOP B9 mim_unit
XXP_r55_c52_B11 TOP B11 mim_unit
XXP_r52_c21_B11 TOP B11 mim_unit
XXP_r29_c54_B8 TOP B8 mim_unit
XXP_r23_c23_B10 TOP B10 mim_unit
XXP_r43_c00_EDGE EDGE_BIAS EDGE_BIAS mim_unit
XXP_r53_c65_EDGE EDGE_BIAS EDGE_BIAS mim_unit
XXP_r37_c18_B9 TOP B9 mim_unit
XXP_r20_c59_B10 TOP B10 mim_unit
XXP_r55_c43_B11 TOP B11 mim_unit
XXP_r52_c12_B11 TOP B11 mim_unit
XXP_r23_c14_B10 TOP B10 mim_unit
XXP_r35_c38_B8 TOP B8 mim_unit
XXP_r32_c20_B6 TOP B6 mim_unit
XXP_r55_c34_B11 TOP B11 mim_unit
XXP_r52_c03_B11 TOP B11 mim_unit
XXP_r32_c61_B2 TOP B2 mim_unit
XXP_r23_c05_B10 TOP B10 mim_unit
XXP_r39_c09_B9 TOP B9 mim_unit
XXP_r58_c56_B11 TOP B11 mim_unit
XXP_r55_c25_B11 TOP B11 mim_unit
XXP_r29_c49_B8 TOP B8 mim_unit
XXP_r27_c60_B9 TOP B9 mim_unit
XXP_r03_c61_B11 TOP B11 mim_unit
XXP_r58_c47_B11 TOP B11 mim_unit
XXP_r55_c16_B11 TOP B11 mim_unit
XXP_r32_c15_B6 TOP B6 mim_unit
XXP_r62_c20_B11 TOP B11 mim_unit
XXP_r03_c52_B11 TOP B11 mim_unit
XXP_r30_c10_B8 TOP B8 mim_unit
XXP_r58_c38_B11 TOP B11 mim_unit
XXP_r55_c07_B11 TOP B11 mim_unit
XXP_r26_c01_B9 TOP B9 mim_unit
XXP_r62_c11_B11 TOP B11 mim_unit
XXP_r03_c43_B11 TOP B11 mim_unit
XXP_r58_c29_B11 TOP B11 mim_unit
XXP_r37_c31_B9 TOP B9 mim_unit
XXP_r62_c02_B11 TOP B11 mim_unit
XXP_r27_c55_B9 TOP B9 mim_unit
XXP_r03_c34_B11 TOP B11 mim_unit
XXP_r09_c20_B11 TOP B11 mim_unit
XXP_r35_c51_B8 TOP B8 mim_unit
XXP_r30_c05_B8 TOP B8 mim_unit
XXP_r25_c59_B9 TOP B9 mim_unit
XXP_r03_c25_B11 TOP B11 mim_unit
XXP_r06_c56_B11 TOP B11 mim_unit
XXP_r13_c60_B11 TOP B11 mim_unit
XXP_r46_c61_B10 TOP B10 mim_unit
XXP_r43_c30_B10 TOP B10 mim_unit
XXP_r39_c22_B9 TOP B9 mim_unit
XXP_r09_c11_B11 TOP B11 mim_unit
XXP_r29_c62_B8 TOP B8 mim_unit
XXP_r03_c16_B11 TOP B11 mim_unit
XXP_r06_c47_B11 TOP B11 mim_unit
XXP_r12_c64_B10 TOP B10 mim_unit
XXP_r37_c26_B9 TOP B9 mim_unit
XXP_r09_c02_B11 TOP B11 mim_unit
XXP_r10_c20_B11 TOP B11 mim_unit
XXP_r13_c51_B11 TOP B11 mim_unit
XXP_r18_c50_B10 TOP B10 mim_unit
XXP_r46_c52_B10 TOP B10 mim_unit
XXP_r43_c21_B10 TOP B10 mim_unit
XXP_r03_c07_B11 TOP B11 mim_unit
XXP_r06_c38_B11 TOP B11 mim_unit
XXP_r35_c46_B8 TOP B8 mim_unit
XXP_r13_c42_B11 TOP B11 mim_unit
XXP_r18_c41_B10 TOP B10 mim_unit
XXP_r46_c43_B10 TOP B10 mim_unit
XXP_r43_c12_B10 TOP B10 mim_unit
XXP_r10_c11_B11 TOP B11 mim_unit
XXP_r06_c29_B11 TOP B11 mim_unit
XXP_r39_c17_B9 TOP B9 mim_unit
XXP_r29_c57_B8 TOP B8 mim_unit
XXP_r00_c06_EDGE EDGE_BIAS EDGE_BIAS mim_unit
XXP_r10_c02_B11 TOP B11 mim_unit
XXP_r13_c33_B11 TOP B11 mim_unit
XXP_r18_c32_B10 TOP B10 mim_unit
XXP_r46_c34_B10 TOP B10 mim_unit
XXP_r43_c03_B10 TOP B10 mim_unit
XXP_r34_c03_B7 TOP B7 mim_unit
XXP_r07_c65_EDGE EDGE_BIAS EDGE_BIAS mim_unit
XXP_r13_c24_B11 TOP B11 mim_unit
XXP_r16_c55_B11 TOP B11 mim_unit
XXP_r18_c23_B10 TOP B10 mim_unit
XXP_r46_c25_B10 TOP B10 mim_unit
XXP_r32_c23_B6 TOP B6 mim_unit
XXP_r51_c61_B11 TOP B11 mim_unit
XXP_r00_c29_EDGE EDGE_BIAS EDGE_BIAS mim_unit
XXP_r22_c63_B10 TOP B10 mim_unit
XXP_r13_c15_B11 TOP B11 mim_unit
XXP_r16_c46_B11 TOP B11 mim_unit
XXP_r18_c14_B10 TOP B10 mim_unit
XXP_r46_c16_B10 TOP B10 mim_unit
XXP_r51_c52_B11 TOP B11 mim_unit
XXP_r22_c54_B10 TOP B10 mim_unit
XXP_r16_c37_B11 TOP B11 mim_unit
XXP_r18_c05_B10 TOP B10 mim_unit
XXP_r46_c07_B10 TOP B10 mim_unit
XXP_r13_c06_B11 TOP B11 mim_unit
XXP_r51_c43_B11 TOP B11 mim_unit
XXP_r27_c63_B9 TOP B9 mim_unit
XXP_r32_c18_B6 TOP B6 mim_unit
XXP_r22_c45_B10 TOP B10 mim_unit
XXP_r16_c28_B11 TOP B11 mim_unit
XXP_r32_c34_B5 TOP B5 mim_unit
XXP_r51_c34_B11 TOP B11 mim_unit
XXP_r32_c50_B4 TOP B4 mim_unit
XXP_r30_c13_B8 TOP B8 mim_unit
XXP_r26_c04_B9 TOP B9 mim_unit
XXP_r16_c19_B11 TOP B11 mim_unit
XXP_r22_c36_B10 TOP B10 mim_unit
XXP_r57_c20_B11 TOP B11 mim_unit
XXP_r39_c30_B9 TOP B9 mim_unit
XXP_r54_c56_B11 TOP B11 mim_unit
XXP_r51_c25_B11 TOP B11 mim_unit
XXP_r12_c00_EDGE EDGE_BIAS EDGE_BIAS mim_unit
XXP_r65_c16_EDGE EDGE_BIAS EDGE_BIAS mim_unit
XXP_r37_c34_B9 TOP B9 mim_unit
XXP_r22_c27_B10 TOP B10 mim_unit
XXP_r61_c60_B11 TOP B11 mim_unit
XXP_r57_c11_B11 TOP B11 mim_unit
XXP_r27_c58_B9 TOP B9 mim_unit
XXP_r22_c65_EDGE EDGE_BIAS EDGE_BIAS mim_unit
XXP_r54_c47_B11 TOP B11 mim_unit
XXP_r51_c16_B11 TOP B11 mim_unit
XXP_r22_c18_B10 TOP B10 mim_unit
XXP_r61_c51_B11 TOP B11 mim_unit
XXP_r57_c02_B11 TOP B11 mim_unit
XXP_r35_c54_B8 TOP B8 mim_unit
XXP_r30_c08_B8 TOP B8 mim_unit
XXP_r54_c38_B11 TOP B11 mim_unit
XXP_r51_c07_B11 TOP B11 mim_unit
XXP_r65_c39_EDGE EDGE_BIAS EDGE_BIAS mim_unit
XXP_r39_c25_B9 TOP B9 mim_unit
XXP_r22_c09_B10 TOP B10 mim_unit
XXP_r61_c42_B11 TOP B11 mim_unit
XXP_r54_c29_B11 TOP B11 mim_unit
XXP_r37_c29_B9 TOP B9 mim_unit
XXP_r34_c11_B7 TOP B7 mim_unit
XXP_r08_c60_B11 TOP B11 mim_unit
XXP_r64_c64_B11 TOP B11 mim_unit
XXP_r61_c33_B11 TOP B11 mim_unit
XXP_r35_c49_B8 TOP B8 mim_unit
XXP_r32_c31_B6 TOP B6 mim_unit
XXP_r05_c20_B11 TOP B11 mim_unit
XXP_r08_c51_B11 TOP B11 mim_unit
XXP_r64_c55_B11 TOP B11 mim_unit
XXP_r61_c24_B11 TOP B11 mim_unit
XXP_r02_c56_B11 TOP B11 mim_unit
XXP_r05_c11_B11 TOP B11 mim_unit
XXP_r08_c42_B11 TOP B11 mim_unit
XXP_r42_c61_B10 TOP B10 mim_unit
XXP_r64_c46_B11 TOP B11 mim_unit
XXP_r61_c15_B11 TOP B11 mim_unit
XXP_r34_c06_B7 TOP B7 mim_unit
XXP_r02_c47_B11 TOP B11 mim_unit
XXP_r42_c52_B10 TOP B10 mim_unit
XXP_r05_c02_B11 TOP B11 mim_unit
XXP_r08_c33_B11 TOP B11 mim_unit
XXP_r00_c62_EDGE EDGE_BIAS EDGE_BIAS mim_unit
XXP_r64_c37_B11 TOP B11 mim_unit
XXP_r61_c06_B11 TOP B11 mim_unit
XXP_r32_c26_B6 TOP B6 mim_unit
XXP_r02_c38_B11 TOP B11 mim_unit
XXP_r32_c42_B5 TOP B5 mim_unit
XXP_r08_c24_B11 TOP B11 mim_unit
XXP_r42_c43_B10 TOP B10 mim_unit
XXP_r30_c21_B8 TOP B8 mim_unit
XXP_r64_c28_B11 TOP B11 mim_unit
XXP_r26_c12_B9 TOP B9 mim_unit
XXP_r02_c29_B11 TOP B11 mim_unit
XXP_r33_c04_B2 TOP B2 mim_unit
XXP_r42_c34_B10 TOP B10 mim_unit
XXP_r08_c15_B11 TOP B11 mim_unit
XXP_r17_c63_B10 TOP B10 mim_unit
XXP_r64_c19_B11 TOP B11 mim_unit
XXP_r48_c20_B10 TOP B10 mim_unit
XXP_r37_c42_B9 TOP B9 mim_unit
XXP_r08_c06_B11 TOP B11 mim_unit
XXP_r12_c55_B11 TOP B11 mim_unit
XXP_r17_c54_B10 TOP B10 mim_unit
XXP_r45_c56_B10 TOP B10 mim_unit
XXP_r42_c25_B10 TOP B10 mim_unit
XXP_r28_c03_B9 TOP B9 mim_unit
XXP_r32_c37_B5 TOP B5 mim_unit
XXP_r15_c10_B11 TOP B11 mim_unit
XXP_r48_c11_B10 TOP B10 mim_unit
XXP_r35_c62_B8 TOP B8 mim_unit
XXP_r32_c53_B4 TOP B4 mim_unit
XXP_r30_c16_B8 TOP B8 mim_unit
XXP_r45_c47_B10 TOP B10 mim_unit
XXP_r42_c16_B10 TOP B10 mim_unit
XXP_r26_c07_B9 TOP B9 mim_unit
XXP_r12_c46_B11 TOP B11 mim_unit
XXP_r17_c45_B10 TOP B10 mim_unit
XXP_r39_c33_B9 TOP B9 mim_unit
XXP_r48_c02_B10 TOP B10 mim_unit
XXP_r37_c00_EDGE EDGE_BIAS EDGE_BIAS mim_unit
XXP_r15_c01_B11 TOP B11 mim_unit
XXP_r12_c37_B11 TOP B11 mim_unit
XXP_r17_c36_B10 TOP B10 mim_unit
XXP_r47_c65_EDGE EDGE_BIAS EDGE_BIAS mim_unit
XXP_r45_c38_B10 TOP B10 mim_unit
XXP_r42_c07_B10 TOP B10 mim_unit
XXP_r37_c37_B9 TOP B9 mim_unit
XXP_r33_c33_DUMMY TOP DUMMY mim_unit
XXP_r24_c40_B10 TOP B10 mim_unit
XXP_r49_c56_B11 TOP B11 mim_unit
XXP_r56_c60_B11 TOP B11 mim_unit
XXP_r45_c29_B10 TOP B10 mim_unit
XXP_r12_c28_B11 TOP B11 mim_unit
XXP_r15_c59_B11 TOP B11 mim_unit
XXP_r17_c27_B10 TOP B10 mim_unit
XXP_r35_c57_B8 TOP B8 mim_unit
XXP_r24_c31_B10 TOP B10 mim_unit
XXP_r49_c47_B11 TOP B11 mim_unit
XXP_r12_c19_B11 TOP B11 mim_unit
XXP_r17_c18_B10 TOP B10 mim_unit
XXP_r56_c51_B11 TOP B11 mim_unit
XXP_r53_c20_B11 TOP B11 mim_unit
XXP_r39_c28_B9 TOP B9 mim_unit
XXP_r24_c22_B10 TOP B10 mim_unit
XXP_r50_c56_B11 TOP B11 mim_unit
XXP_r49_c38_B11 TOP B11 mim_unit
XXP_r34_c14_B7 TOP B7 mim_unit
XXP_r21_c58_B10 TOP B10 mim_unit
XXP_r56_c42_B11 TOP B11 mim_unit
XXP_r17_c09_B10 TOP B10 mim_unit
XXP_r53_c11_B11 TOP B11 mim_unit
XXP_r24_c13_B10 TOP B10 mim_unit
XXP_r50_c47_B11 TOP B11 mim_unit
XXP_r49_c29_B11 TOP B11 mim_unit
XXP_r21_c49_B10 TOP B10 mim_unit
XXP_r59_c64_B11 TOP B11 mim_unit
XXP_r56_c33_B11 TOP B11 mim_unit
XXP_r53_c02_B11 TOP B11 mim_unit
XXP_r08_c64_B9 TOP B9 mim_unit
XXP_r32_c59_B3 TOP B3 mim_unit
XXP_r24_c04_B10 TOP B10 mim_unit
XXP_r50_c38_B11 TOP B11 mim_unit
XXP_r26_c20_B9 TOP B9 mim_unit
XXP_r59_c55_B11 TOP B11 mim_unit
XXP_r56_c24_B11 TOP B11 mim_unit
XXP_r52_c00_EDGE EDGE_BIAS EDGE_BIAS mim_unit
XXP_r50_c29_B11 TOP B11 mim_unit
XXP_r34_c09_B7 TOP B7 mim_unit
XXP_r04_c60_B11 TOP B11 mim_unit
XXP_r62_c65_EDGE EDGE_BIAS EDGE_BIAS mim_unit
XXP_r37_c50_B9 TOP B9 mim_unit
XXP_r00_c19_EDGE EDGE_BIAS EDGE_BIAS mim_unit
XXP_r60_c64_B11 TOP B11 mim_unit
XXP_r59_c46_B11 TOP B11 mim_unit
XXP_r56_c15_B11 TOP B11 mim_unit
XXP_r32_c29_B6 TOP B6 mim_unit
XXP_r28_c11_B9 TOP B9 mim_unit
XXP_r32_c45_B5 TOP B5 mim_unit
XXP_r04_c51_B11 TOP B11 mim_unit
XXP_r01_c20_B11 TOP B11 mim_unit
XXP_r60_c55_B11 TOP B11 mim_unit
XXP_r59_c37_B11 TOP B11 mim_unit
XXP_r30_c24_B8 TOP B8 mim_unit
XXP_r56_c06_B11 TOP B11 mim_unit
XXP_r26_c15_B9 TOP B9 mim_unit
XXP_r63_c10_B11 TOP B11 mim_unit
XXP_r39_c41_B9 TOP B9 mim_unit
XXP_r04_c42_B11 TOP B11 mim_unit
XXP_r01_c11_B11 TOP B11 mim_unit
XXP_r60_c46_B11 TOP B11 mim_unit
XXP_r59_c28_B11 TOP B11 mim_unit
XXP_r37_c45_B9 TOP B9 mim_unit
XXP_r04_c33_B11 TOP B11 mim_unit
XXP_r01_c02_B11 TOP B11 mim_unit
XXP_r60_c37_B11 TOP B11 mim_unit
XXP_r59_c19_B11 TOP B11 mim_unit
XXP_r28_c06_B9 TOP B9 mim_unit
XXP_r32_c56_B4 TOP B4 mim_unit
XXP_r04_c24_B11 TOP B11 mim_unit
XXP_r07_c55_B11 TOP B11 mim_unit
XXP_r36_c02_B8 TOP B8 mim_unit
XXP_r30_c19_B8 TOP B8 mim_unit
XXP_r65_c06_EDGE EDGE_BIAS EDGE_BIAS mim_unit
XXP_r63_c59_B11 TOP B11 mim_unit
XXP_r60_c28_B11 TOP B11 mim_unit
XXP_r47_c60_B10 TOP B10 mim_unit
XXP_r61_c01_B8 TOP B8 mim_unit
XXP_r39_c36_B9 TOP B9 mim_unit
XXP_r04_c15_B11 TOP B11 mim_unit
XXP_r07_c46_B11 TOP B11 mim_unit
XXP_r60_c19_B11 TOP B11 mim_unit
XXP_r34_c22_B7 TOP B7 mim_unit
XXP_r14_c50_B11 TOP B11 mim_unit
XXP_r47_c51_B10 TOP B10 mim_unit
XXP_r44_c20_B10 TOP B10 mim_unit
XXP_r04_c06_B11 TOP B11 mim_unit
XXP_r07_c37_B11 TOP B11 mim_unit
XXP_r41_c56_B10 TOP B10 mim_unit
XXP_r65_c29_EDGE EDGE_BIAS EDGE_BIAS mim_unit
XXP_r47_c42_B10 TOP B10 mim_unit
XXP_r11_c10_B11 TOP B11 mim_unit
XXP_r14_c41_B11 TOP B11 mim_unit
XXP_r19_c40_B10 TOP B10 mim_unit
XXP_r44_c11_B10 TOP B10 mim_unit
XXP_r41_c47_B10 TOP B10 mim_unit
XXP_r07_c28_B11 TOP B11 mim_unit
XXP_r14_c32_B11 TOP B11 mim_unit
XXP_r19_c31_B10 TOP B10 mim_unit
XXP_r47_c33_B10 TOP B10 mim_unit
XXP_r44_c02_B10 TOP B10 mim_unit
XXP_r11_c01_B11 TOP B11 mim_unit
XXP_r34_c17_B7 TOP B7 mim_unit
XXP_r07_c19_B11 TOP B11 mim_unit
XXP_r41_c38_B10 TOP B10 mim_unit
XXP_r14_c23_B11 TOP B11 mim_unit
XXP_r19_c22_B10 TOP B10 mim_unit
XXP_r20_c40_B10 TOP B10 mim_unit
XXP_r47_c24_B10 TOP B10 mim_unit
XXP_r52_c60_B11 TOP B11 mim_unit
XXP_r41_c29_B10 TOP B10 mim_unit
XXP_r11_c59_B11 TOP B11 mim_unit
XXP_r23_c62_B10 TOP B10 mim_unit
XXP_r14_c14_B11 TOP B11 mim_unit
XXP_r19_c13_B10 TOP B10 mim_unit
XXP_r20_c31_B10 TOP B10 mim_unit
XXP_r47_c15_B10 TOP B10 mim_unit
XXP_r30_c32_B8 TOP B8 mim_unit
XXP_r26_c23_B9 TOP B9 mim_unit
XXP_r52_c51_B11 TOP B11 mim_unit
XXP_r23_c53_B10 TOP B10 mim_unit
XXP_r00_c52_EDGE EDGE_BIAS EDGE_BIAS mim_unit
XXP_r06_c00_EDGE EDGE_BIAS EDGE_BIAS mim_unit
XXP_r14_c05_B11 TOP B11 mim_unit
XXP_r19_c04_B10 TOP B10 mim_unit
XXP_r20_c22_B10 TOP B10 mim_unit
XXP_r47_c06_B10 TOP B10 mim_unit
XXP_r16_c65_EDGE EDGE_BIAS EDGE_BIAS mim_unit
XXP_r52_c42_B11 TOP B11 mim_unit
XXP_r37_c53_B9 TOP B9 mim_unit
XXP_r23_c44_B10 TOP B10 mim_unit
XXP_r20_c13_B10 TOP B10 mim_unit
XXP_r28_c14_B9 TOP B9 mim_unit
XXP_r32_c48_B5 TOP B5 mim_unit
XXP_r55_c64_B11 TOP B11 mim_unit
XXP_r54_c01_B10 TOP B10 mim_unit
XXP_r52_c33_B11 TOP B11 mim_unit
XXP_r30_c27_B8 TOP B8 mim_unit
XXP_r36_c10_B8 TOP B8 mim_unit
XXP_r26_c18_B9 TOP B9 mim_unit
XXP_r20_c04_B10 TOP B10 mim_unit
XXP_r23_c35_B10 TOP B10 mim_unit
XXP_r39_c44_B9 TOP B9 mim_unit
XXP_r55_c55_B11 TOP B11 mim_unit
XXP_r52_c24_B11 TOP B11 mim_unit
XXP_r23_c26_B10 TOP B10 mim_unit
XXP_r58_c10_B11 TOP B11 mim_unit
XXP_r37_c48_B9 TOP B9 mim_unit
XXP_r34_c30_B7 TOP B7 mim_unit
XXP_r55_c46_B11 TOP B11 mim_unit
XXP_r52_c15_B11 TOP B11 mim_unit
XXP_r62_c50_B11 TOP B11 mim_unit
XXP_r28_c09_B9 TOP B9 mim_unit
XXP_r23_c17_B10 TOP B10 mim_unit
XXP_r55_c37_B11 TOP B11 mim_unit
XXP_r52_c06_B11 TOP B11 mim_unit
XXP_r36_c05_B8 TOP B8 mim_unit
XXP_r23_c08_B10 TOP B10 mim_unit
XXP_r62_c41_B11 TOP B11 mim_unit
XXP_r39_c39_B9 TOP B9 mim_unit
XXP_r58_c59_B11 TOP B11 mim_unit
XXP_r55_c28_B11 TOP B11 mim_unit
XXP_r34_c25_B7 TOP B7 mim_unit
XXP_r21_c00_EDGE EDGE_BIAS EDGE_BIAS mim_unit
XXP_r65_c62_EDGE EDGE_BIAS EDGE_BIAS mim_unit
XXP_r62_c32_B11 TOP B11 mim_unit
XXP_r31_c65_EDGE EDGE_BIAS EDGE_BIAS mim_unit
XXP_r55_c19_B11 TOP B11 mim_unit
XXP_r09_c50_B11 TOP B11 mim_unit
XXP_r62_c23_B11 TOP B11 mim_unit
XXP_r03_c55_B11 TOP B11 mim_unit
XXP_r30_c40_B8 TOP B8 mim_unit
XXP_r43_c60_B10 TOP B10 mim_unit
XXP_r33_c07_B3 TOP B3 mim_unit
XXP_r26_c31_B9 TOP B9 mim_unit
XXP_r06_c10_B11 TOP B11 mim_unit
XXP_r09_c41_B11 TOP B11 mim_unit
XXP_r62_c14_B11 TOP B11 mim_unit
XXP_r03_c46_B11 TOP B11 mim_unit
XXP_r06_c01_B11 TOP B11 mim_unit
XXP_r09_c32_B11 TOP B11 mim_unit
XXP_r10_c50_B11 TOP B11 mim_unit
XXP_r43_c51_B10 TOP B10 mim_unit
XXP_r37_c61_B9 TOP B9 mim_unit
XXP_r62_c05_B11 TOP B11 mim_unit
XXP_r03_c37_B11 TOP B11 mim_unit
XXP_r28_c22_B9 TOP B9 mim_unit
XXP_r43_c42_B10 TOP B10 mim_unit
XXP_r09_c23_B11 TOP B11 mim_unit
XXP_r10_c41_B11 TOP B11 mim_unit
XXP_r30_c35_B8 TOP B8 mim_unit
XXP_r26_c26_B9 TOP B9 mim_unit
XXP_r03_c28_B11 TOP B11 mim_unit
XXP_r06_c59_B11 TOP B11 mim_unit
XXP_r39_c52_B9 TOP B9 mim_unit
XXP_r00_c09_EDGE EDGE_BIAS EDGE_BIAS mim_unit
XXP_r09_c14_B11 TOP B11 mim_unit
XXP_r10_c32_B11 TOP B11 mim_unit
XXP_r13_c63_B11 TOP B11 mim_unit
XXP_r18_c62_B10 TOP B10 mim_unit
XXP_r46_c64_B10 TOP B10 mim_unit
XXP_r43_c33_B10 TOP B10 mim_unit
XXP_r03_c19_B11 TOP B11 mim_unit
XXP_r37_c56_B9 TOP B9 mim_unit
XXP_r18_c53_B10 TOP B10 mim_unit
XXP_r46_c55_B10 TOP B10 mim_unit
XXP_r43_c24_B10 TOP B10 mim_unit
XXP_r09_c05_B11 TOP B11 mim_unit
XXP_r10_c23_B11 TOP B11 mim_unit
XXP_r13_c54_B11 TOP B11 mim_unit
XXP_r28_c17_B9 TOP B9 mim_unit
XXP_r10_c14_B11 TOP B11 mim_unit
XXP_r13_c45_B11 TOP B11 mim_unit
XXP_r18_c44_B10 TOP B10 mim_unit
XXP_r46_c46_B10 TOP B10 mim_unit
XXP_r43_c15_B10 TOP B10 mim_unit
XXP_r36_c13_B8 TOP B8 mim_unit
XXP_r49_c01_B10 TOP B10 mim_unit
XXP_r39_c47_B9 TOP B9 mim_unit
XXP_r18_c35_B10 TOP B10 mim_unit
XXP_r46_c37_B10 TOP B10 mim_unit
XXP_r43_c06_B10 TOP B10 mim_unit
XXP_r10_c05_B11 TOP B11 mim_unit
XXP_r13_c36_B11 TOP B11 mim_unit
XXP_r34_c33_B7 TOP B7 mim_unit
XXP_r13_c27_B11 TOP B11 mim_unit
XXP_r16_c58_B11 TOP B11 mim_unit
XXP_r18_c26_B10 TOP B10 mim_unit
XXP_r46_c28_B10 TOP B10 mim_unit
XXP_r51_c64_B11 TOP B11 mim_unit
XXP_r50_c01_B10 TOP B10 mim_unit
XXP_r57_c50_B11 TOP B11 mim_unit
XXP_r46_c19_B10 TOP B10 mim_unit
XXP_r36_c08_B8 TOP B8 mim_unit
XXP_r13_c18_B11 TOP B11 mim_unit
XXP_r16_c49_B11 TOP B11 mim_unit
XXP_r18_c17_B10 TOP B10 mim_unit
XXP_r51_c55_B11 TOP B11 mim_unit
XXP_r46_c00_EDGE EDGE_BIAS EDGE_BIAS mim_unit
XXP_r34_c28_B7 TOP B7 mim_unit
XXP_r22_c57_B10 TOP B10 mim_unit
XXP_r13_c09_B11 TOP B11 mim_unit
XXP_r18_c08_B10 TOP B10 mim_unit
XXP_r65_c19_EDGE EDGE_BIAS EDGE_BIAS mim_unit
XXP_r56_c65_EDGE EDGE_BIAS EDGE_BIAS mim_unit
XXP_r57_c41_B11 TOP B11 mim_unit
XXP_r54_c10_B11 TOP B11 mim_unit
XXP_r51_c46_B11 TOP B11 mim_unit
XXP_r22_c48_B10 TOP B10 mim_unit
XXP_r57_c32_B11 TOP B11 mim_unit
XXP_r28_c30_B9 TOP B9 mim_unit
XXP_r40_c03_B9 TOP B9 mim_unit
XXP_r51_c37_B11 TOP B11 mim_unit
XXP_r30_c43_B8 TOP B8 mim_unit
XXP_r26_c34_B9 TOP B9 mim_unit
XXP_r22_c39_B10 TOP B10 mim_unit
XXP_r57_c23_B11 TOP B11 mim_unit
XXP_r39_c60_B9 TOP B9 mim_unit
XXP_r54_c59_B11 TOP B11 mim_unit
XXP_r51_c28_B11 TOP B11 mim_unit
XXP_r61_c63_B11 TOP B11 mim_unit
XXP_r57_c14_B11 TOP B11 mim_unit
XXP_r37_c64_B9 TOP B9 mim_unit
XXP_r51_c19_B11 TOP B11 mim_unit
XXP_r28_c25_B9 TOP B9 mim_unit
XXP_r05_c50_B11 TOP B11 mim_unit
XXP_r61_c54_B11 TOP B11 mim_unit
XXP_r57_c05_B11 TOP B11 mim_unit
XXP_r30_c38_B8 TOP B8 mim_unit
XXP_r00_c42_EDGE EDGE_BIAS EDGE_BIAS mim_unit
XXP_r36_c21_B8 TOP B8 mim_unit
XXP_r26_c29_B9 TOP B9 mim_unit
XXP_r39_c55_B9 TOP B9 mim_unit
XXP_r33_c12_B4 TOP B4 mim_unit
XXP_r05_c41_B11 TOP B11 mim_unit
XXP_r02_c10_B11 TOP B11 mim_unit
XXP_r61_c45_B11 TOP B11 mim_unit
XXP_r61_c00_EDGE EDGE_BIAS EDGE_BIAS mim_unit
XXP_r37_c59_B9 TOP B9 mim_unit
XXP_r34_c41_B7 TOP B7 mim_unit
XXP_r05_c32_B11 TOP B11 mim_unit
XXP_r02_c01_B11 TOP B11 mim_unit
XXP_r08_c63_B11 TOP B11 mim_unit
XXP_r61_c36_B11 TOP B11 mim_unit
XXP_r00_c65_EDGE EDGE_BIAS EDGE_BIAS mim_unit
XXP_r05_c23_B11 TOP B11 mim_unit
XXP_r08_c54_B11 TOP B11 mim_unit
XXP_r64_c58_B11 TOP B11 mim_unit
XXP_r61_c27_B11 TOP B11 mim_unit
XXP_r02_c59_B11 TOP B11 mim_unit
XXP_r36_c16_B8 TOP B8 mim_unit
XXP_r05_c14_B11 TOP B11 mim_unit
XXP_r08_c45_B11 TOP B11 mim_unit
XXP_r42_c64_B10 TOP B10 mim_unit
XXP_r64_c49_B11 TOP B11 mim_unit
XXP_r61_c18_B11 TOP B11 mim_unit
XXP_r48_c50_B10 TOP B10 mim_unit
XXP_r34_c36_B7 TOP B7 mim_unit
XXP_r42_c55_B10 TOP B10 mim_unit
XXP_r05_c05_B11 TOP B11 mim_unit
XXP_r08_c36_B11 TOP B11 mim_unit
XXP_r61_c09_B11 TOP B11 mim_unit
XXP_r15_c40_B11 TOP B11 mim_unit
XXP_r48_c41_B10 TOP B10 mim_unit
XXP_r45_c10_B10 TOP B10 mim_unit
XXP_r40_c11_B9 TOP B9 mim_unit
XXP_r08_c27_B11 TOP B11 mim_unit
XXP_r42_c46_B10 TOP B10 mim_unit
XXP_r30_c51_B8 TOP B8 mim_unit
XXP_r65_c52_EDGE EDGE_BIAS EDGE_BIAS mim_unit
XXP_r48_c32_B10 TOP B10 mim_unit
XXP_r26_c42_B9 TOP B9 mim_unit
XXP_r15_c31_B11 TOP B11 mim_unit
XXP_r42_c37_B10 TOP B10 mim_unit
XXP_r08_c18_B11 TOP B11 mim_unit
XXP_r15_c22_B11 TOP B11 mim_unit
XXP_r48_c23_B10 TOP B10 mim_unit
XXP_r08_c09_B11 TOP B11 mim_unit
XXP_r12_c58_B11 TOP B11 mim_unit
XXP_r17_c57_B10 TOP B10 mim_unit
XXP_r49_c10_B11 TOP B11 mim_unit
XXP_r45_c59_B10 TOP B10 mim_unit
XXP_r42_c28_B10 TOP B10 mim_unit
XXP_r28_c33_B9 TOP B9 mim_unit
XXP_r24_c61_B10 TOP B10 mim_unit
XXP_r48_c14_B10 TOP B10 mim_unit
XXP_r40_c06_B9 TOP B9 mim_unit
XXP_r15_c13_B11 TOP B11 mim_unit
XXP_r21_c30_B10 TOP B10 mim_unit
XXP_r30_c46_B8 TOP B8 mim_unit
XXP_r17_c48_B10 TOP B10 mim_unit
XXP_r53_c50_B11 TOP B11 mim_unit
XXP_r42_c19_B10 TOP B10 mim_unit
XXP_r26_c37_B9 TOP B9 mim_unit
XXP_r12_c49_B11 TOP B11 mim_unit
XXP_r39_c63_B9 TOP B9 mim_unit
XXP_r24_c52_B10 TOP B10 mim_unit
XXP_r15_c04_B11 TOP B11 mim_unit
XXP_r21_c21_B10 TOP B10 mim_unit
XXP_r48_c05_B10 TOP B10 mim_unit
XXP_r17_c39_B10 TOP B10 mim_unit
XXP_r53_c41_B11 TOP B11 mim_unit
XXP_r50_c10_B11 TOP B11 mim_unit
XXP_r24_c43_B10 TOP B10 mim_unit
XXP_r21_c12_B10 TOP B10 mim_unit
XXP_r49_c59_B11 TOP B11 mim_unit
XXP_r38_c04_B9 TOP B9 mim_unit
XXP_r28_c28_B9 TOP B9 mim_unit
XXP_r56_c63_B11 TOP B11 mim_unit
XXP_r53_c32_B11 TOP B11 mim_unit
XXP_r24_c34_B10 TOP B10 mim_unit
XXP_r21_c03_B10 TOP B10 mim_unit
XXP_r36_c24_B8 TOP B8 mim_unit
XXP_r33_c15_B4 TOP B4 mim_unit
XXP_r56_c54_B11 TOP B11 mim_unit
XXP_r53_c23_B11 TOP B11 mim_unit
XXP_r39_c58_B9 TOP B9 mim_unit
XXP_r24_c25_B10 TOP B10 mim_unit
XXP_r15_c00_EDGE EDGE_BIAS EDGE_BIAS mim_unit
XXP_r50_c59_B11 TOP B11 mim_unit
XXP_r34_c44_B7 TOP B7 mim_unit
XXP_r25_c65_EDGE EDGE_BIAS EDGE_BIAS mim_unit
XXP_r56_c45_B11 TOP B11 mim_unit
XXP_r53_c14_B11 TOP B11 mim_unit
XXP_r24_c16_B10 TOP B10 mim_unit
XXP_r01_c50_B11 TOP B11 mim_unit
XXP_r56_c36_B11 TOP B11 mim_unit
XXP_r53_c05_B11 TOP B11 mim_unit
XXP_r63_c40_B11 TOP B11 mim_unit
XXP_r36_c19_B8 TOP B8 mim_unit
XXP_r26_c50_B9 TOP B9 mim_unit
XXP_r24_c07_B10 TOP B10 mim_unit
XXP_r03_c64_B8 TOP B8 mim_unit
XXP_r01_c41_B11 TOP B11 mim_unit
XXP_r59_c58_B11 TOP B11 mim_unit
XXP_r56_c27_B11 TOP B11 mim_unit
XXP_r34_c39_B7 TOP B7 mim_unit
XXP_r63_c31_B11 TOP B11 mim_unit
XXP_r01_c32_B11 TOP B11 mim_unit
XXP_r04_c63_B11 TOP B11 mim_unit
XXP_r59_c49_B11 TOP B11 mim_unit
XXP_r56_c18_B11 TOP B11 mim_unit
XXP_r63_c22_B11 TOP B11 mim_unit
XXP_r40_c14_B9 TOP B9 mim_unit
XXP_r28_c41_B9 TOP B9 mim_unit
XXP_r04_c54_B11 TOP B11 mim_unit
XXP_r01_c23_B11 TOP B11 mim_unit
XXP_r65_c09_EDGE EDGE_BIAS EDGE_BIAS mim_unit
XXP_r60_c58_B11 TOP B11 mim_unit
XXP_r56_c09_B11 TOP B11 mim_unit
XXP_r30_c54_B8 TOP B8 mim_unit
XXP_r26_c45_B9 TOP B9 mim_unit
XXP_r63_c13_B11 TOP B11 mim_unit
XXP_r04_c45_B11 TOP B11 mim_unit
XXP_r01_c14_B11 TOP B11 mim_unit
XXP_r60_c49_B11 TOP B11 mim_unit
XXP_r44_c50_B10 TOP B10 mim_unit
XXP_r30_c00_EDGE EDGE_BIAS EDGE_BIAS mim_unit
XXP_r63_c04_B11 TOP B11 mim_unit
XXP_r40_c65_EDGE EDGE_BIAS EDGE_BIAS mim_unit
XXP_r04_c36_B11 TOP B11 mim_unit
XXP_r01_c05_B11 TOP B11 mim_unit
XXP_r38_c12_B9 TOP B9 mim_unit
XXP_r28_c36_B9 TOP B9 mim_unit
XXP_r11_c40_B11 TOP B11 mim_unit
XXP_r44_c41_B10 TOP B10 mim_unit
XXP_r41_c10_B10 TOP B10 mim_unit
XXP_r40_c09_B9 TOP B9 mim_unit
XXP_r30_c49_B8 TOP B8 mim_unit
XXP_r04_c27_B11 TOP B11 mim_unit
XXP_r07_c58_B11 TOP B11 mim_unit
XXP_r36_c32_B8 TOP B8 mim_unit
XXP_r19_c61_B10 TOP B10 mim_unit
XXP_r47_c63_B10 TOP B10 mim_unit
XXP_r44_c32_B10 TOP B10 mim_unit
XXP_r11_c31_B11 TOP B11 mim_unit
XXP_r14_c62_B11 TOP B11 mim_unit
XXP_r31_c02_B7 TOP B7 mim_unit
XXP_r07_c49_B11 TOP B11 mim_unit
XXP_r04_c18_B11 TOP B11 mim_unit
XXP_r34_c52_B7 TOP B7 mim_unit
XXP_r11_c22_B11 TOP B11 mim_unit
XXP_r14_c53_B11 TOP B11 mim_unit
XXP_r19_c52_B10 TOP B10 mim_unit
XXP_r47_c54_B10 TOP B10 mim_unit
XXP_r44_c23_B10 TOP B10 mim_unit
XXP_r00_c32_EDGE EDGE_BIAS EDGE_BIAS mim_unit
XXP_r38_c07_B9 TOP B9 mim_unit
XXP_r04_c09_B11 TOP B11 mim_unit
XXP_r41_c59_B10 TOP B10 mim_unit
XXP_r19_c43_B10 TOP B10 mim_unit
XXP_r20_c61_B10 TOP B10 mim_unit
XXP_r47_c45_B10 TOP B10 mim_unit
XXP_r44_c14_B10 TOP B10 mim_unit
XXP_r11_c13_B11 TOP B11 mim_unit
XXP_r14_c44_B11 TOP B11 mim_unit
XXP_r45_c01_B11 TOP B11 mim_unit
XXP_r36_c27_B8 TOP B8 mim_unit
XXP_r00_c55_EDGE EDGE_BIAS EDGE_BIAS mim_unit
XXP_r11_c04_B11 TOP B11 mim_unit
XXP_r14_c35_B11 TOP B11 mim_unit
XXP_r19_c34_B10 TOP B10 mim_unit
XXP_r20_c52_B10 TOP B10 mim_unit
XXP_r47_c36_B10 TOP B10 mim_unit
XXP_r44_c05_B10 TOP B10 mim_unit
XXP_r34_c47_B7 TOP B7 mim_unit
XXP_r19_c25_B10 TOP B10 mim_unit
XXP_r20_c43_B10 TOP B10 mim_unit
XXP_r47_c27_B10 TOP B10 mim_unit
XXP_r14_c26_B11 TOP B11 mim_unit
XXP_r52_c63_B11 TOP B11 mim_unit
XXP_r40_c22_B9 TOP B9 mim_unit
XXP_r14_c17_B11 TOP B11 mim_unit
XXP_r19_c16_B10 TOP B10 mim_unit
XXP_r20_c34_B10 TOP B10 mim_unit
XXP_r47_c18_B10 TOP B10 mim_unit
XXP_r33_c20_B5 TOP B5 mim_unit
XXP_r30_c62_B8 TOP B8 mim_unit
XXP_r26_c53_B9 TOP B9 mim_unit
XXP_r52_c54_B11 TOP B11 mim_unit
XXP_r23_c56_B10 TOP B10 mim_unit
XXP_r19_c07_B10 TOP B10 mim_unit
XXP_r20_c25_B10 TOP B10 mim_unit
XXP_r58_c40_B11 TOP B11 mim_unit
XXP_r47_c09_B10 TOP B10 mim_unit
XXP_r14_c08_B11 TOP B11 mim_unit
XXP_r52_c45_B11 TOP B11 mim_unit
XXP_r38_c20_B9 TOP B9 mim_unit
XXP_r23_c47_B10 TOP B10 mim_unit
XXP_r20_c16_B10 TOP B10 mim_unit
XXP_r65_c42_EDGE EDGE_BIAS EDGE_BIAS mim_unit
XXP_r58_c31_B11 TOP B11 mim_unit
XXP_r28_c44_B9 TOP B9 mim_unit
XXP_r40_c17_B9 TOP B9 mim_unit
XXP_r52_c36_B11 TOP B11 mim_unit
XXP_r30_c57_B8 TOP B8 mim_unit
XXP_r20_c07_B10 TOP B10 mim_unit
XXP_r23_c38_B10 TOP B10 mim_unit
XXP_r58_c22_B11 TOP B11 mim_unit
XXP_r36_c40_B8 TOP B8 mim_unit
XXP_r26_c48_B9 TOP B9 mim_unit
XXP_r55_c58_B11 TOP B11 mim_unit
XXP_r55_c00_EDGE EDGE_BIAS EDGE_BIAS mim_unit
XXP_r52_c27_B11 TOP B11 mim_unit
XXP_r31_c10_B7 TOP B7 mim_unit
XXP_r23_c29_B10 TOP B10 mim_unit
XXP_r65_c65_EDGE EDGE_BIAS EDGE_BIAS mim_unit
XXP_r62_c62_B11 TOP B11 mim_unit
XXP_r58_c13_B11 TOP B11 mim_unit
XXP_r34_c60_B7 TOP B7 mim_unit
XXP_r55_c49_B11 TOP B11 mim_unit
XXP_r52_c18_B11 TOP B11 mim_unit
XXP_r38_c15_B9 TOP B9 mim_unit
XXP_r28_c39_B9 TOP B9 mim_unit
XXP_r62_c53_B11 TOP B11 mim_unit
XXP_r58_c04_B11 TOP B11 mim_unit
XXP_r52_c09_B11 TOP B11 mim_unit
XXP_r36_c35_B8 TOP B8 mim_unit
XXP_r06_c40_B11 TOP B11 mim_unit
XXP_r62_c44_B11 TOP B11 mim_unit
XXP_r31_c05_B7 TOP B7 mim_unit
XXP_r34_c55_B7 TOP B7 mim_unit
XXP_r06_c31_B11 TOP B11 mim_unit
XXP_r09_c62_B11 TOP B11 mim_unit
XXP_r62_c35_B11 TOP B11 mim_unit
XXP_r06_c22_B11 TOP B11 mim_unit
XXP_r09_c53_B11 TOP B11 mim_unit
XXP_r40_c30_B9 TOP B9 mim_unit
XXP_r62_c26_B11 TOP B11 mim_unit
XXP_r03_c58_B11 TOP B11 mim_unit
XXP_r26_c61_B9 TOP B9 mim_unit
XXP_r43_c63_B10 TOP B10 mim_unit
XXP_r06_c13_B11 TOP B11 mim_unit
XXP_r09_c44_B11 TOP B11 mim_unit
XXP_r10_c62_B11 TOP B11 mim_unit
XXP_r62_c17_B11 TOP B11 mim_unit
XXP_r03_c49_B11 TOP B11 mim_unit
XXP_r06_c04_B11 TOP B11 mim_unit
XXP_r09_c35_B11 TOP B11 mim_unit
XXP_r10_c53_B11 TOP B11 mim_unit
XXP_r43_c54_B10 TOP B10 mim_unit
XXP_r25_c02_B9 TOP B9 mim_unit
XXP_r62_c08_B11 TOP B11 mim_unit
XXP_r40_c25_B9 TOP B9 mim_unit
XXP_r28_c52_B9 TOP B9 mim_unit
XXP_r43_c45_B10 TOP B10 mim_unit
XXP_r09_c26_B11 TOP B11 mim_unit
XXP_r10_c44_B11 TOP B11 mim_unit
XXP_r16_c30_B11 TOP B11 mim_unit
XXP_r41_c01_B11 TOP B11 mim_unit
XXP_r33_c23_B5 TOP B5 mim_unit
XXP_r26_c56_B9 TOP B9 mim_unit
XXP_r09_c17_B11 TOP B11 mim_unit
XXP_r10_c35_B11 TOP B11 mim_unit
XXP_r43_c36_B10 TOP B10 mim_unit
XXP_r16_c21_B11 TOP B11 mim_unit
XXP_r13_c57_B11 TOP B11 mim_unit
XXP_r18_c56_B10 TOP B10 mim_unit
XXP_r46_c58_B10 TOP B10 mim_unit
XXP_r43_c27_B10 TOP B10 mim_unit
XXP_r09_c08_B11 TOP B11 mim_unit
XXP_r10_c26_B11 TOP B11 mim_unit
XXP_r38_c23_B9 TOP B9 mim_unit
XXP_r28_c47_B9 TOP B9 mim_unit
XXP_r16_c12_B11 TOP B11 mim_unit
XXP_r10_c17_B11 TOP B11 mim_unit
XXP_r13_c48_B11 TOP B11 mim_unit
XXP_r18_c47_B10 TOP B10 mim_unit
XXP_r46_c49_B10 TOP B10 mim_unit
XXP_r43_c18_B10 TOP B10 mim_unit
XXP_r36_c43_B8 TOP B8 mim_unit
XXP_r33_c18_B5 TOP B5 mim_unit
XXP_r16_c03_B11 TOP B11 mim_unit
XXP_r22_c20_B10 TOP B10 mim_unit
XXP_r31_c13_B7 TOP B7 mim_unit
XXP_r09_c00_EDGE EDGE_BIAS EDGE_BIAS mim_unit
XXP_r18_c38_B10 TOP B10 mim_unit
XXP_r54_c40_B11 TOP B11 mim_unit
XXP_r43_c09_B10 TOP B10 mim_unit
XXP_r10_c08_B11 TOP B11 mim_unit
XXP_r13_c39_B11 TOP B11 mim_unit
XXP_r19_c65_EDGE EDGE_BIAS EDGE_BIAS mim_unit
XXP_r34_c63_B7 TOP B7 mim_unit
XXP_r22_c11_B10 TOP B10 mim_unit
XXP_r38_c18_B9 TOP B9 mim_unit
XXP_r18_c29_B10 TOP B10 mim_unit
XXP_r57_c62_B11 TOP B11 mim_unit
XXP_r54_c31_B11 TOP B11 mim_unit
XXP_r22_c02_B10 TOP B10 mim_unit
XXP_r57_c53_B11 TOP B11 mim_unit
XXP_r54_c22_B11 TOP B11 mim_unit
XXP_r36_c38_B8 TOP B8 mim_unit
XXP_r31_c08_B7 TOP B7 mim_unit
XXP_r00_c22_EDGE EDGE_BIAS EDGE_BIAS mim_unit
XXP_r51_c58_B11 TOP B11 mim_unit
XXP_r34_c58_B7 TOP B7 mim_unit
XXP_r57_c44_B11 TOP B11 mim_unit
XXP_r54_c13_B11 TOP B11 mim_unit
XXP_r25_c10_B9 TOP B9 mim_unit
XXP_r51_c49_B11 TOP B11 mim_unit
XXP_r57_c35_B11 TOP B11 mim_unit
XXP_r54_c04_B11 TOP B11 mim_unit
XXP_r40_c33_B9 TOP B9 mim_unit
XXP_r28_c60_B9 TOP B9 mim_unit
XXP_r00_c45_EDGE EDGE_BIAS EDGE_BIAS mim_unit
XXP_r33_c31_B5 TOP B5 mim_unit
XXP_r02_c40_B11 TOP B11 mim_unit
XXP_r57_c26_B11 TOP B11 mim_unit
XXP_r27_c01_B9 TOP B9 mim_unit
XXP_r64_c30_B11 TOP B11 mim_unit
XXP_r24_c00_EDGE EDGE_BIAS EDGE_BIAS mim_unit
XXP_r05_c62_B11 TOP B11 mim_unit
XXP_r02_c31_B11 TOP B11 mim_unit
XXP_r57_c17_B11 TOP B11 mim_unit
XXP_r34_c65_EDGE EDGE_BIAS EDGE_BIAS mim_unit
XXP_r25_c05_B9 TOP B9 mim_unit
XXP_r38_c31_B9 TOP B9 mim_unit
XXP_r64_c21_B11 TOP B11 mim_unit
XXP_r28_c55_B9 TOP B9 mim_unit
XXP_r05_c53_B11 TOP B11 mim_unit
XXP_r02_c22_B11 TOP B11 mim_unit
XXP_r40_c28_B9 TOP B9 mim_unit
XXP_r61_c57_B11 TOP B11 mim_unit
XXP_r57_c08_B11 TOP B11 mim_unit
XXP_r64_c12_B11 TOP B11 mim_unit
XXP_r36_c51_B8 TOP B8 mim_unit
XXP_r33_c26_B5 TOP B5 mim_unit
XXP_r26_c59_B9 TOP B9 mim_unit
XXP_r05_c44_B11 TOP B11 mim_unit
XXP_r02_c13_B11 TOP B11 mim_unit
XXP_r61_c48_B11 TOP B11 mim_unit
XXP_r31_c21_B7 TOP B7 mim_unit
XXP_r65_c32_EDGE EDGE_BIAS EDGE_BIAS mim_unit
XXP_r36_c01_B11 TOP B11 mim_unit
XXP_r64_c03_B11 TOP B11 mim_unit
XXP_r05_c35_B11 TOP B11 mim_unit
XXP_r02_c04_B11 TOP B11 mim_unit
XXP_r61_c39_B11 TOP B11 mim_unit
XXP_r45_c40_B10 TOP B10 mim_unit
XXP_r38_c26_B9 TOP B9 mim_unit
XXP_r05_c26_B11 TOP B11 mim_unit
XXP_r08_c57_B11 TOP B11 mim_unit
XXP_r36_c46_B8 TOP B8 mim_unit
XXP_r29_c03_B8 TOP B8 mim_unit
XXP_r12_c30_B11 TOP B11 mim_unit
XXP_r15_c61_B11 TOP B11 mim_unit
XXP_r65_c55_EDGE EDGE_BIAS EDGE_BIAS mim_unit
XXP_r48_c62_B10 TOP B10 mim_unit
XXP_r45_c31_B10 TOP B10 mim_unit
XXP_r31_c16_B7 TOP B7 mim_unit
XXP_r05_c17_B11 TOP B11 mim_unit
XXP_r08_c48_B11 TOP B11 mim_unit
XXP_r17_c20_B10 TOP B10 mim_unit
XXP_r48_c53_B10 TOP B10 mim_unit
XXP_r45_c22_B10 TOP B10 mim_unit
XXP_r12_c21_B11 TOP B11 mim_unit
XXP_r15_c52_B11 TOP B11 mim_unit
XXP_r08_c39_B11 TOP B11 mim_unit
XXP_r49_c40_B11 TOP B11 mim_unit
XXP_r42_c58_B10 TOP B10 mim_unit
XXP_r05_c08_B11 TOP B11 mim_unit
XXP_r12_c12_B11 TOP B11 mim_unit
XXP_r15_c43_B11 TOP B11 mim_unit
XXP_r17_c11_B10 TOP B10 mim_unit
XXP_r21_c60_B10 TOP B10 mim_unit
XXP_r48_c44_B10 TOP B10 mim_unit
XXP_r45_c13_B10 TOP B10 mim_unit
XXP_r40_c41_B9 TOP B9 mim_unit
XXP_r49_c31_B11 TOP B11 mim_unit
XXP_r42_c49_B10 TOP B10 mim_unit
XXP_r17_c02_B10 TOP B10 mim_unit
XXP_r21_c51_B10 TOP B10 mim_unit
XXP_r48_c35_B10 TOP B10 mim_unit
XXP_r45_c04_B10 TOP B10 mim_unit
XXP_r12_c03_B11 TOP B11 mim_unit
XXP_r15_c34_B11 TOP B11 mim_unit
XXP_r50_c40_B11 TOP B11 mim_unit
XXP_r49_c22_B11 TOP B11 mim_unit
XXP_r15_c25_B11 TOP B11 mim_unit
XXP_r21_c42_B10 TOP B10 mim_unit
XXP_r48_c26_B10 TOP B10 mim_unit
XXP_r25_c13_B9 TOP B9 mim_unit
XXP_r53_c62_B11 TOP B11 mim_unit
XXP_r50_c31_B11 TOP B11 mim_unit
XXP_r49_c13_B11 TOP B11 mim_unit
XXP_r40_c36_B9 TOP B9 mim_unit
XXP_r28_c63_B9 TOP B9 mim_unit
XXP_r21_c33_B10 TOP B10 mim_unit
XXP_r48_c17_B10 TOP B10 mim_unit
XXP_r15_c16_B11 TOP B11 mim_unit
XXP_r53_c53_B11 TOP B11 mim_unit
XXP_r50_c22_B11 TOP B11 mim_unit
XXP_r49_c04_B11 TOP B11 mim_unit
XXP_r49_c00_EDGE EDGE_BIAS EDGE_BIAS mim_unit
XXP_r27_c04_B9 TOP B9 mim_unit
XXP_r24_c55_B10 TOP B10 mim_unit
XXP_r15_c07_B11 TOP B11 mim_unit
XXP_r21_c24_B10 TOP B10 mim_unit
XXP_r59_c65_EDGE EDGE_BIAS EDGE_BIAS mim_unit
XXP_r48_c08_B10 TOP B10 mim_unit
XXP_r53_c44_B11 TOP B11 mim_unit
XXP_r50_c13_B11 TOP B11 mim_unit
XXP_r24_c46_B10 TOP B10 mim_unit
XXP_r25_c08_B9 TOP B9 mim_unit
XXP_r21_c15_B10 TOP B10 mim_unit
XXP_r59_c30_B11 TOP B11 mim_unit
XXP_r38_c34_B9 TOP B9 mim_unit
XXP_r28_c64_B11 TOP B11 mim_unit
XXP_r28_c58_B9 TOP B9 mim_unit
XXP_r53_c35_B11 TOP B11 mim_unit
XXP_r50_c04_B11 TOP B11 mim_unit
XXP_r32_c32_B0 TOP B0 mim_unit
XXP_r24_c37_B10 TOP B10 mim_unit
XXP_r21_c06_B10 TOP B10 mim_unit
XXP_r59_c21_B11 TOP B11 mim_unit
XXP_r36_c54_B8 TOP B8 mim_unit
XXP_r33_c29_B5 TOP B5 mim_unit
XXP_r29_c11_B8 TOP B8 mim_unit
XXP_r56_c57_B11 TOP B11 mim_unit
XXP_r53_c26_B11 TOP B11 mim_unit
XXP_r31_c24_B7 TOP B7 mim_unit
XXP_r24_c28_B10 TOP B10 mim_unit
XXP_r63_c61_B11 TOP B11 mim_unit
XXP_r60_c30_B11 TOP B11 mim_unit
XXP_r59_c12_B11 TOP B11 mim_unit
XXP_r01_c62_B11 TOP B11 mim_unit
XXP_r56_c48_B11 TOP B11 mim_unit
XXP_r53_c17_B11 TOP B11 mim_unit
XXP_r38_c29_B9 TOP B9 mim_unit
XXP_r24_c19_B10 TOP B10 mim_unit
XXP_r63_c52_B11 TOP B11 mim_unit
XXP_r60_c21_B11 TOP B11 mim_unit
XXP_r59_c03_B11 TOP B11 mim_unit
XXP_r01_c53_B11 TOP B11 mim_unit
XXP_r56_c39_B11 TOP B11 mim_unit
XXP_r53_c08_B11 TOP B11 mim_unit
XXP_r29_c06_B8 TOP B8 mim_unit
XXP_r63_c43_B11 TOP B11 mim_unit
XXP_r60_c12_B11 TOP B11 mim_unit
XXP_r36_c49_B8 TOP B8 mim_unit
XXP_r01_c44_B11 TOP B11 mim_unit
XXP_r31_c19_B7 TOP B7 mim_unit
XXP_r07_c30_B11 TOP B11 mim_unit
XXP_r64_c00_EDGE EDGE_BIAS EDGE_BIAS mim_unit
XXP_r63_c34_B11 TOP B11 mim_unit
XXP_r60_c03_B11 TOP B11 mim_unit
XXP_r03_c65_EDGE EDGE_BIAS EDGE_BIAS mim_unit
XXP_r01_c35_B11 TOP B11 mim_unit
XXP_r25_c21_B9 TOP B9 mim_unit
XXP_r41_c40_B10 TOP B10 mim_unit
XXP_r07_c21_B11 TOP B11 mim_unit
XXP_r63_c25_B11 TOP B11 mim_unit
XXP_r40_c44_B9 TOP B9 mim_unit
XXP_r04_c57_B11 TOP B11 mim_unit
XXP_r00_c12_EDGE EDGE_BIAS EDGE_BIAS mim_unit
XXP_r01_c26_B11 TOP B11 mim_unit
XXP_r07_c12_B11 TOP B11 mim_unit
XXP_r11_c61_B11 TOP B11 mim_unit
XXP_r44_c62_B10 TOP B10 mim_unit
XXP_r41_c31_B10 TOP B10 mim_unit
XXP_r63_c16_B11 TOP B11 mim_unit
XXP_r27_c12_B9 TOP B9 mim_unit
XXP_r04_c48_B11 TOP B11 mim_unit
XXP_r01_c17_B11 TOP B11 mim_unit
XXP_r11_c52_B11 TOP B11 mim_unit
XXP_r44_c53_B10 TOP B10 mim_unit
XXP_r41_c22_B10 TOP B10 mim_unit
XXP_r00_c35_EDGE EDGE_BIAS EDGE_BIAS mim_unit
XXP_r07_c03_B11 TOP B11 mim_unit
XXP_r63_c07_B11 TOP B11 mim_unit
XXP_r25_c16_B9 TOP B9 mim_unit
XXP_r04_c39_B11 TOP B11 mim_unit
XXP_r01_c08_B11 TOP B11 mim_unit
XXP_r38_c42_B9 TOP B9 mim_unit
XXP_r11_c43_B11 TOP B11 mim_unit
XXP_r44_c44_B10 TOP B10 mim_unit
XXP_r40_c39_B9 TOP B9 mim_unit
XXP_r41_c13_B10 TOP B10 mim_unit
XXP_r36_c62_B8 TOP B8 mim_unit
XXP_r44_c35_B10 TOP B10 mim_unit
XXP_r41_c04_B10 TOP B10 mim_unit
XXP_r00_c58_EDGE EDGE_BIAS EDGE_BIAS mim_unit
XXP_r11_c34_B11 TOP B11 mim_unit
XXP_r31_c32_B7 TOP B7 mim_unit
XXP_r27_c07_B9 TOP B9 mim_unit
XXP_r35_c03_B8 TOP B8 mim_unit
XXP_r11_c25_B11 TOP B11 mim_unit
XXP_r14_c56_B11 TOP B11 mim_unit
XXP_r19_c55_B10 TOP B10 mim_unit
XXP_r47_c57_B10 TOP B10 mim_unit
XXP_r44_c26_B10 TOP B10 mim_unit
XXP_r38_c37_B9 TOP B9 mim_unit
XXP_r14_c47_B11 TOP B11 mim_unit
XXP_r19_c46_B10 TOP B10 mim_unit
XXP_r47_c48_B10 TOP B10 mim_unit
XXP_r44_c17_B10 TOP B10 mim_unit
XXP_r11_c16_B11 TOP B11 mim_unit
XXP_r65_c22_EDGE EDGE_BIAS EDGE_BIAS mim_unit
XXP_r36_c57_B8 TOP B8 mim_unit
XXP_r29_c14_B8 TOP B8 mim_unit
XXP_r31_c27_B7 TOP B7 mim_unit
XXP_r11_c07_B11 TOP B11 mim_unit
XXP_r14_c38_B11 TOP B11 mim_unit
XXP_r19_c37_B10 TOP B10 mim_unit
XXP_r20_c55_B10 TOP B10 mim_unit
XXP_r47_c39_B10 TOP B10 mim_unit
XXP_r44_c08_B10 TOP B10 mim_unit
XXP_r23_c10_B10 TOP B10 mim_unit
XXP_r14_c29_B11 TOP B11 mim_unit
XXP_r19_c28_B10 TOP B10 mim_unit
XXP_r20_c46_B10 TOP B10 mim_unit
XXP_r58_c61_B11 TOP B11 mim_unit
XXP_r55_c30_B11 TOP B11 mim_unit
XXP_r65_c45_EDGE EDGE_BIAS EDGE_BIAS mim_unit
XXP_r24_c64_B11 TOP B11 mim_unit
XXP_r23_c01_B10 TOP B10 mim_unit
XXP_r40_c52_B9 TOP B9 mim_unit
XXP_r33_c34_B6 TOP B6 mim_unit
XXP_r29_c09_B8 TOP B8 mim_unit
XXP_r19_c19_B10 TOP B10 mim_unit
XXP_r20_c37_B10 TOP B10 mim_unit
XXP_r58_c52_B11 TOP B11 mim_unit
XXP_r55_c21_B11 TOP B11 mim_unit
XXP_r52_c57_B11 TOP B11 mim_unit
XXP_r27_c20_B9 TOP B9 mim_unit
XXP_r23_c59_B10 TOP B10 mim_unit
XXP_r18_c00_EDGE EDGE_BIAS EDGE_BIAS mim_unit
XXP_r20_c28_B10 TOP B10 mim_unit
XXP_r58_c43_B11 TOP B11 mim_unit
XXP_r55_c12_B11 TOP B11 mim_unit
XXP_r28_c65_EDGE EDGE_BIAS EDGE_BIAS mim_unit
XXP_r52_c48_B11 TOP B11 mim_unit
XXP_r25_c24_B9 TOP B9 mim_unit
XXP_r38_c50_B9 TOP B9 mim_unit
XXP_r20_c19_B10 TOP B10 mim_unit
XXP_r58_c34_B11 TOP B11 mim_unit
XXP_r55_c03_B11 TOP B11 mim_unit
XXP_r40_c47_B9 TOP B9 mim_unit
XXP_r52_c39_B11 TOP B11 mim_unit
XXP_r58_c25_B11 TOP B11 mim_unit
XXP_r31_c40_B7 TOP B7 mim_unit
XXP_r27_c15_B9 TOP B9 mim_unit
XXP_r03_c30_B11 TOP B11 mim_unit
XXP_r06_c61_B11 TOP B11 mim_unit
XXP_r58_c16_B11 TOP B11 mim_unit
XXP_r35_c11_B8 TOP B8 mim_unit
XXP_r25_c19_B9 TOP B9 mim_unit
XXP_r38_c45_B9 TOP B9 mim_unit
XXP_r03_c21_B11 TOP B11 mim_unit
XXP_r06_c52_B11 TOP B11 mim_unit
XXP_r62_c56_B11 TOP B11 mim_unit
XXP_r58_c07_B11 TOP B11 mim_unit
XXP_r29_c22_B8 TOP B8 mim_unit
XXP_r03_c12_B11 TOP B11 mim_unit
XXP_r06_c43_B11 TOP B11 mim_unit
XXP_r62_c47_B11 TOP B11 mim_unit
XXP_r31_c35_B7 TOP B7 mim_unit
XXP_r33_c00_EDGE EDGE_BIAS EDGE_BIAS mim_unit
XXP_r06_c34_B11 TOP B11 mim_unit
XXP_r62_c01_B8 TOP B8 mim_unit
XXP_r03_c03_B11 TOP B11 mim_unit
XXP_r62_c38_B11 TOP B11 mim_unit
XXP_r43_c65_EDGE EDGE_BIAS EDGE_BIAS mim_unit
XXP_r35_c06_B8 TOP B8 mim_unit
XXP_r06_c25_B11 TOP B11 mim_unit
XXP_r09_c56_B11 TOP B11 mim_unit
XXP_r40_c60_B9 TOP B9 mim_unit
XXP_r16_c60_B11 TOP B11 mim_unit
XXP_r62_c29_B11 TOP B11 mim_unit
XXP_r46_c30_B10 TOP B10 mim_unit
XXP_r33_c42_B6 TOP B6 mim_unit
XXP_r29_c17_B8 TOP B8 mim_unit
XXP_r06_c16_B11 TOP B11 mim_unit
XXP_r09_c47_B11 TOP B11 mim_unit
XXP_r15_c64_B10 TOP B10 mim_unit
XXP_r13_c20_B11 TOP B11 mim_unit
XXP_r16_c51_B11 TOP B11 mim_unit
XXP_r46_c21_B10 TOP B10 mim_unit
XXP_r43_c57_B10 TOP B10 mim_unit
XXP_r06_c07_B11 TOP B11 mim_unit
XXP_r09_c38_B11 TOP B11 mim_unit
XXP_r10_c56_B11 TOP B11 mim_unit
XXP_r25_c32_B9 TOP B9 mim_unit
XXP_r18_c10_B10 TOP B10 mim_unit
XXP_r46_c12_B10 TOP B10 mim_unit
XXP_r13_c11_B11 TOP B11 mim_unit
XXP_r16_c42_B11 TOP B11 mim_unit
XXP_r40_c55_B9 TOP B9 mim_unit
XXP_r09_c29_B11 TOP B11 mim_unit
XXP_r10_c47_B11 TOP B11 mim_unit
XXP_r43_c48_B10 TOP B10 mim_unit
XXP_r33_c37_B6 TOP B6 mim_unit
XXP_r22_c50_B10 TOP B10 mim_unit
XXP_r13_c02_B11 TOP B11 mim_unit
XXP_r16_c33_B11 TOP B11 mim_unit
XXP_r18_c01_B10 TOP B10 mim_unit
XXP_r19_c64_B11 TOP B11 mim_unit
XXP_r46_c03_B10 TOP B10 mim_unit
XXP_r43_c39_B10 TOP B10 mim_unit
XXP_r27_c23_B9 TOP B9 mim_unit
XXP_r10_c38_B11 TOP B11 mim_unit
XXP_r22_c41_B10 TOP B10 mim_unit
XXP_r00_c02_EDGE EDGE_BIAS EDGE_BIAS mim_unit
XXP_r16_c24_B11 TOP B11 mim_unit
XXP_r25_c27_B9 TOP B9 mim_unit
XXP_r10_c29_B11 TOP B11 mim_unit
XXP_r18_c59_B10 TOP B10 mim_unit
XXP_r54_c61_B11 TOP B11 mim_unit
XXP_r51_c30_B11 TOP B11 mim_unit
XXP_r38_c53_B9 TOP B9 mim_unit
XXP_r16_c15_B11 TOP B11 mim_unit
XXP_r20_c64_B11 TOP B11 mim_unit
XXP_r22_c32_B10 TOP B10 mim_unit
XXP_r54_c52_B11 TOP B11 mim_unit
XXP_r51_c21_B11 TOP B11 mim_unit
XXP_r29_c30_B8 TOP B8 mim_unit
XXP_r00_c25_EDGE EDGE_BIAS EDGE_BIAS mim_unit
XXP_r22_c23_B10 TOP B10 mim_unit
XXP_r27_c18_B9 TOP B9 mim_unit
XXP_r16_c06_B11 TOP B11 mim_unit
XXP_r31_c43_B7 TOP B7 mim_unit
XXP_r54_c43_B11 TOP B11 mim_unit
XXP_r51_c12_B11 TOP B11 mim_unit
XXP_r35_c14_B8 TOP B8 mim_unit
XXP_r22_c14_B10 TOP B10 mim_unit
XXP_r38_c48_B9 TOP B9 mim_unit
XXP_r54_c34_B11 TOP B11 mim_unit
XXP_r51_c03_B11 TOP B11 mim_unit
XXP_r00_c48_EDGE EDGE_BIAS EDGE_BIAS mim_unit
XXP_r22_c05_B10 TOP B10 mim_unit
XXP_r33_c50_B6 TOP B6 mim_unit
XXP_r29_c25_B8 TOP B8 mim_unit
XXP_r57_c56_B11 TOP B11 mim_unit
XXP_r54_c25_B11 TOP B11 mim_unit
XXP_r58_c00_EDGE EDGE_BIAS EDGE_BIAS mim_unit
XXP_r31_c38_B7 TOP B7 mim_unit
XXP_r64_c60_B11 TOP B11 mim_unit
XXP_r02_c61_B11 TOP B11 mim_unit
XXP_r57_c47_B11 TOP B11 mim_unit
XXP_r54_c16_B11 TOP B11 mim_unit
XXP_r35_c09_B8 TOP B8 mim_unit
XXP_r25_c40_B9 TOP B9 mim_unit
XXP_r64_c51_B11 TOP B11 mim_unit
XXP_r65_c12_EDGE EDGE_BIAS EDGE_BIAS mim_unit
XXP_r61_c20_B11 TOP B11 mim_unit
XXP_r02_c52_B11 TOP B11 mim_unit
XXP_r57_c38_B11 TOP B11 mim_unit
XXP_r54_c07_B11 TOP B11 mim_unit
XXP_r40_c63_B9 TOP B9 mim_unit
XXP_r33_c45_B6 TOP B6 mim_unit
XXP_r64_c42_B11 TOP B11 mim_unit
XXP_r61_c11_B11 TOP B11 mim_unit
XXP_r02_c43_B11 TOP B11 mim_unit
XXP_r65_c35_EDGE EDGE_BIAS EDGE_BIAS mim_unit
XXP_r57_c29_B11 TOP B11 mim_unit
XXP_r27_c31_B9 TOP B9 mim_unit
XXP_r64_c33_B11 TOP B11 mim_unit
XXP_r61_c02_B11 TOP B11 mim_unit
XXP_r02_c34_B11 TOP B11 mim_unit
XXP_r25_c35_B9 TOP B9 mim_unit
XXP_r08_c20_B11 TOP B11 mim_unit
XXP_r38_c61_B9 TOP B9 mim_unit
XXP_r64_c24_B11 TOP B11 mim_unit
XXP_r40_c58_B9 TOP B9 mim_unit
XXP_r05_c56_B11 TOP B11 mim_unit
XXP_r02_c25_B11 TOP B11 mim_unit
XXP_r12_c60_B11 TOP B11 mim_unit
XXP_r65_c58_EDGE EDGE_BIAS EDGE_BIAS mim_unit
XXP_r45_c61_B10 TOP B10 mim_unit
XXP_r42_c30_B10 TOP B10 mim_unit
XXP_r08_c11_B11 TOP B11 mim_unit
XXP_r64_c15_B11 TOP B11 mim_unit
XXP_r05_c47_B11 TOP B11 mim_unit
XXP_r02_c16_B11 TOP B11 mim_unit
XXP_r11_c64_B10 TOP B10 mim_unit
XXP_r37_c02_B9 TOP B9 mim_unit
XXP_r31_c51_B7 TOP B7 mim_unit
XXP_r27_c26_B9 TOP B9 mim_unit
XXP_r45_c52_B10 TOP B10 mim_unit
XXP_r08_c02_B11 TOP B11 mim_unit
XXP_r12_c51_B11 TOP B11 mim_unit
XXP_r17_c50_B10 TOP B10 mim_unit
XXP_r42_c21_B10 TOP B10 mim_unit
XXP_r02_c00_EDGE EDGE_BIAS EDGE_BIAS mim_unit
XXP_r64_c06_B11 TOP B11 mim_unit
XXP_r35_c22_B8 TOP B8 mim_unit
XXP_r05_c38_B11 TOP B11 mim_unit
XXP_r02_c07_B11 TOP B11 mim_unit
XXP_r12_c65_EDGE EDGE_BIAS EDGE_BIAS mim_unit
XXP_r38_c56_B9 TOP B9 mim_unit
XXP_r12_c42_B11 TOP B11 mim_unit
XXP_r17_c41_B10 TOP B10 mim_unit
XXP_r45_c43_B10 TOP B10 mim_unit
XXP_r42_c12_B10 TOP B10 mim_unit
XXP_r05_c29_B11 TOP B11 mim_unit
XXP_r49_c61_B11 TOP B11 mim_unit
XXP_r29_c33_B8 TOP B8 mim_unit
XXP_r12_c33_B11 TOP B11 mim_unit
XXP_r17_c32_B10 TOP B10 mim_unit
XXP_r45_c34_B10 TOP B10 mim_unit
XXP_r42_c03_B10 TOP B10 mim_unit
XXP_r49_c52_B11 TOP B11 mim_unit
XXP_r31_c46_B7 TOP B7 mim_unit
XXP_r12_c24_B11 TOP B11 mim_unit
XXP_r15_c55_B11 TOP B11 mim_unit
XXP_r17_c23_B10 TOP B10 mim_unit
XXP_r48_c56_B10 TOP B10 mim_unit
XXP_r45_c25_B10 TOP B10 mim_unit
XXP_r35_c17_B8 TOP B8 mim_unit
XXP_r50_c61_B11 TOP B11 mim_unit
XXP_r49_c43_B11 TOP B11 mim_unit
XXP_r48_c47_B10 TOP B10 mim_unit
XXP_r12_c15_B11 TOP B11 mim_unit
XXP_r15_c46_B11 TOP B11 mim_unit
XXP_r17_c14_B10 TOP B10 mim_unit
XXP_r21_c63_B10 TOP B10 mim_unit
XXP_r45_c16_B10 TOP B10 mim_unit
XXP_r50_c52_B11 TOP B11 mim_unit
XXP_r49_c34_B11 TOP B11 mim_unit
XXP_r33_c53_B6 TOP B6 mim_unit
XXP_r29_c28_B8 TOP B8 mim_unit
XXP_r12_c06_B11 TOP B11 mim_unit
XXP_r15_c37_B11 TOP B11 mim_unit
XXP_r17_c05_B10 TOP B10 mim_unit
XXP_r21_c54_B10 TOP B10 mim_unit
XXP_r48_c38_B10 TOP B10 mim_unit
XXP_r45_c07_B10 TOP B10 mim_unit
XXP_r50_c43_B11 TOP B11 mim_unit
XXP_r49_c25_B11 TOP B11 mim_unit
XXP_r15_c28_B11 TOP B11 mim_unit
XXP_r21_c45_B10 TOP B10 mim_unit
XXP_r59_c60_B11 TOP B11 mim_unit
XXP_r48_c29_B10 TOP B10 mim_unit
XXP_r25_c43_B9 TOP B9 mim_unit
XXP_r50_c34_B11 TOP B11 mim_unit
XXP_r49_c16_B11 TOP B11 mim_unit
XXP_r15_c19_B11 TOP B11 mim_unit
XXP_r21_c36_B10 TOP B10 mim_unit
XXP_r59_c51_B11 TOP B11 mim_unit
XXP_r56_c20_B11 TOP B11 mim_unit
XXP_r33_c48_B6 TOP B6 mim_unit
XXP_r53_c56_B11 TOP B11 mim_unit
XXP_r50_c25_B11 TOP B11 mim_unit
XXP_r49_c07_B11 TOP B11 mim_unit
XXP_r37_c10_B9 TOP B9 mim_unit
XXP_r27_c34_B9 TOP B9 mim_unit
XXP_r24_c58_B10 TOP B10 mim_unit
XXP_r21_c27_B10 TOP B10 mim_unit
XXP_r60_c60_B11 TOP B11 mim_unit
XXP_r59_c42_B11 TOP B11 mim_unit
XXP_r56_c11_B11 TOP B11 mim_unit
XXP_r53_c47_B11 TOP B11 mim_unit
XXP_r50_c16_B11 TOP B11 mim_unit
XXP_r35_c30_B8 TOP B8 mim_unit
XXP_r24_c49_B10 TOP B10 mim_unit
XXP_r25_c38_B9 TOP B9 mim_unit
XXP_r21_c18_B10 TOP B10 mim_unit
XXP_r60_c51_B11 TOP B11 mim_unit
XXP_r59_c33_B11 TOP B11 mim_unit
XXP_r56_c02_B11 TOP B11 mim_unit
XXP_r38_c64_B9 TOP B9 mim_unit
XXP_r53_c38_B11 TOP B11 mim_unit
XXP_r50_c07_B11 TOP B11 mim_unit
XXP_r21_c09_B10 TOP B10 mim_unit
XXP_r60_c42_B11 TOP B11 mim_unit
XXP_r59_c24_B11 TOP B11 mim_unit
XXP_r29_c41_B8 TOP B8 mim_unit
XXP_r53_c29_B11 TOP B11 mim_unit
XXP_r37_c05_B9 TOP B9 mim_unit
XXP_r27_c29_B9 TOP B9 mim_unit
XXP_r07_c60_B11 TOP B11 mim_unit
XXP_r31_c54_B7 TOP B7 mim_unit
XXP_r27_c00_EDGE EDGE_BIAS EDGE_BIAS mim_unit
XXP_r63_c64_B11 TOP B11 mim_unit
XXP_r60_c33_B11 TOP B11 mim_unit
XXP_r59_c15_B11 TOP B11 mim_unit
XXP_r37_c65_EDGE EDGE_BIAS EDGE_BIAS mim_unit
XXP_r35_c25_B8 TOP B8 mim_unit
XXP_r04_c20_B11 TOP B11 mim_unit
XXP_r07_c51_B11 TOP B11 mim_unit
XXP_r63_c55_B11 TOP B11 mim_unit
XXP_r38_c59_B9 TOP B9 mim_unit
XXP_r00_c15_EDGE EDGE_BIAS EDGE_BIAS mim_unit
XXP_r60_c24_B11 TOP B11 mim_unit
XXP_r59_c06_B11 TOP B11 mim_unit
XXP_r01_c56_B11 TOP B11 mim_unit
XXP_r04_c11_B11 TOP B11 mim_unit
XXP_r07_c42_B11 TOP B11 mim_unit
XXP_r41_c61_B10 TOP B10 mim_unit
XXP_r33_c61_B6 TOP B6 mim_unit
XXP_r29_c36_B8 TOP B8 mim_unit
XXP_r63_c46_B11 TOP B11 mim_unit
XXP_r60_c15_B11 TOP B11 mim_unit
XXP_r01_c47_B11 TOP B11 mim_unit
XXP_r31_c49_B7 TOP B7 mim_unit
XXP_r41_c52_B10 TOP B10 mim_unit
XXP_r04_c02_B11 TOP B11 mim_unit
XXP_r00_c38_EDGE EDGE_BIAS EDGE_BIAS mim_unit
XXP_r07_c33_B11 TOP B11 mim_unit
XXP_r32_c02_B6 TOP B6 mim_unit
XXP_r63_c37_B11 TOP B11 mim_unit
XXP_r60_c06_B11 TOP B11 mim_unit
XXP_r25_c51_B9 TOP B9 mim_unit
XXP_r01_c38_B11 TOP B11 mim_unit
XXP_r07_c24_B11 TOP B11 mim_unit
XXP_r41_c43_B10 TOP B10 mim_unit
XXP_r63_c28_B11 TOP B11 mim_unit
XXP_r01_c29_B11 TOP B11 mim_unit
XXP_r33_c56_B6 TOP B6 mim_unit
XXP_r41_c34_B10 TOP B10 mim_unit
XXP_r07_c15_B11 TOP B11 mim_unit
XXP_r65_c02_EDGE EDGE_BIAS EDGE_BIAS mim_unit
XXP_r63_c19_B11 TOP B11 mim_unit
XXP_r47_c20_B10 TOP B10 mim_unit
XXP_r27_c42_B9 TOP B9 mim_unit
XXP_r42_c00_EDGE EDGE_BIAS EDGE_BIAS mim_unit
XXP_r07_c06_B11 TOP B11 mim_unit
XXP_r11_c55_B11 TOP B11 mim_unit
XXP_r44_c56_B10 TOP B10 mim_unit
XXP_r41_c25_B10 TOP B10 mim_unit
XXP_r52_c65_EDGE EDGE_BIAS EDGE_BIAS mim_unit
XXP_r25_c46_B9 TOP B9 mim_unit
XXP_r14_c10_B11 TOP B11 mim_unit
XXP_r47_c11_B10 TOP B10 mim_unit
XXP_r44_c47_B10 TOP B10 mim_unit
XXP_r41_c16_B10 TOP B10 mim_unit
XXP_r11_c46_B11 TOP B11 mim_unit
XXP_r65_c25_EDGE EDGE_BIAS EDGE_BIAS mim_unit
XXP_r47_c02_B10 TOP B10 mim_unit
XXP_r14_c01_B11 TOP B11 mim_unit
XXP_r11_c37_B11 TOP B11 mim_unit
XXP_r44_c38_B10 TOP B10 mim_unit
XXP_r41_c07_B10 TOP B10 mim_unit
XXP_r37_c13_B9 TOP B9 mim_unit
XXP_r31_c62_B7 TOP B7 mim_unit
XXP_r27_c37_B9 TOP B9 mim_unit
XXP_r23_c40_B10 TOP B10 mim_unit
XXP_r19_c58_B10 TOP B10 mim_unit
XXP_r55_c60_B11 TOP B11 mim_unit
XXP_r44_c29_B10 TOP B10 mim_unit
XXP_r35_c33_B8 TOP B8 mim_unit
XXP_r11_c28_B11 TOP B11 mim_unit
XXP_r14_c59_B11 TOP B11 mim_unit
XXP_r65_c48_EDGE EDGE_BIAS EDGE_BIAS mim_unit
XXP_r23_c31_B10 TOP B10 mim_unit
XXP_r39_c04_B9 TOP B9 mim_unit
XXP_r11_c19_B11 TOP B11 mim_unit
XXP_r19_c49_B10 TOP B10 mim_unit
XXP_r55_c51_B11 TOP B11 mim_unit
XXP_r52_c20_B11 TOP B11 mim_unit
XXP_r29_c44_B8 TOP B8 mim_unit
XXP_r23_c22_B10 TOP B10 mim_unit
XXP_r37_c08_B9 TOP B9 mim_unit
XXP_r20_c58_B10 TOP B10 mim_unit
XXP_r55_c42_B11 TOP B11 mim_unit
XXP_r31_c57_B7 TOP B7 mim_unit
XXP_r52_c11_B11 TOP B11 mim_unit
XXP_r23_c13_B10 TOP B10 mim_unit
XXP_r32_c10_B6 TOP B6 mim_unit
XXP_r35_c28_B8 TOP B8 mim_unit
XXP_r20_c49_B10 TOP B10 mim_unit
XXP_r58_c64_B11 TOP B11 mim_unit
XXP_r55_c33_B11 TOP B11 mim_unit
XXP_r52_c02_B11 TOP B11 mim_unit
XXP_r23_c04_B10 TOP B10 mim_unit
XXP_r58_c55_B11 TOP B11 mim_unit
XXP_r55_c24_B11 TOP B11 mim_unit
XXP_r33_c64_B6 TOP B6 mim_unit
XXP_r29_c39_B8 TOP B8 mim_unit
XXP_r03_c60_B11 TOP B11 mim_unit
XXP_r27_c50_B9 TOP B9 mim_unit
XXP_r04_c64_B8 TOP B8 mim_unit
XXP_r58_c46_B11 TOP B11 mim_unit
XXP_r55_c15_B11 TOP B11 mim_unit
XXP_r32_c05_B6 TOP B6 mim_unit
XXP_r25_c54_B9 TOP B9 mim_unit
XXP_r03_c51_B11 TOP B11 mim_unit
XXP_r58_c37_B11 TOP B11 mim_unit
XXP_r55_c06_B11 TOP B11 mim_unit
XXP_r62_c10_B11 TOP B11 mim_unit
XXP_r33_c59_B6 TOP B6 mim_unit
XXP_r03_c42_B11 TOP B11 mim_unit
XXP_r58_c28_B11 TOP B11 mim_unit
XXP_r37_c21_B9 TOP B9 mim_unit
XXP_r27_c45_B9 TOP B9 mim_unit
XXP_r03_c33_B11 TOP B11 mim_unit
XXP_r58_c19_B11 TOP B11 mim_unit
XXP_r06_c65_EDGE EDGE_BIAS EDGE_BIAS mim_unit
XXP_r35_c41_B8 TOP B8 mim_unit
XXP_r25_c49_B9 TOP B9 mim_unit
XXP_r03_c24_B11 TOP B11 mim_unit
XXP_r06_c55_B11 TOP B11 mim_unit
XXP_r62_c59_B11 TOP B11 mim_unit
XXP_r46_c60_B10 TOP B10 mim_unit
XXP_r39_c12_B9 TOP B9 mim_unit
XXP_r09_c10_B11 TOP B11 mim_unit
XXP_r29_c52_B8 TOP B8 mim_unit
XXP_r03_c15_B11 TOP B11 mim_unit
XXP_r06_c46_B11 TOP B11 mim_unit
XXP_r37_c16_B9 TOP B9 mim_unit
XXP_r09_c01_B11 TOP B11 mim_unit
XXP_r13_c50_B11 TOP B11 mim_unit
XXP_r46_c51_B10 TOP B10 mim_unit
XXP_r43_c20_B10 TOP B10 mim_unit
XXP_r03_c06_B11 TOP B11 mim_unit
XXP_r06_c37_B11 TOP B11 mim_unit
XXP_r35_c36_B8 TOP B8 mim_unit
XXP_r46_c42_B10 TOP B10 mim_unit
XXP_r10_c10_B11 TOP B11 mim_unit
XXP_r13_c41_B11 TOP B11 mim_unit
XXP_r18_c40_B10 TOP B10 mim_unit
XXP_r43_c11_B10 TOP B10 mim_unit
XXP_r39_c07_B9 TOP B9 mim_unit
XXP_r06_c28_B11 TOP B11 mim_unit
XXP_r09_c59_B11 TOP B11 mim_unit
XXP_r10_c01_B11 TOP B11 mim_unit
XXP_r13_c32_B11 TOP B11 mim_unit
XXP_r16_c63_B11 TOP B11 mim_unit
XXP_r18_c31_B10 TOP B10 mim_unit
XXP_r46_c33_B10 TOP B10 mim_unit
XXP_r43_c02_B10 TOP B10 mim_unit
XXP_r29_c47_B8 TOP B8 mim_unit
XXP_r06_c19_B11 TOP B11 mim_unit
XXP_r46_c24_B10 TOP B10 mim_unit
XXP_r00_c05_EDGE EDGE_BIAS EDGE_BIAS mim_unit
XXP_r13_c23_B11 TOP B11 mim_unit
XXP_r16_c54_B11 TOP B11 mim_unit
XXP_r18_c22_B10 TOP B10 mim_unit
XXP_r32_c13_B6 TOP B6 mim_unit
XXP_r11_c00_EDGE EDGE_BIAS EDGE_BIAS mim_unit
XXP_r51_c60_B11 TOP B11 mim_unit
XXP_r25_c62_B9 TOP B9 mim_unit
XXP_r10_c59_B11 TOP B11 mim_unit
XXP_r21_c65_EDGE EDGE_BIAS EDGE_BIAS mim_unit
XXP_r22_c62_B10 TOP B10 mim_unit
XXP_r13_c14_B11 TOP B11 mim_unit
XXP_r16_c45_B11 TOP B11 mim_unit
XXP_r18_c13_B10 TOP B10 mim_unit
XXP_r46_c15_B10 TOP B10 mim_unit
XXP_r51_c51_B11 TOP B11 mim_unit
XXP_r00_c28_EDGE EDGE_BIAS EDGE_BIAS mim_unit
XXP_r22_c53_B10 TOP B10 mim_unit
XXP_r13_c05_B11 TOP B11 mim_unit
XXP_r16_c36_B11 TOP B11 mim_unit
XXP_r18_c04_B10 TOP B10 mim_unit
XXP_r46_c06_B10 TOP B10 mim_unit
XXP_r51_c42_B11 TOP B11 mim_unit
XXP_r27_c53_B9 TOP B9 mim_unit
XXP_r22_c44_B10 TOP B10 mim_unit
XXP_r16_c27_B11 TOP B11 mim_unit
XXP_r32_c08_B6 TOP B6 mim_unit
XXP_r25_c57_B9 TOP B9 mim_unit
XXP_r54_c64_B11 TOP B11 mim_unit
XXP_r53_c01_B10 TOP B10 mim_unit
XXP_r51_c33_B11 TOP B11 mim_unit
XXP_r30_c03_B8 TOP B8 mim_unit
XXP_r16_c18_B11 TOP B11 mim_unit
XXP_r22_c35_B10 TOP B10 mim_unit
XXP_r39_c20_B9 TOP B9 mim_unit
XXP_r54_c55_B11 TOP B11 mim_unit
XXP_r51_c24_B11 TOP B11 mim_unit
XXP_r33_c02_B1 TOP B1 mim_unit
XXP_r29_c60_B8 TOP B8 mim_unit
XXP_r16_c09_B11 TOP B11 mim_unit
XXP_r22_c26_B10 TOP B10 mim_unit
XXP_r57_c10_B11 TOP B11 mim_unit
XXP_r37_c24_B9 TOP B9 mim_unit
XXP_r27_c48_B9 TOP B9 mim_unit
XXP_r54_c46_B11 TOP B11 mim_unit
XXP_r51_c15_B11 TOP B11 mim_unit
XXP_r65_c15_EDGE EDGE_BIAS EDGE_BIAS mim_unit
XXP_r61_c50_B11 TOP B11 mim_unit
XXP_r35_c44_B8 TOP B8 mim_unit
XXP_r22_c17_B10 TOP B10 mim_unit
XXP_r54_c37_B11 TOP B11 mim_unit
XXP_r51_c06_B11 TOP B11 mim_unit
XXP_r39_c15_B9 TOP B9 mim_unit
XXP_r22_c08_B10 TOP B10 mim_unit
XXP_r61_c41_B11 TOP B11 mim_unit
XXP_r29_c55_B8 TOP B8 mim_unit
XXP_r57_c59_B11 TOP B11 mim_unit
XXP_r54_c28_B11 TOP B11 mim_unit
XXP_r37_c19_B9 TOP B9 mim_unit
XXP_r64_c63_B11 TOP B11 mim_unit
XXP_r65_c38_EDGE EDGE_BIAS EDGE_BIAS mim_unit
XXP_r61_c32_B11 TOP B11 mim_unit
XXP_r54_c19_B11 TOP B11 mim_unit
XXP_r32_c21_B6 TOP B6 mim_unit
XXP_r08_c50_B11 TOP B11 mim_unit
XXP_r35_c39_B8 TOP B8 mim_unit
XXP_r64_c54_B11 TOP B11 mim_unit
XXP_r61_c23_B11 TOP B11 mim_unit
XXP_r02_c55_B11 TOP B11 mim_unit
XXP_r32_c62_B2 TOP B2 mim_unit
XXP_r42_c60_B10 TOP B10 mim_unit
XXP_r05_c10_B11 TOP B11 mim_unit
XXP_r08_c41_B11 TOP B11 mim_unit
XXP_r64_c45_B11 TOP B11 mim_unit
XXP_r61_c14_B11 TOP B11 mim_unit
XXP_r02_c46_B11 TOP B11 mim_unit
XXP_r05_c01_B11 TOP B11 mim_unit
XXP_r08_c32_B11 TOP B11 mim_unit
XXP_r42_c51_B10 TOP B10 mim_unit
XXP_r36_c00_EDGE EDGE_BIAS EDGE_BIAS mim_unit
XXP_r27_c61_B9 TOP B9 mim_unit
XXP_r64_c36_B11 TOP B11 mim_unit
XXP_r61_c05_B11 TOP B11 mim_unit
XXP_r46_c65_EDGE EDGE_BIAS EDGE_BIAS mim_unit
XXP_r02_c37_B11 TOP B11 mim_unit
XXP_r32_c16_B6 TOP B6 mim_unit
XXP_r42_c42_B10 TOP B10 mim_unit
XXP_r08_c23_B11 TOP B11 mim_unit
XXP_r64_c27_B11 TOP B11 mim_unit
XXP_r30_c11_B8 TOP B8 mim_unit
XXP_r26_c02_B9 TOP B9 mim_unit
XXP_r05_c59_B11 TOP B11 mim_unit
XXP_r00_c61_EDGE EDGE_BIAS EDGE_BIAS mim_unit
XXP_r02_c28_B11 TOP B11 mim_unit
XXP_r08_c14_B11 TOP B11 mim_unit
XXP_r12_c63_B11 TOP B11 mim_unit
XXP_r17_c62_B10 TOP B10 mim_unit
XXP_r45_c64_B10 TOP B10 mim_unit
XXP_r42_c33_B10 TOP B10 mim_unit
XXP_r64_c18_B11 TOP B11 mim_unit
XXP_r37_c32_B9 TOP B9 mim_unit
XXP_r02_c19_B11 TOP B11 mim_unit
XXP_r27_c56_B9 TOP B9 mim_unit
XXP_r17_c53_B10 TOP B10 mim_unit
XXP_r45_c55_B10 TOP B10 mim_unit
XXP_r42_c24_B10 TOP B10 mim_unit
XXP_r08_c05_B11 TOP B11 mim_unit
XXP_r12_c54_B11 TOP B11 mim_unit
XXP_r64_c09_B11 TOP B11 mim_unit
XXP_r48_c10_B10 TOP B10 mim_unit
XXP_r35_c52_B8 TOP B8 mim_unit
XXP_r30_c06_B8 TOP B8 mim_unit
XXP_r12_c45_B11 TOP B11 mim_unit
XXP_r17_c44_B10 TOP B10 mim_unit
XXP_r45_c46_B10 TOP B10 mim_unit
XXP_r42_c15_B10 TOP B10 mim_unit
XXP_r39_c23_B9 TOP B9 mim_unit
XXP_r49_c64_B11 TOP B11 mim_unit
XXP_r29_c63_B8 TOP B8 mim_unit
XXP_r17_c35_B10 TOP B10 mim_unit
XXP_r45_c37_B10 TOP B10 mim_unit
XXP_r42_c06_B10 TOP B10 mim_unit
XXP_r12_c36_B11 TOP B11 mim_unit
XXP_r37_c27_B9 TOP B9 mim_unit
XXP_r49_c55_B11 TOP B11 mim_unit
XXP_r51_c00_EDGE EDGE_BIAS EDGE_BIAS mim_unit
XXP_r12_c27_B11 TOP B11 mim_unit
XXP_r15_c58_B11 TOP B11 mim_unit
XXP_r17_c26_B10 TOP B10 mim_unit
XXP_r48_c59_B10 TOP B10 mim_unit
XXP_r45_c28_B10 TOP B10 mim_unit
XXP_r35_c47_B8 TOP B8 mim_unit
XXP_r61_c65_EDGE EDGE_BIAS EDGE_BIAS mim_unit
XXP_r24_c30_B10 TOP B10 mim_unit
XXP_r50_c64_B11 TOP B11 mim_unit
XXP_r49_c46_B11 TOP B11 mim_unit
XXP_r56_c50_B11 TOP B11 mim_unit
XXP_r45_c19_B10 TOP B10 mim_unit
XXP_r39_c18_B9 TOP B9 mim_unit
XXP_r12_c18_B11 TOP B11 mim_unit
XXP_r15_c49_B11 TOP B11 mim_unit
XXP_r17_c17_B10 TOP B10 mim_unit
XXP_r24_c21_B10 TOP B10 mim_unit
XXP_r50_c55_B11 TOP B11 mim_unit
XXP_r49_c37_B11 TOP B11 mim_unit
XXP_r29_c58_B8 TOP B8 mim_unit
XXP_r34_c04_B7 TOP B7 mim_unit
XXP_r12_c09_B11 TOP B11 mim_unit
XXP_r17_c08_B10 TOP B10 mim_unit
XXP_r21_c57_B10 TOP B10 mim_unit
XXP_r56_c41_B11 TOP B11 mim_unit
XXP_r53_c10_B11 TOP B11 mim_unit
XXP_r24_c12_B10 TOP B10 mim_unit
XXP_r50_c46_B11 TOP B11 mim_unit
XXP_r49_c28_B11 TOP B11 mim_unit
XXP_r32_c24_B6 TOP B6 mim_unit
XXP_r21_c48_B10 TOP B10 mim_unit
XXP_r59_c63_B11 TOP B11 mim_unit
XXP_r56_c32_B11 TOP B11 mim_unit
XXP_r32_c40_B5 TOP B5 mim_unit
XXP_r24_c03_B10 TOP B10 mim_unit
XXP_r50_c37_B11 TOP B11 mim_unit
XXP_r49_c19_B11 TOP B11 mim_unit
XXP_r26_c10_B9 TOP B9 mim_unit
XXP_r21_c39_B10 TOP B10 mim_unit
XXP_r59_c54_B11 TOP B11 mim_unit
XXP_r56_c23_B11 TOP B11 mim_unit
XXP_r53_c59_B11 TOP B11 mim_unit
XXP_r50_c28_B11 TOP B11 mim_unit
XXP_r37_c40_B9 TOP B9 mim_unit
XXP_r60_c63_B11 TOP B11 mim_unit
XXP_r59_c45_B11 TOP B11 mim_unit
XXP_r56_c14_B11 TOP B11 mim_unit
XXP_r50_c19_B11 TOP B11 mim_unit
XXP_r32_c19_B6 TOP B6 mim_unit
XXP_r28_c01_B9 TOP B9 mim_unit
XXP_r04_c50_B11 TOP B11 mim_unit
XXP_r35_c60_B8 TOP B8 mim_unit
XXP_r32_c51_B4 TOP B4 mim_unit
XXP_r32_c35_B5 TOP B5 mim_unit
XXP_r00_c18_EDGE EDGE_BIAS EDGE_BIAS mim_unit
XXP_r60_c54_B11 TOP B11 mim_unit
XXP_r59_c36_B11 TOP B11 mim_unit
XXP_r56_c05_B11 TOP B11 mim_unit
XXP_r30_c14_B8 TOP B8 mim_unit
XXP_r26_c05_B9 TOP B9 mim_unit
XXP_r39_c31_B9 TOP B9 mim_unit
XXP_r04_c41_B11 TOP B11 mim_unit
XXP_r01_c10_B11 TOP B11 mim_unit
XXP_r60_c45_B11 TOP B11 mim_unit
XXP_r59_c27_B11 TOP B11 mim_unit
XXP_r37_c35_B9 TOP B9 mim_unit
XXP_r27_c59_B9 TOP B9 mim_unit
XXP_r04_c32_B11 TOP B11 mim_unit
XXP_r01_c01_B11 TOP B11 mim_unit
XXP_r07_c63_B11 TOP B11 mim_unit
XXP_r60_c36_B11 TOP B11 mim_unit
XXP_r59_c18_B11 TOP B11 mim_unit
XXP_r35_c55_B8 TOP B8 mim_unit
XXP_r30_c09_B8 TOP B8 mim_unit
XXP_r04_c23_B11 TOP B11 mim_unit
XXP_r07_c54_B11 TOP B11 mim_unit
XXP_r63_c58_B11 TOP B11 mim_unit
XXP_r60_c27_B11 TOP B11 mim_unit
XXP_r59_c09_B11 TOP B11 mim_unit
XXP_r01_c59_B11 TOP B11 mim_unit
XXP_r39_c26_B9 TOP B9 mim_unit
XXP_r04_c14_B11 TOP B11 mim_unit
XXP_r07_c45_B11 TOP B11 mim_unit
XXP_r41_c64_B10 TOP B10 mim_unit
XXP_r65_c05_EDGE EDGE_BIAS EDGE_BIAS mim_unit
XXP_r63_c49_B11 TOP B11 mim_unit
XXP_r60_c18_B11 TOP B11 mim_unit
XXP_r47_c50_B10 TOP B10 mim_unit
XXP_r34_c12_B7 TOP B7 mim_unit
XXP_r41_c55_B10 TOP B10 mim_unit
XXP_r04_c05_B11 TOP B11 mim_unit
XXP_r05_c00_EDGE EDGE_BIAS EDGE_BIAS mim_unit
XXP_r07_c36_B11 TOP B11 mim_unit
XXP_r60_c09_B11 TOP B11 mim_unit
XXP_r14_c40_B11 TOP B11 mim_unit
XXP_r15_c65_EDGE EDGE_BIAS EDGE_BIAS mim_unit
XXP_r47_c41_B10 TOP B10 mim_unit
XXP_r44_c10_B10 TOP B10 mim_unit
XXP_r32_c57_B3 TOP B3 mim_unit
XXP_r07_c27_B11 TOP B11 mim_unit
XXP_r41_c46_B10 TOP B10 mim_unit
XXP_r65_c28_EDGE EDGE_BIAS EDGE_BIAS mim_unit
XXP_r47_c32_B10 TOP B10 mim_unit
XXP_r14_c31_B11 TOP B11 mim_unit
XXP_r19_c30_B10 TOP B10 mim_unit
XXP_r41_c37_B10 TOP B10 mim_unit
XXP_r34_c07_B7 TOP B7 mim_unit
XXP_r07_c18_B11 TOP B11 mim_unit
XXP_r14_c22_B11 TOP B11 mim_unit
XXP_r19_c21_B10 TOP B10 mim_unit
XXP_r47_c23_B10 TOP B10 mim_unit
XXP_r07_c09_B11 TOP B11 mim_unit
XXP_r11_c58_B11 TOP B11 mim_unit
XXP_r44_c59_B10 TOP B10 mim_unit
XXP_r41_c28_B10 TOP B10 mim_unit
XXP_r32_c43_B5 TOP B5 mim_unit
XXP_r32_c27_B6 TOP B6 mim_unit
XXP_r23_c61_B10 TOP B10 mim_unit
XXP_r47_c14_B10 TOP B10 mim_unit
XXP_r30_c22_B8 TOP B8 mim_unit
XXP_r14_c13_B11 TOP B11 mim_unit
XXP_r19_c12_B10 TOP B10 mim_unit
XXP_r20_c30_B10 TOP B10 mim_unit
XXP_r26_c13_B9 TOP B9 mim_unit
XXP_r52_c50_B11 TOP B11 mim_unit
XXP_r48_c01_B11 TOP B11 mim_unit
XXP_r41_c19_B10 TOP B10 mim_unit
XXP_r11_c49_B11 TOP B11 mim_unit
XXP_r23_c52_B10 TOP B10 mim_unit
XXP_r14_c04_B11 TOP B11 mim_unit
XXP_r19_c03_B10 TOP B10 mim_unit
XXP_r20_c21_B10 TOP B10 mim_unit
XXP_r47_c05_B10 TOP B10 mim_unit
XXP_r37_c43_B9 TOP B9 mim_unit
XXP_r52_c41_B11 TOP B11 mim_unit
XXP_r23_c43_B10 TOP B10 mim_unit
XXP_r00_c51_EDGE EDGE_BIAS EDGE_BIAS mim_unit
XXP_r20_c12_B10 TOP B10 mim_unit
XXP_r28_c04_B9 TOP B9 mim_unit
XXP_r20_c00_EDGE EDGE_BIAS EDGE_BIAS mim_unit
XXP_r55_c63_B11 TOP B11 mim_unit
XXP_r52_c32_B11 TOP B11 mim_unit
XXP_r35_c63_B8 TOP B8 mim_unit
XXP_r32_c38_B5 TOP B5 mim_unit
XXP_r32_c54_B4 TOP B4 mim_unit
XXP_r30_c65_EDGE EDGE_BIAS EDGE_BIAS mim_unit
XXP_r30_c17_B8 TOP B8 mim_unit
XXP_r20_c03_B10 TOP B10 mim_unit
XXP_r23_c34_B10 TOP B10 mim_unit
XXP_r26_c08_B9 TOP B9 mim_unit
XXP_r39_c34_B9 TOP B9 mim_unit
XXP_r55_c54_B11 TOP B11 mim_unit
XXP_r52_c23_B11 TOP B11 mim_unit
XXP_r34_c20_B7 TOP B7 mim_unit
XXP_r23_c25_B10 TOP B10 mim_unit
XXP_r37_c38_B9 TOP B9 mim_unit
XXP_r55_c45_B11 TOP B11 mim_unit
XXP_r52_c14_B11 TOP B11 mim_unit
XXP_r23_c16_B10 TOP B10 mim_unit
XXP_r35_c58_B8 TOP B8 mim_unit
XXP_r32_c49_B4 TOP B4 mim_unit
XXP_r55_c36_B11 TOP B11 mim_unit
XXP_r52_c05_B11 TOP B11 mim_unit
XXP_r62_c40_B11 TOP B11 mim_unit
XXP_r39_c29_B9 TOP B9 mim_unit
XXP_r23_c07_B10 TOP B10 mim_unit
XXP_r58_c58_B11 TOP B11 mim_unit
XXP_r55_c27_B11 TOP B11 mim_unit
XXP_r34_c15_B7 TOP B7 mim_unit
XXP_r62_c31_B11 TOP B11 mim_unit
XXP_r03_c63_B11 TOP B11 mim_unit
XXP_r58_c49_B11 TOP B11 mim_unit
XXP_r55_c18_B11 TOP B11 mim_unit
XXP_r62_c22_B11 TOP B11 mim_unit
XXP_r03_c54_B11 TOP B11 mim_unit
XXP_r65_c61_EDGE EDGE_BIAS EDGE_BIAS mim_unit
XXP_r63_c01_B7 TOP B7 mim_unit
XXP_r30_c30_B8 TOP B8 mim_unit
XXP_r55_c09_B11 TOP B11 mim_unit
XXP_r26_c21_B9 TOP B9 mim_unit
XXP_r09_c40_B11 TOP B11 mim_unit
XXP_r62_c13_B11 TOP B11 mim_unit
XXP_r03_c45_B11 TOP B11 mim_unit
XXP_r43_c50_B10 TOP B10 mim_unit
XXP_r37_c51_B9 TOP B9 mim_unit
XXP_r09_c31_B11 TOP B11 mim_unit
XXP_r62_c04_B11 TOP B11 mim_unit
XXP_r03_c36_B11 TOP B11 mim_unit
XXP_r28_c12_B9 TOP B9 mim_unit
XXP_r09_c22_B11 TOP B11 mim_unit
XXP_r10_c40_B11 TOP B11 mim_unit
XXP_r43_c41_B10 TOP B10 mim_unit
XXP_r32_c46_B5 TOP B5 mim_unit
XXP_r30_c25_B8 TOP B8 mim_unit
XXP_r26_c16_B9 TOP B9 mim_unit
XXP_r03_c27_B11 TOP B11 mim_unit
XXP_r06_c58_B11 TOP B11 mim_unit
XXP_r18_c61_B10 TOP B10 mim_unit
XXP_r46_c63_B10 TOP B10 mim_unit
XXP_r43_c32_B10 TOP B10 mim_unit
XXP_r39_c42_B9 TOP B9 mim_unit
XXP_r09_c13_B11 TOP B11 mim_unit
XXP_r10_c31_B11 TOP B11 mim_unit
XXP_r13_c62_B11 TOP B11 mim_unit
XXP_r06_c49_B11 TOP B11 mim_unit
XXP_r03_c18_B11 TOP B11 mim_unit
XXP_r37_c46_B9 TOP B9 mim_unit
XXP_r00_c08_EDGE EDGE_BIAS EDGE_BIAS mim_unit
XXP_r09_c04_B11 TOP B11 mim_unit
XXP_r10_c22_B11 TOP B11 mim_unit
XXP_r13_c53_B11 TOP B11 mim_unit
XXP_r18_c52_B10 TOP B10 mim_unit
XXP_r46_c54_B10 TOP B10 mim_unit
XXP_r45_c00_EDGE EDGE_BIAS EDGE_BIAS mim_unit
XXP_r43_c23_B10 TOP B10 mim_unit
XXP_r55_c65_EDGE EDGE_BIAS EDGE_BIAS mim_unit
XXP_r28_c07_B9 TOP B9 mim_unit
XXP_r03_c09_B11 TOP B11 mim_unit
XXP_r18_c43_B10 TOP B10 mim_unit
XXP_r46_c45_B10 TOP B10 mim_unit
XXP_r43_c14_B10 TOP B10 mim_unit
XXP_r10_c13_B11 TOP B11 mim_unit
XXP_r13_c44_B11 TOP B11 mim_unit
XXP_r36_c03_B8 TOP B8 mim_unit
XXP_r44_c01_B11 TOP B11 mim_unit
XXP_r39_c37_B9 TOP B9 mim_unit
XXP_r10_c04_B11 TOP B11 mim_unit
XXP_r13_c35_B11 TOP B11 mim_unit
XXP_r18_c34_B10 TOP B10 mim_unit
XXP_r46_c36_B10 TOP B10 mim_unit
XXP_r43_c05_B10 TOP B10 mim_unit
XXP_r34_c23_B7 TOP B7 mim_unit
XXP_r18_c25_B10 TOP B10 mim_unit
XXP_r46_c27_B10 TOP B10 mim_unit
XXP_r13_c26_B11 TOP B11 mim_unit
XXP_r16_c57_B11 TOP B11 mim_unit
XXP_r51_c63_B11 TOP B11 mim_unit
XXP_r13_c17_B11 TOP B11 mim_unit
XXP_r16_c48_B11 TOP B11 mim_unit
XXP_r18_c16_B10 TOP B10 mim_unit
XXP_r46_c18_B10 TOP B10 mim_unit
XXP_r33_c05_B3 TOP B3 mim_unit
XXP_r51_c54_B11 TOP B11 mim_unit
XXP_r22_c56_B10 TOP B10 mim_unit
XXP_r18_c07_B10 TOP B10 mim_unit
XXP_r57_c40_B11 TOP B11 mim_unit
XXP_r46_c09_B10 TOP B10 mim_unit
XXP_r34_c18_B7 TOP B7 mim_unit
XXP_r13_c08_B11 TOP B11 mim_unit
XXP_r16_c39_B11 TOP B11 mim_unit
XXP_r51_c45_B11 TOP B11 mim_unit
XXP_r28_c20_B9 TOP B9 mim_unit
XXP_r22_c47_B10 TOP B10 mim_unit
XXP_r65_c18_EDGE EDGE_BIAS EDGE_BIAS mim_unit
XXP_r60_c00_EDGE EDGE_BIAS EDGE_BIAS mim_unit
XXP_r57_c31_B11 TOP B11 mim_unit
XXP_r30_c33_B8 TOP B8 mim_unit
XXP_r51_c36_B11 TOP B11 mim_unit
XXP_r26_c24_B9 TOP B9 mim_unit
XXP_r22_c38_B10 TOP B10 mim_unit
XXP_r57_c22_B11 TOP B11 mim_unit
XXP_r39_c50_B9 TOP B9 mim_unit
XXP_r54_c58_B11 TOP B11 mim_unit
XXP_r51_c27_B11 TOP B11 mim_unit
XXP_r37_c54_B9 TOP B9 mim_unit
XXP_r22_c29_B10 TOP B10 mim_unit
XXP_r61_c62_B11 TOP B11 mim_unit
XXP_r57_c13_B11 TOP B11 mim_unit
XXP_r54_c49_B11 TOP B11 mim_unit
XXP_r51_c18_B11 TOP B11 mim_unit
XXP_r28_c15_B9 TOP B9 mim_unit
XXP_r61_c53_B11 TOP B11 mim_unit
XXP_r57_c04_B11 TOP B11 mim_unit
XXP_r30_c28_B8 TOP B8 mim_unit
XXP_r51_c09_B11 TOP B11 mim_unit
XXP_r36_c11_B8 TOP B8 mim_unit
XXP_r26_c19_B9 TOP B9 mim_unit
XXP_r05_c40_B11 TOP B11 mim_unit
XXP_r39_c45_B9 TOP B9 mim_unit
XXP_r61_c44_B11 TOP B11 mim_unit
XXP_r57_c01_B9 TOP B9 mim_unit
XXP_r00_c41_EDGE EDGE_BIAS EDGE_BIAS mim_unit
XXP_r34_c31_B7 TOP B7 mim_unit
XXP_r08_c62_B11 TOP B11 mim_unit
XXP_r37_c49_B9 TOP B9 mim_unit
XXP_r05_c31_B11 TOP B11 mim_unit
XXP_r61_c35_B11 TOP B11 mim_unit
XXP_r09_c65_EDGE EDGE_BIAS EDGE_BIAS mim_unit
XXP_r05_c22_B11 TOP B11 mim_unit
XXP_r08_c53_B11 TOP B11 mim_unit
XXP_r00_c64_EDGE EDGE_BIAS EDGE_BIAS mim_unit
XXP_r64_c57_B11 TOP B11 mim_unit
XXP_r61_c26_B11 TOP B11 mim_unit
XXP_r36_c06_B8 TOP B8 mim_unit
XXP_r02_c58_B11 TOP B11 mim_unit
XXP_r42_c63_B10 TOP B10 mim_unit
XXP_r05_c13_B11 TOP B11 mim_unit
XXP_r08_c44_B11 TOP B11 mim_unit
XXP_r64_c48_B11 TOP B11 mim_unit
XXP_r61_c17_B11 TOP B11 mim_unit
XXP_r02_c49_B11 TOP B11 mim_unit
XXP_r39_c01_B11 TOP B11 mim_unit
XXP_r34_c26_B7 TOP B7 mim_unit
XXP_r05_c04_B11 TOP B11 mim_unit
XXP_r08_c35_B11 TOP B11 mim_unit
XXP_r42_c54_B10 TOP B10 mim_unit
XXP_r64_c39_B11 TOP B11 mim_unit
XXP_r61_c08_B11 TOP B11 mim_unit
XXP_r48_c40_B10 TOP B10 mim_unit
XXP_r42_c45_B10 TOP B10 mim_unit
XXP_r30_c41_B8 TOP B8 mim_unit
XXP_r08_c26_B11 TOP B11 mim_unit
XXP_r26_c32_B9 TOP B9 mim_unit
XXP_r15_c30_B11 TOP B11 mim_unit
XXP_r48_c31_B10 TOP B10 mim_unit
XXP_r40_c01_B11 TOP B11 mim_unit
XXP_r33_c08_B3 TOP B3 mim_unit
XXP_r08_c17_B11 TOP B11 mim_unit
XXP_r42_c36_B10 TOP B10 mim_unit
XXP_r65_c51_EDGE EDGE_BIAS EDGE_BIAS mim_unit
XXP_r48_c22_B10 TOP B10 mim_unit
XXP_r37_c62_B9 TOP B9 mim_unit
XXP_r15_c21_B11 TOP B11 mim_unit
XXP_r12_c57_B11 TOP B11 mim_unit
XXP_r17_c56_B10 TOP B10 mim_unit
XXP_r45_c58_B10 TOP B10 mim_unit
XXP_r42_c27_B10 TOP B10 mim_unit
XXP_r08_c08_B11 TOP B11 mim_unit
XXP_r14_c00_EDGE EDGE_BIAS EDGE_BIAS mim_unit
XXP_r28_c23_B9 TOP B9 mim_unit
XXP_r24_c65_EDGE EDGE_BIAS EDGE_BIAS mim_unit
XXP_r24_c60_B10 TOP B10 mim_unit
XXP_r15_c12_B11 TOP B11 mim_unit
XXP_r48_c13_B10 TOP B10 mim_unit
XXP_r30_c36_B8 TOP B8 mim_unit
XXP_r26_c27_B9 TOP B9 mim_unit
XXP_r12_c48_B11 TOP B11 mim_unit
XXP_r17_c47_B10 TOP B10 mim_unit
XXP_r45_c49_B10 TOP B10 mim_unit
XXP_r42_c18_B10 TOP B10 mim_unit
XXP_r33_c10_B4 TOP B4 mim_unit
XXP_r24_c51_B10 TOP B10 mim_unit
XXP_r48_c04_B10 TOP B10 mim_unit
XXP_r39_c53_B9 TOP B9 mim_unit
XXP_r15_c03_B11 TOP B11 mim_unit
XXP_r21_c20_B10 TOP B10 mim_unit
XXP_r17_c38_B10 TOP B10 mim_unit
XXP_r53_c40_B11 TOP B11 mim_unit
XXP_r42_c09_B10 TOP B10 mim_unit
XXP_r12_c39_B11 TOP B11 mim_unit
XXP_r37_c57_B9 TOP B9 mim_unit
XXP_r24_c42_B10 TOP B10 mim_unit
XXP_r21_c11_B10 TOP B10 mim_unit
XXP_r49_c58_B11 TOP B11 mim_unit
XXP_r28_c18_B9 TOP B9 mim_unit
XXP_r17_c29_B10 TOP B10 mim_unit
XXP_r56_c62_B11 TOP B11 mim_unit
XXP_r53_c31_B11 TOP B11 mim_unit
XXP_r24_c33_B10 TOP B10 mim_unit
XXP_r49_c49_B11 TOP B11 mim_unit
XXP_r21_c02_B10 TOP B10 mim_unit
XXP_r36_c14_B8 TOP B8 mim_unit
XXP_r56_c53_B11 TOP B11 mim_unit
XXP_r53_c22_B11 TOP B11 mim_unit
XXP_r39_c48_B9 TOP B9 mim_unit
XXP_r24_c24_B10 TOP B10 mim_unit
XXP_r50_c58_B11 TOP B11 mim_unit
XXP_r34_c34_B7 TOP B7 mim_unit
XXP_r56_c44_B11 TOP B11 mim_unit
XXP_r53_c13_B11 TOP B11 mim_unit
XXP_r24_c15_B10 TOP B10 mim_unit
XXP_r50_c49_B11 TOP B11 mim_unit
XXP_r56_c35_B11 TOP B11 mim_unit
XXP_r53_c04_B11 TOP B11 mim_unit
XXP_r36_c09_B8 TOP B8 mim_unit
XXP_r24_c06_B10 TOP B10 mim_unit
XXP_r26_c40_B9 TOP B9 mim_unit
XXP_r01_c40_B11 TOP B11 mim_unit
XXP_r59_c57_B11 TOP B11 mim_unit
XXP_r56_c26_B11 TOP B11 mim_unit
XXP_r63_c30_B11 TOP B11 mim_unit
XXP_r34_c29_B7 TOP B7 mim_unit
XXP_r01_c31_B11 TOP B11 mim_unit
XXP_r04_c62_B11 TOP B11 mim_unit
XXP_r32_c64_B11 TOP B11 mim_unit
XXP_r59_c48_B11 TOP B11 mim_unit
XXP_r56_c17_B11 TOP B11 mim_unit
XXP_r28_c31_B9 TOP B9 mim_unit
XXP_r63_c21_B11 TOP B11 mim_unit
XXP_r40_c04_B9 TOP B9 mim_unit
XXP_r04_c53_B11 TOP B11 mim_unit
XXP_r01_c22_B11 TOP B11 mim_unit
XXP_r30_c44_B8 TOP B8 mim_unit
XXP_r60_c57_B11 TOP B11 mim_unit
XXP_r59_c39_B11 TOP B11 mim_unit
XXP_r56_c08_B11 TOP B11 mim_unit
XXP_r26_c35_B9 TOP B9 mim_unit
XXP_r63_c12_B11 TOP B11 mim_unit
XXP_r04_c44_B11 TOP B11 mim_unit
XXP_r39_c61_B9 TOP B9 mim_unit
XXP_r01_c13_B11 TOP B11 mim_unit
XXP_r65_c08_EDGE EDGE_BIAS EDGE_BIAS mim_unit
XXP_r60_c48_B11 TOP B11 mim_unit
XXP_r35_c01_B11 TOP B11 mim_unit
XXP_r63_c03_B11 TOP B11 mim_unit
XXP_r39_c00_EDGE EDGE_BIAS EDGE_BIAS mim_unit
XXP_r04_c35_B11 TOP B11 mim_unit
XXP_r01_c04_B11 TOP B11 mim_unit
XXP_r49_c65_EDGE EDGE_BIAS EDGE_BIAS mim_unit
XXP_r38_c02_B9 TOP B9 mim_unit
XXP_r60_c39_B11 TOP B11 mim_unit
XXP_r44_c40_B10 TOP B10 mim_unit
XXP_r28_c26_B9 TOP B9 mim_unit
XXP_r04_c26_B11 TOP B11 mim_unit
XXP_r07_c57_B11 TOP B11 mim_unit
XXP_r30_c39_B8 TOP B8 mim_unit
XXP_r36_c22_B8 TOP B8 mim_unit
XXP_r33_c13_B4 TOP B4 mim_unit
XXP_r11_c30_B11 TOP B11 mim_unit
XXP_r14_c61_B11 TOP B11 mim_unit
XXP_r19_c60_B10 TOP B10 mim_unit
XXP_r47_c62_B10 TOP B10 mim_unit
XXP_r44_c31_B10 TOP B10 mim_unit
XXP_r39_c56_B9 TOP B9 mim_unit
XXP_r04_c17_B11 TOP B11 mim_unit
XXP_r07_c48_B11 TOP B11 mim_unit
XXP_r34_c42_B7 TOP B7 mim_unit
XXP_r19_c51_B10 TOP B10 mim_unit
XXP_r47_c53_B10 TOP B10 mim_unit
XXP_r44_c22_B10 TOP B10 mim_unit
XXP_r11_c21_B11 TOP B11 mim_unit
XXP_r14_c52_B11 TOP B11 mim_unit
XXP_r07_c39_B11 TOP B11 mim_unit
XXP_r41_c58_B10 TOP B10 mim_unit
XXP_r04_c08_B11 TOP B11 mim_unit
XXP_r11_c12_B11 TOP B11 mim_unit
XXP_r14_c43_B11 TOP B11 mim_unit
XXP_r19_c42_B10 TOP B10 mim_unit
XXP_r20_c60_B10 TOP B10 mim_unit
XXP_r47_c44_B10 TOP B10 mim_unit
XXP_r44_c13_B10 TOP B10 mim_unit
XXP_r00_c31_EDGE EDGE_BIAS EDGE_BIAS mim_unit
XXP_r41_c49_B10 TOP B10 mim_unit
XXP_r36_c17_B8 TOP B8 mim_unit
XXP_r19_c33_B10 TOP B10 mim_unit
XXP_r20_c51_B10 TOP B10 mim_unit
XXP_r47_c35_B10 TOP B10 mim_unit
XXP_r44_c04_B10 TOP B10 mim_unit
XXP_r11_c03_B11 TOP B11 mim_unit
XXP_r14_c34_B11 TOP B11 mim_unit
XXP_r34_c37_B7 TOP B7 mim_unit
XXP_r00_c54_EDGE EDGE_BIAS EDGE_BIAS mim_unit
XXP_r14_c25_B11 TOP B11 mim_unit
XXP_r19_c24_B10 TOP B10 mim_unit
XXP_r20_c42_B10 TOP B10 mim_unit
XXP_r54_c00_EDGE EDGE_BIAS EDGE_BIAS mim_unit
XXP_r47_c26_B10 TOP B10 mim_unit
XXP_r64_c65_EDGE EDGE_BIAS EDGE_BIAS mim_unit
XXP_r52_c62_B11 TOP B11 mim_unit
XXP_r40_c12_B9 TOP B9 mim_unit
XXP_r19_c15_B10 TOP B10 mim_unit
XXP_r20_c33_B10 TOP B10 mim_unit
XXP_r47_c17_B10 TOP B10 mim_unit
XXP_r30_c52_B8 TOP B8 mim_unit
XXP_r14_c16_B11 TOP B11 mim_unit
XXP_r26_c43_B9 TOP B9 mim_unit
XXP_r52_c53_B11 TOP B11 mim_unit
XXP_r23_c55_B10 TOP B10 mim_unit
XXP_r14_c07_B11 TOP B11 mim_unit
XXP_r19_c06_B10 TOP B10 mim_unit
XXP_r20_c24_B10 TOP B10 mim_unit
XXP_r47_c08_B10 TOP B10 mim_unit
XXP_r52_c44_B11 TOP B11 mim_unit
XXP_r23_c46_B10 TOP B10 mim_unit
XXP_r20_c15_B10 TOP B10 mim_unit
XXP_r58_c30_B11 TOP B11 mim_unit
XXP_r38_c10_B9 TOP B9 mim_unit
XXP_r28_c34_B9 TOP B9 mim_unit
XXP_r40_c07_B9 TOP B9 mim_unit
XXP_r27_c64_B11 TOP B11 mim_unit
XXP_r52_c35_B11 TOP B11 mim_unit
XXP_r36_c30_B8 TOP B8 mim_unit
XXP_r30_c47_B8 TOP B8 mim_unit
XXP_r26_c38_B9 TOP B9 mim_unit
XXP_r20_c06_B10 TOP B10 mim_unit
XXP_r23_c37_B10 TOP B10 mim_unit
XXP_r65_c41_EDGE EDGE_BIAS EDGE_BIAS mim_unit
XXP_r58_c21_B11 TOP B11 mim_unit
XXP_r55_c57_B11 TOP B11 mim_unit
XXP_r39_c64_B9 TOP B9 mim_unit
XXP_r52_c26_B11 TOP B11 mim_unit
XXP_r23_c28_B10 TOP B10 mim_unit
XXP_r62_c61_B11 TOP B11 mim_unit
XXP_r58_c12_B11 TOP B11 mim_unit
XXP_r34_c50_B7 TOP B7 mim_unit
XXP_r55_c48_B11 TOP B11 mim_unit
XXP_r52_c17_B11 TOP B11 mim_unit
XXP_r38_c05_B9 TOP B9 mim_unit
XXP_r28_c29_B9 TOP B9 mim_unit
XXP_r23_c19_B10 TOP B10 mim_unit
XXP_r65_c64_EDGE EDGE_BIAS EDGE_BIAS mim_unit
XXP_r62_c52_B11 TOP B11 mim_unit
XXP_r58_c03_B11 TOP B11 mim_unit
XXP_r55_c39_B11 TOP B11 mim_unit
XXP_r52_c08_B11 TOP B11 mim_unit
XXP_r36_c25_B8 TOP B8 mim_unit
XXP_r33_c16_B4 TOP B4 mim_unit
XXP_r62_c43_B11 TOP B11 mim_unit
XXP_r39_c59_B9 TOP B9 mim_unit
XXP_r34_c45_B7 TOP B7 mim_unit
XXP_r06_c30_B11 TOP B11 mim_unit
XXP_r09_c61_B11 TOP B11 mim_unit
XXP_r62_c34_B11 TOP B11 mim_unit
XXP_r09_c52_B11 TOP B11 mim_unit
XXP_r06_c21_B11 TOP B11 mim_unit
XXP_r62_c25_B11 TOP B11 mim_unit
XXP_r40_c20_B9 TOP B9 mim_unit
XXP_r03_c57_B11 TOP B11 mim_unit
XXP_r30_c60_B8 TOP B8 mim_unit
XXP_r26_c51_B9 TOP B9 mim_unit
XXP_r06_c12_B11 TOP B11 mim_unit
XXP_r09_c43_B11 TOP B11 mim_unit
XXP_r10_c61_B11 TOP B11 mim_unit
XXP_r43_c62_B10 TOP B10 mim_unit
XXP_r62_c16_B11 TOP B11 mim_unit
XXP_r03_c48_B11 TOP B11 mim_unit
XXP_r09_c34_B11 TOP B11 mim_unit
XXP_r10_c52_B11 TOP B11 mim_unit
XXP_r43_c53_B10 TOP B10 mim_unit
XXP_r06_c03_B11 TOP B11 mim_unit
XXP_r08_c00_EDGE EDGE_BIAS EDGE_BIAS mim_unit
XXP_r62_c07_B11 TOP B11 mim_unit
XXP_r03_c39_B11 TOP B11 mim_unit
XXP_r28_c42_B9 TOP B9 mim_unit
XXP_r18_c65_EDGE EDGE_BIAS EDGE_BIAS mim_unit
XXP_r40_c15_B9 TOP B9 mim_unit
XXP_r09_c25_B11 TOP B11 mim_unit
XXP_r10_c43_B11 TOP B11 mim_unit
XXP_r43_c44_B10 TOP B10 mim_unit
XXP_r30_c55_B8 TOP B8 mim_unit
XXP_r26_c46_B9 TOP B9 mim_unit
XXP_r10_c34_B11 TOP B11 mim_unit
XXP_r43_c35_B10 TOP B10 mim_unit
XXP_r09_c16_B11 TOP B11 mim_unit
XXP_r16_c20_B11 TOP B11 mim_unit
XXP_r46_c57_B10 TOP B10 mim_unit
XXP_r09_c07_B11 TOP B11 mim_unit
XXP_r10_c25_B11 TOP B11 mim_unit
XXP_r13_c56_B11 TOP B11 mim_unit
XXP_r18_c55_B10 TOP B10 mim_unit
XXP_r43_c26_B10 TOP B10 mim_unit
XXP_r38_c13_B9 TOP B9 mim_unit
XXP_r28_c37_B9 TOP B9 mim_unit
XXP_r16_c11_B11 TOP B11 mim_unit
XXP_r13_c47_B11 TOP B11 mim_unit
XXP_r18_c46_B10 TOP B10 mim_unit
XXP_r46_c48_B10 TOP B10 mim_unit
XXP_r43_c17_B10 TOP B10 mim_unit
XXP_r10_c16_B11 TOP B11 mim_unit
XXP_r36_c33_B8 TOP B8 mim_unit
XXP_r16_c02_B11 TOP B11 mim_unit
XXP_r31_c03_B7 TOP B7 mim_unit
XXP_r10_c07_B11 TOP B11 mim_unit
XXP_r13_c38_B11 TOP B11 mim_unit
XXP_r18_c37_B10 TOP B10 mim_unit
XXP_r46_c39_B10 TOP B10 mim_unit
XXP_r43_c08_B10 TOP B10 mim_unit
XXP_r34_c53_B7 TOP B7 mim_unit
XXP_r22_c10_B10 TOP B10 mim_unit
XXP_r38_c08_B9 TOP B9 mim_unit
XXP_r13_c29_B11 TOP B11 mim_unit
XXP_r18_c28_B10 TOP B10 mim_unit
XXP_r57_c61_B11 TOP B11 mim_unit
XXP_r54_c30_B11 TOP B11 mim_unit
XXP_r23_c00_EDGE EDGE_BIAS EDGE_BIAS mim_unit
XXP_r33_c65_EDGE EDGE_BIAS EDGE_BIAS mim_unit
XXP_r23_c64_B11 TOP B11 mim_unit
XXP_r22_c01_B10 TOP B10 mim_unit
XXP_r36_c28_B8 TOP B8 mim_unit
XXP_r18_c19_B10 TOP B10 mim_unit
XXP_r57_c52_B11 TOP B11 mim_unit
XXP_r54_c21_B11 TOP B11 mim_unit
XXP_r51_c57_B11 TOP B11 mim_unit
XXP_r22_c59_B10 TOP B10 mim_unit
XXP_r57_c43_B11 TOP B11 mim_unit
XXP_r54_c12_B11 TOP B11 mim_unit
XXP_r34_c48_B7 TOP B7 mim_unit
XXP_r00_c21_EDGE EDGE_BIAS EDGE_BIAS mim_unit
XXP_r51_c48_B11 TOP B11 mim_unit
XXP_r28_c50_B9 TOP B9 mim_unit
XXP_r57_c34_B11 TOP B11 mim_unit
XXP_r54_c03_B11 TOP B11 mim_unit
XXP_r40_c23_B9 TOP B9 mim_unit
XXP_r51_c39_B11 TOP B11 mim_unit
XXP_r30_c63_B8 TOP B8 mim_unit
XXP_r33_c21_B5 TOP B5 mim_unit
XXP_r26_c54_B9 TOP B9 mim_unit
XXP_r57_c25_B11 TOP B11 mim_unit
XXP_r00_c44_EDGE EDGE_BIAS EDGE_BIAS mim_unit
XXP_r02_c30_B11 TOP B11 mim_unit
XXP_r05_c61_B11 TOP B11 mim_unit
XXP_r57_c16_B11 TOP B11 mim_unit
XXP_r64_c20_B11 TOP B11 mim_unit
XXP_r38_c21_B9 TOP B9 mim_unit
XXP_r28_c45_B9 TOP B9 mim_unit
XXP_r05_c52_B11 TOP B11 mim_unit
XXP_r02_c21_B11 TOP B11 mim_unit
XXP_r40_c18_B9 TOP B9 mim_unit
XXP_r61_c56_B11 TOP B11 mim_unit
XXP_r57_c07_B11 TOP B11 mim_unit
XXP_r36_c41_B8 TOP B8 mim_unit
XXP_r30_c58_B8 TOP B8 mim_unit
XXP_r26_c49_B9 TOP B9 mim_unit
XXP_r64_c11_B11 TOP B11 mim_unit
XXP_r05_c43_B11 TOP B11 mim_unit
XXP_r02_c12_B11 TOP B11 mim_unit
XXP_r31_c11_B7 TOP B7 mim_unit
XXP_r61_c47_B11 TOP B11 mim_unit
XXP_r64_c02_B11 TOP B11 mim_unit
XXP_r34_c61_B7 TOP B7 mim_unit
XXP_r05_c34_B11 TOP B11 mim_unit
XXP_r02_c03_B11 TOP B11 mim_unit
XXP_r61_c38_B11 TOP B11 mim_unit
XXP_r38_c16_B9 TOP B9 mim_unit
XXP_r65_c31_EDGE EDGE_BIAS EDGE_BIAS mim_unit
XXP_r05_c25_B11 TOP B11 mim_unit
XXP_r08_c56_B11 TOP B11 mim_unit
XXP_r15_c60_B11 TOP B11 mim_unit
XXP_r61_c29_B11 TOP B11 mim_unit
XXP_r48_c61_B10 TOP B10 mim_unit
XXP_r45_c30_B10 TOP B10 mim_unit
XXP_r36_c36_B8 TOP B8 mim_unit
XXP_r31_c06_B7 TOP B7 mim_unit
XXP_r05_c16_B11 TOP B11 mim_unit
XXP_r08_c47_B11 TOP B11 mim_unit
XXP_r14_c64_B10 TOP B10 mim_unit
XXP_r34_c56_B7 TOP B7 mim_unit
XXP_r12_c20_B11 TOP B11 mim_unit
XXP_r15_c51_B11 TOP B11 mim_unit
XXP_r65_c54_EDGE EDGE_BIAS EDGE_BIAS mim_unit
XXP_r48_c52_B10 TOP B10 mim_unit
XXP_r45_c21_B10 TOP B10 mim_unit
XXP_r48_c00_EDGE EDGE_BIAS EDGE_BIAS mim_unit
XXP_r42_c57_B10 TOP B10 mim_unit
XXP_r05_c07_B11 TOP B11 mim_unit
XXP_r08_c38_B11 TOP B11 mim_unit
XXP_r58_c65_EDGE EDGE_BIAS EDGE_BIAS mim_unit
XXP_r15_c42_B11 TOP B11 mim_unit
XXP_r17_c10_B10 TOP B10 mim_unit
XXP_r48_c43_B10 TOP B10 mim_unit
XXP_r45_c12_B10 TOP B10 mim_unit
XXP_r12_c11_B11 TOP B11 mim_unit
XXP_r40_c31_B9 TOP B9 mim_unit
XXP_r08_c29_B11 TOP B11 mim_unit
XXP_r49_c30_B11 TOP B11 mim_unit
XXP_r42_c48_B10 TOP B10 mim_unit
XXP_r26_c62_B9 TOP B9 mim_unit
XXP_r12_c02_B11 TOP B11 mim_unit
XXP_r15_c33_B11 TOP B11 mim_unit
XXP_r17_c01_B10 TOP B10 mim_unit
XXP_r18_c64_B11 TOP B11 mim_unit
XXP_r21_c50_B10 TOP B10 mim_unit
XXP_r48_c34_B10 TOP B10 mim_unit
XXP_r45_c03_B10 TOP B10 mim_unit
XXP_r42_c39_B10 TOP B10 mim_unit
XXP_r49_c21_B11 TOP B11 mim_unit
XXP_r21_c41_B10 TOP B10 mim_unit
XXP_r48_c25_B10 TOP B10 mim_unit
XXP_r25_c03_B9 TOP B9 mim_unit
XXP_r15_c24_B11 TOP B11 mim_unit
XXP_r17_c59_B10 TOP B10 mim_unit
XXP_r53_c61_B11 TOP B11 mim_unit
XXP_r50_c30_B11 TOP B11 mim_unit
XXP_r49_c12_B11 TOP B11 mim_unit
XXP_r28_c53_B9 TOP B9 mim_unit
XXP_r40_c26_B9 TOP B9 mim_unit
XXP_r24_c63_B10 TOP B10 mim_unit
XXP_r15_c15_B11 TOP B11 mim_unit
XXP_r21_c32_B10 TOP B10 mim_unit
XXP_r48_c16_B10 TOP B10 mim_unit
XXP_r53_c52_B11 TOP B11 mim_unit
XXP_r33_c24_B5 TOP B5 mim_unit
XXP_r26_c57_B9 TOP B9 mim_unit
XXP_r50_c21_B11 TOP B11 mim_unit
XXP_r49_c03_B11 TOP B11 mim_unit
XXP_r24_c54_B10 TOP B10 mim_unit
XXP_r21_c23_B10 TOP B10 mim_unit
XXP_r48_c07_B10 TOP B10 mim_unit
XXP_r15_c06_B11 TOP B11 mim_unit
XXP_r53_c43_B11 TOP B11 mim_unit
XXP_r50_c12_B11 TOP B11 mim_unit
XXP_r24_c45_B10 TOP B10 mim_unit
XXP_r21_c14_B10 TOP B10 mim_unit
XXP_r63_c00_EDGE EDGE_BIAS EDGE_BIAS mim_unit
XXP_r38_c24_B9 TOP B9 mim_unit
XXP_r28_c48_B9 TOP B9 mim_unit
XXP_r53_c34_B11 TOP B11 mim_unit
XXP_r50_c03_B11 TOP B11 mim_unit
XXP_r24_c36_B10 TOP B10 mim_unit
XXP_r02_c65_EDGE EDGE_BIAS EDGE_BIAS mim_unit
XXP_r21_c05_B10 TOP B10 mim_unit
XXP_r59_c20_B11 TOP B11 mim_unit
XXP_r33_c19_B5 TOP B5 mim_unit
XXP_r29_c01_B8 TOP B8 mim_unit
XXP_r36_c44_B8 TOP B8 mim_unit
XXP_r56_c56_B11 TOP B11 mim_unit
XXP_r53_c25_B11 TOP B11 mim_unit
XXP_r31_c14_B7 TOP B7 mim_unit
XXP_r24_c27_B10 TOP B10 mim_unit
XXP_r63_c60_B11 TOP B11 mim_unit
XXP_r59_c11_B11 TOP B11 mim_unit
XXP_r34_c64_B7 TOP B7 mim_unit
XXP_r01_c61_B11 TOP B11 mim_unit
XXP_r56_c47_B11 TOP B11 mim_unit
XXP_r53_c16_B11 TOP B11 mim_unit
XXP_r38_c19_B9 TOP B9 mim_unit
XXP_r24_c18_B10 TOP B10 mim_unit
XXP_r63_c51_B11 TOP B11 mim_unit
XXP_r60_c20_B11 TOP B11 mim_unit
XXP_r59_c02_B11 TOP B11 mim_unit
XXP_r01_c52_B11 TOP B11 mim_unit
XXP_r05_c64_B9 TOP B9 mim_unit
XXP_r56_c38_B11 TOP B11 mim_unit
XXP_r53_c07_B11 TOP B11 mim_unit
XXP_r36_c39_B8 TOP B8 mim_unit
XXP_r24_c09_B10 TOP B10 mim_unit
XXP_r63_c42_B11 TOP B11 mim_unit
XXP_r60_c11_B11 TOP B11 mim_unit
XXP_r01_c43_B11 TOP B11 mim_unit
XXP_r56_c29_B11 TOP B11 mim_unit
XXP_r31_c09_B7 TOP B7 mim_unit
XXP_r63_c33_B11 TOP B11 mim_unit
XXP_r60_c02_B11 TOP B11 mim_unit
XXP_r34_c59_B7 TOP B7 mim_unit
XXP_r01_c34_B11 TOP B11 mim_unit
XXP_r09_c64_B10 TOP B10 mim_unit
XXP_r25_c11_B9 TOP B9 mim_unit
XXP_r07_c20_B11 TOP B11 mim_unit
XXP_r28_c61_B9 TOP B9 mim_unit
XXP_r63_c24_B11 TOP B11 mim_unit
XXP_r40_c34_B9 TOP B9 mim_unit
XXP_r04_c56_B11 TOP B11 mim_unit
XXP_r01_c25_B11 TOP B11 mim_unit
XXP_r07_c11_B11 TOP B11 mim_unit
XXP_r11_c60_B11 TOP B11 mim_unit
XXP_r44_c61_B10 TOP B10 mim_unit
XXP_r41_c30_B10 TOP B10 mim_unit
XXP_r33_c32_B5 TOP B5 mim_unit
XXP_r63_c15_B11 TOP B11 mim_unit
XXP_r04_c47_B11 TOP B11 mim_unit
XXP_r00_c11_EDGE EDGE_BIAS EDGE_BIAS mim_unit
XXP_r01_c16_B11 TOP B11 mim_unit
XXP_r10_c64_B10 TOP B10 mim_unit
XXP_r27_c02_B9 TOP B9 mim_unit
XXP_r44_c52_B10 TOP B10 mim_unit
XXP_r07_c02_B11 TOP B11 mim_unit
XXP_r11_c51_B11 TOP B11 mim_unit
XXP_r41_c21_B10 TOP B10 mim_unit
XXP_r25_c06_B9 TOP B9 mim_unit
XXP_r63_c06_B11 TOP B11 mim_unit
XXP_r04_c38_B11 TOP B11 mim_unit
XXP_r01_c07_B11 TOP B11 mim_unit
XXP_r38_c32_B9 TOP B9 mim_unit
XXP_r28_c56_B9 TOP B9 mim_unit
XXP_r11_c42_B11 TOP B11 mim_unit
XXP_r44_c43_B10 TOP B10 mim_unit
XXP_r40_c29_B9 TOP B9 mim_unit
XXP_r41_c12_B10 TOP B10 mim_unit
XXP_r00_c34_EDGE EDGE_BIAS EDGE_BIAS mim_unit
XXP_r04_c29_B11 TOP B11 mim_unit
XXP_r36_c52_B8 TOP B8 mim_unit
XXP_r33_c27_B5 TOP B5 mim_unit
XXP_r11_c33_B11 TOP B11 mim_unit
XXP_r19_c63_B10 TOP B10 mim_unit
XXP_r44_c34_B10 TOP B10 mim_unit
XXP_r41_c03_B10 TOP B10 mim_unit
XXP_r31_c22_B7 TOP B7 mim_unit
XXP_r11_c24_B11 TOP B11 mim_unit
XXP_r14_c55_B11 TOP B11 mim_unit
XXP_r19_c54_B10 TOP B10 mim_unit
XXP_r47_c56_B10 TOP B10 mim_unit
XXP_r44_c25_B10 TOP B10 mim_unit
XXP_r00_c57_EDGE EDGE_BIAS EDGE_BIAS mim_unit
XXP_r38_c27_B9 TOP B9 mim_unit
XXP_r17_c00_EDGE EDGE_BIAS EDGE_BIAS mim_unit
XXP_r27_c65_EDGE EDGE_BIAS EDGE_BIAS mim_unit
XXP_r47_c47_B10 TOP B10 mim_unit
XXP_r11_c15_B11 TOP B11 mim_unit
XXP_r14_c46_B11 TOP B11 mim_unit
XXP_r19_c45_B10 TOP B10 mim_unit
XXP_r20_c63_B10 TOP B10 mim_unit
XXP_r44_c16_B10 TOP B10 mim_unit
XXP_r29_c04_B8 TOP B8 mim_unit
XXP_r36_c47_B8 TOP B8 mim_unit
XXP_r31_c17_B7 TOP B7 mim_unit
XXP_r11_c06_B11 TOP B11 mim_unit
XXP_r14_c37_B11 TOP B11 mim_unit
XXP_r19_c36_B10 TOP B10 mim_unit
XXP_r20_c54_B10 TOP B10 mim_unit
XXP_r47_c38_B10 TOP B10 mim_unit
XXP_r44_c07_B10 TOP B10 mim_unit
XXP_r65_c21_EDGE EDGE_BIAS EDGE_BIAS mim_unit
XXP_r58_c60_B11 TOP B11 mim_unit
XXP_r47_c29_B10 TOP B10 mim_unit
XXP_r14_c28_B11 TOP B11 mim_unit
XXP_r19_c27_B10 TOP B10 mim_unit
XXP_r20_c45_B10 TOP B10 mim_unit
XXP_r40_c42_B9 TOP B9 mim_unit
XXP_r14_c19_B11 TOP B11 mim_unit
XXP_r19_c18_B10 TOP B10 mim_unit
XXP_r20_c36_B10 TOP B10 mim_unit
XXP_r58_c51_B11 TOP B11 mim_unit
XXP_r55_c20_B11 TOP B11 mim_unit
XXP_r65_c44_EDGE EDGE_BIAS EDGE_BIAS mim_unit
XXP_r52_c56_B11 TOP B11 mim_unit
XXP_r27_c10_B9 TOP B9 mim_unit
XXP_r23_c58_B10 TOP B10 mim_unit
XXP_r19_c09_B10 TOP B10 mim_unit
XXP_r20_c27_B10 TOP B10 mim_unit
XXP_r58_c42_B11 TOP B11 mim_unit
XXP_r55_c11_B11 TOP B11 mim_unit
XXP_r52_c47_B11 TOP B11 mim_unit
XXP_r25_c14_B9 TOP B9 mim_unit
XXP_r23_c49_B10 TOP B10 mim_unit
XXP_r20_c18_B10 TOP B10 mim_unit
XXP_r58_c33_B11 TOP B11 mim_unit
XXP_r55_c02_B11 TOP B11 mim_unit
XXP_r38_c40_B9 TOP B9 mim_unit
XXP_r32_c00_EDGE EDGE_BIAS EDGE_BIAS mim_unit
XXP_r42_c65_EDGE EDGE_BIAS EDGE_BIAS mim_unit
XXP_r40_c37_B9 TOP B9 mim_unit
XXP_r52_c38_B11 TOP B11 mim_unit
XXP_r36_c60_B8 TOP B8 mim_unit
XXP_r20_c09_B10 TOP B10 mim_unit
XXP_r58_c24_B11 TOP B11 mim_unit
XXP_r64_c01_B6 TOP B6 mim_unit
XXP_r52_c29_B11 TOP B11 mim_unit
XXP_r31_c30_B7 TOP B7 mim_unit
XXP_r27_c05_B9 TOP B9 mim_unit
XXP_r06_c60_B11 TOP B11 mim_unit
XXP_r62_c64_B11 TOP B11 mim_unit
XXP_r58_c15_B11 TOP B11 mim_unit
XXP_r25_c09_B9 TOP B9 mim_unit
XXP_r38_c35_B9 TOP B9 mim_unit
XXP_r03_c20_B11 TOP B11 mim_unit
XXP_r06_c51_B11 TOP B11 mim_unit
XXP_r62_c55_B11 TOP B11 mim_unit
XXP_r28_c59_B9 TOP B9 mim_unit
XXP_r58_c06_B11 TOP B11 mim_unit
XXP_r29_c12_B8 TOP B8 mim_unit
XXP_r03_c11_B11 TOP B11 mim_unit
XXP_r06_c42_B11 TOP B11 mim_unit
XXP_r36_c55_B8 TOP B8 mim_unit
XXP_r62_c46_B11 TOP B11 mim_unit
XXP_r31_c25_B7 TOP B7 mim_unit
XXP_r03_c02_B11 TOP B11 mim_unit
XXP_r06_c33_B11 TOP B11 mim_unit
XXP_r62_c37_B11 TOP B11 mim_unit
XXP_r06_c24_B11 TOP B11 mim_unit
XXP_r09_c55_B11 TOP B11 mim_unit
XXP_r40_c50_B9 TOP B9 mim_unit
XXP_r62_c28_B11 TOP B11 mim_unit
XXP_r29_c07_B8 TOP B8 mim_unit
XXP_r06_c15_B11 TOP B11 mim_unit
XXP_r09_c46_B11 TOP B11 mim_unit
XXP_r16_c50_B11 TOP B11 mim_unit
XXP_r62_c19_B11 TOP B11 mim_unit
XXP_r46_c20_B10 TOP B10 mim_unit
XXP_r06_c06_B11 TOP B11 mim_unit
XXP_r09_c37_B11 TOP B11 mim_unit
XXP_r10_c55_B11 TOP B11 mim_unit
XXP_r43_c56_B10 TOP B10 mim_unit
XXP_r25_c22_B9 TOP B9 mim_unit
XXP_r13_c10_B11 TOP B11 mim_unit
XXP_r16_c41_B11 TOP B11 mim_unit
XXP_r46_c11_B10 TOP B10 mim_unit
XXP_r43_c47_B10 TOP B10 mim_unit
XXP_r40_c45_B9 TOP B9 mim_unit
XXP_r09_c28_B11 TOP B11 mim_unit
XXP_r10_c46_B11 TOP B11 mim_unit
XXP_r16_c32_B11 TOP B11 mim_unit
XXP_r46_c02_B10 TOP B10 mim_unit
XXP_r13_c01_B11 TOP B11 mim_unit
XXP_r09_c19_B11 TOP B11 mim_unit
XXP_r10_c37_B11 TOP B11 mim_unit
XXP_r43_c38_B10 TOP B10 mim_unit
XXP_r27_c13_B9 TOP B9 mim_unit
XXP_r16_c23_B11 TOP B11 mim_unit
XXP_r22_c40_B10 TOP B10 mim_unit
XXP_r25_c17_B9 TOP B9 mim_unit
XXP_r18_c58_B10 TOP B10 mim_unit
XXP_r57_c00_EDGE EDGE_BIAS EDGE_BIAS mim_unit
XXP_r54_c60_B11 TOP B11 mim_unit
XXP_r43_c29_B10 TOP B10 mim_unit
XXP_r10_c28_B11 TOP B11 mim_unit
XXP_r13_c59_B11 TOP B11 mim_unit
XXP_r38_c43_B9 TOP B9 mim_unit
XXP_r16_c14_B11 TOP B11 mim_unit
XXP_r22_c31_B10 TOP B10 mim_unit
XXP_r00_c01_EDGE EDGE_BIAS EDGE_BIAS mim_unit
XXP_r10_c19_B11 TOP B11 mim_unit
XXP_r18_c49_B10 TOP B10 mim_unit
XXP_r54_c51_B11 TOP B11 mim_unit
XXP_r51_c20_B11 TOP B11 mim_unit
XXP_r36_c63_B8 TOP B8 mim_unit
XXP_r29_c20_B8 TOP B8 mim_unit
XXP_r16_c05_B11 TOP B11 mim_unit
XXP_r22_c22_B10 TOP B10 mim_unit
XXP_r31_c33_B7 TOP B7 mim_unit
XXP_r27_c08_B9 TOP B9 mim_unit
XXP_r54_c42_B11 TOP B11 mim_unit
XXP_r51_c11_B11 TOP B11 mim_unit
XXP_r00_c24_EDGE EDGE_BIAS EDGE_BIAS mim_unit
XXP_r22_c13_B10 TOP B10 mim_unit
XXP_r35_c04_B8 TOP B8 mim_unit
XXP_r38_c38_B9 TOP B9 mim_unit
XXP_r57_c64_B11 TOP B11 mim_unit
XXP_r56_c01_B10 TOP B10 mim_unit
XXP_r54_c33_B11 TOP B11 mim_unit
XXP_r51_c02_B11 TOP B11 mim_unit
XXP_r22_c04_B10 TOP B10 mim_unit
XXP_r33_c40_B6 TOP B6 mim_unit
XXP_r29_c15_B8 TOP B8 mim_unit
XXP_r57_c55_B11 TOP B11 mim_unit
XXP_r54_c24_B11 TOP B11 mim_unit
XXP_r36_c58_B8 TOP B8 mim_unit
XXP_r00_c47_EDGE EDGE_BIAS EDGE_BIAS mim_unit
XXP_r31_c28_B7 TOP B7 mim_unit
XXP_r02_c60_B11 TOP B11 mim_unit
XXP_r57_c46_B11 TOP B11 mim_unit
XXP_r54_c15_B11 TOP B11 mim_unit
XXP_r25_c30_B9 TOP B9 mim_unit
XXP_r64_c50_B11 TOP B11 mim_unit
XXP_r02_c51_B11 TOP B11 mim_unit
XXP_r57_c37_B11 TOP B11 mim_unit
XXP_r40_c53_B9 TOP B9 mim_unit
XXP_r01_c00_EDGE EDGE_BIAS EDGE_BIAS mim_unit
XXP_r54_c06_B11 TOP B11 mim_unit
XXP_r11_c65_EDGE EDGE_BIAS EDGE_BIAS mim_unit
XXP_r64_c41_B11 TOP B11 mim_unit
XXP_r65_c11_EDGE EDGE_BIAS EDGE_BIAS mim_unit
XXP_r61_c10_B11 TOP B11 mim_unit
XXP_r33_c35_B6 TOP B6 mim_unit
XXP_r02_c42_B11 TOP B11 mim_unit
XXP_r57_c28_B11 TOP B11 mim_unit
XXP_r27_c21_B9 TOP B9 mim_unit
XXP_r64_c32_B11 TOP B11 mim_unit
XXP_r02_c33_B11 TOP B11 mim_unit
XXP_r57_c19_B11 TOP B11 mim_unit
XXP_r25_c25_B9 TOP B9 mim_unit
XXP_r65_c34_EDGE EDGE_BIAS EDGE_BIAS mim_unit
.ends

.subckt cdac_diff_routed P_TOP P_B11 P_B10 P_B9 P_B8 P_B7 P_B6 P_B5 P_B4 P_B3 P_B2
+ P_B1 P_B0 P_DUMMY P_EDGE_BIAS N_TOP N_B11 N_B10 N_B9 N_B8 N_B7 N_B6 N_B5 N_B4 N_B3
+ N_B2 N_B1 N_B0 N_DUMMY N_EDGE_BIAS
XX_CDAC_N N_TOP N_B11 N_B10 N_B9 N_B8 N_B7 N_B6 N_B5 N_B4 N_B3 N_B2 N_B1 N_B0 N_DUMMY
+ N_EDGE_BIAS cdac_side_n_routed
XX_CDAC_P P_TOP P_B11 P_B10 P_B9 P_B8 P_B7 P_B6 P_B5 P_B4 P_B3 P_B2 P_B1 P_B0 P_DUMMY
+ P_EDGE_BIAS cdac_side_p_routed
.ends
