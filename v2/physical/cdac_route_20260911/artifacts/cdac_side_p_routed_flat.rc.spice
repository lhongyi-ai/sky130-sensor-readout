* NGSPICE file created from cdac_side_p_routed_flat.ext - technology: sky130A

.subckt cdac_side_p_routed_flat TOP B11 B10 B9 B8 B7 B6 B5 B4 B3 B2 B1 B0 DUMMY EDGE_BIAS
X0 B11.t1409 TOP.t2300 sky130_fd_pr__cap_mim_m3_1 l=3 w=3
X1 B11.t958 TOP.t3202 sky130_fd_pr__cap_mim_m3_1 l=3 w=3
X2 B11.t1651 TOP.t1816 sky130_fd_pr__cap_mim_m3_1 l=3 w=3
X3 B10.t665 TOP.t5964 sky130_fd_pr__cap_mim_m3_1 l=3 w=3
X4 B10.t907 TOP.t5480 sky130_fd_pr__cap_mim_m3_1 l=3 w=3
X5 B8.t34 TOP.t7738 sky130_fd_pr__cap_mim_m3_1 l=3 w=3
X6 B11.t678 TOP.t3762 sky130_fd_pr__cap_mim_m3_1 l=3 w=3
X7 B6.t55 TOP.t5136 sky130_fd_pr__cap_mim_m3_1 l=3 w=3
X8 B9.t129 TOP.t764 sky130_fd_pr__cap_mim_m3_1 l=3 w=3
X9 B11.t920 TOP.t3278 sky130_fd_pr__cap_mim_m3_1 l=3 w=3
X10 B10.t627 TOP.t6040 sky130_fd_pr__cap_mim_m3_1 l=3 w=3
X11 B11.t1832 TOP.t1454 sky130_fd_pr__cap_mim_m3_1 l=3 w=3
X12 B9.t56 TOP.t910 sky130_fd_pr__cap_mim_m3_1 l=3 w=3
X13 EDGE_BIAS.t114 EDGE_BIAS.t115 sky130_fd_pr__cap_mim_m3_1 l=3 w=3
X14 B6.t16 TOP.t5214 sky130_fd_pr__cap_mim_m3_1 l=3 w=3
X15 B11.t435 TOP.t4248 sky130_fd_pr__cap_mim_m3_1 l=3 w=3
X16 B10.t571 TOP.t6152 sky130_fd_pr__cap_mim_m3_1 l=3 w=3
X17 B8.t206 TOP.t7394 sky130_fd_pr__cap_mim_m3_1 l=3 w=3
X18 EDGE_BIAS.t261 EDGE_BIAS.t262 sky130_fd_pr__cap_mim_m3_1 l=3 w=3
X19 B11.t240 TOP.t4638 sky130_fd_pr__cap_mim_m3_1 l=3 w=3
X20 EDGE_BIAS.t705 EDGE_BIAS.t706 sky130_fd_pr__cap_mim_m3_1 l=3 w=3
X21 B11.t2036 TOP.t1046 sky130_fd_pr__cap_mim_m3_1 l=3 w=3
X22 B11.t219 TOP.t4680 sky130_fd_pr__cap_mim_m3_1 l=3 w=3
X23 B11.t1998 TOP.t1122 sky130_fd_pr__cap_mim_m3_1 l=3 w=3
X24 B11.t1316 TOP.t2486 sky130_fd_pr__cap_mim_m3_1 l=3 w=3
X25 B10.t856 TOP.t5582 sky130_fd_pr__cap_mim_m3_1 l=3 w=3
X26 B8.t168 TOP.t7470 sky130_fd_pr__cap_mim_m3_1 l=3 w=3
X27 B11.t1122 TOP.t2874 sky130_fd_pr__cap_mim_m3_1 l=3 w=3
X28 B8.t130 TOP.t7546 sky130_fd_pr__cap_mim_m3_1 l=3 w=3
X29 B8.t58 TOP.t7690 sky130_fd_pr__cap_mim_m3_1 l=3 w=3
X30 B11.t1558 TOP.t2002 sky130_fd_pr__cap_mim_m3_1 l=3 w=3
X31 B10.t818 TOP.t5658 sky130_fd_pr__cap_mim_m3_1 l=3 w=3
X32 B10.t267 TOP.t6760 sky130_fd_pr__cap_mim_m3_1 l=3 w=3
X33 B11.t1960 TOP.t1198 sky130_fd_pr__cap_mim_m3_1 l=3 w=3
X34 B11.t1278 TOP.t2562 sky130_fd_pr__cap_mim_m3_1 l=3 w=3
X35 EDGE_BIAS.t621 EDGE_BIAS.t622 sky130_fd_pr__cap_mim_m3_1 l=3 w=3
X36 B11.t1856 TOP.t1406 sky130_fd_pr__cap_mim_m3_1 l=3 w=3
X37 B11.t1084 TOP.t2950 sky130_fd_pr__cap_mim_m3_1 l=3 w=3
X38 B7.t91 TOP.t7880 sky130_fd_pr__cap_mim_m3_1 l=3 w=3
X39 EDGE_BIAS.t432 EDGE_BIAS.t433 sky130_fd_pr__cap_mim_m3_1 l=3 w=3
X40 B9.t336 TOP.t350 sky130_fd_pr__cap_mim_m3_1 l=3 w=3
X41 B10.t229 TOP.t6836 sky130_fd_pr__cap_mim_m3_1 l=3 w=3
X42 B11.t1739 TOP.t1640 sky130_fd_pr__cap_mim_m3_1 l=3 w=3
X43 B10.t471 TOP.t6352 sky130_fd_pr__cap_mim_m3_1 l=3 w=3
X44 B11.t1701 TOP.t1716 sky130_fd_pr__cap_mim_m3_1 l=3 w=3
X45 B9.t298 TOP.t426 sky130_fd_pr__cap_mim_m3_1 l=3 w=3
X46 B11.t997 TOP.t3124 sky130_fd_pr__cap_mim_m3_1 l=3 w=3
X47 B11.t1507 TOP.t2104 sky130_fd_pr__cap_mim_m3_1 l=3 w=3
X48 B10.t433 TOP.t6428 sky130_fd_pr__cap_mim_m3_1 l=3 w=3
X49 EDGE_BIAS.t315 EDGE_BIAS.t316 sky130_fd_pr__cap_mim_m3_1 l=3 w=3
X50 B11.t1984 TOP.t1150 sky130_fd_pr__cap_mim_m3_1 l=3 w=3
X51 B11.t1469 TOP.t2180 sky130_fd_pr__cap_mim_m3_1 l=3 w=3
X52 B11.t64 TOP.t4990 sky130_fd_pr__cap_mim_m3_1 l=3 w=3
X53 B11.t454 TOP.t4210 sky130_fd_pr__cap_mim_m3_1 l=3 w=3
X54 B11.t1867 TOP.t1384 sky130_fd_pr__cap_mim_m3_1 l=3 w=3
X55 B11.t1431 TOP.t2256 sky130_fd_pr__cap_mim_m3_1 l=3 w=3
X56 B10.t725 TOP.t5844 sky130_fd_pr__cap_mim_m3_1 l=3 w=3
X57 B9.t106 TOP.t810 sky130_fd_pr__cap_mim_m3_1 l=3 w=3
X58 B10.t967 TOP.t5360 sky130_fd_pr__cap_mim_m3_1 l=3 w=3
X59 B10.t531 TOP.t6232 sky130_fd_pr__cap_mim_m3_1 l=3 w=3
X60 B9.t68 TOP.t886 sky130_fd_pr__cap_mim_m3_1 l=3 w=3
X61 B10.t253 TOP.t6788 sky130_fd_pr__cap_mim_m3_1 l=3 w=3
X62 B11.t1393 TOP.t2332 sky130_fd_pr__cap_mim_m3_1 l=3 w=3
X63 B8.t245 TOP.t7316 sky130_fd_pr__cap_mim_m3_1 l=3 w=3
X64 B10.t687 TOP.t5920 sky130_fd_pr__cap_mim_m3_1 l=3 w=3
X65 B11.t1635 TOP.t1848 sky130_fd_pr__cap_mim_m3_1 l=3 w=3
X66 B10.t929 TOP.t5436 sky130_fd_pr__cap_mim_m3_1 l=3 w=3
X67 B9.t489 TOP.t44 sky130_fd_pr__cap_mim_m3_1 l=3 w=3
X68 B11.t92 TOP.t4934 sky130_fd_pr__cap_mim_m3_1 l=3 w=3
X69 EDGE_BIAS.t486 EDGE_BIAS.t487 sky130_fd_pr__cap_mim_m3_1 l=3 w=3
X70 B8.t18 TOP.t7770 sky130_fd_pr__cap_mim_m3_1 l=3 w=3
X71 B11.t662 TOP.t3794 sky130_fd_pr__cap_mim_m3_1 l=3 w=3
X72 B11.t1172 TOP.t2774 sky130_fd_pr__cap_mim_m3_1 l=3 w=3
X73 B6.t39 TOP.t5168 sky130_fd_pr__cap_mim_m3_1 l=3 w=3
X74 B11.t904 TOP.t3310 sky130_fd_pr__cap_mim_m3_1 l=3 w=3
X75 B11.t1597 TOP.t1924 sky130_fd_pr__cap_mim_m3_1 l=3 w=3
X76 B11.t1816 TOP.t1486 sky130_fd_pr__cap_mim_m3_1 l=3 w=3
X77 B9.t234 TOP.t554 sky130_fd_pr__cap_mim_m3_1 l=3 w=3
X78 B9.t40 TOP.t942 sky130_fd_pr__cap_mim_m3_1 l=3 w=3
X79 B11.t252 TOP.t4614 sky130_fd_pr__cap_mim_m3_1 l=3 w=3
X80 EDGE_BIAS.t162 EDGE_BIAS.t163 sky130_fd_pr__cap_mim_m3_1 l=3 w=3
X81 B0.t0 TOP.t8064 sky130_fd_pr__cap_mim_m3_1 l=3 w=3
X82 B11.t866 TOP.t3386 sky130_fd_pr__cap_mim_m3_1 l=3 w=3
X83 EDGE_BIAS.t369 EDGE_BIAS.t370 sky130_fd_pr__cap_mim_m3_1 l=3 w=3
X84 B11.t1778 TOP.t1562 sky130_fd_pr__cap_mim_m3_1 l=3 w=3
X85 B11.t1417 TOP.t2284 sky130_fd_pr__cap_mim_m3_1 l=3 w=3
X86 B11.t2020 TOP.t1078 sky130_fd_pr__cap_mim_m3_1 l=3 w=3
X87 B10.t878 TOP.t5538 sky130_fd_pr__cap_mim_m3_1 l=3 w=3
X88 B10.t840 TOP.t5614 sky130_fd_pr__cap_mim_m3_1 l=3 w=3
X89 B11.t1300 TOP.t2518 sky130_fd_pr__cap_mim_m3_1 l=3 w=3
X90 B11.t1144 TOP.t2830 sky130_fd_pr__cap_mim_m3_1 l=3 w=3
X91 B8.t152 TOP.t7502 sky130_fd_pr__cap_mim_m3_1 l=3 w=3
X92 B11.t686 TOP.t3746 sky130_fd_pr__cap_mim_m3_1 l=3 w=3
X93 B11.t1106 TOP.t2906 sky130_fd_pr__cap_mim_m3_1 l=3 w=3
X94 B9.t396 TOP.t230 sky130_fd_pr__cap_mim_m3_1 l=3 w=3
X95 EDGE_BIAS.t240 EDGE_BIAS.t241 sky130_fd_pr__cap_mim_m3_1 l=3 w=3
X96 B10.t802 TOP.t5690 sky130_fd_pr__cap_mim_m3_1 l=3 w=3
X97 B11.t61 TOP.t4996 sky130_fd_pr__cap_mim_m3_1 l=3 w=3
X98 B11.t419 TOP.t4280 sky130_fd_pr__cap_mim_m3_1 l=3 w=3
X99 B11.t1262 TOP.t2594 sky130_fd_pr__cap_mim_m3_1 l=3 w=3
X100 B7.t113 TOP.t7836 sky130_fd_pr__cap_mim_m3_1 l=3 w=3
X101 B7.t44 TOP.t7974 sky130_fd_pr__cap_mim_m3_1 l=3 w=3
X102 B11.t1068 TOP.t2982 sky130_fd_pr__cap_mim_m3_1 l=3 w=3
X103 B9.t358 TOP.t306 sky130_fd_pr__cap_mim_m3_1 l=3 w=3
X104 B10.t213 TOP.t6868 sky130_fd_pr__cap_mim_m3_1 l=3 w=3
X105 B10.t1006 TOP.t5282 sky130_fd_pr__cap_mim_m3_1 l=3 w=3
X106 B10.t455 TOP.t6384 sky130_fd_pr__cap_mim_m3_1 l=3 w=3
X107 B10.t175 TOP.t6944 sky130_fd_pr__cap_mim_m3_1 l=3 w=3
X108 B11.t2044 TOP.t1030 sky130_fd_pr__cap_mim_m3_1 l=3 w=3
X109 B11.t1685 TOP.t1748 sky130_fd_pr__cap_mim_m3_1 l=3 w=3
X110 B11.t981 TOP.t3156 sky130_fd_pr__cap_mim_m3_1 l=3 w=3
X111 B11.t1491 TOP.t2136 sky130_fd_pr__cap_mim_m3_1 l=3 w=3
X112 B10.t417 TOP.t6460 sky130_fd_pr__cap_mim_m3_1 l=3 w=3
X113 B11.t1211 TOP.t2696 sky130_fd_pr__cap_mim_m3_1 l=3 w=3
X114 B10.t826 TOP.t5642 sky130_fd_pr__cap_mim_m3_1 l=3 w=3
X115 EDGE_BIAS.t774 EDGE_BIAS.t775 sky130_fd_pr__cap_mim_m3_1 l=3 w=3
X116 B11.t1453 TOP.t2212 sky130_fd_pr__cap_mim_m3_1 l=3 w=3
X117 B11.t1286 TOP.t2546 sky130_fd_pr__cap_mim_m3_1 l=3 w=3
X118 B11.t217 TOP.t4684 sky130_fd_pr__cap_mim_m3_1 l=3 w=3
X119 B10.t709 TOP.t5876 sky130_fd_pr__cap_mim_m3_1 l=3 w=3
X120 B10.t553 TOP.t6188 sky130_fd_pr__cap_mim_m3_1 l=3 w=3
X121 B9.t90 TOP.t842 sky130_fd_pr__cap_mim_m3_1 l=3 w=3
X122 B10.t515 TOP.t6264 sky130_fd_pr__cap_mim_m3_1 l=3 w=3
X123 B8.t78 TOP.t7650 sky130_fd_pr__cap_mim_m3_1 l=3 w=3
X124 B11.t5 TOP.t5108 sky130_fd_pr__cap_mim_m3_1 l=3 w=3
X125 B11.t753 TOP.t3612 sky130_fd_pr__cap_mim_m3_1 l=3 w=3
X126 EDGE_BIAS.t294 EDGE_BIAS.t295 sky130_fd_pr__cap_mim_m3_1 l=3 w=3
X127 B8.t229 TOP.t7348 sky130_fd_pr__cap_mim_m3_1 l=3 w=3
X128 B11.t1657 TOP.t1804 sky130_fd_pr__cap_mim_m3_1 l=3 w=3
X129 B10.t671 TOP.t5952 sky130_fd_pr__cap_mim_m3_1 l=3 w=3
X130 B9.t473 TOP.t76 sky130_fd_pr__cap_mim_m3_1 l=3 w=3
X131 B11.t1619 TOP.t1880 sky130_fd_pr__cap_mim_m3_1 l=3 w=3
X132 B10.t913 TOP.t5468 sky130_fd_pr__cap_mim_m3_1 l=3 w=3
X133 B8.t40 TOP.t7726 sky130_fd_pr__cap_mim_m3_1 l=3 w=3
X134 B11.t646 TOP.t3826 sky130_fd_pr__cap_mim_m3_1 l=3 w=3
X135 B11.t1581 TOP.t1956 sky130_fd_pr__cap_mim_m3_1 l=3 w=3
X136 B9.t435 TOP.t152 sky130_fd_pr__cap_mim_m3_1 l=3 w=3
X137 B11.t888 TOP.t3342 sky130_fd_pr__cap_mim_m3_1 l=3 w=3
X138 B11.t608 TOP.t3902 sky130_fd_pr__cap_mim_m3_1 l=3 w=3
X139 B11.t1800 TOP.t1518 sky130_fd_pr__cap_mim_m3_1 l=3 w=3
X140 B11.t1477 TOP.t2164 sky130_fd_pr__cap_mim_m3_1 l=3 w=3
X141 B11.t850 TOP.t3418 sky130_fd_pr__cap_mim_m3_1 l=3 w=3
X142 B11.t1762 TOP.t1594 sky130_fd_pr__cap_mim_m3_1 l=3 w=3
X143 B10.t695 TOP.t5904 sky130_fd_pr__cap_mim_m3_1 l=3 w=3
X144 B8.t253 TOP.t7300 sky130_fd_pr__cap_mim_m3_1 l=3 w=3
X145 B11.t133 TOP.t4852 sky130_fd_pr__cap_mim_m3_1 l=3 w=3
X146 B11.t2004 TOP.t1110 sky130_fd_pr__cap_mim_m3_1 l=3 w=3
X147 B10.t862 TOP.t5570 sky130_fd_pr__cap_mim_m3_1 l=3 w=3
X148 B11.t452 TOP.t4214 sky130_fd_pr__cap_mim_m3_1 l=3 w=3
X149 B11.t1724 TOP.t1670 sky130_fd_pr__cap_mim_m3_1 l=3 w=3
X150 B11.t1128 TOP.t2862 sky130_fd_pr__cap_mim_m3_1 l=3 w=3
X151 B8.t136 TOP.t7534 sky130_fd_pr__cap_mim_m3_1 l=3 w=3
X152 B10.t273 TOP.t6748 sky130_fd_pr__cap_mim_m3_1 l=3 w=3
X153 B11.t1966 TOP.t1186 sky130_fd_pr__cap_mim_m3_1 l=3 w=3
X154 EDGE_BIAS.t348 EDGE_BIAS.t349 sky130_fd_pr__cap_mim_m3_1 l=3 w=3
X155 B11.t1246 TOP.t2626 sky130_fd_pr__cap_mim_m3_1 l=3 w=3
X156 B11.t1090 TOP.t2938 sky130_fd_pr__cap_mim_m3_1 l=3 w=3
X157 B11.t1052 TOP.t3014 sky130_fd_pr__cap_mim_m3_1 l=3 w=3
X158 B7.t97 TOP.t7868 sky130_fd_pr__cap_mim_m3_1 l=3 w=3
X159 B7.t28 TOP.t8006 sky130_fd_pr__cap_mim_m3_1 l=3 w=3
X160 B11.t161 TOP.t4796 sky130_fd_pr__cap_mim_m3_1 l=3 w=3
X161 EDGE_BIAS.t24 EDGE_BIAS.t25 sky130_fd_pr__cap_mim_m3_1 l=3 w=3
X162 B9.t342 TOP.t338 sky130_fd_pr__cap_mim_m3_1 l=3 w=3
X163 B10.t235 TOP.t6824 sky130_fd_pr__cap_mim_m3_1 l=3 w=3
X164 B10.t990 TOP.t5314 sky130_fd_pr__cap_mim_m3_1 l=3 w=3
X165 B8.t117 TOP.t7572 sky130_fd_pr__cap_mim_m3_1 l=3 w=3
X166 B11.t342 TOP.t4434 sky130_fd_pr__cap_mim_m3_1 l=3 w=3
X167 B11.t713 TOP.t3692 sky130_fd_pr__cap_mim_m3_1 l=3 w=3
X168 B10.t886 TOP.t5522 sky130_fd_pr__cap_mim_m3_1 l=3 w=3
X169 B9.t304 TOP.t414 sky130_fd_pr__cap_mim_m3_1 l=3 w=3
X170 EDGE_BIAS.t231 EDGE_BIAS.t232 sky130_fd_pr__cap_mim_m3_1 l=3 w=3
X171 B11.t1195 TOP.t2728 sky130_fd_pr__cap_mim_m3_1 l=3 w=3
X172 B7.t121 TOP.t7820 sky130_fd_pr__cap_mim_m3_1 l=3 w=3
X173 B11.t1873 TOP.t1372 sky130_fd_pr__cap_mim_m3_1 l=3 w=3
X174 B11.t1437 TOP.t2244 sky130_fd_pr__cap_mim_m3_1 l=3 w=3
X175 B10.t537 TOP.t6220 sky130_fd_pr__cap_mim_m3_1 l=3 w=3
X176 B9.t74 TOP.t874 sky130_fd_pr__cap_mim_m3_1 l=3 w=3
X177 B11.t1399 TOP.t2320 sky130_fd_pr__cap_mim_m3_1 l=3 w=3
X178 B11.t77 TOP.t4964 sky130_fd_pr__cap_mim_m3_1 l=3 w=3
X179 B11.t488 TOP.t4142 sky130_fd_pr__cap_mim_m3_1 l=3 w=3
X180 EDGE_BIAS.t402 EDGE_BIAS.t403 sky130_fd_pr__cap_mim_m3_1 l=3 w=3
X181 B11.t1641 TOP.t1836 sky130_fd_pr__cap_mim_m3_1 l=3 w=3
X182 B10.t655 TOP.t5984 sky130_fd_pr__cap_mim_m3_1 l=3 w=3
X183 B9.t495 TOP.t32 sky130_fd_pr__cap_mim_m3_1 l=3 w=3
X184 B9.t457 TOP.t108 sky130_fd_pr__cap_mim_m3_1 l=3 w=3
X185 B11.t396 TOP.t4326 sky130_fd_pr__cap_mim_m3_1 l=3 w=3
X186 B11.t1537 TOP.t2044 sky130_fd_pr__cap_mim_m3_1 l=3 w=3
X187 B10.t897 TOP.t5500 sky130_fd_pr__cap_mim_m3_1 l=3 w=3
X188 B8.t24 TOP.t7758 sky130_fd_pr__cap_mim_m3_1 l=3 w=3
X189 B11.t668 TOP.t3782 sky130_fd_pr__cap_mim_m3_1 l=3 w=3
X190 B10.t617 TOP.t6060 sky130_fd_pr__cap_mim_m3_1 l=3 w=3
X191 B11.t258 TOP.t4602 sky130_fd_pr__cap_mim_m3_1 l=3 w=3
X192 B9.t419 TOP.t184 sky130_fd_pr__cap_mim_m3_1 l=3 w=3
X193 B10.t312 TOP.t6670 sky130_fd_pr__cap_mim_m3_1 l=3 w=3
X194 B11.t1822 TOP.t1474 sky130_fd_pr__cap_mim_m3_1 l=3 w=3
X195 B9.t240 TOP.t542 sky130_fd_pr__cap_mim_m3_1 l=3 w=3
X196 B9.t46 TOP.t930 sky130_fd_pr__cap_mim_m3_1 l=3 w=3
X197 B11.t183 TOP.t4752 sky130_fd_pr__cap_mim_m3_1 l=3 w=3
X198 EDGE_BIAS.t144 EDGE_BIAS.t145 sky130_fd_pr__cap_mim_m3_1 l=3 w=3
X199 B11.t502 TOP.t4114 sky130_fd_pr__cap_mim_m3_1 l=3 w=3
X200 B11.t1784 TOP.t1550 sky130_fd_pr__cap_mim_m3_1 l=3 w=3
X201 B11.t1746 TOP.t1626 sky130_fd_pr__cap_mim_m3_1 l=3 w=3
X202 B11.t286 TOP.t4546 sky130_fd_pr__cap_mim_m3_1 l=3 w=3
X203 B11.t2026 TOP.t1066 sky130_fd_pr__cap_mim_m3_1 l=3 w=3
X204 B11.t1665 TOP.t1788 sky130_fd_pr__cap_mim_m3_1 l=3 w=3
X205 B10.t846 TOP.t5602 sky130_fd_pr__cap_mim_m3_1 l=3 w=3
X206 B11.t1988 TOP.t1142 sky130_fd_pr__cap_mim_m3_1 l=3 w=3
X207 B11.t1306 TOP.t2506 sky130_fd_pr__cap_mim_m3_1 l=3 w=3
X208 B11.t1708 TOP.t1702 sky130_fd_pr__cap_mim_m3_1 l=3 w=3
X209 B11.t1112 TOP.t2894 sky130_fd_pr__cap_mim_m3_1 l=3 w=3
X210 B11.t1950 TOP.t1218 sky130_fd_pr__cap_mim_m3_1 l=3 w=3
X211 B10.t808 TOP.t5678 sky130_fd_pr__cap_mim_m3_1 l=3 w=3
X212 B11.t17 TOP.t5084 sky130_fd_pr__cap_mim_m3_1 l=3 w=3
X213 B11.t1268 TOP.t2582 sky130_fd_pr__cap_mim_m3_1 l=3 w=3
X214 B7.t81 TOP.t7900 sky130_fd_pr__cap_mim_m3_1 l=3 w=3
X215 B7.t50 TOP.t7962 sky130_fd_pr__cap_mim_m3_1 l=3 w=3
X216 EDGE_BIAS.t456 EDGE_BIAS.t457 sky130_fd_pr__cap_mim_m3_1 l=3 w=3
X217 B11.t1074 TOP.t2970 sky130_fd_pr__cap_mim_m3_1 l=3 w=3
X218 B7.t12 TOP.t8038 sky130_fd_pr__cap_mim_m3_1 l=3 w=3
X219 B11.t1912 TOP.t1294 sky130_fd_pr__cap_mim_m3_1 l=3 w=3
X220 B9.t326 TOP.t370 sky130_fd_pr__cap_mim_m3_1 l=3 w=3
X221 B10.t219 TOP.t6856 sky130_fd_pr__cap_mim_m3_1 l=3 w=3
X222 B11.t697 TOP.t3724 sky130_fd_pr__cap_mim_m3_1 l=3 w=3
X223 B8.t101 TOP.t7604 sky130_fd_pr__cap_mim_m3_1 l=3 w=3
X224 B10.t181 TOP.t6932 sky130_fd_pr__cap_mim_m3_1 l=3 w=3
X225 B9.t288 TOP.t446 sky130_fd_pr__cap_mim_m3_1 l=3 w=3
X226 B11.t987 TOP.t3144 sky130_fd_pr__cap_mim_m3_1 l=3 w=3
X227 B11.t1497 TOP.t2124 sky130_fd_pr__cap_mim_m3_1 l=3 w=3
X228 B11.t1732 TOP.t1654 sky130_fd_pr__cap_mim_m3_1 l=3 w=3
X229 B11.t1217 TOP.t2684 sky130_fd_pr__cap_mim_m3_1 l=3 w=3
X230 B11.t202 TOP.t4714 sky130_fd_pr__cap_mim_m3_1 l=3 w=3
X231 B11.t1179 TOP.t2760 sky130_fd_pr__cap_mim_m3_1 l=3 w=3
X232 B4.t12 TOP.t8158 sky130_fd_pr__cap_mim_m3_1 l=3 w=3
X233 B11.t1459 TOP.t2200 sky130_fd_pr__cap_mim_m3_1 l=3 w=3
X234 B11.t1421 TOP.t2276 sky130_fd_pr__cap_mim_m3_1 l=3 w=3
X235 B11.t1098 TOP.t2922 sky130_fd_pr__cap_mim_m3_1 l=3 w=3
X236 B10.t715 TOP.t5864 sky130_fd_pr__cap_mim_m3_1 l=3 w=3
X237 EDGE_BIAS.t27 EDGE_BIAS.t28 sky130_fd_pr__cap_mim_m3_1 l=3 w=3
X238 EDGE_BIAS.t210 EDGE_BIAS.t211 sky130_fd_pr__cap_mim_m3_1 l=3 w=3
X239 B10.t521 TOP.t6252 sky130_fd_pr__cap_mim_m3_1 l=3 w=3
X240 EDGE_BIAS.t672 EDGE_BIAS.t673 sky130_fd_pr__cap_mim_m3_1 l=3 w=3
X241 B11.t1383 TOP.t2352 sky130_fd_pr__cap_mim_m3_1 l=3 w=3
X242 B8.t235 TOP.t7336 sky130_fd_pr__cap_mim_m3_1 l=3 w=3
X243 B11.t57 TOP.t5004 sky130_fd_pr__cap_mim_m3_1 l=3 w=3
X244 B11.t308 TOP.t4502 sky130_fd_pr__cap_mim_m3_1 l=3 w=3
X245 B10.t677 TOP.t5940 sky130_fd_pr__cap_mim_m3_1 l=3 w=3
X246 B9.t479 TOP.t64 sky130_fd_pr__cap_mim_m3_1 l=3 w=3
X247 B11.t1625 TOP.t1868 sky130_fd_pr__cap_mim_m3_1 l=3 w=3
X248 B11.t652 TOP.t3814 sky130_fd_pr__cap_mim_m3_1 l=3 w=3
X249 B11.t1345 TOP.t2428 sky130_fd_pr__cap_mim_m3_1 l=3 w=3
X250 B8.t8 TOP.t7790 sky130_fd_pr__cap_mim_m3_1 l=3 w=3
X251 B11.t1587 TOP.t1944 sky130_fd_pr__cap_mim_m3_1 l=3 w=3
X252 B9.t224 TOP.t574 sky130_fd_pr__cap_mim_m3_1 l=3 w=3
X253 B11.t614 TOP.t3890 sky130_fd_pr__cap_mim_m3_1 l=3 w=3
X254 B10.t296 TOP.t6702 sky130_fd_pr__cap_mim_m3_1 l=3 w=3
X255 B11.t1806 TOP.t1506 sky130_fd_pr__cap_mim_m3_1 l=3 w=3
X256 B9.t30 TOP.t962 sky130_fd_pr__cap_mim_m3_1 l=3 w=3
X257 B11.t319 TOP.t4480 sky130_fd_pr__cap_mim_m3_1 l=3 w=3
X258 EDGE_BIAS.t192 EDGE_BIAS.t193 sky130_fd_pr__cap_mim_m3_1 l=3 w=3
X259 B9.t509 TOP.t4 sky130_fd_pr__cap_mim_m3_1 l=3 w=3
X260 B5.t6 TOP.t8116 sky130_fd_pr__cap_mim_m3_1 l=3 w=3
X261 B11.t1768 TOP.t1582 sky130_fd_pr__cap_mim_m3_1 l=3 w=3
X262 B10.t500 TOP.t6294 sky130_fd_pr__cap_mim_m3_1 l=3 w=3
X263 B11.t2010 TOP.t1098 sky130_fd_pr__cap_mim_m3_1 l=3 w=3
X264 B10.t868 TOP.t5558 sky130_fd_pr__cap_mim_m3_1 l=3 w=3
X265 B10.t830 TOP.t5634 sky130_fd_pr__cap_mim_m3_1 l=3 w=3
X266 B9.t503 TOP.t16 sky130_fd_pr__cap_mim_m3_1 l=3 w=3
X267 B11.t1134 TOP.t2850 sky130_fd_pr__cap_mim_m3_1 l=3 w=3
X268 B8.t142 TOP.t7522 sky130_fd_pr__cap_mim_m3_1 l=3 w=3
X269 B10.t68 TOP.t7158 sky130_fd_pr__cap_mim_m3_1 l=3 w=3
X270 B11.t1972 TOP.t1174 sky130_fd_pr__cap_mim_m3_1 l=3 w=3
X271 B11.t1536 TOP.t2046 sky130_fd_pr__cap_mim_m3_1 l=3 w=3
X272 EDGE_BIAS.t264 EDGE_BIAS.t265 sky130_fd_pr__cap_mim_m3_1 l=3 w=3
X273 B11.t167 TOP.t4784 sky130_fd_pr__cap_mim_m3_1 l=3 w=3
X274 B11.t1934 TOP.t1250 sky130_fd_pr__cap_mim_m3_1 l=3 w=3
X275 B10.t792 TOP.t5710 sky130_fd_pr__cap_mim_m3_1 l=3 w=3
X276 B11.t75 TOP.t4968 sky130_fd_pr__cap_mim_m3_1 l=3 w=3
X277 B11.t465 TOP.t4188 sky130_fd_pr__cap_mim_m3_1 l=3 w=3
X278 B11.t1252 TOP.t2614 sky130_fd_pr__cap_mim_m3_1 l=3 w=3
X279 B11.t1058 TOP.t3002 sky130_fd_pr__cap_mim_m3_1 l=3 w=3
X280 B7.t103 TOP.t7856 sky130_fd_pr__cap_mim_m3_1 l=3 w=3
X281 B7.t34 TOP.t7994 sky130_fd_pr__cap_mim_m3_1 l=3 w=3
X282 B10.t203 TOP.t6888 sky130_fd_pr__cap_mim_m3_1 l=3 w=3
X283 B11.t1896 TOP.t1326 sky130_fd_pr__cap_mim_m3_1 l=3 w=3
X284 B10.t754 TOP.t5786 sky130_fd_pr__cap_mim_m3_1 l=3 w=3
X285 B11.t1792 TOP.t1534 sky130_fd_pr__cap_mim_m3_1 l=3 w=3
X286 B10.t996 TOP.t5302 sky130_fd_pr__cap_mim_m3_1 l=3 w=3
X287 B10.t165 TOP.t6964 sky130_fd_pr__cap_mim_m3_1 l=3 w=3
X288 B10.t1016 TOP.t5262 sky130_fd_pr__cap_mim_m3_1 l=3 w=3
X289 B11.t971 TOP.t3176 sky130_fd_pr__cap_mim_m3_1 l=3 w=3
X290 B11.t1481 TOP.t2156 sky130_fd_pr__cap_mim_m3_1 l=3 w=3
X291 B10.t407 TOP.t6480 sky130_fd_pr__cap_mim_m3_1 l=3 w=3
X292 B11.t1201 TOP.t2716 sky130_fd_pr__cap_mim_m3_1 l=3 w=3
X293 B11.t355 TOP.t4408 sky130_fd_pr__cap_mim_m3_1 l=3 w=3
X294 B11.t34 TOP.t5050 sky130_fd_pr__cap_mim_m3_1 l=3 w=3
X295 B11.t933 TOP.t3252 sky130_fd_pr__cap_mim_m3_1 l=3 w=3
X296 B10.t369 TOP.t6556 sky130_fd_pr__cap_mim_m3_1 l=3 w=3
X297 B11.t1443 TOP.t2232 sky130_fd_pr__cap_mim_m3_1 l=3 w=3
X298 B7.t58 TOP.t7946 sky130_fd_pr__cap_mim_m3_1 l=3 w=3
X299 B10.t543 TOP.t6208 sky130_fd_pr__cap_mim_m3_1 l=3 w=3
X300 B9.t80 TOP.t862 sky130_fd_pr__cap_mim_m3_1 l=3 w=3
X301 B11.t1405 TOP.t2308 sky130_fd_pr__cap_mim_m3_1 l=3 w=3
X302 EDGE_BIAS.t318 EDGE_BIAS.t319 sky130_fd_pr__cap_mim_m3_1 l=3 w=3
X303 B11.t1367 TOP.t2384 sky130_fd_pr__cap_mim_m3_1 l=3 w=3
X304 B8.t219 TOP.t7368 sky130_fd_pr__cap_mim_m3_1 l=3 w=3
X305 B11.t1647 TOP.t1824 sky130_fd_pr__cap_mim_m3_1 l=3 w=3
X306 B11.t1609 TOP.t1900 sky130_fd_pr__cap_mim_m3_1 l=3 w=3
X307 B10.t661 TOP.t5972 sky130_fd_pr__cap_mim_m3_1 l=3 w=3
X308 B9.t463 TOP.t96 sky130_fd_pr__cap_mim_m3_1 l=3 w=3
X309 B11.t636 TOP.t3846 sky130_fd_pr__cap_mim_m3_1 l=3 w=3
X310 B10.t28 TOP.t7238 sky130_fd_pr__cap_mim_m3_1 l=3 w=3
X311 B11.t1329 TOP.t2460 sky130_fd_pr__cap_mim_m3_1 l=3 w=3
X312 B10.t623 TOP.t6048 sky130_fd_pr__cap_mim_m3_1 l=3 w=3
X313 B8.t181 TOP.t7444 sky130_fd_pr__cap_mim_m3_1 l=3 w=3
X314 B11.t111 TOP.t4896 sky130_fd_pr__cap_mim_m3_1 l=3 w=3
X315 B11.t1571 TOP.t1976 sky130_fd_pr__cap_mim_m3_1 l=3 w=3
X316 B11.t1225 TOP.t2668 sky130_fd_pr__cap_mim_m3_1 l=3 w=3
X317 B9.t425 TOP.t172 sky130_fd_pr__cap_mim_m3_1 l=3 w=3
X318 B11.t430 TOP.t4258 sky130_fd_pr__cap_mim_m3_1 l=3 w=3
X319 B9.t52 TOP.t918 sky130_fd_pr__cap_mim_m3_1 l=3 w=3
X320 B11.t598 TOP.t3922 sky130_fd_pr__cap_mim_m3_1 l=3 w=3
X321 B11.t1031 TOP.t3056 sky130_fd_pr__cap_mim_m3_1 l=3 w=3
X322 B11.t840 TOP.t3438 sky130_fd_pr__cap_mim_m3_1 l=3 w=3
X323 B11.t1752 TOP.t1614 sky130_fd_pr__cap_mim_m3_1 l=3 w=3
X324 B11.t200 TOP.t4718 sky130_fd_pr__cap_mim_m3_1 l=3 w=3
X325 B10.t852 TOP.t5590 sky130_fd_pr__cap_mim_m3_1 l=3 w=3
X326 B11.t802 TOP.t3514 sky130_fd_pr__cap_mim_m3_1 l=3 w=3
X327 B11.t1994 TOP.t1130 sky130_fd_pr__cap_mim_m3_1 l=3 w=3
X328 B11.t1714 TOP.t1690 sky130_fd_pr__cap_mim_m3_1 l=3 w=3
X329 B11.t1118 TOP.t2882 sky130_fd_pr__cap_mim_m3_1 l=3 w=3
X330 EDGE_BIAS.t372 EDGE_BIAS.t373 sky130_fd_pr__cap_mim_m3_1 l=3 w=3
X331 B11.t1956 TOP.t1206 sky130_fd_pr__cap_mim_m3_1 l=3 w=3
X332 B10.t814 TOP.t5666 sky130_fd_pr__cap_mim_m3_1 l=3 w=3
X333 B11.t1852 TOP.t1414 sky130_fd_pr__cap_mim_m3_1 l=3 w=3
X334 B11.t1236 TOP.t2646 sky130_fd_pr__cap_mim_m3_1 l=3 w=3
X335 B11.t1080 TOP.t2958 sky130_fd_pr__cap_mim_m3_1 l=3 w=3
X336 B10.t776 TOP.t5742 sky130_fd_pr__cap_mim_m3_1 l=3 w=3
X337 B7.t87 TOP.t7888 sky130_fd_pr__cap_mim_m3_1 l=3 w=3
X338 EDGE_BIAS.t741 EDGE_BIAS.t742 sky130_fd_pr__cap_mim_m3_1 l=3 w=3
X339 B11.t1042 TOP.t3034 sky130_fd_pr__cap_mim_m3_1 l=3 w=3
X340 B7.t18 TOP.t8026 sky130_fd_pr__cap_mim_m3_1 l=3 w=3
X341 B9.t119 TOP.t784 sky130_fd_pr__cap_mim_m3_1 l=3 w=3
X342 B10.t738 TOP.t5818 sky130_fd_pr__cap_mim_m3_1 l=3 w=3
X343 B11.t703 TOP.t3712 sky130_fd_pr__cap_mim_m3_1 l=3 w=3
X344 B10.t980 TOP.t5334 sky130_fd_pr__cap_mim_m3_1 l=3 w=3
X345 B8.t107 TOP.t7592 sky130_fd_pr__cap_mim_m3_1 l=3 w=3
X346 B11.t993 TOP.t3132 sky130_fd_pr__cap_mim_m3_1 l=3 w=3
X347 B7.t63 TOP.t7936 sky130_fd_pr__cap_mim_m3_1 l=3 w=3
X348 B10.t942 TOP.t5410 sky130_fd_pr__cap_mim_m3_1 l=3 w=3
X349 B11.t1980 TOP.t1158 sky130_fd_pr__cap_mim_m3_1 l=3 w=3
X350 B11.t1185 TOP.t2748 sky130_fd_pr__cap_mim_m3_1 l=3 w=3
X351 B11.t1427 TOP.t2264 sky130_fd_pr__cap_mim_m3_1 l=3 w=3
X352 B11.t236 TOP.t4646 sky130_fd_pr__cap_mim_m3_1 l=3 w=3
X353 B10.t527 TOP.t6240 sky130_fd_pr__cap_mim_m3_1 l=3 w=3
X354 EDGE_BIAS.t426 EDGE_BIAS.t427 sky130_fd_pr__cap_mim_m3_1 l=3 w=3
X355 B11.t1389 TOP.t2340 sky130_fd_pr__cap_mim_m3_1 l=3 w=3
X356 B8.t241 TOP.t7324 sky130_fd_pr__cap_mim_m3_1 l=3 w=3
X357 B11.t144 TOP.t4830 sky130_fd_pr__cap_mim_m3_1 l=3 w=3
X358 B11.t13 TOP.t5092 sky130_fd_pr__cap_mim_m3_1 l=3 w=3
X359 B11.t1631 TOP.t1856 sky130_fd_pr__cap_mim_m3_1 l=3 w=3
X360 B10.t645 TOP.t6004 sky130_fd_pr__cap_mim_m3_1 l=3 w=3
X361 B9.t485 TOP.t52 sky130_fd_pr__cap_mim_m3_1 l=3 w=3
X362 B8.t203 TOP.t7400 sky130_fd_pr__cap_mim_m3_1 l=3 w=3
X363 B9.t447 TOP.t128 sky130_fd_pr__cap_mim_m3_1 l=3 w=3
X364 B8.t165 TOP.t7476 sky130_fd_pr__cap_mim_m3_1 l=3 w=3
X365 B10.t12 TOP.t7270 sky130_fd_pr__cap_mim_m3_1 l=3 w=3
X366 B11.t1593 TOP.t1932 sky130_fd_pr__cap_mim_m3_1 l=3 w=3
X367 B11.t1157 TOP.t2804 sky130_fd_pr__cap_mim_m3_1 l=3 w=3
X368 B10.t607 TOP.t6080 sky130_fd_pr__cap_mim_m3_1 l=3 w=3
X369 B9.t409 TOP.t204 sky130_fd_pr__cap_mim_m3_1 l=3 w=3
X370 B11.t250 TOP.t4618 sky130_fd_pr__cap_mim_m3_1 l=3 w=3
X371 B10.t302 TOP.t6690 sky130_fd_pr__cap_mim_m3_1 l=3 w=3
X372 B11.t1812 TOP.t1494 sky130_fd_pr__cap_mim_m3_1 l=3 w=3
X373 B9.t36 TOP.t950 sky130_fd_pr__cap_mim_m3_1 l=3 w=3
X374 EDGE_BIAS.t174 EDGE_BIAS.t175 sky130_fd_pr__cap_mim_m3_1 l=3 w=3
X375 B11.t1774 TOP.t1570 sky130_fd_pr__cap_mim_m3_1 l=3 w=3
X376 B9.t371 TOP.t280 sky130_fd_pr__cap_mim_m3_1 l=3 w=3
X377 B11.t1736 TOP.t1646 sky130_fd_pr__cap_mim_m3_1 l=3 w=3
X378 B11.t1413 TOP.t2292 sky130_fd_pr__cap_mim_m3_1 l=3 w=3
X379 B11.t2016 TOP.t1086 sky130_fd_pr__cap_mim_m3_1 l=3 w=3
X380 B10.t836 TOP.t5622 sky130_fd_pr__cap_mim_m3_1 l=3 w=3
X381 EDGE_BIAS.t591 EDGE_BIAS.t592 sky130_fd_pr__cap_mim_m3_1 l=3 w=3
X382 B11.t1698 TOP.t1722 sky130_fd_pr__cap_mim_m3_1 l=3 w=3
X383 EDGE_BIAS.t285 EDGE_BIAS.t286 sky130_fd_pr__cap_mim_m3_1 l=3 w=3
X384 B11.t1940 TOP.t1238 sky130_fd_pr__cap_mim_m3_1 l=3 w=3
X385 B10.t798 TOP.t5698 sky130_fd_pr__cap_mim_m3_1 l=3 w=3
X386 B11.t379 TOP.t4360 sky130_fd_pr__cap_mim_m3_1 l=3 w=3
X387 B11.t1064 TOP.t2990 sky130_fd_pr__cap_mim_m3_1 l=3 w=3
X388 B7.t71 TOP.t7920 sky130_fd_pr__cap_mim_m3_1 l=3 w=3
X389 B7.t40 TOP.t7982 sky130_fd_pr__cap_mim_m3_1 l=3 w=3
X390 B7.t2 TOP.t8058 sky130_fd_pr__cap_mim_m3_1 l=3 w=3
X391 B9.t60 TOP.t902 sky130_fd_pr__cap_mim_m3_1 l=3 w=3
X392 B11.t1902 TOP.t1314 sky130_fd_pr__cap_mim_m3_1 l=3 w=3
X393 B10.t566 TOP.t6162 sky130_fd_pr__cap_mim_m3_1 l=3 w=3
X394 B9.t103 TOP.t816 sky130_fd_pr__cap_mim_m3_1 l=3 w=3
X395 B10.t1002 TOP.t5290 sky130_fd_pr__cap_mim_m3_1 l=3 w=3
X396 B11.t88 TOP.t4942 sky130_fd_pr__cap_mim_m3_1 l=3 w=3
X397 B7.t127 TOP.t7808 sky130_fd_pr__cap_mim_m3_1 l=3 w=3
X398 B9.t278 TOP.t466 sky130_fd_pr__cap_mim_m3_1 l=3 w=3
X399 B8.t91 TOP.t7624 sky130_fd_pr__cap_mim_m3_1 l=3 w=3
X400 B11.t407 TOP.t4304 sky130_fd_pr__cap_mim_m3_1 l=3 w=3
X401 B11.t361 TOP.t4396 sky130_fd_pr__cap_mim_m3_1 l=3 w=3
X402 B11.t977 TOP.t3164 sky130_fd_pr__cap_mim_m3_1 l=3 w=3
X403 B11.t1487 TOP.t2144 sky130_fd_pr__cap_mim_m3_1 l=3 w=3
X404 B8.t53 TOP.t7700 sky130_fd_pr__cap_mim_m3_1 l=3 w=3
X405 B11.t1207 TOP.t2704 sky130_fd_pr__cap_mim_m3_1 l=3 w=3
X406 B11.t269 TOP.t4580 sky130_fd_pr__cap_mim_m3_1 l=3 w=3
X407 B11.t1449 TOP.t2220 sky130_fd_pr__cap_mim_m3_1 l=3 w=3
X408 B11.t1169 TOP.t2780 sky130_fd_pr__cap_mim_m3_1 l=3 w=3
X409 B10.t822 TOP.t5650 sky130_fd_pr__cap_mim_m3_1 l=3 w=3
X410 B5.t26 TOP.t8076 sky130_fd_pr__cap_mim_m3_1 l=3 w=3
X411 B11.t1851 TOP.t1416 sky130_fd_pr__cap_mim_m3_1 l=3 w=3
X412 EDGE_BIAS.t339 EDGE_BIAS.t340 sky130_fd_pr__cap_mim_m3_1 l=3 w=3
X413 EDGE_BIAS.t57 EDGE_BIAS.t58 sky130_fd_pr__cap_mim_m3_1 l=3 w=3
X414 B11.t1373 TOP.t2372 sky130_fd_pr__cap_mim_m3_1 l=3 w=3
X415 B8.t225 TOP.t7356 sky130_fd_pr__cap_mim_m3_1 l=3 w=3
X416 B11.t297 TOP.t4524 sky130_fd_pr__cap_mim_m3_1 l=3 w=3
X417 B11.t1615 TOP.t1888 sky130_fd_pr__cap_mim_m3_1 l=3 w=3
X418 B9.t469 TOP.t84 sky130_fd_pr__cap_mim_m3_1 l=3 w=3
X419 B11.t1001 TOP.t3116 sky130_fd_pr__cap_mim_m3_1 l=3 w=3
X420 B11.t1335 TOP.t2448 sky130_fd_pr__cap_mim_m3_1 l=3 w=3
X421 B11.t1141 TOP.t2836 sky130_fd_pr__cap_mim_m3_1 l=3 w=3
X422 B11.t1577 TOP.t1964 sky130_fd_pr__cap_mim_m3_1 l=3 w=3
X423 B9.t431 TOP.t160 sky130_fd_pr__cap_mim_m3_1 l=3 w=3
X424 B10.t286 TOP.t6722 sky130_fd_pr__cap_mim_m3_1 l=3 w=3
X425 B11.t1796 TOP.t1526 sky130_fd_pr__cap_mim_m3_1 l=3 w=3
X426 B10.t1021 TOP.t5252 sky130_fd_pr__cap_mim_m3_1 l=3 w=3
X427 B9.t214 TOP.t594 sky130_fd_pr__cap_mim_m3_1 l=3 w=3
X428 B9.t20 TOP.t982 sky130_fd_pr__cap_mim_m3_1 l=3 w=3
X429 B10.t248 TOP.t6798 sky130_fd_pr__cap_mim_m3_1 l=3 w=3
X430 B11.t1758 TOP.t1602 sky130_fd_pr__cap_mim_m3_1 l=3 w=3
X431 B9.t176 TOP.t670 sky130_fd_pr__cap_mim_m3_1 l=3 w=3
X432 B11.t30 TOP.t5058 sky130_fd_pr__cap_mim_m3_1 l=3 w=3
X433 B11.t2000 TOP.t1118 sky130_fd_pr__cap_mim_m3_1 l=3 w=3
X434 B10.t858 TOP.t5578 sky130_fd_pr__cap_mim_m3_1 l=3 w=3
X435 B8.t249 TOP.t7308 sky130_fd_pr__cap_mim_m3_1 l=3 w=3
X436 B10.t490 TOP.t6314 sky130_fd_pr__cap_mim_m3_1 l=3 w=3
X437 B11.t1720 TOP.t1678 sky130_fd_pr__cap_mim_m3_1 l=3 w=3
X438 EDGE_BIAS.t723 EDGE_BIAS.t724 sky130_fd_pr__cap_mim_m3_1 l=3 w=3
X439 B11.t1962 TOP.t1194 sky130_fd_pr__cap_mim_m3_1 l=3 w=3
X440 B11.t1682 TOP.t1754 sky130_fd_pr__cap_mim_m3_1 l=3 w=3
X441 B11.t1526 TOP.t2066 sky130_fd_pr__cap_mim_m3_1 l=3 w=3
X442 B11.t1165 TOP.t2788 sky130_fd_pr__cap_mim_m3_1 l=3 w=3
X443 B11.t213 TOP.t4692 sky130_fd_pr__cap_mim_m3_1 l=3 w=3
X444 B11.t1924 TOP.t1270 sky130_fd_pr__cap_mim_m3_1 l=3 w=3
X445 B11.t1601 TOP.t1916 sky130_fd_pr__cap_mim_m3_1 l=3 w=3
X446 B10.t782 TOP.t5730 sky130_fd_pr__cap_mim_m3_1 l=3 w=3
X447 B11.t1048 TOP.t3022 sky130_fd_pr__cap_mim_m3_1 l=3 w=3
X448 B7.t24 TOP.t8014 sky130_fd_pr__cap_mim_m3_1 l=3 w=3
X449 B11.t1886 TOP.t1346 sky130_fd_pr__cap_mim_m3_1 l=3 w=3
X450 B10.t744 TOP.t5806 sky130_fd_pr__cap_mim_m3_1 l=3 w=3
X451 B10.t550 TOP.t6194 sky130_fd_pr__cap_mim_m3_1 l=3 w=3
X452 EDGE_BIAS.t639 EDGE_BIAS.t640 sky130_fd_pr__cap_mim_m3_1 l=3 w=3
X453 B10.t986 TOP.t5322 sky130_fd_pr__cap_mim_m3_1 l=3 w=3
X454 B8.t113 TOP.t7580 sky130_fd_pr__cap_mim_m3_1 l=3 w=3
X455 B11.t1036 TOP.t3046 sky130_fd_pr__cap_mim_m3_1 l=3 w=3
X456 B10.t155 TOP.t6984 sky130_fd_pr__cap_mim_m3_1 l=3 w=3
X457 B11.t961 TOP.t3196 sky130_fd_pr__cap_mim_m3_1 l=3 w=3
X458 B11.t681 TOP.t3756 sky130_fd_pr__cap_mim_m3_1 l=3 w=3
X459 B11.t1191 TOP.t2736 sky130_fd_pr__cap_mim_m3_1 l=3 w=3
X460 B11.t923 TOP.t3272 sky130_fd_pr__cap_mim_m3_1 l=3 w=3
X461 B10.t117 TOP.t7060 sky130_fd_pr__cap_mim_m3_1 l=3 w=3
X462 B11.t1433 TOP.t2252 sky130_fd_pr__cap_mim_m3_1 l=3 w=3
X463 EDGE_BIAS.t105 EDGE_BIAS.t106 sky130_fd_pr__cap_mim_m3_1 l=3 w=3
X464 B11.t1395 TOP.t2328 sky130_fd_pr__cap_mim_m3_1 l=3 w=3
X465 B10.t574 TOP.t6146 sky130_fd_pr__cap_mim_m3_1 l=3 w=3
X466 B11.t448 TOP.t4222 sky130_fd_pr__cap_mim_m3_1 l=3 w=3
X467 B11.t1357 TOP.t2404 sky130_fd_pr__cap_mim_m3_1 l=3 w=3
X468 B10.t1010 TOP.t5274 sky130_fd_pr__cap_mim_m3_1 l=3 w=3
X469 B8.t209 TOP.t7388 sky130_fd_pr__cap_mim_m3_1 l=3 w=3
X470 B11.t2039 TOP.t1040 sky130_fd_pr__cap_mim_m3_1 l=3 w=3
X471 B9.t453 TOP.t116 sky130_fd_pr__cap_mim_m3_1 l=3 w=3
X472 B8.t171 TOP.t7464 sky130_fd_pr__cap_mim_m3_1 l=3 w=3
X473 B11.t178 TOP.t4762 sky130_fd_pr__cap_mim_m3_1 l=3 w=3
X474 B10.t18 TOP.t7258 sky130_fd_pr__cap_mim_m3_1 l=3 w=3
X475 B11.t1319 TOP.t2480 sky130_fd_pr__cap_mim_m3_1 l=3 w=3
X476 B11.t1561 TOP.t1996 sky130_fd_pr__cap_mim_m3_1 l=3 w=3
X477 B9.t415 TOP.t192 sky130_fd_pr__cap_mim_m3_1 l=3 w=3
X478 B11.t476 TOP.t4166 sky130_fd_pr__cap_mim_m3_1 l=3 w=3
X479 B10.t308 TOP.t6678 sky130_fd_pr__cap_mim_m3_1 l=3 w=3
X480 B11.t1281 TOP.t2556 sky130_fd_pr__cap_mim_m3_1 l=3 w=3
X481 B11.t1027 TOP.t3064 sky130_fd_pr__cap_mim_m3_1 l=3 w=3
X482 B9.t42 TOP.t938 sky130_fd_pr__cap_mim_m3_1 l=3 w=3
X483 B11.t588 TOP.t3942 sky130_fd_pr__cap_mim_m3_1 l=3 w=3
X484 B11.t338 TOP.t4442 sky130_fd_pr__cap_mim_m3_1 l=3 w=3
X485 B11.t1742 TOP.t1634 sky130_fd_pr__cap_mim_m3_1 l=3 w=3
X486 B11.t550 TOP.t4018 sky130_fd_pr__cap_mim_m3_1 l=3 w=3
X487 EDGE_BIAS.t201 EDGE_BIAS.t202 sky130_fd_pr__cap_mim_m3_1 l=3 w=3
X488 B10.t842 TOP.t5610 sky130_fd_pr__cap_mim_m3_1 l=3 w=3
X489 B11.t1704 TOP.t1710 sky130_fd_pr__cap_mim_m3_1 l=3 w=3
X490 B11.t1510 TOP.t2098 sky130_fd_pr__cap_mim_m3_1 l=3 w=3
X491 B11.t1946 TOP.t1226 sky130_fd_pr__cap_mim_m3_1 l=3 w=3
X492 B10.t804 TOP.t5686 sky130_fd_pr__cap_mim_m3_1 l=3 w=3
X493 B9.t439 TOP.t144 sky130_fd_pr__cap_mim_m3_1 l=3 w=3
X494 B10.t766 TOP.t5762 sky130_fd_pr__cap_mim_m3_1 l=3 w=3
X495 B11.t1472 TOP.t2174 sky130_fd_pr__cap_mim_m3_1 l=3 w=3
X496 B7.t8 TOP.t8046 sky130_fd_pr__cap_mim_m3_1 l=3 w=3
X497 B11.t94 TOP.t4930 sky130_fd_pr__cap_mim_m3_1 l=3 w=3
X498 B11.t1908 TOP.t1302 sky130_fd_pr__cap_mim_m3_1 l=3 w=3
X499 B10.t728 TOP.t5838 sky130_fd_pr__cap_mim_m3_1 l=3 w=3
X500 B9.t109 TOP.t804 sky130_fd_pr__cap_mim_m3_1 l=3 w=3
X501 B11.t392 TOP.t4334 sky130_fd_pr__cap_mim_m3_1 l=3 w=3
X502 B11.t693 TOP.t3732 sky130_fd_pr__cap_mim_m3_1 l=3 w=3
X503 B10.t970 TOP.t5354 sky130_fd_pr__cap_mim_m3_1 l=3 w=3
X504 B8.t97 TOP.t7612 sky130_fd_pr__cap_mim_m3_1 l=3 w=3
X505 B10.t690 TOP.t5914 sky130_fd_pr__cap_mim_m3_1 l=3 w=3
X506 B11.t983 TOP.t3152 sky130_fd_pr__cap_mim_m3_1 l=3 w=3
X507 B11.t1728 TOP.t1662 sky130_fd_pr__cap_mim_m3_1 l=3 w=3
X508 B10.t932 TOP.t5430 sky130_fd_pr__cap_mim_m3_1 l=3 w=3
X509 B11.t1175 TOP.t2768 sky130_fd_pr__cap_mim_m3_1 l=3 w=3
X510 B4.t8 TOP.t8166 sky130_fd_pr__cap_mim_m3_1 l=3 w=3
X511 B11.t498 TOP.t4122 sky130_fd_pr__cap_mim_m3_1 l=3 w=3
X512 EDGE_BIAS.t255 EDGE_BIAS.t256 sky130_fd_pr__cap_mim_m3_1 l=3 w=3
X513 B11.t42 TOP.t5034 sky130_fd_pr__cap_mim_m3_1 l=3 w=3
X514 B11.t303 TOP.t4512 sky130_fd_pr__cap_mim_m3_1 l=3 w=3
X515 B11.t282 TOP.t4554 sky130_fd_pr__cap_mim_m3_1 l=3 w=3
X516 EDGE_BIAS.t39 EDGE_BIAS.t40 sky130_fd_pr__cap_mim_m3_1 l=3 w=3
X517 EDGE_BIAS.t153 EDGE_BIAS.t154 sky130_fd_pr__cap_mim_m3_1 l=3 w=3
X518 B11.t1379 TOP.t2360 sky130_fd_pr__cap_mim_m3_1 l=3 w=3
X519 B8.t231 TOP.t7344 sky130_fd_pr__cap_mim_m3_1 l=3 w=3
X520 B8.t193 TOP.t7420 sky130_fd_pr__cap_mim_m3_1 l=3 w=3
X521 B8.t121 TOP.t7564 sky130_fd_pr__cap_mim_m3_1 l=3 w=3
X522 B11.t1621 TOP.t1876 sky130_fd_pr__cap_mim_m3_1 l=3 w=3
X523 B11.t2023 TOP.t1072 sky130_fd_pr__cap_mim_m3_1 l=3 w=3
X524 B10.t881 TOP.t5532 sky130_fd_pr__cap_mim_m3_1 l=3 w=3
X525 B11.t1341 TOP.t2436 sky130_fd_pr__cap_mim_m3_1 l=3 w=3
X526 B11.t1147 TOP.t2824 sky130_fd_pr__cap_mim_m3_1 l=3 w=3
X527 B8.t155 TOP.t7496 sky130_fd_pr__cap_mim_m3_1 l=3 w=3
X528 B11.t1583 TOP.t1952 sky130_fd_pr__cap_mim_m3_1 l=3 w=3
X529 B10.t597 TOP.t6100 sky130_fd_pr__cap_mim_m3_1 l=3 w=3
X530 B10.t292 TOP.t6710 sky130_fd_pr__cap_mim_m3_1 l=3 w=3
X531 B11.t1802 TOP.t1514 sky130_fd_pr__cap_mim_m3_1 l=3 w=3
X532 B9.t399 TOP.t224 sky130_fd_pr__cap_mim_m3_1 l=3 w=3
X533 B7.t116 TOP.t7830 sky130_fd_pr__cap_mim_m3_1 l=3 w=3
X534 B9.t26 TOP.t970 sky130_fd_pr__cap_mim_m3_1 l=3 w=3
X535 B9.t361 TOP.t300 sky130_fd_pr__cap_mim_m3_1 l=3 w=3
X536 B11.t1764 TOP.t1590 sky130_fd_pr__cap_mim_m3_1 l=3 w=3
X537 B10.t496 TOP.t6302 sky130_fd_pr__cap_mim_m3_1 l=3 w=3
X538 EDGE_BIAS.t309 EDGE_BIAS.t310 sky130_fd_pr__cap_mim_m3_1 l=3 w=3
X539 B11.t2047 TOP.t1024 sky130_fd_pr__cap_mim_m3_1 l=3 w=3
X540 B11.t1532 TOP.t2054 sky130_fd_pr__cap_mim_m3_1 l=3 w=3
X541 B11.t127 TOP.t4864 sky130_fd_pr__cap_mim_m3_1 l=3 w=3
X542 B11.t1688 TOP.t1742 sky130_fd_pr__cap_mim_m3_1 l=3 w=3
X543 B11.t1494 TOP.t2130 sky130_fd_pr__cap_mim_m3_1 l=3 w=3
X544 B11.t1930 TOP.t1258 sky130_fd_pr__cap_mim_m3_1 l=3 w=3
X545 B10.t788 TOP.t5718 sky130_fd_pr__cap_mim_m3_1 l=3 w=3
X546 B10.t316 TOP.t6662 sky130_fd_pr__cap_mim_m3_1 l=3 w=3
X547 B11.t1054 TOP.t3010 sky130_fd_pr__cap_mim_m3_1 l=3 w=3
X548 B11.t1456 TOP.t2206 sky130_fd_pr__cap_mim_m3_1 l=3 w=3
X549 B10.t750 TOP.t5794 sky130_fd_pr__cap_mim_m3_1 l=3 w=3
X550 B11.t1892 TOP.t1334 sky130_fd_pr__cap_mim_m3_1 l=3 w=3
X551 B10.t556 TOP.t6182 sky130_fd_pr__cap_mim_m3_1 l=3 w=3
X552 B9.t93 TOP.t836 sky130_fd_pr__cap_mim_m3_1 l=3 w=3
X553 B9.t510 TOP.t2 sky130_fd_pr__cap_mim_m3_1 l=3 w=3
X554 B10.t992 TOP.t5310 sky130_fd_pr__cap_mim_m3_1 l=3 w=3
X555 B8.t81 TOP.t7644 sky130_fd_pr__cap_mim_m3_1 l=3 w=3
X556 B11.t155 TOP.t4808 sky130_fd_pr__cap_mim_m3_1 l=3 w=3
X557 B11.t1660 TOP.t1798 sky130_fd_pr__cap_mim_m3_1 l=3 w=3
X558 B11.t967 TOP.t3184 sky130_fd_pr__cap_mim_m3_1 l=3 w=3
X559 B8.t43 TOP.t7720 sky130_fd_pr__cap_mim_m3_1 l=3 w=3
X560 B11.t1197 TOP.t2724 sky130_fd_pr__cap_mim_m3_1 l=3 w=3
X561 B5.t16 TOP.t8096 sky130_fd_pr__cap_mim_m3_1 l=3 w=3
X562 B11.t315 TOP.t4488 sky130_fd_pr__cap_mim_m3_1 l=3 w=3
X563 B11.t929 TOP.t3260 sky130_fd_pr__cap_mim_m3_1 l=3 w=3
X564 B11.t1841 TOP.t1436 sky130_fd_pr__cap_mim_m3_1 l=3 w=3
X565 EDGE_BIAS.t87 EDGE_BIAS.t88 sky130_fd_pr__cap_mim_m3_1 l=3 w=3
X566 B11.t1916 TOP.t1286 sky130_fd_pr__cap_mim_m3_1 l=3 w=3
X567 B11.t1480 TOP.t2158 sky130_fd_pr__cap_mim_m3_1 l=3 w=3
X568 B11.t1363 TOP.t2392 sky130_fd_pr__cap_mim_m3_1 l=3 w=3
X569 B8.t215 TOP.t7376 sky130_fd_pr__cap_mim_m3_1 l=3 w=3
X570 B11.t21 TOP.t5076 sky130_fd_pr__cap_mim_m3_1 l=3 w=3
X571 B9.t459 TOP.t104 sky130_fd_pr__cap_mim_m3_1 l=3 w=3
X572 B10.t383 TOP.t6528 sky130_fd_pr__cap_mim_m3_1 l=3 w=3
X573 EDGE_BIAS.t234 EDGE_BIAS.t235 sky130_fd_pr__cap_mim_m3_1 l=3 w=3
X574 B11.t1325 TOP.t2468 sky130_fd_pr__cap_mim_m3_1 l=3 w=3
X575 B10.t865 TOP.t5564 sky130_fd_pr__cap_mim_m3_1 l=3 w=3
X576 B8.t177 TOP.t7452 sky130_fd_pr__cap_mim_m3_1 l=3 w=3
X577 B11.t71 TOP.t4976 sky130_fd_pr__cap_mim_m3_1 l=3 w=3
X578 B11.t482 TOP.t4154 sky130_fd_pr__cap_mim_m3_1 l=3 w=3
X579 B11.t1131 TOP.t2856 sky130_fd_pr__cap_mim_m3_1 l=3 w=3
X580 B11.t1567 TOP.t1984 sky130_fd_pr__cap_mim_m3_1 l=3 w=3
X581 B9.t421 TOP.t180 sky130_fd_pr__cap_mim_m3_1 l=3 w=3
X582 B11.t390 TOP.t4338 sky130_fd_pr__cap_mim_m3_1 l=3 w=3
X583 B10.t276 TOP.t6742 sky130_fd_pr__cap_mim_m3_1 l=3 w=3
X584 B11.t1093 TOP.t2932 sky130_fd_pr__cap_mim_m3_1 l=3 w=3
X585 B9.t10 TOP.t1002 sky130_fd_pr__cap_mim_m3_1 l=3 w=3
X586 EDGE_BIAS.t15 EDGE_BIAS.t16 sky130_fd_pr__cap_mim_m3_1 l=3 w=3
X587 B10.t238 TOP.t6818 sky130_fd_pr__cap_mim_m3_1 l=3 w=3
X588 B11.t1748 TOP.t1622 sky130_fd_pr__cap_mim_m3_1 l=3 w=3
X589 B10.t480 TOP.t6334 sky130_fd_pr__cap_mim_m3_1 l=3 w=3
X590 B11.t1710 TOP.t1698 sky130_fd_pr__cap_mim_m3_1 l=3 w=3
X591 B11.t1672 TOP.t1774 sky130_fd_pr__cap_mim_m3_1 l=3 w=3
X592 B11.t1516 TOP.t2086 sky130_fd_pr__cap_mim_m3_1 l=3 w=3
X593 B11.t1349 TOP.t2420 sky130_fd_pr__cap_mim_m3_1 l=3 w=3
X594 B10.t889 TOP.t5516 sky130_fd_pr__cap_mim_m3_1 l=3 w=3
X595 B11.t280 TOP.t4558 sky130_fd_pr__cap_mim_m3_1 l=3 w=3
X596 B10.t772 TOP.t5750 sky130_fd_pr__cap_mim_m3_1 l=3 w=3
X597 B7.t14 TOP.t8034 sky130_fd_pr__cap_mim_m3_1 l=3 w=3
X598 B11.t816 TOP.t3486 sky130_fd_pr__cap_mim_m3_1 l=3 w=3
X599 B11.t1876 TOP.t1366 sky130_fd_pr__cap_mim_m3_1 l=3 w=3
X600 EDGE_BIAS.t288 EDGE_BIAS.t289 sky130_fd_pr__cap_mim_m3_1 l=3 w=3
X601 B10.t734 TOP.t5826 sky130_fd_pr__cap_mim_m3_1 l=3 w=3
X602 B9.t115 TOP.t792 sky130_fd_pr__cap_mim_m3_1 l=3 w=3
X603 B10.t540 TOP.t6214 sky130_fd_pr__cap_mim_m3_1 l=3 w=3
X604 B8.t103 TOP.t7600 sky130_fd_pr__cap_mim_m3_1 l=3 w=3
X605 B10.t976 TOP.t5342 sky130_fd_pr__cap_mim_m3_1 l=3 w=3
X606 B11.t951 TOP.t3216 sky130_fd_pr__cap_mim_m3_1 l=3 w=3
X607 B10.t343 TOP.t6608 sky130_fd_pr__cap_mim_m3_1 l=3 w=3
X608 B11.t1644 TOP.t1830 sky130_fd_pr__cap_mim_m3_1 l=3 w=3
X609 B10.t938 TOP.t5418 sky130_fd_pr__cap_mim_m3_1 l=3 w=3
X610 B9.t498 TOP.t26 sky130_fd_pr__cap_mim_m3_1 l=3 w=3
X611 B11.t426 TOP.t4266 sky130_fd_pr__cap_mim_m3_1 l=3 w=3
X612 B11.t1540 TOP.t2038 sky130_fd_pr__cap_mim_m3_1 l=3 w=3
X613 B11.t671 TOP.t3776 sky130_fd_pr__cap_mim_m3_1 l=3 w=3
X614 B11.t1181 TOP.t2756 sky130_fd_pr__cap_mim_m3_1 l=3 w=3
X615 B11.t913 TOP.t3292 sky130_fd_pr__cap_mim_m3_1 l=3 w=3
X616 B11.t1825 TOP.t1468 sky130_fd_pr__cap_mim_m3_1 l=3 w=3
X617 B11.t196 TOP.t4726 sky130_fd_pr__cap_mim_m3_1 l=3 w=3
X618 EDGE_BIAS.t135 EDGE_BIAS.t136 sky130_fd_pr__cap_mim_m3_1 l=3 w=3
X619 B10.t758 TOP.t5778 sky130_fd_pr__cap_mim_m3_1 l=3 w=3
X620 B8.t199 TOP.t7408 sky130_fd_pr__cap_mim_m3_1 l=3 w=3
X621 B11.t121 TOP.t4876 sky130_fd_pr__cap_mim_m3_1 l=3 w=3
X622 B11.t1787 TOP.t1544 sky130_fd_pr__cap_mim_m3_1 l=3 w=3
X623 B11.t2029 TOP.t1060 sky130_fd_pr__cap_mim_m3_1 l=3 w=3
X624 EDGE_BIAS.t690 EDGE_BIAS.t691 sky130_fd_pr__cap_mim_m3_1 l=3 w=3
X625 B11.t1309 TOP.t2500 sky130_fd_pr__cap_mim_m3_1 l=3 w=3
X626 B11.t1153 TOP.t2812 sky130_fd_pr__cap_mim_m3_1 l=3 w=3
X627 EDGE_BIAS.t342 EDGE_BIAS.t343 sky130_fd_pr__cap_mim_m3_1 l=3 w=3
X628 B8.t161 TOP.t7484 sky130_fd_pr__cap_mim_m3_1 l=3 w=3
X629 B11.t224 TOP.t4670 sky130_fd_pr__cap_mim_m3_1 l=3 w=3
X630 B10.t8 TOP.t7278 sky130_fd_pr__cap_mim_m3_1 l=3 w=3
X631 B11.t1115 TOP.t2888 sky130_fd_pr__cap_mim_m3_1 l=3 w=3
X632 B9.t405 TOP.t212 sky130_fd_pr__cap_mim_m3_1 l=3 w=3
X633 B10.t298 TOP.t6698 sky130_fd_pr__cap_mim_m3_1 l=3 w=3
X634 B11.t1551 TOP.t2016 sky130_fd_pr__cap_mim_m3_1 l=3 w=3
X635 B11.t1271 TOP.t2576 sky130_fd_pr__cap_mim_m3_1 l=3 w=3
X636 B11.t776 TOP.t3566 sky130_fd_pr__cap_mim_m3_1 l=3 w=3
X637 B11.t1077 TOP.t2964 sky130_fd_pr__cap_mim_m3_1 l=3 w=3
X638 B9.t367 TOP.t288 sky130_fd_pr__cap_mim_m3_1 l=3 w=3
X639 B7.t53 TOP.t7956 sky130_fd_pr__cap_mim_m3_1 l=3 w=3
X640 EDGE_BIAS.t225 EDGE_BIAS.t226 sky130_fd_pr__cap_mim_m3_1 l=3 w=3
X641 B11.t738 TOP.t3642 sky130_fd_pr__cap_mim_m3_1 l=3 w=3
X642 B11.t38 TOP.t5042 sky130_fd_pr__cap_mim_m3_1 l=3 w=3
X643 B11.t1694 TOP.t1730 sky130_fd_pr__cap_mim_m3_1 l=3 w=3
X644 B11.t1500 TOP.t2118 sky130_fd_pr__cap_mim_m3_1 l=3 w=3
X645 B8.t185 TOP.t7436 sky130_fd_pr__cap_mim_m3_1 l=3 w=3
X646 B11.t1936 TOP.t1246 sky130_fd_pr__cap_mim_m3_1 l=3 w=3
X647 B11.t125 TOP.t4868 sky130_fd_pr__cap_mim_m3_1 l=3 w=3
X648 B11.t1220 TOP.t2678 sky130_fd_pr__cap_mim_m3_1 l=3 w=3
X649 B11.t1462 TOP.t2194 sky130_fd_pr__cap_mim_m3_1 l=3 w=3
X650 EDGE_BIAS.t396 EDGE_BIAS.t397 sky130_fd_pr__cap_mim_m3_1 l=3 w=3
X651 B11.t140 TOP.t4838 sky130_fd_pr__cap_mim_m3_1 l=3 w=3
X652 B11.t1898 TOP.t1322 sky130_fd_pr__cap_mim_m3_1 l=3 w=3
X653 B10.t718 TOP.t5858 sky130_fd_pr__cap_mim_m3_1 l=3 w=3
X654 B10.t562 TOP.t6170 sky130_fd_pr__cap_mim_m3_1 l=3 w=3
X655 B9.t99 TOP.t824 sky130_fd_pr__cap_mim_m3_1 l=3 w=3
X656 B11.t459 TOP.t4200 sky130_fd_pr__cap_mim_m3_1 l=3 w=3
X657 B10.t960 TOP.t5374 sky130_fd_pr__cap_mim_m3_1 l=3 w=3
X658 B10.t524 TOP.t6246 sky130_fd_pr__cap_mim_m3_1 l=3 w=3
X659 B8.t87 TOP.t7632 sky130_fd_pr__cap_mim_m3_1 l=3 w=3
X660 B10.t680 TOP.t5934 sky130_fd_pr__cap_mim_m3_1 l=3 w=3
X661 B11.t321 TOP.t4476 sky130_fd_pr__cap_mim_m3_1 l=3 w=3
X662 B10.t327 TOP.t6640 sky130_fd_pr__cap_mim_m3_1 l=3 w=3
X663 B10.t922 TOP.t5450 sky130_fd_pr__cap_mim_m3_1 l=3 w=3
X664 B9.t482 TOP.t58 sky130_fd_pr__cap_mim_m3_1 l=3 w=3
X665 B8.t49 TOP.t7708 sky130_fd_pr__cap_mim_m3_1 l=3 w=3
X666 B11.t246 TOP.t4626 sky130_fd_pr__cap_mim_m3_1 l=3 w=3
X667 EDGE_BIAS.t279 EDGE_BIAS.t280 sky130_fd_pr__cap_mim_m3_1 l=3 w=3
X668 B11.t1847 TOP.t1424 sky130_fd_pr__cap_mim_m3_1 l=3 w=3
X669 EDGE_BIAS.t69 EDGE_BIAS.t70 sky130_fd_pr__cap_mim_m3_1 l=3 w=3
X670 B11.t1809 TOP.t1500 sky130_fd_pr__cap_mim_m3_1 l=3 w=3
X671 B11.t349 TOP.t4420 sky130_fd_pr__cap_mim_m3_1 l=3 w=3
X672 EDGE_BIAS.t183 EDGE_BIAS.t184 sky130_fd_pr__cap_mim_m3_1 l=3 w=3
X673 B9.t123 TOP.t776 sky130_fd_pr__cap_mim_m3_1 l=3 w=3
X674 B11.t1369 TOP.t2380 sky130_fd_pr__cap_mim_m3_1 l=3 w=3
X675 B11.t1771 TOP.t1576 sky130_fd_pr__cap_mim_m3_1 l=3 w=3
X676 B11.t2013 TOP.t1092 sky130_fd_pr__cap_mim_m3_1 l=3 w=3
X677 B11.t1331 TOP.t2456 sky130_fd_pr__cap_mim_m3_1 l=3 w=3
X678 B10.t871 TOP.t5552 sky130_fd_pr__cap_mim_m3_1 l=3 w=3
X679 B11.t1137 TOP.t2844 sky130_fd_pr__cap_mim_m3_1 l=3 w=3
X680 B8.t145 TOP.t7516 sky130_fd_pr__cap_mim_m3_1 l=3 w=3
X681 B9.t389 TOP.t244 sky130_fd_pr__cap_mim_m3_1 l=3 w=3
X682 B10.t282 TOP.t6730 sky130_fd_pr__cap_mim_m3_1 l=3 w=3
X683 B11.t1975 TOP.t1168 sky130_fd_pr__cap_mim_m3_1 l=3 w=3
X684 B7.t106 TOP.t7850 sky130_fd_pr__cap_mim_m3_1 l=3 w=3
X685 B7.t37 TOP.t7988 sky130_fd_pr__cap_mim_m3_1 l=3 w=3
X686 B11.t105 TOP.t4908 sky130_fd_pr__cap_mim_m3_1 l=3 w=3
X687 B11.t760 TOP.t3598 sky130_fd_pr__cap_mim_m3_1 l=3 w=3
X688 B9.t351 TOP.t320 sky130_fd_pr__cap_mim_m3_1 l=3 w=3
X689 B11.t403 TOP.t4312 sky130_fd_pr__cap_mim_m3_1 l=3 w=3
X690 B10.t244 TOP.t6806 sky130_fd_pr__cap_mim_m3_1 l=3 w=3
X691 B11.t1795 TOP.t1528 sky130_fd_pr__cap_mim_m3_1 l=3 w=3
X692 B11.t722 TOP.t3674 sky130_fd_pr__cap_mim_m3_1 l=3 w=3
X693 B11.t265 TOP.t4588 sky130_fd_pr__cap_mim_m3_1 l=3 w=3
X694 B11.t1678 TOP.t1762 sky130_fd_pr__cap_mim_m3_1 l=3 w=3
X695 B11.t1522 TOP.t2074 sky130_fd_pr__cap_mim_m3_1 l=3 w=3
X696 B11.t1484 TOP.t2150 sky130_fd_pr__cap_mim_m3_1 l=3 w=3
X697 B11.t1161 TOP.t2796 sky130_fd_pr__cap_mim_m3_1 l=3 w=3
X698 B10.t778 TOP.t5738 sky130_fd_pr__cap_mim_m3_1 l=3 w=3
X699 EDGE_BIAS.t204 EDGE_BIAS.t205 sky130_fd_pr__cap_mim_m3_1 l=3 w=3
X700 B11.t1204 TOP.t2710 sky130_fd_pr__cap_mim_m3_1 l=3 w=3
X701 B9.t190 TOP.t642 sky130_fd_pr__cap_mim_m3_1 l=3 w=3
X702 B11.t1882 TOP.t1354 sky130_fd_pr__cap_mim_m3_1 l=3 w=3
X703 B11.t1446 TOP.t2226 sky130_fd_pr__cap_mim_m3_1 l=3 w=3
X704 B10.t740 TOP.t5814 sky130_fd_pr__cap_mim_m3_1 l=3 w=3
X705 B11.t371 TOP.t4376 sky130_fd_pr__cap_mim_m3_1 l=3 w=3
X706 B10.t546 TOP.t6202 sky130_fd_pr__cap_mim_m3_1 l=3 w=3
X707 B9.t83 TOP.t856 sky130_fd_pr__cap_mim_m3_1 l=3 w=3
X708 EDGE_BIAS.t759 EDGE_BIAS.t760 sky130_fd_pr__cap_mim_m3_1 l=3 w=3
X709 B8.t71 TOP.t7664 sky130_fd_pr__cap_mim_m3_1 l=3 w=3
X710 B11.t1408 TOP.t2302 sky130_fd_pr__cap_mim_m3_1 l=3 w=3
X711 B11.t1650 TOP.t1818 sky130_fd_pr__cap_mim_m3_1 l=3 w=3
X712 B8.t33 TOP.t7740 sky130_fd_pr__cap_mim_m3_1 l=3 w=3
X713 B11.t677 TOP.t3764 sky130_fd_pr__cap_mim_m3_1 l=3 w=3
X714 B6.t54 TOP.t5138 sky130_fd_pr__cap_mim_m3_1 l=3 w=3
X715 B11.t1228 TOP.t2662 sky130_fd_pr__cap_mim_m3_1 l=3 w=3
X716 B11.t1831 TOP.t1456 sky130_fd_pr__cap_mim_m3_1 l=3 w=3
X717 B9.t55 TOP.t912 sky130_fd_pr__cap_mim_m3_1 l=3 w=3
X718 EDGE_BIAS.t117 EDGE_BIAS.t118 sky130_fd_pr__cap_mim_m3_1 l=3 w=3
X719 B6.t15 TOP.t5216 sky130_fd_pr__cap_mim_m3_1 l=3 w=3
X720 B10.t570 TOP.t6154 sky130_fd_pr__cap_mim_m3_1 l=3 w=3
X721 B8.t205 TOP.t7396 sky130_fd_pr__cap_mim_m3_1 l=3 w=3
X722 EDGE_BIAS.t258 EDGE_BIAS.t259 sky130_fd_pr__cap_mim_m3_1 l=3 w=3
X723 B11.t230 TOP.t4658 sky130_fd_pr__cap_mim_m3_1 l=3 w=3
X724 B10.t131 TOP.t7032 sky130_fd_pr__cap_mim_m3_1 l=3 w=3
X725 B11.t2035 TOP.t1048 sky130_fd_pr__cap_mim_m3_1 l=3 w=3
X726 B11.t1997 TOP.t1124 sky130_fd_pr__cap_mim_m3_1 l=3 w=3
X727 B11.t1315 TOP.t2488 sky130_fd_pr__cap_mim_m3_1 l=3 w=3
X728 B10.t855 TOP.t5584 sky130_fd_pr__cap_mim_m3_1 l=3 w=3
X729 B8.t167 TOP.t7472 sky130_fd_pr__cap_mim_m3_1 l=3 w=3
X730 B11.t138 TOP.t4842 sky130_fd_pr__cap_mim_m3_1 l=3 w=3
X731 B11.t1121 TOP.t2876 sky130_fd_pr__cap_mim_m3_1 l=3 w=3
X732 B10.t817 TOP.t5660 sky130_fd_pr__cap_mim_m3_1 l=3 w=3
X733 B9.t150 TOP.t722 sky130_fd_pr__cap_mim_m3_1 l=3 w=3
X734 B10.t266 TOP.t6762 sky130_fd_pr__cap_mim_m3_1 l=3 w=3
X735 B11.t1959 TOP.t1200 sky130_fd_pr__cap_mim_m3_1 l=3 w=3
X736 B11.t1277 TOP.t2564 sky130_fd_pr__cap_mim_m3_1 l=3 w=3
X737 EDGE_BIAS.t651 EDGE_BIAS.t652 sky130_fd_pr__cap_mim_m3_1 l=3 w=3
X738 B11.t1855 TOP.t1408 sky130_fd_pr__cap_mim_m3_1 l=3 w=3
X739 B11.t1083 TOP.t2952 sky130_fd_pr__cap_mim_m3_1 l=3 w=3
X740 B10.t228 TOP.t6838 sky130_fd_pr__cap_mim_m3_1 l=3 w=3
X741 B10.t1017 TOP.t5260 sky130_fd_pr__cap_mim_m3_1 l=3 w=3
X742 B10.t470 TOP.t6354 sky130_fd_pr__cap_mim_m3_1 l=3 w=3
X743 B11.t996 TOP.t3126 sky130_fd_pr__cap_mim_m3_1 l=3 w=3
X744 B11.t1506 TOP.t2106 sky130_fd_pr__cap_mim_m3_1 l=3 w=3
X745 B10.t432 TOP.t6430 sky130_fd_pr__cap_mim_m3_1 l=3 w=3
X746 B11.t564 TOP.t3990 sky130_fd_pr__cap_mim_m3_1 l=3 w=3
X747 EDGE_BIAS.t312 EDGE_BIAS.t313 sky130_fd_pr__cap_mim_m3_1 l=3 w=3
X748 B11.t1468 TOP.t2182 sky130_fd_pr__cap_mim_m3_1 l=3 w=3
X749 B11.t1866 TOP.t1386 sky130_fd_pr__cap_mim_m3_1 l=3 w=3
X750 B11.t1430 TOP.t2258 sky130_fd_pr__cap_mim_m3_1 l=3 w=3
X751 B10.t724 TOP.t5846 sky130_fd_pr__cap_mim_m3_1 l=3 w=3
X752 B9.t105 TOP.t812 sky130_fd_pr__cap_mim_m3_1 l=3 w=3
X753 B10.t530 TOP.t6234 sky130_fd_pr__cap_mim_m3_1 l=3 w=3
X754 B11.t1392 TOP.t2334 sky130_fd_pr__cap_mim_m3_1 l=3 w=3
X755 B8.t244 TOP.t7318 sky130_fd_pr__cap_mim_m3_1 l=3 w=3
X756 B11.t174 TOP.t4770 sky130_fd_pr__cap_mim_m3_1 l=3 w=3
X757 B10.t91 TOP.t7112 sky130_fd_pr__cap_mim_m3_1 l=3 w=3
X758 B10.t686 TOP.t5922 sky130_fd_pr__cap_mim_m3_1 l=3 w=3
X759 B11.t493 TOP.t4132 sky130_fd_pr__cap_mim_m3_1 l=3 w=3
X760 B10.t333 TOP.t6628 sky130_fd_pr__cap_mim_m3_1 l=3 w=3
X761 B11.t1634 TOP.t1850 sky130_fd_pr__cap_mim_m3_1 l=3 w=3
X762 B9.t488 TOP.t46 sky130_fd_pr__cap_mim_m3_1 l=3 w=3
X763 B11.t82 TOP.t4954 sky130_fd_pr__cap_mim_m3_1 l=3 w=3
X764 B10.t53 TOP.t7188 sky130_fd_pr__cap_mim_m3_1 l=3 w=3
X765 B11.t661 TOP.t3796 sky130_fd_pr__cap_mim_m3_1 l=3 w=3
X766 B11.t1596 TOP.t1926 sky130_fd_pr__cap_mim_m3_1 l=3 w=3
X767 B11.t1032 TOP.t3054 sky130_fd_pr__cap_mim_m3_1 l=3 w=3
X768 B11.t903 TOP.t3312 sky130_fd_pr__cap_mim_m3_1 l=3 w=3
X769 B11.t1815 TOP.t1488 sky130_fd_pr__cap_mim_m3_1 l=3 w=3
X770 B11.t263 TOP.t4592 sky130_fd_pr__cap_mim_m3_1 l=3 w=3
X771 EDGE_BIAS.t165 EDGE_BIAS.t166 sky130_fd_pr__cap_mim_m3_1 l=3 w=3
X772 B11.t865 TOP.t3388 sky130_fd_pr__cap_mim_m3_1 l=3 w=3
X773 B11.t1777 TOP.t1564 sky130_fd_pr__cap_mim_m3_1 l=3 w=3
X774 EDGE_BIAS.t366 EDGE_BIAS.t367 sky130_fd_pr__cap_mim_m3_1 l=3 w=3
X775 B11.t2019 TOP.t1080 sky130_fd_pr__cap_mim_m3_1 l=3 w=3
X776 B10.t877 TOP.t5540 sky130_fd_pr__cap_mim_m3_1 l=3 w=3
X777 B10.t839 TOP.t5616 sky130_fd_pr__cap_mim_m3_1 l=3 w=3
X778 B11.t1299 TOP.t2520 sky130_fd_pr__cap_mim_m3_1 l=3 w=3
X779 B11.t1143 TOP.t2832 sky130_fd_pr__cap_mim_m3_1 l=3 w=3
X780 B8.t151 TOP.t7504 sky130_fd_pr__cap_mim_m3_1 l=3 w=3
X781 B11.t1105 TOP.t2908 sky130_fd_pr__cap_mim_m3_1 l=3 w=3
X782 B10.t801 TOP.t5692 sky130_fd_pr__cap_mim_m3_1 l=3 w=3
X783 B9.t134 TOP.t754 sky130_fd_pr__cap_mim_m3_1 l=3 w=3
X784 B11.t409 TOP.t4300 sky130_fd_pr__cap_mim_m3_1 l=3 w=3
X785 B11.t524 TOP.t4070 sky130_fd_pr__cap_mim_m3_1 l=3 w=3
X786 B11.t1261 TOP.t2596 sky130_fd_pr__cap_mim_m3_1 l=3 w=3
X787 B7.t112 TOP.t7838 sky130_fd_pr__cap_mim_m3_1 l=3 w=3
X788 B7.t43 TOP.t7976 sky130_fd_pr__cap_mim_m3_1 l=3 w=3
X789 B11.t766 TOP.t3586 sky130_fd_pr__cap_mim_m3_1 l=3 w=3
X790 B11.t1067 TOP.t2984 sky130_fd_pr__cap_mim_m3_1 l=3 w=3
X791 B10.t1005 TOP.t5284 sky130_fd_pr__cap_mim_m3_1 l=3 w=3
X792 B11.t728 TOP.t3662 sky130_fd_pr__cap_mim_m3_1 l=3 w=3
X793 B11.t2043 TOP.t1032 sky130_fd_pr__cap_mim_m3_1 l=3 w=3
X794 B11.t1684 TOP.t1750 sky130_fd_pr__cap_mim_m3_1 l=3 w=3
X795 B11.t1490 TOP.t2138 sky130_fd_pr__cap_mim_m3_1 l=3 w=3
X796 B11.t2 TOP.t5114 sky130_fd_pr__cap_mim_m3_1 l=3 w=3
X797 B11.t1210 TOP.t2698 sky130_fd_pr__cap_mim_m3_1 l=3 w=3
X798 B11.t299 TOP.t4520 sky130_fd_pr__cap_mim_m3_1 l=3 w=3
X799 B11.t1452 TOP.t2214 sky130_fd_pr__cap_mim_m3_1 l=3 w=3
X800 B11.t207 TOP.t4704 sky130_fd_pr__cap_mim_m3_1 l=3 w=3
X801 B10.t708 TOP.t5878 sky130_fd_pr__cap_mim_m3_1 l=3 w=3
X802 B10.t552 TOP.t6190 sky130_fd_pr__cap_mim_m3_1 l=3 w=3
X803 B9.t89 TOP.t844 sky130_fd_pr__cap_mim_m3_1 l=3 w=3
X804 B10.t514 TOP.t6266 sky130_fd_pr__cap_mim_m3_1 l=3 w=3
X805 B11.t752 TOP.t3614 sky130_fd_pr__cap_mim_m3_1 l=3 w=3
X806 B8.t228 TOP.t7350 sky130_fd_pr__cap_mim_m3_1 l=3 w=3
X807 B10.t75 TOP.t7144 sky130_fd_pr__cap_mim_m3_1 l=3 w=3
X808 B11.t1656 TOP.t1806 sky130_fd_pr__cap_mim_m3_1 l=3 w=3
X809 B10.t670 TOP.t5954 sky130_fd_pr__cap_mim_m3_1 l=3 w=3
X810 B9.t472 TOP.t78 sky130_fd_pr__cap_mim_m3_1 l=3 w=3
X811 B10.t912 TOP.t5470 sky130_fd_pr__cap_mim_m3_1 l=3 w=3
X812 B11.t313 TOP.t4492 sky130_fd_pr__cap_mim_m3_1 l=3 w=3
X813 B10.t37 TOP.t7220 sky130_fd_pr__cap_mim_m3_1 l=3 w=3
X814 B9.t434 TOP.t154 sky130_fd_pr__cap_mim_m3_1 l=3 w=3
X815 B11.t1837 TOP.t1444 sky130_fd_pr__cap_mim_m3_1 l=3 w=3
X816 B11.t1476 TOP.t2166 sky130_fd_pr__cap_mim_m3_1 l=3 w=3
X817 EDGE_BIAS.t99 EDGE_BIAS.t100 sky130_fd_pr__cap_mim_m3_1 l=3 w=3
X818 B11.t1799 TOP.t1520 sky130_fd_pr__cap_mim_m3_1 l=3 w=3
X819 B11.t1761 TOP.t1596 sky130_fd_pr__cap_mim_m3_1 l=3 w=3
X820 B11.t2003 TOP.t1112 sky130_fd_pr__cap_mim_m3_1 l=3 w=3
X821 B10.t861 TOP.t5572 sky130_fd_pr__cap_mim_m3_1 l=3 w=3
X822 B11.t442 TOP.t4234 sky130_fd_pr__cap_mim_m3_1 l=3 w=3
X823 B11.t1723 TOP.t1672 sky130_fd_pr__cap_mim_m3_1 l=3 w=3
X824 B11.t1127 TOP.t2864 sky130_fd_pr__cap_mim_m3_1 l=3 w=3
X825 B8.t135 TOP.t7536 sky130_fd_pr__cap_mim_m3_1 l=3 w=3
X826 EDGE_BIAS.t633 EDGE_BIAS.t634 sky130_fd_pr__cap_mim_m3_1 l=3 w=3
X827 B11.t1965 TOP.t1188 sky130_fd_pr__cap_mim_m3_1 l=3 w=3
X828 B11.t508 TOP.t4102 sky130_fd_pr__cap_mim_m3_1 l=3 w=3
X829 B7.t96 TOP.t7870 sky130_fd_pr__cap_mim_m3_1 l=3 w=3
X830 B11.t1089 TOP.t2940 sky130_fd_pr__cap_mim_m3_1 l=3 w=3
X831 B7.t27 TOP.t8008 sky130_fd_pr__cap_mim_m3_1 l=3 w=3
X832 B11.t151 TOP.t4816 sky130_fd_pr__cap_mim_m3_1 l=3 w=3
X833 B6.t63 TOP.t5120 sky130_fd_pr__cap_mim_m3_1 l=3 w=3
X834 B9.t341 TOP.t340 sky130_fd_pr__cap_mim_m3_1 l=3 w=3
X835 B11.t470 TOP.t4178 sky130_fd_pr__cap_mim_m3_1 l=3 w=3
X836 B8.t116 TOP.t7574 sky130_fd_pr__cap_mim_m3_1 l=3 w=3
X837 B11.t332 TOP.t4454 sky130_fd_pr__cap_mim_m3_1 l=3 w=3
X838 B11.t712 TOP.t3694 sky130_fd_pr__cap_mim_m3_1 l=3 w=3
X839 B10.t885 TOP.t5524 sky130_fd_pr__cap_mim_m3_1 l=3 w=3
X840 B9.t303 TOP.t416 sky130_fd_pr__cap_mim_m3_1 l=3 w=3
X841 B11.t46 TOP.t5026 sky130_fd_pr__cap_mim_m3_1 l=3 w=3
X842 B11.t1512 TOP.t2094 sky130_fd_pr__cap_mim_m3_1 l=3 w=3
X843 EDGE_BIAS.t228 EDGE_BIAS.t229 sky130_fd_pr__cap_mim_m3_1 l=3 w=3
X844 B11.t1194 TOP.t2730 sky130_fd_pr__cap_mim_m3_1 l=3 w=3
X845 B11.t360 TOP.t4398 sky130_fd_pr__cap_mim_m3_1 l=3 w=3
X846 B11.t1436 TOP.t2246 sky130_fd_pr__cap_mim_m3_1 l=3 w=3
X847 B10.t536 TOP.t6222 sky130_fd_pr__cap_mim_m3_1 l=3 w=3
X848 B9.t73 TOP.t876 sky130_fd_pr__cap_mim_m3_1 l=3 w=3
X849 B11.t1398 TOP.t2322 sky130_fd_pr__cap_mim_m3_1 l=3 w=3
X850 B9.t494 TOP.t34 sky130_fd_pr__cap_mim_m3_1 l=3 w=3
X851 B11.t1640 TOP.t1838 sky130_fd_pr__cap_mim_m3_1 l=3 w=3
X852 B11.t386 TOP.t4346 sky130_fd_pr__cap_mim_m3_1 l=3 w=3
X853 B10.t1022 TOP.t5250 sky130_fd_pr__cap_mim_m3_1 l=3 w=3
X854 B8.t23 TOP.t7760 sky130_fd_pr__cap_mim_m3_1 l=3 w=3
X855 B11.t19 TOP.t5080 sky130_fd_pr__cap_mim_m3_1 l=3 w=3
X856 B9.t239 TOP.t544 sky130_fd_pr__cap_mim_m3_1 l=3 w=3
X857 B11.t116 TOP.t4886 sky130_fd_pr__cap_mim_m3_1 l=3 w=3
X858 B10.t311 TOP.t6672 sky130_fd_pr__cap_mim_m3_1 l=3 w=3
X859 B11.t1821 TOP.t1476 sky130_fd_pr__cap_mim_m3_1 l=3 w=3
X860 B9.t45 TOP.t932 sky130_fd_pr__cap_mim_m3_1 l=3 w=3
X861 EDGE_BIAS.t147 EDGE_BIAS.t148 sky130_fd_pr__cap_mim_m3_1 l=3 w=3
X862 B11.t1783 TOP.t1552 sky130_fd_pr__cap_mim_m3_1 l=3 w=3
X863 B11.t1745 TOP.t1628 sky130_fd_pr__cap_mim_m3_1 l=3 w=3
X864 B11.t276 TOP.t4566 sky130_fd_pr__cap_mim_m3_1 l=3 w=3
X865 B11.t2025 TOP.t1068 sky130_fd_pr__cap_mim_m3_1 l=3 w=3
X866 B11.t1664 TOP.t1790 sky130_fd_pr__cap_mim_m3_1 l=3 w=3
X867 B10.t845 TOP.t5604 sky130_fd_pr__cap_mim_m3_1 l=3 w=3
X868 B11.t1987 TOP.t1144 sky130_fd_pr__cap_mim_m3_1 l=3 w=3
X869 B11.t1707 TOP.t1704 sky130_fd_pr__cap_mim_m3_1 l=3 w=3
X870 B11.t1111 TOP.t2896 sky130_fd_pr__cap_mim_m3_1 l=3 w=3
X871 B11.t1949 TOP.t1220 sky130_fd_pr__cap_mim_m3_1 l=3 w=3
X872 B10.t807 TOP.t5680 sky130_fd_pr__cap_mim_m3_1 l=3 w=3
X873 B9.t140 TOP.t742 sky130_fd_pr__cap_mim_m3_1 l=3 w=3
X874 B11.t1073 TOP.t2972 sky130_fd_pr__cap_mim_m3_1 l=3 w=3
X875 B7.t49 TOP.t7964 sky130_fd_pr__cap_mim_m3_1 l=3 w=3
X876 B11.t1037 TOP.t3044 sky130_fd_pr__cap_mim_m3_1 l=3 w=3
X877 B11.t1911 TOP.t1296 sky130_fd_pr__cap_mim_m3_1 l=3 w=3
X878 B11.t59 TOP.t5000 sky130_fd_pr__cap_mim_m3_1 l=3 w=3
X879 B10.t218 TOP.t6858 sky130_fd_pr__cap_mim_m3_1 l=3 w=3
X880 B11.t696 TOP.t3726 sky130_fd_pr__cap_mim_m3_1 l=3 w=3
X881 B10.t180 TOP.t6934 sky130_fd_pr__cap_mim_m3_1 l=3 w=3
X882 B11.t986 TOP.t3146 sky130_fd_pr__cap_mim_m3_1 l=3 w=3
X883 B11.t1496 TOP.t2126 sky130_fd_pr__cap_mim_m3_1 l=3 w=3
X884 B11.t1216 TOP.t2686 sky130_fd_pr__cap_mim_m3_1 l=3 w=3
X885 B11.t1178 TOP.t2762 sky130_fd_pr__cap_mim_m3_1 l=3 w=3
X886 B11.t1458 TOP.t2202 sky130_fd_pr__cap_mim_m3_1 l=3 w=3
X887 B11.t1420 TOP.t2278 sky130_fd_pr__cap_mim_m3_1 l=3 w=3
X888 B11.t1097 TOP.t2924 sky130_fd_pr__cap_mim_m3_1 l=3 w=3
X889 B11.t436 TOP.t4246 sky130_fd_pr__cap_mim_m3_1 l=3 w=3
X890 EDGE_BIAS.t30 EDGE_BIAS.t31 sky130_fd_pr__cap_mim_m3_1 l=3 w=3
X891 B10.t520 TOP.t6254 sky130_fd_pr__cap_mim_m3_1 l=3 w=3
X892 EDGE_BIAS.t702 EDGE_BIAS.t703 sky130_fd_pr__cap_mim_m3_1 l=3 w=3
X893 B10.t81 TOP.t7132 sky130_fd_pr__cap_mim_m3_1 l=3 w=3
X894 B11.t1382 TOP.t2354 sky130_fd_pr__cap_mim_m3_1 l=3 w=3
X895 B8.t234 TOP.t7338 sky130_fd_pr__cap_mim_m3_1 l=3 w=3
X896 B11.t241 TOP.t4636 sky130_fd_pr__cap_mim_m3_1 l=3 w=3
X897 B11.t1624 TOP.t1870 sky130_fd_pr__cap_mim_m3_1 l=3 w=3
X898 B9.t478 TOP.t66 sky130_fd_pr__cap_mim_m3_1 l=3 w=3
X899 B10.t323 TOP.t6648 sky130_fd_pr__cap_mim_m3_1 l=3 w=3
X900 B11.t651 TOP.t3816 sky130_fd_pr__cap_mim_m3_1 l=3 w=3
X901 B10.t43 TOP.t7208 sky130_fd_pr__cap_mim_m3_1 l=3 w=3
X902 B11.t1344 TOP.t2430 sky130_fd_pr__cap_mim_m3_1 l=3 w=3
X903 B11.t1586 TOP.t1946 sky130_fd_pr__cap_mim_m3_1 l=3 w=3
X904 B11.t613 TOP.t3892 sky130_fd_pr__cap_mim_m3_1 l=3 w=3
X905 B11.t1805 TOP.t1508 sky130_fd_pr__cap_mim_m3_1 l=3 w=3
X906 EDGE_BIAS.t195 EDGE_BIAS.t196 sky130_fd_pr__cap_mim_m3_1 l=3 w=3
X907 EDGE_BIAS.t579 EDGE_BIAS.t580 sky130_fd_pr__cap_mim_m3_1 l=3 w=3
X908 B11.t1767 TOP.t1584 sky130_fd_pr__cap_mim_m3_1 l=3 w=3
X909 B10.t867 TOP.t5560 sky130_fd_pr__cap_mim_m3_1 l=3 w=3
X910 B11.t2009 TOP.t1100 sky130_fd_pr__cap_mim_m3_1 l=3 w=3
X911 B10.t829 TOP.t5636 sky130_fd_pr__cap_mim_m3_1 l=3 w=3
X912 B9.t502 TOP.t18 sky130_fd_pr__cap_mim_m3_1 l=3 w=3
X913 B11.t440 TOP.t4238 sky130_fd_pr__cap_mim_m3_1 l=3 w=3
X914 B10.t67 TOP.t7160 sky130_fd_pr__cap_mim_m3_1 l=3 w=3
X915 B11.t1971 TOP.t1176 sky130_fd_pr__cap_mim_m3_1 l=3 w=3
X916 B11.t1535 TOP.t2048 sky130_fd_pr__cap_mim_m3_1 l=3 w=3
X917 B11.t157 TOP.t4804 sky130_fd_pr__cap_mim_m3_1 l=3 w=3
X918 B11.t514 TOP.t4090 sky130_fd_pr__cap_mim_m3_1 l=3 w=3
X919 B10.t791 TOP.t5712 sky130_fd_pr__cap_mim_m3_1 l=3 w=3
X920 B11.t65 TOP.t4988 sky130_fd_pr__cap_mim_m3_1 l=3 w=3
X921 B11.t455 TOP.t4208 sky130_fd_pr__cap_mim_m3_1 l=3 w=3
X922 B11.t1251 TOP.t2616 sky130_fd_pr__cap_mim_m3_1 l=3 w=3
X923 B11.t1057 TOP.t3004 sky130_fd_pr__cap_mim_m3_1 l=3 w=3
X924 B7.t33 TOP.t7996 sky130_fd_pr__cap_mim_m3_1 l=3 w=3
X925 B11.t756 TOP.t3606 sky130_fd_pr__cap_mim_m3_1 l=3 w=3
X926 B10.t753 TOP.t5788 sky130_fd_pr__cap_mim_m3_1 l=3 w=3
X927 B11.t718 TOP.t3682 sky130_fd_pr__cap_mim_m3_1 l=3 w=3
X928 B11.t1791 TOP.t1536 sky130_fd_pr__cap_mim_m3_1 l=3 w=3
X929 B10.t995 TOP.t5304 sky130_fd_pr__cap_mim_m3_1 l=3 w=3
X930 EDGE_BIAS.t249 EDGE_BIAS.t250 sky130_fd_pr__cap_mim_m3_1 l=3 w=3
X931 B11.t1200 TOP.t2718 sky130_fd_pr__cap_mim_m3_1 l=3 w=3
X932 B11.t345 TOP.t4428 sky130_fd_pr__cap_mim_m3_1 l=3 w=3
X933 B11.t366 TOP.t4386 sky130_fd_pr__cap_mim_m3_1 l=3 w=3
X934 B11.t1442 TOP.t2234 sky130_fd_pr__cap_mim_m3_1 l=3 w=3
X935 B7.t57 TOP.t7948 sky130_fd_pr__cap_mim_m3_1 l=3 w=3
X936 EDGE_BIAS.t78 EDGE_BIAS.t79 sky130_fd_pr__cap_mim_m3_1 l=3 w=3
X937 B11.t1404 TOP.t2310 sky130_fd_pr__cap_mim_m3_1 l=3 w=3
X938 B10.t660 TOP.t5974 sky130_fd_pr__cap_mim_m3_1 l=3 w=3
X939 B8.t218 TOP.t7370 sky130_fd_pr__cap_mim_m3_1 l=3 w=3
X940 B11.t1646 TOP.t1826 sky130_fd_pr__cap_mim_m3_1 l=3 w=3
X941 B9.t462 TOP.t98 sky130_fd_pr__cap_mim_m3_1 l=3 w=3
X942 B10.t27 TOP.t7240 sky130_fd_pr__cap_mim_m3_1 l=3 w=3
X943 B10.t622 TOP.t6050 sky130_fd_pr__cap_mim_m3_1 l=3 w=3
X944 B8.t180 TOP.t7446 sky130_fd_pr__cap_mim_m3_1 l=3 w=3
X945 B11.t101 TOP.t4916 sky130_fd_pr__cap_mim_m3_1 l=3 w=3
X946 B11.t1224 TOP.t2670 sky130_fd_pr__cap_mim_m3_1 l=3 w=3
X947 B9.t424 TOP.t174 sky130_fd_pr__cap_mim_m3_1 l=3 w=3
X948 B11.t420 TOP.t4278 sky130_fd_pr__cap_mim_m3_1 l=3 w=3
X949 B11.t1827 TOP.t1464 sky130_fd_pr__cap_mim_m3_1 l=3 w=3
X950 B9.t51 TOP.t920 sky130_fd_pr__cap_mim_m3_1 l=3 w=3
X951 EDGE_BIAS.t6 EDGE_BIAS.t7 sky130_fd_pr__cap_mim_m3_1 l=3 w=3
X952 B11.t1751 TOP.t1616 sky130_fd_pr__cap_mim_m3_1 l=3 w=3
X953 B11.t190 TOP.t4738 sky130_fd_pr__cap_mim_m3_1 l=3 w=3
X954 B11.t1993 TOP.t1132 sky130_fd_pr__cap_mim_m3_1 l=3 w=3
X955 B10.t851 TOP.t5592 sky130_fd_pr__cap_mim_m3_1 l=3 w=3
X956 B11.t1713 TOP.t1692 sky130_fd_pr__cap_mim_m3_1 l=3 w=3
X957 B11.t1117 TOP.t2884 sky130_fd_pr__cap_mim_m3_1 l=3 w=3
X958 B6.t29 TOP.t5188 sky130_fd_pr__cap_mim_m3_1 l=3 w=3
X959 B11.t1955 TOP.t1208 sky130_fd_pr__cap_mim_m3_1 l=3 w=3
X960 B11.t1519 TOP.t2080 sky130_fd_pr__cap_mim_m3_1 l=3 w=3
X961 B10.t813 TOP.t5668 sky130_fd_pr__cap_mim_m3_1 l=3 w=3
X962 B9.t511 TOP.t0 sky130_fd_pr__cap_mim_m3_1 l=3 w=3
X963 B11.t1079 TOP.t2960 sky130_fd_pr__cap_mim_m3_1 l=3 w=3
X964 B7.t86 TOP.t7890 sky130_fd_pr__cap_mim_m3_1 l=3 w=3
X965 B11.t218 TOP.t4682 sky130_fd_pr__cap_mim_m3_1 l=3 w=3
X966 EDGE_BIAS.t771 EDGE_BIAS.t772 sky130_fd_pr__cap_mim_m3_1 l=3 w=3
X967 B7.t17 TOP.t8028 sky130_fd_pr__cap_mim_m3_1 l=3 w=3
X968 B9.t118 TOP.t786 sky130_fd_pr__cap_mim_m3_1 l=3 w=3
X969 B11.t15 TOP.t5088 sky130_fd_pr__cap_mim_m3_1 l=3 w=3
X970 B11.t702 TOP.t3714 sky130_fd_pr__cap_mim_m3_1 l=3 w=3
X971 B8.t106 TOP.t7594 sky130_fd_pr__cap_mim_m3_1 l=3 w=3
X972 B11.t992 TOP.t3134 sky130_fd_pr__cap_mim_m3_1 l=3 w=3
X973 B11.t1543 TOP.t2032 sky130_fd_pr__cap_mim_m3_1 l=3 w=3
X974 B11.t1979 TOP.t1160 sky130_fd_pr__cap_mim_m3_1 l=3 w=3
X975 B11.t1184 TOP.t2750 sky130_fd_pr__cap_mim_m3_1 l=3 w=3
X976 B11.t1426 TOP.t2266 sky130_fd_pr__cap_mim_m3_1 l=3 w=3
X977 B10.t526 TOP.t6242 sky130_fd_pr__cap_mim_m3_1 l=3 w=3
X978 B10.t446 TOP.t6402 sky130_fd_pr__cap_mim_m3_1 l=3 w=3
X979 B11.t1388 TOP.t2342 sky130_fd_pr__cap_mim_m3_1 l=3 w=3
X980 B8.t240 TOP.t7326 sky130_fd_pr__cap_mim_m3_1 l=3 w=3
X981 B11.t134 TOP.t4850 sky130_fd_pr__cap_mim_m3_1 l=3 w=3
X982 B11.t1630 TOP.t1858 sky130_fd_pr__cap_mim_m3_1 l=3 w=3
X983 B10.t1018 TOP.t5258 sky130_fd_pr__cap_mim_m3_1 l=3 w=3
X984 B9.t484 TOP.t54 sky130_fd_pr__cap_mim_m3_1 l=3 w=3
X985 B11.t453 TOP.t4212 sky130_fd_pr__cap_mim_m3_1 l=3 w=3
X986 B11.t1156 TOP.t2806 sky130_fd_pr__cap_mim_m3_1 l=3 w=3
X987 B5.t5 TOP.t8118 sky130_fd_pr__cap_mim_m3_1 l=3 w=3
X988 B11.t55 TOP.t5008 sky130_fd_pr__cap_mim_m3_1 l=3 w=3
X989 B10.t11 TOP.t7272 sky130_fd_pr__cap_mim_m3_1 l=3 w=3
X990 B11.t1592 TOP.t1934 sky130_fd_pr__cap_mim_m3_1 l=3 w=3
X991 B11.t1811 TOP.t1496 sky130_fd_pr__cap_mim_m3_1 l=3 w=3
X992 B10.t301 TOP.t6692 sky130_fd_pr__cap_mim_m3_1 l=3 w=3
X993 B9.t35 TOP.t952 sky130_fd_pr__cap_mim_m3_1 l=3 w=3
X994 B11.t1773 TOP.t1572 sky130_fd_pr__cap_mim_m3_1 l=3 w=3
X995 B11.t1735 TOP.t1648 sky130_fd_pr__cap_mim_m3_1 l=3 w=3
X996 B11.t1412 TOP.t2294 sky130_fd_pr__cap_mim_m3_1 l=3 w=3
X997 B11.t343 TOP.t4432 sky130_fd_pr__cap_mim_m3_1 l=3 w=3
X998 B10.t835 TOP.t5624 sky130_fd_pr__cap_mim_m3_1 l=3 w=3
X999 B11.t1697 TOP.t1724 sky130_fd_pr__cap_mim_m3_1 l=3 w=3
X1000 EDGE_BIAS.t282 EDGE_BIAS.t283 sky130_fd_pr__cap_mim_m3_1 l=3 w=3
X1001 B9.t130 TOP.t762 sky130_fd_pr__cap_mim_m3_1 l=3 w=3
X1002 B11.t879 TOP.t3360 sky130_fd_pr__cap_mim_m3_1 l=3 w=3
X1003 B11.t1939 TOP.t1240 sky130_fd_pr__cap_mim_m3_1 l=3 w=3
X1004 B10.t797 TOP.t5700 sky130_fd_pr__cap_mim_m3_1 l=3 w=3
X1005 B11.t1063 TOP.t2992 sky130_fd_pr__cap_mim_m3_1 l=3 w=3
X1006 B7.t39 TOP.t7984 sky130_fd_pr__cap_mim_m3_1 l=3 w=3
X1007 B11.t1901 TOP.t1316 sky130_fd_pr__cap_mim_m3_1 l=3 w=3
X1008 B10.t565 TOP.t6164 sky130_fd_pr__cap_mim_m3_1 l=3 w=3
X1009 B10.t406 TOP.t6482 sky130_fd_pr__cap_mim_m3_1 l=3 w=3
X1010 B11.t489 TOP.t4140 sky130_fd_pr__cap_mim_m3_1 l=3 w=3
X1011 B10.t1001 TOP.t5292 sky130_fd_pr__cap_mim_m3_1 l=3 w=3
X1012 B11.t99 TOP.t4920 sky130_fd_pr__cap_mim_m3_1 l=3 w=3
X1013 B11.t78 TOP.t4962 sky130_fd_pr__cap_mim_m3_1 l=3 w=3
X1014 B11.t397 TOP.t4324 sky130_fd_pr__cap_mim_m3_1 l=3 w=3
X1015 B11.t976 TOP.t3166 sky130_fd_pr__cap_mim_m3_1 l=3 w=3
X1016 B10.t368 TOP.t6558 sky130_fd_pr__cap_mim_m3_1 l=3 w=3
X1017 B11.t1206 TOP.t2706 sky130_fd_pr__cap_mim_m3_1 l=3 w=3
X1018 B11.t259 TOP.t4600 sky130_fd_pr__cap_mim_m3_1 l=3 w=3
X1019 B11.t1168 TOP.t2782 sky130_fd_pr__cap_mim_m3_1 l=3 w=3
X1020 B10.t821 TOP.t5652 sky130_fd_pr__cap_mim_m3_1 l=3 w=3
X1021 B11.t184 TOP.t4750 sky130_fd_pr__cap_mim_m3_1 l=3 w=3
X1022 B11.t1850 TOP.t1418 sky130_fd_pr__cap_mim_m3_1 l=3 w=3
X1023 EDGE_BIAS.t60 EDGE_BIAS.t61 sky130_fd_pr__cap_mim_m3_1 l=3 w=3
X1024 EDGE_BIAS.t336 EDGE_BIAS.t337 sky130_fd_pr__cap_mim_m3_1 l=3 w=3
X1025 B11.t748 TOP.t3622 sky130_fd_pr__cap_mim_m3_1 l=3 w=3
X1026 B10.t71 TOP.t7152 sky130_fd_pr__cap_mim_m3_1 l=3 w=3
X1027 B11.t1372 TOP.t2374 sky130_fd_pr__cap_mim_m3_1 l=3 w=3
X1028 B8.t224 TOP.t7358 sky130_fd_pr__cap_mim_m3_1 l=3 w=3
X1029 B11.t287 TOP.t4544 sky130_fd_pr__cap_mim_m3_1 l=3 w=3
X1030 B11.t1614 TOP.t1890 sky130_fd_pr__cap_mim_m3_1 l=3 w=3
X1031 B9.t468 TOP.t86 sky130_fd_pr__cap_mim_m3_1 l=3 w=3
X1032 B10.t33 TOP.t7228 sky130_fd_pr__cap_mim_m3_1 l=3 w=3
X1033 B11.t1334 TOP.t2450 sky130_fd_pr__cap_mim_m3_1 l=3 w=3
X1034 B11.t1140 TOP.t2838 sky130_fd_pr__cap_mim_m3_1 l=3 w=3
X1035 B3.t1 TOP.t8142 sky130_fd_pr__cap_mim_m3_1 l=3 w=3
X1036 B11.t839 TOP.t3440 sky130_fd_pr__cap_mim_m3_1 l=3 w=3
X1037 B11.t1576 TOP.t1966 sky130_fd_pr__cap_mim_m3_1 l=3 w=3
X1038 B9.t430 TOP.t162 sky130_fd_pr__cap_mim_m3_1 l=3 w=3
X1039 B11.t27 TOP.t5064 sky130_fd_pr__cap_mim_m3_1 l=3 w=3
X1040 EDGE_BIAS.t219 EDGE_BIAS.t220 sky130_fd_pr__cap_mim_m3_1 l=3 w=3
X1041 B11.t801 TOP.t3516 sky130_fd_pr__cap_mim_m3_1 l=3 w=3
X1042 B11.t1757 TOP.t1604 sky130_fd_pr__cap_mim_m3_1 l=3 w=3
X1043 B8.t248 TOP.t7310 sky130_fd_pr__cap_mim_m3_1 l=3 w=3
X1044 B11.t1999 TOP.t1120 sky130_fd_pr__cap_mim_m3_1 l=3 w=3
X1045 B11.t188 TOP.t4742 sky130_fd_pr__cap_mim_m3_1 l=3 w=3
X1046 B11.t1719 TOP.t1680 sky130_fd_pr__cap_mim_m3_1 l=3 w=3
X1047 B11.t1525 TOP.t2068 sky130_fd_pr__cap_mim_m3_1 l=3 w=3
X1048 EDGE_BIAS.t753 EDGE_BIAS.t754 sky130_fd_pr__cap_mim_m3_1 l=3 w=3
X1049 B11.t1961 TOP.t1196 sky130_fd_pr__cap_mim_m3_1 l=3 w=3
X1050 B11.t203 TOP.t4712 sky130_fd_pr__cap_mim_m3_1 l=3 w=3
X1051 B11.t504 TOP.t4110 sky130_fd_pr__cap_mim_m3_1 l=3 w=3
X1052 B10.t781 TOP.t5732 sky130_fd_pr__cap_mim_m3_1 l=3 w=3
X1053 B11.t1047 TOP.t3024 sky130_fd_pr__cap_mim_m3_1 l=3 w=3
X1054 B7.t23 TOP.t8016 sky130_fd_pr__cap_mim_m3_1 l=3 w=3
X1055 B10.t743 TOP.t5808 sky130_fd_pr__cap_mim_m3_1 l=3 w=3
X1056 B10.t549 TOP.t6196 sky130_fd_pr__cap_mim_m3_1 l=3 w=3
X1057 EDGE_BIAS.t669 EDGE_BIAS.t670 sky130_fd_pr__cap_mim_m3_1 l=3 w=3
X1058 B11.t708 TOP.t3702 sky130_fd_pr__cap_mim_m3_1 l=3 w=3
X1059 B10.t390 TOP.t6514 sky130_fd_pr__cap_mim_m3_1 l=3 w=3
X1060 B10.t985 TOP.t5324 sky130_fd_pr__cap_mim_m3_1 l=3 w=3
X1061 B8.t112 TOP.t7582 sky130_fd_pr__cap_mim_m3_1 l=3 w=3
X1062 B11.t309 TOP.t4500 sky130_fd_pr__cap_mim_m3_1 l=3 w=3
X1063 B10.t352 TOP.t6590 sky130_fd_pr__cap_mim_m3_1 l=3 w=3
X1064 B11.t1190 TOP.t2738 sky130_fd_pr__cap_mim_m3_1 l=3 w=3
X1065 B11.t1432 TOP.t2254 sky130_fd_pr__cap_mim_m3_1 l=3 w=3
X1066 B11.t1834 TOP.t1450 sky130_fd_pr__cap_mim_m3_1 l=3 w=3
X1067 B9.t317 TOP.t388 sky130_fd_pr__cap_mim_m3_1 l=3 w=3
X1068 EDGE_BIAS.t108 EDGE_BIAS.t109 sky130_fd_pr__cap_mim_m3_1 l=3 w=3
X1069 B11.t1394 TOP.t2330 sky130_fd_pr__cap_mim_m3_1 l=3 w=3
X1070 B8.t208 TOP.t7390 sky130_fd_pr__cap_mim_m3_1 l=3 w=3
X1071 B11.t2038 TOP.t1042 sky130_fd_pr__cap_mim_m3_1 l=3 w=3
X1072 B9.t452 TOP.t118 sky130_fd_pr__cap_mim_m3_1 l=3 w=3
X1073 B8.t170 TOP.t7466 sky130_fd_pr__cap_mim_m3_1 l=3 w=3
X1074 B11.t168 TOP.t4782 sky130_fd_pr__cap_mim_m3_1 l=3 w=3
X1075 B10.t17 TOP.t7260 sky130_fd_pr__cap_mim_m3_1 l=3 w=3
X1076 B11.t823 TOP.t3472 sky130_fd_pr__cap_mim_m3_1 l=3 w=3
X1077 B10.t307 TOP.t6680 sky130_fd_pr__cap_mim_m3_1 l=3 w=3
X1078 B9.t414 TOP.t194 sky130_fd_pr__cap_mim_m3_1 l=3 w=3
X1079 B11.t466 TOP.t4186 sky130_fd_pr__cap_mim_m3_1 l=3 w=3
X1080 B11.t785 TOP.t3548 sky130_fd_pr__cap_mim_m3_1 l=3 w=3
X1081 B11.t1858 TOP.t1402 sky130_fd_pr__cap_mim_m3_1 l=3 w=3
X1082 B11.t328 TOP.t4462 sky130_fd_pr__cap_mim_m3_1 l=3 w=3
X1083 EDGE_BIAS.t603 EDGE_BIAS.t604 sky130_fd_pr__cap_mim_m3_1 l=3 w=3
X1084 B11.t6 TOP.t5106 sky130_fd_pr__cap_mim_m3_1 l=3 w=3
X1085 B11.t1741 TOP.t1636 sky130_fd_pr__cap_mim_m3_1 l=3 w=3
X1086 B11.t747 TOP.t3624 sky130_fd_pr__cap_mim_m3_1 l=3 w=3
X1087 B10.t841 TOP.t5612 sky130_fd_pr__cap_mim_m3_1 l=3 w=3
X1088 B9.t253 TOP.t516 sky130_fd_pr__cap_mim_m3_1 l=3 w=3
X1089 EDGE_BIAS.t198 EDGE_BIAS.t199 sky130_fd_pr__cap_mim_m3_1 l=3 w=3
X1090 B11.t1703 TOP.t1712 sky130_fd_pr__cap_mim_m3_1 l=3 w=3
X1091 B11.t1509 TOP.t2100 sky130_fd_pr__cap_mim_m3_1 l=3 w=3
X1092 B11.t1945 TOP.t1228 sky130_fd_pr__cap_mim_m3_1 l=3 w=3
X1093 B10.t803 TOP.t5688 sky130_fd_pr__cap_mim_m3_1 l=3 w=3
X1094 B11.t44 TOP.t5030 sky130_fd_pr__cap_mim_m3_1 l=3 w=3
X1095 B11.t1471 TOP.t2176 sky130_fd_pr__cap_mim_m3_1 l=3 w=3
X1096 B9.t277 TOP.t468 sky130_fd_pr__cap_mim_m3_1 l=3 w=3
X1097 B7.t7 TOP.t8048 sky130_fd_pr__cap_mim_m3_1 l=3 w=3
X1098 B11.t84 TOP.t4950 sky130_fd_pr__cap_mim_m3_1 l=3 w=3
X1099 B11.t1907 TOP.t1304 sky130_fd_pr__cap_mim_m3_1 l=3 w=3
X1100 B9.t108 TOP.t806 sky130_fd_pr__cap_mim_m3_1 l=3 w=3
X1101 B8.t96 TOP.t7614 sky130_fd_pr__cap_mim_m3_1 l=3 w=3
X1102 B10.t3 TOP.t7288 sky130_fd_pr__cap_mim_m3_1 l=3 w=3
X1103 B11.t1727 TOP.t1664 sky130_fd_pr__cap_mim_m3_1 l=3 w=3
X1104 B11.t112 TOP.t4894 sky130_fd_pr__cap_mim_m3_1 l=3 w=3
X1105 B11.t431 TOP.t4256 sky130_fd_pr__cap_mim_m3_1 l=3 w=3
X1106 B11.t1174 TOP.t2770 sky130_fd_pr__cap_mim_m3_1 l=3 w=3
X1107 B5.t31 TOP.t8066 sky130_fd_pr__cap_mim_m3_1 l=3 w=3
X1108 B10.t194 TOP.t6906 sky130_fd_pr__cap_mim_m3_1 l=3 w=3
X1109 EDGE_BIAS.t252 EDGE_BIAS.t253 sky130_fd_pr__cap_mim_m3_1 l=3 w=3
X1110 B11.t293 TOP.t4532 sky130_fd_pr__cap_mim_m3_1 l=3 w=3
X1111 EDGE_BIAS.t42 EDGE_BIAS.t43 sky130_fd_pr__cap_mim_m3_1 l=3 w=3
X1112 EDGE_BIAS.t156 EDGE_BIAS.t157 sky130_fd_pr__cap_mim_m3_1 l=3 w=3
X1113 B11.t1378 TOP.t2362 sky130_fd_pr__cap_mim_m3_1 l=3 w=3
X1114 B8.t230 TOP.t7346 sky130_fd_pr__cap_mim_m3_1 l=3 w=3
X1115 B11.t201 TOP.t4716 sky130_fd_pr__cap_mim_m3_1 l=3 w=3
X1116 B9.t213 TOP.t596 sky130_fd_pr__cap_mim_m3_1 l=3 w=3
X1117 B11.t2022 TOP.t1074 sky130_fd_pr__cap_mim_m3_1 l=3 w=3
X1118 B10.t880 TOP.t5534 sky130_fd_pr__cap_mim_m3_1 l=3 w=3
X1119 B11.t1340 TOP.t2438 sky130_fd_pr__cap_mim_m3_1 l=3 w=3
X1120 B11.t1146 TOP.t2826 sky130_fd_pr__cap_mim_m3_1 l=3 w=3
X1121 B4.t3 TOP.t8176 sky130_fd_pr__cap_mim_m3_1 l=3 w=3
X1122 B9.t175 TOP.t672 sky130_fd_pr__cap_mim_m3_1 l=3 w=3
X1123 B10.t291 TOP.t6712 sky130_fd_pr__cap_mim_m3_1 l=3 w=3
X1124 B9.t25 TOP.t972 sky130_fd_pr__cap_mim_m3_1 l=3 w=3
X1125 B10.t495 TOP.t6304 sky130_fd_pr__cap_mim_m3_1 l=3 w=3
X1126 B11.t627 TOP.t3864 sky130_fd_pr__cap_mim_m3_1 l=3 w=3
X1127 B11.t1687 TOP.t1744 sky130_fd_pr__cap_mim_m3_1 l=3 w=3
X1128 B11.t1531 TOP.t2056 sky130_fd_pr__cap_mim_m3_1 l=3 w=3
X1129 EDGE_BIAS.t306 EDGE_BIAS.t307 sky130_fd_pr__cap_mim_m3_1 l=3 w=3
X1130 B10.t63 TOP.t7168 sky130_fd_pr__cap_mim_m3_1 l=3 w=3
X1131 B11.t1493 TOP.t2132 sky130_fd_pr__cap_mim_m3_1 l=3 w=3
X1132 B11.t1929 TOP.t1260 sky130_fd_pr__cap_mim_m3_1 l=3 w=3
X1133 B10.t787 TOP.t5720 sky130_fd_pr__cap_mim_m3_1 l=3 w=3
X1134 B9.t261 TOP.t500 sky130_fd_pr__cap_mim_m3_1 l=3 w=3
X1135 B10.t154 TOP.t6986 sky130_fd_pr__cap_mim_m3_1 l=3 w=3
X1136 B11.t1455 TOP.t2208 sky130_fd_pr__cap_mim_m3_1 l=3 w=3
X1137 B10.t749 TOP.t5796 sky130_fd_pr__cap_mim_m3_1 l=3 w=3
X1138 B11.t237 TOP.t4644 sky130_fd_pr__cap_mim_m3_1 l=3 w=3
X1139 B11.t1891 TOP.t1336 sky130_fd_pr__cap_mim_m3_1 l=3 w=3
X1140 B10.t555 TOP.t6184 sky130_fd_pr__cap_mim_m3_1 l=3 w=3
X1141 B11.t23 TOP.t5072 sky130_fd_pr__cap_mim_m3_1 l=3 w=3
X1142 B10.t396 TOP.t6502 sky130_fd_pr__cap_mim_m3_1 l=3 w=3
X1143 B11.t145 TOP.t4828 sky130_fd_pr__cap_mim_m3_1 l=3 w=3
X1144 B10.t116 TOP.t7062 sky130_fd_pr__cap_mim_m3_1 l=3 w=3
X1145 B11.t966 TOP.t3186 sky130_fd_pr__cap_mim_m3_1 l=3 w=3
X1146 B10.t358 TOP.t6578 sky130_fd_pr__cap_mim_m3_1 l=3 w=3
X1147 B11.t1659 TOP.t1800 sky130_fd_pr__cap_mim_m3_1 l=3 w=3
X1148 B11.t326 TOP.t4466 sky130_fd_pr__cap_mim_m3_1 l=3 w=3
X1149 B11.t928 TOP.t3262 sky130_fd_pr__cap_mim_m3_1 l=3 w=3
X1150 B11.t1840 TOP.t1438 sky130_fd_pr__cap_mim_m3_1 l=3 w=3
X1151 EDGE_BIAS.t90 EDGE_BIAS.t91 sky130_fd_pr__cap_mim_m3_1 l=3 w=3
X1152 B8.t214 TOP.t7378 sky130_fd_pr__cap_mim_m3_1 l=3 w=3
X1153 B11.t1362 TOP.t2394 sky130_fd_pr__cap_mim_m3_1 l=3 w=3
X1154 B9.t197 TOP.t628 sky130_fd_pr__cap_mim_m3_1 l=3 w=3
X1155 B11.t587 TOP.t3944 sky130_fd_pr__cap_mim_m3_1 l=3 w=3
X1156 B10.t382 TOP.t6530 sky130_fd_pr__cap_mim_m3_1 l=3 w=3
X1157 B11.t1324 TOP.t2470 sky130_fd_pr__cap_mim_m3_1 l=3 w=3
X1158 B10.t864 TOP.t5566 sky130_fd_pr__cap_mim_m3_1 l=3 w=3
X1159 B8.t176 TOP.t7454 sky130_fd_pr__cap_mim_m3_1 l=3 w=3
X1160 EDGE_BIAS.t573 EDGE_BIAS.t574 sky130_fd_pr__cap_mim_m3_1 l=3 w=3
X1161 B11.t472 TOP.t4174 sky130_fd_pr__cap_mim_m3_1 l=3 w=3
X1162 B11.t829 TOP.t3460 sky130_fd_pr__cap_mim_m3_1 l=3 w=3
X1163 B10.t23 TOP.t7248 sky130_fd_pr__cap_mim_m3_1 l=3 w=3
X1164 B11.t1130 TOP.t2858 sky130_fd_pr__cap_mim_m3_1 l=3 w=3
X1165 B11.t1566 TOP.t1986 sky130_fd_pr__cap_mim_m3_1 l=3 w=3
X1166 B9.t159 TOP.t704 sky130_fd_pr__cap_mim_m3_1 l=3 w=3
X1167 B11.t380 TOP.t4358 sky130_fd_pr__cap_mim_m3_1 l=3 w=3
X1168 B11.t549 TOP.t4020 sky130_fd_pr__cap_mim_m3_1 l=3 w=3
X1169 B11.t791 TOP.t3536 sky130_fd_pr__cap_mim_m3_1 l=3 w=3
X1170 B11.t1092 TOP.t2934 sky130_fd_pr__cap_mim_m3_1 l=3 w=3
X1171 EDGE_BIAS.t18 EDGE_BIAS.t19 sky130_fd_pr__cap_mim_m3_1 l=3 w=3
X1172 B11.t1747 TOP.t1624 sky130_fd_pr__cap_mim_m3_1 l=3 w=3
X1173 B10.t636 TOP.t6022 sky130_fd_pr__cap_mim_m3_1 l=3 w=3
X1174 B11.t362 TOP.t4394 sky130_fd_pr__cap_mim_m3_1 l=3 w=3
X1175 B11.t1709 TOP.t1700 sky130_fd_pr__cap_mim_m3_1 l=3 w=3
X1176 B11.t1515 TOP.t2088 sky130_fd_pr__cap_mim_m3_1 l=3 w=3
X1177 B11.t270 TOP.t4578 sky130_fd_pr__cap_mim_m3_1 l=3 w=3
X1178 B10.t771 TOP.t5752 sky130_fd_pr__cap_mim_m3_1 l=3 w=3
X1179 B11.t815 TOP.t3488 sky130_fd_pr__cap_mim_m3_1 l=3 w=3
X1180 B10.t138 TOP.t7018 sky130_fd_pr__cap_mim_m3_1 l=3 w=3
X1181 B10.t733 TOP.t5828 sky130_fd_pr__cap_mim_m3_1 l=3 w=3
X1182 B9.t114 TOP.t794 sky130_fd_pr__cap_mim_m3_1 l=3 w=3
X1183 B10.t539 TOP.t6216 sky130_fd_pr__cap_mim_m3_1 l=3 w=3
X1184 B11.t376 TOP.t4366 sky130_fd_pr__cap_mim_m3_1 l=3 w=3
X1185 B11.t698 TOP.t3722 sky130_fd_pr__cap_mim_m3_1 l=3 w=3
X1186 B10.t975 TOP.t5344 sky130_fd_pr__cap_mim_m3_1 l=3 w=3
X1187 B10.t100 TOP.t7094 sky130_fd_pr__cap_mim_m3_1 l=3 w=3
X1188 B10.t342 TOP.t6610 sky130_fd_pr__cap_mim_m3_1 l=3 w=3
X1189 B10.t937 TOP.t5420 sky130_fd_pr__cap_mim_m3_1 l=3 w=3
X1190 B9.t497 TOP.t28 sky130_fd_pr__cap_mim_m3_1 l=3 w=3
X1191 B11.t416 TOP.t4286 sky130_fd_pr__cap_mim_m3_1 l=3 w=3
X1192 B11.t1539 TOP.t2040 sky130_fd_pr__cap_mim_m3_1 l=3 w=3
X1193 B10.t62 TOP.t7170 sky130_fd_pr__cap_mim_m3_1 l=3 w=3
X1194 B11.t1180 TOP.t2758 sky130_fd_pr__cap_mim_m3_1 l=3 w=3
X1195 B11.t1824 TOP.t1470 sky130_fd_pr__cap_mim_m3_1 l=3 w=3
X1196 EDGE_BIAS.t138 EDGE_BIAS.t139 sky130_fd_pr__cap_mim_m3_1 l=3 w=3
X1197 B10.t596 TOP.t6102 sky130_fd_pr__cap_mim_m3_1 l=3 w=3
X1198 B8.t198 TOP.t7410 sky130_fd_pr__cap_mim_m3_1 l=3 w=3
X1199 B11.t40 TOP.t5038 sky130_fd_pr__cap_mim_m3_1 l=3 w=3
X1200 B11.t1786 TOP.t1546 sky130_fd_pr__cap_mim_m3_1 l=3 w=3
X1201 B11.t2028 TOP.t1062 sky130_fd_pr__cap_mim_m3_1 l=3 w=3
X1202 EDGE_BIAS.t720 EDGE_BIAS.t721 sky130_fd_pr__cap_mim_m3_1 l=3 w=3
X1203 B11.t571 TOP.t3976 sky130_fd_pr__cap_mim_m3_1 l=3 w=3
X1204 B11.t1152 TOP.t2814 sky130_fd_pr__cap_mim_m3_1 l=3 w=3
X1205 B8.t160 TOP.t7486 sky130_fd_pr__cap_mim_m3_1 l=3 w=3
X1206 B11.t214 TOP.t4690 sky130_fd_pr__cap_mim_m3_1 l=3 w=3
X1207 B11.t1008 TOP.t3102 sky130_fd_pr__cap_mim_m3_1 l=3 w=3
X1208 EDGE_BIAS.t3 EDGE_BIAS.t4 sky130_fd_pr__cap_mim_m3_1 l=3 w=3
X1209 B9.t404 TOP.t214 sky130_fd_pr__cap_mim_m3_1 l=3 w=3
X1210 B11.t533 TOP.t4052 sky130_fd_pr__cap_mim_m3_1 l=3 w=3
X1211 B11.t775 TOP.t3568 sky130_fd_pr__cap_mim_m3_1 l=3 w=3
X1212 B9.t366 TOP.t290 sky130_fd_pr__cap_mim_m3_1 l=3 w=3
X1213 B7.t52 TOP.t7958 sky130_fd_pr__cap_mim_m3_1 l=3 w=3
X1214 EDGE_BIAS.t636 EDGE_BIAS.t637 sky130_fd_pr__cap_mim_m3_1 l=3 w=3
X1215 EDGE_BIAS.t222 EDGE_BIAS.t223 sky130_fd_pr__cap_mim_m3_1 l=3 w=3
X1216 B11.t737 TOP.t3644 sky130_fd_pr__cap_mim_m3_1 l=3 w=3
X1217 B11.t1693 TOP.t1732 sky130_fd_pr__cap_mim_m3_1 l=3 w=3
X1218 B11.t1499 TOP.t2120 sky130_fd_pr__cap_mim_m3_1 l=3 w=3
X1219 B11.t1219 TOP.t2680 sky130_fd_pr__cap_mim_m3_1 l=3 w=3
X1220 B9.t267 TOP.t488 sky130_fd_pr__cap_mim_m3_1 l=3 w=3
X1221 B11.t1461 TOP.t2196 sky130_fd_pr__cap_mim_m3_1 l=3 w=3
X1222 B10.t561 TOP.t6172 sky130_fd_pr__cap_mim_m3_1 l=3 w=3
X1223 B9.t98 TOP.t826 sky130_fd_pr__cap_mim_m3_1 l=3 w=3
X1224 B11.t449 TOP.t4220 sky130_fd_pr__cap_mim_m3_1 l=3 w=3
X1225 B10.t1023 TOP.t5248 sky130_fd_pr__cap_mim_m3_1 l=3 w=3
X1226 B8.t86 TOP.t7634 sky130_fd_pr__cap_mim_m3_1 l=3 w=3
X1227 B10.t326 TOP.t6642 sky130_fd_pr__cap_mim_m3_1 l=3 w=3
X1228 B8.t48 TOP.t7710 sky130_fd_pr__cap_mim_m3_1 l=3 w=3
X1229 B11.t179 TOP.t4760 sky130_fd_pr__cap_mim_m3_1 l=3 w=3
X1230 EDGE_BIAS.t276 EDGE_BIAS.t277 sky130_fd_pr__cap_mim_m3_1 l=3 w=3
X1231 B11.t1846 TOP.t1426 sky130_fd_pr__cap_mim_m3_1 l=3 w=3
X1232 EDGE_BIAS.t72 EDGE_BIAS.t73 sky130_fd_pr__cap_mim_m3_1 l=3 w=3
X1233 B11.t1808 TOP.t1502 sky130_fd_pr__cap_mim_m3_1 l=3 w=3
X1234 B11.t339 TOP.t4440 sky130_fd_pr__cap_mim_m3_1 l=3 w=3
X1235 EDGE_BIAS.t186 EDGE_BIAS.t187 sky130_fd_pr__cap_mim_m3_1 l=3 w=3
X1236 B11.t1770 TOP.t1578 sky130_fd_pr__cap_mim_m3_1 l=3 w=3
X1237 B10.t580 TOP.t6134 sky130_fd_pr__cap_mim_m3_1 l=3 w=3
X1238 B9.t203 TOP.t616 sky130_fd_pr__cap_mim_m3_1 l=3 w=3
X1239 B11.t2012 TOP.t1094 sky130_fd_pr__cap_mim_m3_1 l=3 w=3
X1240 B10.t870 TOP.t5554 sky130_fd_pr__cap_mim_m3_1 l=3 w=3
X1241 B11.t1136 TOP.t2846 sky130_fd_pr__cap_mim_m3_1 l=3 w=3
X1242 B1.t0 TOP.t8148 sky130_fd_pr__cap_mim_m3_1 l=3 w=3
X1243 B9.t165 TOP.t692 sky130_fd_pr__cap_mim_m3_1 l=3 w=3
X1244 B10.t281 TOP.t6732 sky130_fd_pr__cap_mim_m3_1 l=3 w=3
X1245 B11.t1974 TOP.t1170 sky130_fd_pr__cap_mim_m3_1 l=3 w=3
X1246 B11.t95 TOP.t4928 sky130_fd_pr__cap_mim_m3_1 l=3 w=3
X1247 B11.t759 TOP.t3600 sky130_fd_pr__cap_mim_m3_1 l=3 w=3
X1248 B11.t393 TOP.t4332 sky130_fd_pr__cap_mim_m3_1 l=3 w=3
X1249 B11.t414 TOP.t4290 sky130_fd_pr__cap_mim_m3_1 l=3 w=3
X1250 B10.t243 TOP.t6808 sky130_fd_pr__cap_mim_m3_1 l=3 w=3
X1251 B11.t721 TOP.t3676 sky130_fd_pr__cap_mim_m3_1 l=3 w=3
X1252 B11.t1677 TOP.t1764 sky130_fd_pr__cap_mim_m3_1 l=3 w=3
X1253 B11.t1521 TOP.t2076 sky130_fd_pr__cap_mim_m3_1 l=3 w=3
X1254 B11.t1483 TOP.t2152 sky130_fd_pr__cap_mim_m3_1 l=3 w=3
X1255 B11.t1160 TOP.t2798 sky130_fd_pr__cap_mim_m3_1 l=3 w=3
X1256 B11.t499 TOP.t4120 sky130_fd_pr__cap_mim_m3_1 l=3 w=3
X1257 B11.t1203 TOP.t2712 sky130_fd_pr__cap_mim_m3_1 l=3 w=3
X1258 B9.t189 TOP.t644 sky130_fd_pr__cap_mim_m3_1 l=3 w=3
X1259 B11.t52 TOP.t5014 sky130_fd_pr__cap_mim_m3_1 l=3 w=3
X1260 B11.t304 TOP.t4510 sky130_fd_pr__cap_mim_m3_1 l=3 w=3
X1261 B10.t144 TOP.t7006 sky130_fd_pr__cap_mim_m3_1 l=3 w=3
X1262 B11.t1881 TOP.t1356 sky130_fd_pr__cap_mim_m3_1 l=3 w=3
X1263 B11.t1445 TOP.t2228 sky130_fd_pr__cap_mim_m3_1 l=3 w=3
X1264 B10.t386 TOP.t6522 sky130_fd_pr__cap_mim_m3_1 l=3 w=3
X1265 B10.t545 TOP.t6204 sky130_fd_pr__cap_mim_m3_1 l=3 w=3
X1266 B11.t1407 TOP.t2304 sky130_fd_pr__cap_mim_m3_1 l=3 w=3
X1267 B10.t106 TOP.t7082 sky130_fd_pr__cap_mim_m3_1 l=3 w=3
X1268 B10.t348 TOP.t6598 sky130_fd_pr__cap_mim_m3_1 l=3 w=3
X1269 B11.t1649 TOP.t1820 sky130_fd_pr__cap_mim_m3_1 l=3 w=3
X1270 B11.t676 TOP.t3766 sky130_fd_pr__cap_mim_m3_1 l=3 w=3
X1271 B11.t1830 TOP.t1458 sky130_fd_pr__cap_mim_m3_1 l=3 w=3
X1272 EDGE_BIAS.t120 EDGE_BIAS.t121 sky130_fd_pr__cap_mim_m3_1 l=3 w=3
X1273 B10.t569 TOP.t6156 sky130_fd_pr__cap_mim_m3_1 l=3 w=3
X1274 B11.t503 TOP.t4112 sky130_fd_pr__cap_mim_m3_1 l=3 w=3
X1275 B11.t220 TOP.t4678 sky130_fd_pr__cap_mim_m3_1 l=3 w=3
X1276 B10.t130 TOP.t7034 sky130_fd_pr__cap_mim_m3_1 l=3 w=3
X1277 B11.t2034 TOP.t1050 sky130_fd_pr__cap_mim_m3_1 l=3 w=3
X1278 B11.t577 TOP.t3964 sky130_fd_pr__cap_mim_m3_1 l=3 w=3
X1279 B11.t1314 TOP.t2490 sky130_fd_pr__cap_mim_m3_1 l=3 w=3
X1280 B10.t854 TOP.t5586 sky130_fd_pr__cap_mim_m3_1 l=3 w=3
X1281 B11.t128 TOP.t4862 sky130_fd_pr__cap_mim_m3_1 l=3 w=3
X1282 B11.t819 TOP.t3480 sky130_fd_pr__cap_mim_m3_1 l=3 w=3
X1283 B10.t13 TOP.t7268 sky130_fd_pr__cap_mim_m3_1 l=3 w=3
X1284 B11.t1120 TOP.t2878 sky130_fd_pr__cap_mim_m3_1 l=3 w=3
X1285 B10.t816 TOP.t5662 sky130_fd_pr__cap_mim_m3_1 l=3 w=3
X1286 B9.t149 TOP.t724 sky130_fd_pr__cap_mim_m3_1 l=3 w=3
X1287 B11.t539 TOP.t4040 sky130_fd_pr__cap_mim_m3_1 l=3 w=3
X1288 B11.t1276 TOP.t2566 sky130_fd_pr__cap_mim_m3_1 l=3 w=3
X1289 EDGE_BIAS.t681 EDGE_BIAS.t682 sky130_fd_pr__cap_mim_m3_1 l=3 w=3
X1290 EDGE_BIAS.t618 EDGE_BIAS.t619 sky130_fd_pr__cap_mim_m3_1 l=3 w=3
X1291 B11.t781 TOP.t3556 sky130_fd_pr__cap_mim_m3_1 l=3 w=3
X1292 B11.t1854 TOP.t1410 sky130_fd_pr__cap_mim_m3_1 l=3 w=3
X1293 B11.t1082 TOP.t2954 sky130_fd_pr__cap_mim_m3_1 l=3 w=3
X1294 B11.t705 TOP.t3708 sky130_fd_pr__cap_mim_m3_1 l=3 w=3
X1295 B11.t743 TOP.t3632 sky130_fd_pr__cap_mim_m3_1 l=3 w=3
X1296 B11.t1505 TOP.t2108 sky130_fd_pr__cap_mim_m3_1 l=3 w=3
X1297 B11.t563 TOP.t3992 sky130_fd_pr__cap_mim_m3_1 l=3 w=3
X1298 B11.t1467 TOP.t2184 sky130_fd_pr__cap_mim_m3_1 l=3 w=3
X1299 B10.t723 TOP.t5848 sky130_fd_pr__cap_mim_m3_1 l=3 w=3
X1300 B10.t529 TOP.t6236 sky130_fd_pr__cap_mim_m3_1 l=3 w=3
X1301 B8.t243 TOP.t7320 sky130_fd_pr__cap_mim_m3_1 l=3 w=3
X1302 B11.t164 TOP.t4790 sky130_fd_pr__cap_mim_m3_1 l=3 w=3
X1303 B11.t31 TOP.t5056 sky130_fd_pr__cap_mim_m3_1 l=3 w=3
X1304 B10.t90 TOP.t7114 sky130_fd_pr__cap_mim_m3_1 l=3 w=3
X1305 B10.t685 TOP.t5924 sky130_fd_pr__cap_mim_m3_1 l=3 w=3
X1306 B9.t487 TOP.t48 sky130_fd_pr__cap_mim_m3_1 l=3 w=3
X1307 B11.t483 TOP.t4152 sky130_fd_pr__cap_mim_m3_1 l=3 w=3
X1308 B10.t332 TOP.t6630 sky130_fd_pr__cap_mim_m3_1 l=3 w=3
X1309 B11.t72 TOP.t4974 sky130_fd_pr__cap_mim_m3_1 l=3 w=3
X1310 B10.t52 TOP.t7190 sky130_fd_pr__cap_mim_m3_1 l=3 w=3
X1311 B11.t1814 TOP.t1490 sky130_fd_pr__cap_mim_m3_1 l=3 w=3
X1312 B11.t253 TOP.t4612 sky130_fd_pr__cap_mim_m3_1 l=3 w=3
X1313 EDGE_BIAS.t168 EDGE_BIAS.t169 sky130_fd_pr__cap_mim_m3_1 l=3 w=3
X1314 B11.t1776 TOP.t1566 sky130_fd_pr__cap_mim_m3_1 l=3 w=3
X1315 B10.t586 TOP.t6122 sky130_fd_pr__cap_mim_m3_1 l=3 w=3
X1316 B2.t3 TOP.t8184 sky130_fd_pr__cap_mim_m3_1 l=3 w=3
X1317 B11.t2018 TOP.t1082 sky130_fd_pr__cap_mim_m3_1 l=3 w=3
X1318 B10.t876 TOP.t5542 sky130_fd_pr__cap_mim_m3_1 l=3 w=3
X1319 B11.t4 TOP.t5110 sky130_fd_pr__cap_mim_m3_1 l=3 w=3
X1320 B8.t254 TOP.t7298 sky130_fd_pr__cap_mim_m3_1 l=3 w=3
X1321 B11.t1142 TOP.t2834 sky130_fd_pr__cap_mim_m3_1 l=3 w=3
X1322 B8.t150 TOP.t7506 sky130_fd_pr__cap_mim_m3_1 l=3 w=3
X1323 B11.t281 TOP.t4556 sky130_fd_pr__cap_mim_m3_1 l=3 w=3
X1324 B11.t523 TOP.t4072 sky130_fd_pr__cap_mim_m3_1 l=3 w=3
X1325 B9.t133 TOP.t756 sky130_fd_pr__cap_mim_m3_1 l=3 w=3
X1326 B11.t399 TOP.t4320 sky130_fd_pr__cap_mim_m3_1 l=3 w=3
X1327 B7.t111 TOP.t7840 sky130_fd_pr__cap_mim_m3_1 l=3 w=3
X1328 B7.t42 TOP.t7978 sky130_fd_pr__cap_mim_m3_1 l=3 w=3
X1329 B11.t765 TOP.t3588 sky130_fd_pr__cap_mim_m3_1 l=3 w=3
X1330 B11.t727 TOP.t3664 sky130_fd_pr__cap_mim_m3_1 l=3 w=3
X1331 B11.t427 TOP.t4264 sky130_fd_pr__cap_mim_m3_1 l=3 w=3
X1332 B11.t2042 TOP.t1034 sky130_fd_pr__cap_mim_m3_1 l=3 w=3
X1333 B11.t1489 TOP.t2140 sky130_fd_pr__cap_mim_m3_1 l=3 w=3
X1334 B11.t1209 TOP.t2700 sky130_fd_pr__cap_mim_m3_1 l=3 w=3
X1335 B10.t509 TOP.t6276 sky130_fd_pr__cap_mim_m3_1 l=3 w=3
X1336 B9.t257 TOP.t508 sky130_fd_pr__cap_mim_m3_1 l=3 w=3
X1337 B11.t1451 TOP.t2216 sky130_fd_pr__cap_mim_m3_1 l=3 w=3
X1338 B11.t197 TOP.t4724 sky130_fd_pr__cap_mim_m3_1 l=3 w=3
X1339 B10.t551 TOP.t6192 sky130_fd_pr__cap_mim_m3_1 l=3 w=3
X1340 B9.t88 TOP.t846 sky130_fd_pr__cap_mim_m3_1 l=3 w=3
X1341 B11.t122 TOP.t4874 sky130_fd_pr__cap_mim_m3_1 l=3 w=3
X1342 B11.t751 TOP.t3616 sky130_fd_pr__cap_mim_m3_1 l=3 w=3
X1343 B10.t74 TOP.t7146 sky130_fd_pr__cap_mim_m3_1 l=3 w=3
X1344 B6.t53 TOP.t5140 sky130_fd_pr__cap_mim_m3_1 l=3 w=3
X1345 B11.t1655 TOP.t1808 sky130_fd_pr__cap_mim_m3_1 l=3 w=3
X1346 EDGE_BIAS.t687 EDGE_BIAS.t688 sky130_fd_pr__cap_mim_m3_1 l=3 w=3
X1347 B6.t14 TOP.t5218 sky130_fd_pr__cap_mim_m3_1 l=3 w=3
X1348 B10.t36 TOP.t7222 sky130_fd_pr__cap_mim_m3_1 l=3 w=3
X1349 B11.t1836 TOP.t1446 sky130_fd_pr__cap_mim_m3_1 l=3 w=3
X1350 B11.t1798 TOP.t1522 sky130_fd_pr__cap_mim_m3_1 l=3 w=3
X1351 B11.t1475 TOP.t2168 sky130_fd_pr__cap_mim_m3_1 l=3 w=3
X1352 B11.t1760 TOP.t1598 sky130_fd_pr__cap_mim_m3_1 l=3 w=3
X1353 B11.t48 TOP.t5022 sky130_fd_pr__cap_mim_m3_1 l=3 w=3
X1354 B11.t942 TOP.t3234 sky130_fd_pr__cap_mim_m3_1 l=3 w=3
X1355 B10.t860 TOP.t5574 sky130_fd_pr__cap_mim_m3_1 l=3 w=3
X1356 B9.t193 TOP.t636 sky130_fd_pr__cap_mim_m3_1 l=3 w=3
X1357 B10.t378 TOP.t6538 sky130_fd_pr__cap_mim_m3_1 l=3 w=3
X1358 B11.t2002 TOP.t1114 sky130_fd_pr__cap_mim_m3_1 l=3 w=3
X1359 B11.t1722 TOP.t1674 sky130_fd_pr__cap_mim_m3_1 l=3 w=3
X1360 B11.t1126 TOP.t2866 sky130_fd_pr__cap_mim_m3_1 l=3 w=3
X1361 B11.t1964 TOP.t1190 sky130_fd_pr__cap_mim_m3_1 l=3 w=3
X1362 B9.t155 TOP.t712 sky130_fd_pr__cap_mim_m3_1 l=3 w=3
X1363 B10.t469 TOP.t6356 sky130_fd_pr__cap_mim_m3_1 l=3 w=3
X1364 B11.t507 TOP.t4104 sky130_fd_pr__cap_mim_m3_1 l=3 w=3
X1365 B11.t162 TOP.t4794 sky130_fd_pr__cap_mim_m3_1 l=3 w=3
X1366 B11.t1088 TOP.t2942 sky130_fd_pr__cap_mim_m3_1 l=3 w=3
X1367 B11.t141 TOP.t4836 sky130_fd_pr__cap_mim_m3_1 l=3 w=3
X1368 B10.t431 TOP.t6432 sky130_fd_pr__cap_mim_m3_1 l=3 w=3
X1369 B11.t460 TOP.t4198 sky130_fd_pr__cap_mim_m3_1 l=3 w=3
X1370 B11.t711 TOP.t3696 sky130_fd_pr__cap_mim_m3_1 l=3 w=3
X1371 B11.t322 TOP.t4474 sky130_fd_pr__cap_mim_m3_1 l=3 w=3
X1372 B10.t884 TOP.t5526 sky130_fd_pr__cap_mim_m3_1 l=3 w=3
X1373 EDGE_BIAS.t570 EDGE_BIAS.t571 sky130_fd_pr__cap_mim_m3_1 l=3 w=3
X1374 B11.t247 TOP.t4624 sky130_fd_pr__cap_mim_m3_1 l=3 w=3
X1375 B11.t1193 TOP.t2732 sky130_fd_pr__cap_mim_m3_1 l=3 w=3
X1376 B11.t1435 TOP.t2248 sky130_fd_pr__cap_mim_m3_1 l=3 w=3
X1377 B11.t350 TOP.t4418 sky130_fd_pr__cap_mim_m3_1 l=3 w=3
X1378 B11.t811 TOP.t3496 sky130_fd_pr__cap_mim_m3_1 l=3 w=3
X1379 B10.t134 TOP.t7026 sky130_fd_pr__cap_mim_m3_1 l=3 w=3
X1380 B10.t535 TOP.t6224 sky130_fd_pr__cap_mim_m3_1 l=3 w=3
X1381 B11.t1397 TOP.t2324 sky130_fd_pr__cap_mim_m3_1 l=3 w=3
X1382 B6.t37 TOP.t5172 sky130_fd_pr__cap_mim_m3_1 l=3 w=3
X1383 B11.t902 TOP.t3314 sky130_fd_pr__cap_mim_m3_1 l=3 w=3
X1384 B10.t96 TOP.t7102 sky130_fd_pr__cap_mim_m3_1 l=3 w=3
X1385 B9.t493 TOP.t36 sky130_fd_pr__cap_mim_m3_1 l=3 w=3
X1386 B10.t338 TOP.t6618 sky130_fd_pr__cap_mim_m3_1 l=3 w=3
X1387 B11.t1639 TOP.t1840 sky130_fd_pr__cap_mim_m3_1 l=3 w=3
X1388 EDGE_BIAS.t543 EDGE_BIAS.t544 sky130_fd_pr__cap_mim_m3_1 l=3 w=3
X1389 B10.t58 TOP.t7178 sky130_fd_pr__cap_mim_m3_1 l=3 w=3
X1390 B5.t14 TOP.t8100 sky130_fd_pr__cap_mim_m3_1 l=3 w=3
X1391 B11.t864 TOP.t3390 sky130_fd_pr__cap_mim_m3_1 l=3 w=3
X1392 B10.t20 TOP.t7254 sky130_fd_pr__cap_mim_m3_1 l=3 w=3
X1393 B11.t106 TOP.t4906 sky130_fd_pr__cap_mim_m3_1 l=3 w=3
X1394 B11.t1820 TOP.t1478 sky130_fd_pr__cap_mim_m3_1 l=3 w=3
X1395 EDGE_BIAS.t150 EDGE_BIAS.t151 sky130_fd_pr__cap_mim_m3_1 l=3 w=3
X1396 B10.t951 TOP.t5392 sky130_fd_pr__cap_mim_m3_1 l=3 w=3
X1397 B11.t251 TOP.t4616 sky130_fd_pr__cap_mim_m3_1 l=3 w=3
X1398 B11.t1782 TOP.t1554 sky130_fd_pr__cap_mim_m3_1 l=3 w=3
X1399 B11.t266 TOP.t4586 sky130_fd_pr__cap_mim_m3_1 l=3 w=3
X1400 B11.t2024 TOP.t1070 sky130_fd_pr__cap_mim_m3_1 l=3 w=3
X1401 B10.t844 TOP.t5606 sky130_fd_pr__cap_mim_m3_1 l=3 w=3
X1402 B11.t567 TOP.t3984 sky130_fd_pr__cap_mim_m3_1 l=3 w=3
X1403 B11.t1110 TOP.t2898 sky130_fd_pr__cap_mim_m3_1 l=3 w=3
X1404 B11.t529 TOP.t4060 sky130_fd_pr__cap_mim_m3_1 l=3 w=3
X1405 B10.t806 TOP.t5682 sky130_fd_pr__cap_mim_m3_1 l=3 w=3
X1406 B9.t139 TOP.t744 sky130_fd_pr__cap_mim_m3_1 l=3 w=3
X1407 B10.t453 TOP.t6388 sky130_fd_pr__cap_mim_m3_1 l=3 w=3
X1408 B11.t1072 TOP.t2974 sky130_fd_pr__cap_mim_m3_1 l=3 w=3
X1409 B7.t48 TOP.t7966 sky130_fd_pr__cap_mim_m3_1 l=3 w=3
X1410 B11.t372 TOP.t4374 sky130_fd_pr__cap_mim_m3_1 l=3 w=3
X1411 B11.t771 TOP.t3576 sky130_fd_pr__cap_mim_m3_1 l=3 w=3
X1412 B10.t415 TOP.t6464 sky130_fd_pr__cap_mim_m3_1 l=3 w=3
X1413 B11.t695 TOP.t3728 sky130_fd_pr__cap_mim_m3_1 l=3 w=3
X1414 B11.t733 TOP.t3652 sky130_fd_pr__cap_mim_m3_1 l=3 w=3
X1415 B10.t377 TOP.t6540 sky130_fd_pr__cap_mim_m3_1 l=3 w=3
X1416 B11.t1495 TOP.t2128 sky130_fd_pr__cap_mim_m3_1 l=3 w=3
X1417 B9.t380 TOP.t262 sky130_fd_pr__cap_mim_m3_1 l=3 w=3
X1418 B11.t1215 TOP.t2688 sky130_fd_pr__cap_mim_m3_1 l=3 w=3
X1419 B11.t1457 TOP.t2204 sky130_fd_pr__cap_mim_m3_1 l=3 w=3
X1420 B11.t0 TOP.t5118 sky130_fd_pr__cap_mim_m3_1 l=3 w=3
X1421 B10.t911 TOP.t5472 sky130_fd_pr__cap_mim_m3_1 l=3 w=3
X1422 B10.t519 TOP.t6256 sky130_fd_pr__cap_mim_m3_1 l=3 w=3
X1423 EDGE_BIAS.t33 EDGE_BIAS.t34 sky130_fd_pr__cap_mim_m3_1 l=3 w=3
X1424 EDGE_BIAS.t732 EDGE_BIAS.t733 sky130_fd_pr__cap_mim_m3_1 l=3 w=3
X1425 B10.t80 TOP.t7134 sky130_fd_pr__cap_mim_m3_1 l=3 w=3
X1426 B8.t233 TOP.t7340 sky130_fd_pr__cap_mim_m3_1 l=3 w=3
X1427 B11.t231 TOP.t4656 sky130_fd_pr__cap_mim_m3_1 l=3 w=3
X1428 B11.t886 TOP.t3346 sky130_fd_pr__cap_mim_m3_1 l=3 w=3
X1429 B9.t477 TOP.t68 sky130_fd_pr__cap_mim_m3_1 l=3 w=3
X1430 B11.t1013 TOP.t3092 sky130_fd_pr__cap_mim_m3_1 l=3 w=3
X1431 B10.t42 TOP.t7210 sky130_fd_pr__cap_mim_m3_1 l=3 w=3
X1432 B11.t848 TOP.t3422 sky130_fd_pr__cap_mim_m3_1 l=3 w=3
X1433 B11.t1804 TOP.t1510 sky130_fd_pr__cap_mim_m3_1 l=3 w=3
X1434 B11.t810 TOP.t3498 sky130_fd_pr__cap_mim_m3_1 l=3 w=3
X1435 B8.t62 TOP.t7682 sky130_fd_pr__cap_mim_m3_1 l=3 w=3
X1436 EDGE_BIAS.t0 EDGE_BIAS.t1 sky130_fd_pr__cap_mim_m3_1 l=3 w=3
X1437 B11.t1766 TOP.t1586 sky130_fd_pr__cap_mim_m3_1 l=3 w=3
X1438 B10.t576 TOP.t6142 sky130_fd_pr__cap_mim_m3_1 l=3 w=3
X1439 B10.t866 TOP.t5562 sky130_fd_pr__cap_mim_m3_1 l=3 w=3
X1440 B11.t2008 TOP.t1102 sky130_fd_pr__cap_mim_m3_1 l=3 w=3
X1441 B9.t340 TOP.t342 sky130_fd_pr__cap_mim_m3_1 l=3 w=3
X1442 B10.t66 TOP.t7162 sky130_fd_pr__cap_mim_m3_1 l=3 w=3
X1443 B11.t1970 TOP.t1178 sky130_fd_pr__cap_mim_m3_1 l=3 w=3
X1444 B11.t1534 TOP.t2050 sky130_fd_pr__cap_mim_m3_1 l=3 w=3
X1445 B11.t147 TOP.t4824 sky130_fd_pr__cap_mim_m3_1 l=3 w=3
X1446 B11.t513 TOP.t4092 sky130_fd_pr__cap_mim_m3_1 l=3 w=3
X1447 B9.t302 TOP.t418 sky130_fd_pr__cap_mim_m3_1 l=3 w=3
X1448 B7.t32 TOP.t7998 sky130_fd_pr__cap_mim_m3_1 l=3 w=3
X1449 B10.t4 TOP.t7286 sky130_fd_pr__cap_mim_m3_1 l=3 w=3
X1450 B11.t717 TOP.t3684 sky130_fd_pr__cap_mim_m3_1 l=3 w=3
X1451 B11.t1790 TOP.t1538 sky130_fd_pr__cap_mim_m3_1 l=3 w=3
X1452 B11.t175 TOP.t4768 sky130_fd_pr__cap_mim_m3_1 l=3 w=3
X1453 B11.t83 TOP.t4952 sky130_fd_pr__cap_mim_m3_1 l=3 w=3
X1454 B11.t494 TOP.t4130 sky130_fd_pr__cap_mim_m3_1 l=3 w=3
X1455 EDGE_BIAS.t246 EDGE_BIAS.t247 sky130_fd_pr__cap_mim_m3_1 l=3 w=3
X1456 B9.t185 TOP.t652 sky130_fd_pr__cap_mim_m3_1 l=3 w=3
X1457 B11.t356 TOP.t4406 sky130_fd_pr__cap_mim_m3_1 l=3 w=3
X1458 B10.t257 TOP.t6780 sky130_fd_pr__cap_mim_m3_1 l=3 w=3
X1459 B11.t1199 TOP.t2720 sky130_fd_pr__cap_mim_m3_1 l=3 w=3
X1460 B11.t1441 TOP.t2236 sky130_fd_pr__cap_mim_m3_1 l=3 w=3
X1461 B11.t264 TOP.t4590 sky130_fd_pr__cap_mim_m3_1 l=3 w=3
X1462 B10.t895 TOP.t5504 sky130_fd_pr__cap_mim_m3_1 l=3 w=3
X1463 B8.t22 TOP.t7762 sky130_fd_pr__cap_mim_m3_1 l=3 w=3
X1464 EDGE_BIAS.t81 EDGE_BIAS.t82 sky130_fd_pr__cap_mim_m3_1 l=3 w=3
X1465 B11.t1403 TOP.t2312 sky130_fd_pr__cap_mim_m3_1 l=3 w=3
X1466 B6.t43 TOP.t5160 sky130_fd_pr__cap_mim_m3_1 l=3 w=3
X1467 B9.t238 TOP.t546 sky130_fd_pr__cap_mim_m3_1 l=3 w=3
X1468 B6.t4 TOP.t5238 sky130_fd_pr__cap_mim_m3_1 l=3 w=3
X1469 B10.t26 TOP.t7242 sky130_fd_pr__cap_mim_m3_1 l=3 w=3
X1470 B11.t1223 TOP.t2672 sky130_fd_pr__cap_mim_m3_1 l=3 w=3
X1471 B11.t410 TOP.t4298 sky130_fd_pr__cap_mim_m3_1 l=3 w=3
X1472 B9.t50 TOP.t922 sky130_fd_pr__cap_mim_m3_1 l=3 w=3
X1473 B11.t690 TOP.t3738 sky130_fd_pr__cap_mim_m3_1 l=3 w=3
X1474 B10.t126 TOP.t7042 sky130_fd_pr__cap_mim_m3_1 l=3 w=3
X1475 B11.t1750 TOP.t1618 sky130_fd_pr__cap_mim_m3_1 l=3 w=3
X1476 B11.t1992 TOP.t1134 sky130_fd_pr__cap_mim_m3_1 l=3 w=3
X1477 B10.t850 TOP.t5594 sky130_fd_pr__cap_mim_m3_1 l=3 w=3
X1478 B11.t12 TOP.t5094 sky130_fd_pr__cap_mim_m3_1 l=3 w=3
X1479 B11.t1712 TOP.t1694 sky130_fd_pr__cap_mim_m3_1 l=3 w=3
X1480 B11.t1518 TOP.t2082 sky130_fd_pr__cap_mim_m3_1 l=3 w=3
X1481 B9.t324 TOP.t374 sky130_fd_pr__cap_mim_m3_1 l=3 w=3
X1482 B6.t28 TOP.t5190 sky130_fd_pr__cap_mim_m3_1 l=3 w=3
X1483 B11.t300 TOP.t4518 sky130_fd_pr__cap_mim_m3_1 l=3 w=3
X1484 B10.t217 TOP.t6860 sky130_fd_pr__cap_mim_m3_1 l=3 w=3
X1485 B11.t1954 TOP.t1210 sky130_fd_pr__cap_mim_m3_1 l=3 w=3
X1486 B10.t812 TOP.t5670 sky130_fd_pr__cap_mim_m3_1 l=3 w=3
X1487 B9.t145 TOP.t732 sky130_fd_pr__cap_mim_m3_1 l=3 w=3
X1488 B10.t459 TOP.t6376 sky130_fd_pr__cap_mim_m3_1 l=3 w=3
X1489 EDGE_BIAS.t738 EDGE_BIAS.t739 sky130_fd_pr__cap_mim_m3_1 l=3 w=3
X1490 B11.t208 TOP.t4702 sky130_fd_pr__cap_mim_m3_1 l=3 w=3
X1491 B9.t286 TOP.t450 sky130_fd_pr__cap_mim_m3_1 l=3 w=3
X1492 B10.t179 TOP.t6936 sky130_fd_pr__cap_mim_m3_1 l=3 w=3
X1493 B10.t421 TOP.t6452 sky130_fd_pr__cap_mim_m3_1 l=3 w=3
X1494 B11.t701 TOP.t3716 sky130_fd_pr__cap_mim_m3_1 l=3 w=3
X1495 B11.t1290 TOP.t2538 sky130_fd_pr__cap_mim_m3_1 l=3 w=3
X1496 B11.t991 TOP.t3136 sky130_fd_pr__cap_mim_m3_1 l=3 w=3
X1497 B11.t559 TOP.t4000 sky130_fd_pr__cap_mim_m3_1 l=3 w=3
X1498 B11.t1183 TOP.t2752 sky130_fd_pr__cap_mim_m3_1 l=3 w=3
X1499 B11.t1425 TOP.t2268 sky130_fd_pr__cap_mim_m3_1 l=3 w=3
X1500 B8.t6 TOP.t7794 sky130_fd_pr__cap_mim_m3_1 l=3 w=3
X1501 B10.t445 TOP.t6404 sky130_fd_pr__cap_mim_m3_1 l=3 w=3
X1502 B11.t650 TOP.t3818 sky130_fd_pr__cap_mim_m3_1 l=3 w=3
X1503 B10.t86 TOP.t7122 sky130_fd_pr__cap_mim_m3_1 l=3 w=3
X1504 B11.t1387 TOP.t2344 sky130_fd_pr__cap_mim_m3_1 l=3 w=3
X1505 B8.t239 TOP.t7328 sky130_fd_pr__cap_mim_m3_1 l=3 w=3
X1506 EDGE_BIAS.t567 EDGE_BIAS.t568 sky130_fd_pr__cap_mim_m3_1 l=3 w=3
X1507 B11.t892 TOP.t3334 sky130_fd_pr__cap_mim_m3_1 l=3 w=3
X1508 B11.t1629 TOP.t1860 sky130_fd_pr__cap_mim_m3_1 l=3 w=3
X1509 B11.t443 TOP.t4232 sky130_fd_pr__cap_mim_m3_1 l=3 w=3
X1510 B11.t612 TOP.t3894 sky130_fd_pr__cap_mim_m3_1 l=3 w=3
X1511 B10.t328 TOP.t6638 sky130_fd_pr__cap_mim_m3_1 l=3 w=3
X1512 B9.t222 TOP.t578 sky130_fd_pr__cap_mim_m3_1 l=3 w=3
X1513 B10.t48 TOP.t7198 sky130_fd_pr__cap_mim_m3_1 l=3 w=3
X1514 B11.t1155 TOP.t2808 sky130_fd_pr__cap_mim_m3_1 l=3 w=3
X1515 B5.t4 TOP.t8120 sky130_fd_pr__cap_mim_m3_1 l=3 w=3
X1516 EDGE_BIAS.t630 EDGE_BIAS.t631 sky130_fd_pr__cap_mim_m3_1 l=3 w=3
X1517 B11.t854 TOP.t3410 sky130_fd_pr__cap_mim_m3_1 l=3 w=3
X1518 B10.t10 TOP.t7274 sky130_fd_pr__cap_mim_m3_1 l=3 w=3
X1519 B11.t1591 TOP.t1936 sky130_fd_pr__cap_mim_m3_1 l=3 w=3
X1520 B9.t184 TOP.t654 sky130_fd_pr__cap_mim_m3_1 l=3 w=3
X1521 B11.t1810 TOP.t1498 sky130_fd_pr__cap_mim_m3_1 l=3 w=3
X1522 B10.t699 TOP.t5896 sky130_fd_pr__cap_mim_m3_1 l=3 w=3
X1523 B11.t1772 TOP.t1574 sky130_fd_pr__cap_mim_m3_1 l=3 w=3
X1524 EDGE_BIAS.t588 EDGE_BIAS.t589 sky130_fd_pr__cap_mim_m3_1 l=3 w=3
X1525 B11.t333 TOP.t4452 sky130_fd_pr__cap_mim_m3_1 l=3 w=3
X1526 B11.t1250 TOP.t2618 sky130_fd_pr__cap_mim_m3_1 l=3 w=3
X1527 B10.t834 TOP.t5626 sky130_fd_pr__cap_mim_m3_1 l=3 w=3
X1528 B11.t1018 TOP.t3082 sky130_fd_pr__cap_mim_m3_1 l=3 w=3
X1529 B11.t519 TOP.t4080 sky130_fd_pr__cap_mim_m3_1 l=3 w=3
X1530 B11.t878 TOP.t3362 sky130_fd_pr__cap_mim_m3_1 l=3 w=3
X1531 B10.t201 TOP.t6892 sky130_fd_pr__cap_mim_m3_1 l=3 w=3
X1532 B10.t796 TOP.t5702 sky130_fd_pr__cap_mim_m3_1 l=3 w=3
X1533 B11.t1062 TOP.t2994 sky130_fd_pr__cap_mim_m3_1 l=3 w=3
X1534 B11.t761 TOP.t3596 sky130_fd_pr__cap_mim_m3_1 l=3 w=3
X1535 B10.t163 TOP.t6968 sky130_fd_pr__cap_mim_m3_1 l=3 w=3
X1536 B10.t564 TOP.t6166 sky130_fd_pr__cap_mim_m3_1 l=3 w=3
X1537 B10.t405 TOP.t6484 sky130_fd_pr__cap_mim_m3_1 l=3 w=3
X1538 B11.t479 TOP.t4160 sky130_fd_pr__cap_mim_m3_1 l=3 w=3
X1539 B11.t723 TOP.t3672 sky130_fd_pr__cap_mim_m3_1 l=3 w=3
X1540 B10.t1000 TOP.t5294 sky130_fd_pr__cap_mim_m3_1 l=3 w=3
X1541 B11.t89 TOP.t4940 sky130_fd_pr__cap_mim_m3_1 l=3 w=3
X1542 B11.t68 TOP.t4982 sky130_fd_pr__cap_mim_m3_1 l=3 w=3
X1543 B10.t125 TOP.t7044 sky130_fd_pr__cap_mim_m3_1 l=3 w=3
X1544 B11.t387 TOP.t4344 sky130_fd_pr__cap_mim_m3_1 l=3 w=3
X1545 B7.t125 TOP.t7812 sky130_fd_pr__cap_mim_m3_1 l=3 w=3
X1546 B10.t367 TOP.t6560 sky130_fd_pr__cap_mim_m3_1 l=3 w=3
X1547 B11.t29 TOP.t5060 sky130_fd_pr__cap_mim_m3_1 l=3 w=3
X1548 B11.t1205 TOP.t2708 sky130_fd_pr__cap_mim_m3_1 l=3 w=3
X1549 B11.t117 TOP.t4884 sky130_fd_pr__cap_mim_m3_1 l=3 w=3
X1550 B11.t1849 TOP.t1420 sky130_fd_pr__cap_mim_m3_1 l=3 w=3
X1551 B10.t659 TOP.t5976 sky130_fd_pr__cap_mim_m3_1 l=3 w=3
X1552 B10.t901 TOP.t5492 sky130_fd_pr__cap_mim_m3_1 l=3 w=3
X1553 EDGE_BIAS.t63 EDGE_BIAS.t64 sky130_fd_pr__cap_mim_m3_1 l=3 w=3
X1554 B11.t634 TOP.t3850 sky130_fd_pr__cap_mim_m3_1 l=3 w=3
X1555 B11.t1009 TOP.t3100 sky130_fd_pr__cap_mim_m3_1 l=3 w=3
X1556 B10.t621 TOP.t6052 sky130_fd_pr__cap_mim_m3_1 l=3 w=3
X1557 B8.t223 TOP.t7360 sky130_fd_pr__cap_mim_m3_1 l=3 w=3
X1558 B11.t277 TOP.t4564 sky130_fd_pr__cap_mim_m3_1 l=3 w=3
X1559 B9.t467 TOP.t88 sky130_fd_pr__cap_mim_m3_1 l=3 w=3
X1560 B11.t596 TOP.t3926 sky130_fd_pr__cap_mim_m3_1 l=3 w=3
X1561 B10.t32 TOP.t7230 sky130_fd_pr__cap_mim_m3_1 l=3 w=3
X1562 B3.t0 TOP.t8144 sky130_fd_pr__cap_mim_m3_1 l=3 w=3
X1563 B11.t838 TOP.t3442 sky130_fd_pr__cap_mim_m3_1 l=3 w=3
X1564 B9.t429 TOP.t164 sky130_fd_pr__cap_mim_m3_1 l=3 w=3
X1565 B11.t558 TOP.t4002 sky130_fd_pr__cap_mim_m3_1 l=3 w=3
X1566 B11.t800 TOP.t3518 sky130_fd_pr__cap_mim_m3_1 l=3 w=3
X1567 EDGE_BIAS.t216 EDGE_BIAS.t217 sky130_fd_pr__cap_mim_m3_1 l=3 w=3
X1568 B11.t1756 TOP.t1606 sky130_fd_pr__cap_mim_m3_1 l=3 w=3
X1569 B11.t1234 TOP.t2650 sky130_fd_pr__cap_mim_m3_1 l=3 w=3
X1570 B7.t85 TOP.t7892 sky130_fd_pr__cap_mim_m3_1 l=3 w=3
X1571 B11.t1718 TOP.t1682 sky130_fd_pr__cap_mim_m3_1 l=3 w=3
X1572 B11.t1524 TOP.t2070 sky130_fd_pr__cap_mim_m3_1 l=3 w=3
X1573 B9.t330 TOP.t362 sky130_fd_pr__cap_mim_m3_1 l=3 w=3
X1574 B10.t0 TOP.t7294 sky130_fd_pr__cap_mim_m3_1 l=3 w=3
X1575 B11.t118 TOP.t4882 sky130_fd_pr__cap_mim_m3_1 l=3 w=3
X1576 B9.t292 TOP.t438 sky130_fd_pr__cap_mim_m3_1 l=3 w=3
X1577 B7.t22 TOP.t8018 sky130_fd_pr__cap_mim_m3_1 l=3 w=3
X1578 B11.t437 TOP.t4244 sky130_fd_pr__cap_mim_m3_1 l=3 w=3
X1579 B11.t242 TOP.t4634 sky130_fd_pr__cap_mim_m3_1 l=3 w=3
X1580 EDGE_BIAS.t699 EDGE_BIAS.t700 sky130_fd_pr__cap_mim_m3_1 l=3 w=3
X1581 B11.t707 TOP.t3704 sky130_fd_pr__cap_mim_m3_1 l=3 w=3
X1582 B10.t389 TOP.t6516 sky130_fd_pr__cap_mim_m3_1 l=3 w=3
X1583 B8.t111 TOP.t7584 sky130_fd_pr__cap_mim_m3_1 l=3 w=3
X1584 B10.t351 TOP.t6592 sky130_fd_pr__cap_mim_m3_1 l=3 w=3
X1585 B11.t1189 TOP.t2740 sky130_fd_pr__cap_mim_m3_1 l=3 w=3
X1586 B11.t1833 TOP.t1452 sky130_fd_pr__cap_mim_m3_1 l=3 w=3
X1587 B10.t643 TOP.t6008 sky130_fd_pr__cap_mim_m3_1 l=3 w=3
X1588 B9.t316 TOP.t390 sky130_fd_pr__cap_mim_m3_1 l=3 w=3
X1589 B11.t8 TOP.t5102 sky130_fd_pr__cap_mim_m3_1 l=3 w=3
X1590 EDGE_BIAS.t111 EDGE_BIAS.t112 sky130_fd_pr__cap_mim_m3_1 l=3 w=3
X1591 B8.t12 TOP.t7782 sky130_fd_pr__cap_mim_m3_1 l=3 w=3
X1592 B10.t605 TOP.t6084 sky130_fd_pr__cap_mim_m3_1 l=3 w=3
X1593 B6.t33 TOP.t5180 sky130_fd_pr__cap_mim_m3_1 l=3 w=3
X1594 B11.t2037 TOP.t1044 sky130_fd_pr__cap_mim_m3_1 l=3 w=3
X1595 B9.t228 TOP.t566 sky130_fd_pr__cap_mim_m3_1 l=3 w=3
X1596 B5.t10 TOP.t8108 sky130_fd_pr__cap_mim_m3_1 l=3 w=3
X1597 B11.t158 TOP.t4802 sky130_fd_pr__cap_mim_m3_1 l=3 w=3
X1598 B11.t822 TOP.t3474 sky130_fd_pr__cap_mim_m3_1 l=3 w=3
X1599 B10.t16 TOP.t7262 sky130_fd_pr__cap_mim_m3_1 l=3 w=3
X1600 B11.t477 TOP.t4164 sky130_fd_pr__cap_mim_m3_1 l=3 w=3
X1601 B10.t306 TOP.t6682 sky130_fd_pr__cap_mim_m3_1 l=3 w=3
X1602 B11.t66 TOP.t4986 sky130_fd_pr__cap_mim_m3_1 l=3 w=3
X1603 B11.t456 TOP.t4206 sky130_fd_pr__cap_mim_m3_1 l=3 w=3
X1604 B11.t784 TOP.t3550 sky130_fd_pr__cap_mim_m3_1 l=3 w=3
X1605 B11.t1740 TOP.t1638 sky130_fd_pr__cap_mim_m3_1 l=3 w=3
X1606 EDGE_BIAS.t540 EDGE_BIAS.t541 sky130_fd_pr__cap_mim_m3_1 l=3 w=3
X1607 B11.t746 TOP.t3626 sky130_fd_pr__cap_mim_m3_1 l=3 w=3
X1608 B7.t69 TOP.t7924 sky130_fd_pr__cap_mim_m3_1 l=3 w=3
X1609 B9.t252 TOP.t518 sky130_fd_pr__cap_mim_m3_1 l=3 w=3
X1610 B11.t1702 TOP.t1714 sky130_fd_pr__cap_mim_m3_1 l=3 w=3
X1611 B11.t1508 TOP.t2102 sky130_fd_pr__cap_mim_m3_1 l=3 w=3
X1612 B9.t135 TOP.t752 sky130_fd_pr__cap_mim_m3_1 l=3 w=3
X1613 B11.t367 TOP.t4384 sky130_fd_pr__cap_mim_m3_1 l=3 w=3
X1614 B10.t207 TOP.t6880 sky130_fd_pr__cap_mim_m3_1 l=3 w=3
X1615 B11.t1944 TOP.t1230 sky130_fd_pr__cap_mim_m3_1 l=3 w=3
X1616 B10.t449 TOP.t6396 sky130_fd_pr__cap_mim_m3_1 l=3 w=3
X1617 B10.t169 TOP.t6956 sky130_fd_pr__cap_mim_m3_1 l=3 w=3
X1618 B11.t1470 TOP.t2178 sky130_fd_pr__cap_mim_m3_1 l=3 w=3
X1619 B9.t276 TOP.t470 sky130_fd_pr__cap_mim_m3_1 l=3 w=3
X1620 B11.t1906 TOP.t1306 sky130_fd_pr__cap_mim_m3_1 l=3 w=3
X1621 B10.t411 TOP.t6472 sky130_fd_pr__cap_mim_m3_1 l=3 w=3
X1622 EDGE_BIAS.t513 EDGE_BIAS.t514 sky130_fd_pr__cap_mim_m3_1 l=3 w=3
X1623 B10.t335 TOP.t6624 sky130_fd_pr__cap_mim_m3_1 l=3 w=3
X1624 B10.t373 TOP.t6548 sky130_fd_pr__cap_mim_m3_1 l=3 w=3
X1625 B11.t102 TOP.t4914 sky130_fd_pr__cap_mim_m3_1 l=3 w=3
X1626 B11.t421 TOP.t4276 sky130_fd_pr__cap_mim_m3_1 l=3 w=3
X1627 B11.t1173 TOP.t2772 sky130_fd_pr__cap_mim_m3_1 l=3 w=3
X1628 B10.t193 TOP.t6908 sky130_fd_pr__cap_mim_m3_1 l=3 w=3
X1629 B11.t283 TOP.t4552 sky130_fd_pr__cap_mim_m3_1 l=3 w=3
X1630 B11.t640 TOP.t3838 sky130_fd_pr__cap_mim_m3_1 l=3 w=3
X1631 EDGE_BIAS.t45 EDGE_BIAS.t46 sky130_fd_pr__cap_mim_m3_1 l=3 w=3
X1632 B10.t76 TOP.t7142 sky130_fd_pr__cap_mim_m3_1 l=3 w=3
X1633 B11.t1377 TOP.t2364 sky130_fd_pr__cap_mim_m3_1 l=3 w=3
X1634 B11.t191 TOP.t4736 sky130_fd_pr__cap_mim_m3_1 l=3 w=3
X1635 B11.t882 TOP.t3354 sky130_fd_pr__cap_mim_m3_1 l=3 w=3
X1636 B9.t212 TOP.t598 sky130_fd_pr__cap_mim_m3_1 l=3 w=3
X1637 B11.t602 TOP.t3914 sky130_fd_pr__cap_mim_m3_1 l=3 w=3
X1638 B10.t879 TOP.t5536 sky130_fd_pr__cap_mim_m3_1 l=3 w=3
X1639 B10.t38 TOP.t7218 sky130_fd_pr__cap_mim_m3_1 l=3 w=3
X1640 B11.t1339 TOP.t2440 sky130_fd_pr__cap_mim_m3_1 l=3 w=3
X1641 B11.t1145 TOP.t2828 sky130_fd_pr__cap_mim_m3_1 l=3 w=3
X1642 B4.t2 TOP.t8178 sky130_fd_pr__cap_mim_m3_1 l=3 w=3
X1643 B11.t844 TOP.t3430 sky130_fd_pr__cap_mim_m3_1 l=3 w=3
X1644 B9.t174 TOP.t674 sky130_fd_pr__cap_mim_m3_1 l=3 w=3
X1645 B11.t806 TOP.t3506 sky130_fd_pr__cap_mim_m3_1 l=3 w=3
X1646 B11.t768 TOP.t3582 sky130_fd_pr__cap_mim_m3_1 l=3 w=3
X1647 B11.t25 TOP.t5068 sky130_fd_pr__cap_mim_m3_1 l=3 w=3
X1648 B11.t730 TOP.t3658 sky130_fd_pr__cap_mim_m3_1 l=3 w=3
X1649 B11.t1240 TOP.t2638 sky130_fd_pr__cap_mim_m3_1 l=3 w=3
X1650 B11.t626 TOP.t3866 sky130_fd_pr__cap_mim_m3_1 l=3 w=3
X1651 B11.t1530 TOP.t2058 sky130_fd_pr__cap_mim_m3_1 l=3 w=3
X1652 B11.t509 TOP.t4100 sky130_fd_pr__cap_mim_m3_1 l=3 w=3
X1653 B10.t786 TOP.t5722 sky130_fd_pr__cap_mim_m3_1 l=3 w=3
X1654 B9.t260 TOP.t502 sky130_fd_pr__cap_mim_m3_1 l=3 w=3
X1655 B10.t153 TOP.t6988 sky130_fd_pr__cap_mim_m3_1 l=3 w=3
X1656 B10.t748 TOP.t5798 sky130_fd_pr__cap_mim_m3_1 l=3 w=3
X1657 B11.t227 TOP.t4664 sky130_fd_pr__cap_mim_m3_1 l=3 w=3
X1658 B10.t554 TOP.t6186 sky130_fd_pr__cap_mim_m3_1 l=3 w=3
X1659 B10.t395 TOP.t6504 sky130_fd_pr__cap_mim_m3_1 l=3 w=3
X1660 B11.t135 TOP.t4848 sky130_fd_pr__cap_mim_m3_1 l=3 w=3
X1661 B10.t115 TOP.t7064 sky130_fd_pr__cap_mim_m3_1 l=3 w=3
X1662 B11.t754 TOP.t3610 sky130_fd_pr__cap_mim_m3_1 l=3 w=3
X1663 B10.t357 TOP.t6580 sky130_fd_pr__cap_mim_m3_1 l=3 w=3
X1664 B11.t316 TOP.t4486 sky130_fd_pr__cap_mim_m3_1 l=3 w=3
X1665 B11.t1839 TOP.t1440 sky130_fd_pr__cap_mim_m3_1 l=3 w=3
X1666 B10.t649 TOP.t5996 sky130_fd_pr__cap_mim_m3_1 l=3 w=3
X1667 EDGE_BIAS.t93 EDGE_BIAS.t94 sky130_fd_pr__cap_mim_m3_1 l=3 w=3
X1668 B10.t891 TOP.t5512 sky130_fd_pr__cap_mim_m3_1 l=3 w=3
X1669 B10.t611 TOP.t6072 sky130_fd_pr__cap_mim_m3_1 l=3 w=3
X1670 B8.t213 TOP.t7380 sky130_fd_pr__cap_mim_m3_1 l=3 w=3
X1671 B11.t344 TOP.t4430 sky130_fd_pr__cap_mim_m3_1 l=3 w=3
X1672 B9.t196 TOP.t630 sky130_fd_pr__cap_mim_m3_1 l=3 w=3
X1673 B11.t586 TOP.t3946 sky130_fd_pr__cap_mim_m3_1 l=3 w=3
X1674 B10.t381 TOP.t6532 sky130_fd_pr__cap_mim_m3_1 l=3 w=3
X1675 B8.t175 TOP.t7456 sky130_fd_pr__cap_mim_m3_1 l=3 w=3
X1676 B11.t462 TOP.t4194 sky130_fd_pr__cap_mim_m3_1 l=3 w=3
X1677 B11.t828 TOP.t3462 sky130_fd_pr__cap_mim_m3_1 l=3 w=3
X1678 B10.t22 TOP.t7250 sky130_fd_pr__cap_mim_m3_1 l=3 w=3
X1679 B9.t158 TOP.t706 sky130_fd_pr__cap_mim_m3_1 l=3 w=3
X1680 B11.t548 TOP.t4022 sky130_fd_pr__cap_mim_m3_1 l=3 w=3
X1681 B11.t790 TOP.t3538 sky130_fd_pr__cap_mim_m3_1 l=3 w=3
X1682 EDGE_BIAS.t21 EDGE_BIAS.t22 sky130_fd_pr__cap_mim_m3_1 l=3 w=3
X1683 B11.t100 TOP.t4918 sky130_fd_pr__cap_mim_m3_1 l=3 w=3
X1684 B11.t490 TOP.t4138 sky130_fd_pr__cap_mim_m3_1 l=3 w=3
X1685 B10.t635 TOP.t6024 sky130_fd_pr__cap_mim_m3_1 l=3 w=3
X1686 B7.t75 TOP.t7912 sky130_fd_pr__cap_mim_m3_1 l=3 w=3
X1687 B11.t398 TOP.t4322 sky130_fd_pr__cap_mim_m3_1 l=3 w=3
X1688 B9.t64 TOP.t894 sky130_fd_pr__cap_mim_m3_1 l=3 w=3
X1689 B11.t1514 TOP.t2090 sky130_fd_pr__cap_mim_m3_1 l=3 w=3
X1690 B9.t320 TOP.t382 sky130_fd_pr__cap_mim_m3_1 l=3 w=3
X1691 B6.t24 TOP.t5198 sky130_fd_pr__cap_mim_m3_1 l=3 w=3
X1692 B11.t260 TOP.t4598 sky130_fd_pr__cap_mim_m3_1 l=3 w=3
X1693 B11.t185 TOP.t4748 sky130_fd_pr__cap_mim_m3_1 l=3 w=3
X1694 B9.t282 TOP.t458 sky130_fd_pr__cap_mim_m3_1 l=3 w=3
X1695 B11.t814 TOP.t3490 sky130_fd_pr__cap_mim_m3_1 l=3 w=3
X1696 B10.t137 TOP.t7020 sky130_fd_pr__cap_mim_m3_1 l=3 w=3
X1697 B9.t113 TOP.t796 sky130_fd_pr__cap_mim_m3_1 l=3 w=3
X1698 B5.t30 TOP.t8068 sky130_fd_pr__cap_mim_m3_1 l=3 w=3
X1699 B10.t99 TOP.t7096 sky130_fd_pr__cap_mim_m3_1 l=3 w=3
X1700 B10.t341 TOP.t6612 sky130_fd_pr__cap_mim_m3_1 l=3 w=3
X1701 B11.t1538 TOP.t2042 sky130_fd_pr__cap_mim_m3_1 l=3 w=3
X1702 B11.t37 TOP.t5044 sky130_fd_pr__cap_mim_m3_1 l=3 w=3
X1703 B10.t61 TOP.t7172 sky130_fd_pr__cap_mim_m3_1 l=3 w=3
X1704 B11.t1823 TOP.t1472 sky130_fd_pr__cap_mim_m3_1 l=3 w=3
X1705 B10.t441 TOP.t6412 sky130_fd_pr__cap_mim_m3_1 l=3 w=3
X1706 B11.t1005 TOP.t3108 sky130_fd_pr__cap_mim_m3_1 l=3 w=3
X1707 EDGE_BIAS.t141 EDGE_BIAS.t142 sky130_fd_pr__cap_mim_m3_1 l=3 w=3
X1708 B8.t2 TOP.t7802 sky130_fd_pr__cap_mim_m3_1 l=3 w=3
X1709 B10.t595 TOP.t6104 sky130_fd_pr__cap_mim_m3_1 l=3 w=3
X1710 B11.t1785 TOP.t1548 sky130_fd_pr__cap_mim_m3_1 l=3 w=3
X1711 B9.t218 TOP.t586 sky130_fd_pr__cap_mim_m3_1 l=3 w=3
X1712 B11.t2027 TOP.t1064 sky130_fd_pr__cap_mim_m3_1 l=3 w=3
X1713 B9.t24 TOP.t974 sky130_fd_pr__cap_mim_m3_1 l=3 w=3
X1714 EDGE_BIAS.t750 EDGE_BIAS.t751 sky130_fd_pr__cap_mim_m3_1 l=3 w=3
X1715 B11.t570 TOP.t3978 sky130_fd_pr__cap_mim_m3_1 l=3 w=3
X1716 B11.t1151 TOP.t2816 sky130_fd_pr__cap_mim_m3_1 l=3 w=3
X1717 B5.t0 TOP.t8128 sky130_fd_pr__cap_mim_m3_1 l=3 w=3
X1718 B11.t225 TOP.t4668 sky130_fd_pr__cap_mim_m3_1 l=3 w=3
X1719 B11.t204 TOP.t4710 sky130_fd_pr__cap_mim_m3_1 l=3 w=3
X1720 EDGE_BIAS.t483 EDGE_BIAS.t484 sky130_fd_pr__cap_mim_m3_1 l=3 w=3
X1721 B9.t180 TOP.t662 sky130_fd_pr__cap_mim_m3_1 l=3 w=3
X1722 B9.t142 TOP.t738 sky130_fd_pr__cap_mim_m3_1 l=3 w=3
X1723 B10.t494 TOP.t6306 sky130_fd_pr__cap_mim_m3_1 l=3 w=3
X1724 B11.t532 TOP.t4054 sky130_fd_pr__cap_mim_m3_1 l=3 w=3
X1725 B11.t774 TOP.t3570 sky130_fd_pr__cap_mim_m3_1 l=3 w=3
X1726 EDGE_BIAS.t666 EDGE_BIAS.t667 sky130_fd_pr__cap_mim_m3_1 l=3 w=3
X1727 EDGE_BIAS.t564 EDGE_BIAS.t565 sky130_fd_pr__cap_mim_m3_1 l=3 w=3
X1728 B11.t310 TOP.t4498 sky130_fd_pr__cap_mim_m3_1 l=3 w=3
X1729 B11.t1605 TOP.t1908 sky130_fd_pr__cap_mim_m3_1 l=3 w=3
X1730 B11.t736 TOP.t3646 sky130_fd_pr__cap_mim_m3_1 l=3 w=3
X1731 B11.t1692 TOP.t1734 sky130_fd_pr__cap_mim_m3_1 l=3 w=3
X1732 B11.t874 TOP.t3370 sky130_fd_pr__cap_mim_m3_1 l=3 w=3
X1733 B10.t197 TOP.t6900 sky130_fd_pr__cap_mim_m3_1 l=3 w=3
X1734 B11.t1498 TOP.t2122 sky130_fd_pr__cap_mim_m3_1 l=3 w=3
X1735 B11.t1218 TOP.t2682 sky130_fd_pr__cap_mim_m3_1 l=3 w=3
X1736 B9.t266 TOP.t490 sky130_fd_pr__cap_mim_m3_1 l=3 w=3
X1737 B10.t159 TOP.t6976 sky130_fd_pr__cap_mim_m3_1 l=3 w=3
X1738 B11.t1460 TOP.t2198 sky130_fd_pr__cap_mim_m3_1 l=3 w=3
X1739 B11.t965 TOP.t3188 sky130_fd_pr__cap_mim_m3_1 l=3 w=3
X1740 B10.t560 TOP.t6174 sky130_fd_pr__cap_mim_m3_1 l=3 w=3
X1741 EDGE_BIAS.t537 EDGE_BIAS.t538 sky130_fd_pr__cap_mim_m3_1 l=3 w=3
X1742 B10.t401 TOP.t6492 sky130_fd_pr__cap_mim_m3_1 l=3 w=3
X1743 B10.t121 TOP.t7052 sky130_fd_pr__cap_mim_m3_1 l=3 w=3
X1744 B6.t62 TOP.t5122 sky130_fd_pr__cap_mim_m3_1 l=3 w=3
X1745 B11.t927 TOP.t3264 sky130_fd_pr__cap_mim_m3_1 l=3 w=3
X1746 B10.t83 TOP.t7128 sky130_fd_pr__cap_mim_m3_1 l=3 w=3
X1747 B10.t363 TOP.t6568 sky130_fd_pr__cap_mim_m3_1 l=3 w=3
X1748 B10.t325 TOP.t6644 sky130_fd_pr__cap_mim_m3_1 l=3 w=3
X1749 B11.t169 TOP.t4780 sky130_fd_pr__cap_mim_m3_1 l=3 w=3
X1750 B10.t45 TOP.t7204 sky130_fd_pr__cap_mim_m3_1 l=3 w=3
X1751 B6.t23 TOP.t5200 sky130_fd_pr__cap_mim_m3_1 l=3 w=3
X1752 B11.t314 TOP.t4490 sky130_fd_pr__cap_mim_m3_1 l=3 w=3
X1753 B10.t1014 TOP.t5266 sky130_fd_pr__cap_mim_m3_1 l=3 w=3
X1754 B11.t1845 TOP.t1428 sky130_fd_pr__cap_mim_m3_1 l=3 w=3
X1755 EDGE_BIAS.t75 EDGE_BIAS.t76 sky130_fd_pr__cap_mim_m3_1 l=3 w=3
X1756 EDGE_BIAS.t600 EDGE_BIAS.t601 sky130_fd_pr__cap_mim_m3_1 l=3 w=3
X1757 B11.t16 TOP.t5086 sky130_fd_pr__cap_mim_m3_1 l=3 w=3
X1758 B11.t329 TOP.t4460 sky130_fd_pr__cap_mim_m3_1 l=3 w=3
X1759 B11.t630 TOP.t3858 sky130_fd_pr__cap_mim_m3_1 l=3 w=3
X1760 B11.t1565 TOP.t1988 sky130_fd_pr__cap_mim_m3_1 l=3 w=3
X1761 B10.t579 TOP.t6136 sky130_fd_pr__cap_mim_m3_1 l=3 w=3
X1762 B9.t202 TOP.t618 sky130_fd_pr__cap_mim_m3_1 l=3 w=3
X1763 B11.t592 TOP.t3934 sky130_fd_pr__cap_mim_m3_1 l=3 w=3
X1764 B10.t869 TOP.t5556 sky130_fd_pr__cap_mim_m3_1 l=3 w=3
X1765 B9.t8 TOP.t1006 sky130_fd_pr__cap_mim_m3_1 l=3 w=3
X1766 B11.t834 TOP.t3450 sky130_fd_pr__cap_mim_m3_1 l=3 w=3
X1767 B11.t1135 TOP.t2848 sky130_fd_pr__cap_mim_m3_1 l=3 w=3
X1768 B11.t1023 TOP.t3072 sky130_fd_pr__cap_mim_m3_1 l=3 w=3
X1769 B10.t69 TOP.t7156 sky130_fd_pr__cap_mim_m3_1 l=3 w=3
X1770 B9.t164 TOP.t694 sky130_fd_pr__cap_mim_m3_1 l=3 w=3
X1771 B11.t54 TOP.t5010 sky130_fd_pr__cap_mim_m3_1 l=3 w=3
X1772 B11.t516 TOP.t4086 sky130_fd_pr__cap_mim_m3_1 l=3 w=3
X1773 B11.t554 TOP.t4010 sky130_fd_pr__cap_mim_m3_1 l=3 w=3
X1774 B10.t478 TOP.t6338 sky130_fd_pr__cap_mim_m3_1 l=3 w=3
X1775 B11.t796 TOP.t3526 sky130_fd_pr__cap_mim_m3_1 l=3 w=3
X1776 B11.t85 TOP.t4948 sky130_fd_pr__cap_mim_m3_1 l=3 w=3
X1777 B11.t758 TOP.t3602 sky130_fd_pr__cap_mim_m3_1 l=3 w=3
X1778 B10.t440 TOP.t6414 sky130_fd_pr__cap_mim_m3_1 l=3 w=3
X1779 B11.t383 TOP.t4352 sky130_fd_pr__cap_mim_m3_1 l=3 w=3
X1780 B11.t404 TOP.t4310 sky130_fd_pr__cap_mim_m3_1 l=3 w=3
X1781 B9.t443 TOP.t136 sky130_fd_pr__cap_mim_m3_1 l=3 w=3
X1782 B11.t720 TOP.t3678 sky130_fd_pr__cap_mim_m3_1 l=3 w=3
X1783 B11.t1230 TOP.t2658 sky130_fd_pr__cap_mim_m3_1 l=3 w=3
X1784 B11.t1520 TOP.t2078 sky130_fd_pr__cap_mim_m3_1 l=3 w=3
X1785 B11.t113 TOP.t4892 sky130_fd_pr__cap_mim_m3_1 l=3 w=3
X1786 B11.t56 TOP.t5006 sky130_fd_pr__cap_mim_m3_1 l=3 w=3
X1787 B11.t432 TOP.t4254 sky130_fd_pr__cap_mim_m3_1 l=3 w=3
X1788 B10.t974 TOP.t5346 sky130_fd_pr__cap_mim_m3_1 l=3 w=3
X1789 B9.t188 TOP.t646 sky130_fd_pr__cap_mim_m3_1 l=3 w=3
X1790 B11.t294 TOP.t4530 sky130_fd_pr__cap_mim_m3_1 l=3 w=3
X1791 B10.t143 TOP.t7008 sky130_fd_pr__cap_mim_m3_1 l=3 w=3
X1792 B11.t949 TOP.t3220 sky130_fd_pr__cap_mim_m3_1 l=3 w=3
X1793 B11.t1014 TOP.t3090 sky130_fd_pr__cap_mim_m3_1 l=3 w=3
X1794 B10.t936 TOP.t5422 sky130_fd_pr__cap_mim_m3_1 l=3 w=3
X1795 B10.t544 TOP.t6206 sky130_fd_pr__cap_mim_m3_1 l=3 w=3
X1796 B11.t911 TOP.t3296 sky130_fd_pr__cap_mim_m3_1 l=3 w=3
X1797 B10.t105 TOP.t7084 sky130_fd_pr__cap_mim_m3_1 l=3 w=3
X1798 B10.t347 TOP.t6600 sky130_fd_pr__cap_mim_m3_1 l=3 w=3
X1799 B11.t873 TOP.t3372 sky130_fd_pr__cap_mim_m3_1 l=3 w=3
X1800 B10.t639 TOP.t6016 sky130_fd_pr__cap_mim_m3_1 l=3 w=3
X1801 B9.t312 TOP.t398 sky130_fd_pr__cap_mim_m3_1 l=3 w=3
X1802 B8.t125 TOP.t7556 sky130_fd_pr__cap_mim_m3_1 l=3 w=3
X1803 B11.t1829 TOP.t1460 sky130_fd_pr__cap_mim_m3_1 l=3 w=3
X1804 EDGE_BIAS.t123 EDGE_BIAS.t124 sky130_fd_pr__cap_mim_m3_1 l=3 w=3
X1805 B10.t601 TOP.t6092 sky130_fd_pr__cap_mim_m3_1 l=3 w=3
X1806 B11.t1549 TOP.t2020 sky130_fd_pr__cap_mim_m3_1 l=3 w=3
X1807 B9.t403 TOP.t216 sky130_fd_pr__cap_mim_m3_1 l=3 w=3
X1808 B11.t210 TOP.t4698 sky130_fd_pr__cap_mim_m3_1 l=3 w=3
X1809 B10.t129 TOP.t7036 sky130_fd_pr__cap_mim_m3_1 l=3 w=3
X1810 B11.t2033 TOP.t1052 sky130_fd_pr__cap_mim_m3_1 l=3 w=3
X1811 B11.t576 TOP.t3966 sky130_fd_pr__cap_mim_m3_1 l=3 w=3
X1812 B10.t5 TOP.t7284 sky130_fd_pr__cap_mim_m3_1 l=3 w=3
X1813 B9.t365 TOP.t292 sky130_fd_pr__cap_mim_m3_1 l=3 w=3
X1814 B11.t433 TOP.t4252 sky130_fd_pr__cap_mim_m3_1 l=3 w=3
X1815 B9.t148 TOP.t726 sky130_fd_pr__cap_mim_m3_1 l=3 w=3
X1816 B11.t538 TOP.t4042 sky130_fd_pr__cap_mim_m3_1 l=3 w=3
X1817 B11.t238 TOP.t4642 sky130_fd_pr__cap_mim_m3_1 l=3 w=3
X1818 EDGE_BIAS.t648 EDGE_BIAS.t649 sky130_fd_pr__cap_mim_m3_1 l=3 w=3
X1819 B11.t780 TOP.t3558 sky130_fd_pr__cap_mim_m3_1 l=3 w=3
X1820 B11.t1853 TOP.t1412 sky130_fd_pr__cap_mim_m3_1 l=3 w=3
X1821 B11.t146 TOP.t4826 sky130_fd_pr__cap_mim_m3_1 l=3 w=3
X1822 B11.t33 TOP.t5052 sky130_fd_pr__cap_mim_m3_1 l=3 w=3
X1823 B11.t704 TOP.t3710 sky130_fd_pr__cap_mim_m3_1 l=3 w=3
X1824 B11.t742 TOP.t3634 sky130_fd_pr__cap_mim_m3_1 l=3 w=3
X1825 B10.t320 TOP.t6654 sky130_fd_pr__cap_mim_m3_1 l=3 w=3
X1826 B7.t65 TOP.t7932 sky130_fd_pr__cap_mim_m3_1 l=3 w=3
X1827 B9.t248 TOP.t526 sky130_fd_pr__cap_mim_m3_1 l=3 w=3
X1828 B11.t1504 TOP.t2110 sky130_fd_pr__cap_mim_m3_1 l=3 w=3
X1829 B11.t327 TOP.t4464 sky130_fd_pr__cap_mim_m3_1 l=3 w=3
X1830 B11.t562 TOP.t3994 sky130_fd_pr__cap_mim_m3_1 l=3 w=3
X1831 B10.t958 TOP.t5378 sky130_fd_pr__cap_mim_m3_1 l=3 w=3
X1832 B9.t272 TOP.t478 sky130_fd_pr__cap_mim_m3_1 l=3 w=3
X1833 B8.t85 TOP.t7636 sky130_fd_pr__cap_mim_m3_1 l=3 w=3
X1834 B11.t1466 TOP.t2186 sky130_fd_pr__cap_mim_m3_1 l=3 w=3
X1835 B8.t47 TOP.t7712 sky130_fd_pr__cap_mim_m3_1 l=3 w=3
X1836 B10.t920 TOP.t5454 sky130_fd_pr__cap_mim_m3_1 l=3 w=3
X1837 B5.t20 TOP.t8088 sky130_fd_pr__cap_mim_m3_1 l=3 w=3
X1838 B10.t89 TOP.t7116 sky130_fd_pr__cap_mim_m3_1 l=3 w=3
X1839 B11.t473 TOP.t4172 sky130_fd_pr__cap_mim_m3_1 l=3 w=3
X1840 B10.t331 TOP.t6632 sky130_fd_pr__cap_mim_m3_1 l=3 w=3
X1841 B7.t0 TOP.t8062 sky130_fd_pr__cap_mim_m3_1 l=3 w=3
X1842 B10.t51 TOP.t7192 sky130_fd_pr__cap_mim_m3_1 l=3 w=3
X1843 B11.t1920 TOP.t1278 sky130_fd_pr__cap_mim_m3_1 l=3 w=3
X1844 B11.t381 TOP.t4356 sky130_fd_pr__cap_mim_m3_1 l=3 w=3
X1845 B10.t189 TOP.t6916 sky130_fd_pr__cap_mim_m3_1 l=3 w=3
X1846 B11.t1813 TOP.t1492 sky130_fd_pr__cap_mim_m3_1 l=3 w=3
X1847 EDGE_BIAS.t171 EDGE_BIAS.t172 sky130_fd_pr__cap_mim_m3_1 l=3 w=3
X1848 B11.t1775 TOP.t1568 sky130_fd_pr__cap_mim_m3_1 l=3 w=3
X1849 B10.t585 TOP.t6124 sky130_fd_pr__cap_mim_m3_1 l=3 w=3
X1850 B2.t2 TOP.t8186 sky130_fd_pr__cap_mim_m3_1 l=3 w=3
X1851 B10.t280 TOP.t6734 sky130_fd_pr__cap_mim_m3_1 l=3 w=3
X1852 B9.t387 TOP.t248 sky130_fd_pr__cap_mim_m3_1 l=3 w=3
X1853 B9.t208 TOP.t606 sky130_fd_pr__cap_mim_m3_1 l=3 w=3
X1854 B11.t363 TOP.t4392 sky130_fd_pr__cap_mim_m3_1 l=3 w=3
X1855 B11.t2017 TOP.t1084 sky130_fd_pr__cap_mim_m3_1 l=3 w=3
X1856 B10.t875 TOP.t5544 sky130_fd_pr__cap_mim_m3_1 l=3 w=3
X1857 B3.t2 TOP.t8140 sky130_fd_pr__cap_mim_m3_1 l=3 w=3
X1858 B9.t14 TOP.t994 sky130_fd_pr__cap_mim_m3_1 l=3 w=3
X1859 B9.t349 TOP.t324 sky130_fd_pr__cap_mim_m3_1 l=3 w=3
X1860 B11.t271 TOP.t4576 sky130_fd_pr__cap_mim_m3_1 l=3 w=3
X1861 B10.t242 TOP.t6810 sky130_fd_pr__cap_mim_m3_1 l=3 w=3
X1862 B9.t170 TOP.t682 sky130_fd_pr__cap_mim_m3_1 l=3 w=3
X1863 B11.t522 TOP.t4074 sky130_fd_pr__cap_mim_m3_1 l=3 w=3
X1864 B9.t132 TOP.t758 sky130_fd_pr__cap_mim_m3_1 l=3 w=3
X1865 B10.t484 TOP.t6326 sky130_fd_pr__cap_mim_m3_1 l=3 w=3
X1866 B9.t311 TOP.t400 sky130_fd_pr__cap_mim_m3_1 l=3 w=3
X1867 B11.t764 TOP.t3590 sky130_fd_pr__cap_mim_m3_1 l=3 w=3
X1868 B11.t1353 TOP.t2412 sky130_fd_pr__cap_mim_m3_1 l=3 w=3
X1869 B11.t726 TOP.t3666 sky130_fd_pr__cap_mim_m3_1 l=3 w=3
X1870 B11.t417 TOP.t4284 sky130_fd_pr__cap_mim_m3_1 l=3 w=3
X1871 B11.t622 TOP.t3874 sky130_fd_pr__cap_mim_m3_1 l=3 w=3
X1872 B11.t1880 TOP.t1358 sky130_fd_pr__cap_mim_m3_1 l=3 w=3
X1873 B11.t1488 TOP.t2142 sky130_fd_pr__cap_mim_m3_1 l=3 w=3
X1874 B11.t1208 TOP.t2702 sky130_fd_pr__cap_mim_m3_1 l=3 w=3
X1875 B8.t69 TOP.t7668 sky130_fd_pr__cap_mim_m3_1 l=3 w=3
X1876 B10.t508 TOP.t6278 sky130_fd_pr__cap_mim_m3_1 l=3 w=3
X1877 B9.t256 TOP.t510 sky130_fd_pr__cap_mim_m3_1 l=3 w=3
X1878 B10.t149 TOP.t6996 sky130_fd_pr__cap_mim_m3_1 l=3 w=3
X1879 B11.t1450 TOP.t2218 sky130_fd_pr__cap_mim_m3_1 l=3 w=3
X1880 EDGE_BIAS.t561 EDGE_BIAS.t562 sky130_fd_pr__cap_mim_m3_1 l=3 w=3
X1881 B11.t955 TOP.t3208 sky130_fd_pr__cap_mim_m3_1 l=3 w=3
X1882 B10.t391 TOP.t6512 sky130_fd_pr__cap_mim_m3_1 l=3 w=3
X1883 B8.t31 TOP.t7744 sky130_fd_pr__cap_mim_m3_1 l=3 w=3
X1884 B11.t50 TOP.t5018 sky130_fd_pr__cap_mim_m3_1 l=3 w=3
X1885 B11.t675 TOP.t3768 sky130_fd_pr__cap_mim_m3_1 l=3 w=3
X1886 B11.t750 TOP.t3618 sky130_fd_pr__cap_mim_m3_1 l=3 w=3
X1887 B11.t917 TOP.t3284 sky130_fd_pr__cap_mim_m3_1 l=3 w=3
X1888 B10.t73 TOP.t7148 sky130_fd_pr__cap_mim_m3_1 l=3 w=3
X1889 B10.t111 TOP.t7072 sky130_fd_pr__cap_mim_m3_1 l=3 w=3
X1890 B6.t52 TOP.t5142 sky130_fd_pr__cap_mim_m3_1 l=3 w=3
X1891 B10.t353 TOP.t6588 sky130_fd_pr__cap_mim_m3_1 l=3 w=3
X1892 B11.t1654 TOP.t1810 sky130_fd_pr__cap_mim_m3_1 l=3 w=3
X1893 B9.t247 TOP.t528 sky130_fd_pr__cap_mim_m3_1 l=3 w=3
X1894 EDGE_BIAS.t717 EDGE_BIAS.t718 sky130_fd_pr__cap_mim_m3_1 l=3 w=3
X1895 B10.t762 TOP.t5770 sky130_fd_pr__cap_mim_m3_1 l=3 w=3
X1896 B6.t13 TOP.t5220 sky130_fd_pr__cap_mim_m3_1 l=3 w=3
X1897 B10.t35 TOP.t7224 sky130_fd_pr__cap_mim_m3_1 l=3 w=3
X1898 B11.t1835 TOP.t1448 sky130_fd_pr__cap_mim_m3_1 l=3 w=3
X1899 B11.t1313 TOP.t2492 sky130_fd_pr__cap_mim_m3_1 l=3 w=3
X1900 B11.t1555 TOP.t2008 sky130_fd_pr__cap_mim_m3_1 l=3 w=3
X1901 B11.t941 TOP.t3236 sky130_fd_pr__cap_mim_m3_1 l=3 w=3
X1902 B10.t264 TOP.t6766 sky130_fd_pr__cap_mim_m3_1 l=3 w=3
X1903 B11.t1275 TOP.t2568 sky130_fd_pr__cap_mim_m3_1 l=3 w=3
X1904 B10.t859 TOP.t5576 sky130_fd_pr__cap_mim_m3_1 l=3 w=3
X1905 B11.t1019 TOP.t3080 sky130_fd_pr__cap_mim_m3_1 l=3 w=3
X1906 B11.t582 TOP.t3954 sky130_fd_pr__cap_mim_m3_1 l=3 w=3
X1907 B11.t824 TOP.t3470 sky130_fd_pr__cap_mim_m3_1 l=3 w=3
X1908 B11.t1125 TOP.t2868 sky130_fd_pr__cap_mim_m3_1 l=3 w=3
X1909 B10.t226 TOP.t6842 sky130_fd_pr__cap_mim_m3_1 l=3 w=3
X1910 B9.t154 TOP.t714 sky130_fd_pr__cap_mim_m3_1 l=3 w=3
X1911 B10.t468 TOP.t6358 sky130_fd_pr__cap_mim_m3_1 l=3 w=3
X1912 B11.t506 TOP.t4106 sky130_fd_pr__cap_mim_m3_1 l=3 w=3
X1913 B11.t544 TOP.t4030 sky130_fd_pr__cap_mim_m3_1 l=3 w=3
X1914 B11.t152 TOP.t4814 sky130_fd_pr__cap_mim_m3_1 l=3 w=3
X1915 B11.t131 TOP.t4856 sky130_fd_pr__cap_mim_m3_1 l=3 w=3
X1916 B11.t786 TOP.t3546 sky130_fd_pr__cap_mim_m3_1 l=3 w=3
X1917 B11.t1087 TOP.t2944 sky130_fd_pr__cap_mim_m3_1 l=3 w=3
X1918 B10.t188 TOP.t6918 sky130_fd_pr__cap_mim_m3_1 l=3 w=3
X1919 B8.t189 TOP.t7428 sky130_fd_pr__cap_mim_m3_1 l=3 w=3
X1920 B10.t430 TOP.t6434 sky130_fd_pr__cap_mim_m3_1 l=3 w=3
X1921 B11.t450 TOP.t4218 sky130_fd_pr__cap_mim_m3_1 l=3 w=3
X1922 B10.t631 TOP.t6032 sky130_fd_pr__cap_mim_m3_1 l=3 w=3
X1923 B11.t710 TOP.t3698 sky130_fd_pr__cap_mim_m3_1 l=3 w=3
X1924 B11.t180 TOP.t4758 sky130_fd_pr__cap_mim_m3_1 l=3 w=3
X1925 B10.t722 TOP.t5850 sky130_fd_pr__cap_mim_m3_1 l=3 w=3
X1926 B11.t1864 TOP.t1390 sky130_fd_pr__cap_mim_m3_1 l=3 w=3
X1927 B10.t964 TOP.t5366 sky130_fd_pr__cap_mim_m3_1 l=3 w=3
X1928 B11.t755 TOP.t3608 sky130_fd_pr__cap_mim_m3_1 l=3 w=3
X1929 B10.t684 TOP.t5926 sky130_fd_pr__cap_mim_m3_1 l=3 w=3
X1930 B11.t340 TOP.t4438 sky130_fd_pr__cap_mim_m3_1 l=3 w=3
X1931 B11.t1010 TOP.t3098 sky130_fd_pr__cap_mim_m3_1 l=3 w=3
X1932 B10.t926 TOP.t5442 sky130_fd_pr__cap_mim_m3_1 l=3 w=3
X1933 B10.t534 TOP.t6226 sky130_fd_pr__cap_mim_m3_1 l=3 w=3
X1934 B11.t659 TOP.t3800 sky130_fd_pr__cap_mim_m3_1 l=3 w=3
X1935 B6.t36 TOP.t5174 sky130_fd_pr__cap_mim_m3_1 l=3 w=3
X1936 B11.t901 TOP.t3316 sky130_fd_pr__cap_mim_m3_1 l=3 w=3
X1937 B10.t95 TOP.t7104 sky130_fd_pr__cap_mim_m3_1 l=3 w=3
X1938 B9.t492 TOP.t38 sky130_fd_pr__cap_mim_m3_1 l=3 w=3
X1939 B10.t337 TOP.t6620 sky130_fd_pr__cap_mim_m3_1 l=3 w=3
X1940 B11.t621 TOP.t3876 sky130_fd_pr__cap_mim_m3_1 l=3 w=3
X1941 B10.t57 TOP.t7180 sky130_fd_pr__cap_mim_m3_1 l=3 w=3
X1942 B5.t13 TOP.t8102 sky130_fd_pr__cap_mim_m3_1 l=3 w=3
X1943 B9.t127 TOP.t768 sky130_fd_pr__cap_mim_m3_1 l=3 w=3
X1944 B11.t863 TOP.t3392 sky130_fd_pr__cap_mim_m3_1 l=3 w=3
X1945 B10.t19 TOP.t7256 sky130_fd_pr__cap_mim_m3_1 l=3 w=3
X1946 B11.t96 TOP.t4926 sky130_fd_pr__cap_mim_m3_1 l=3 w=3
X1947 B11.t1819 TOP.t1480 sky130_fd_pr__cap_mim_m3_1 l=3 w=3
X1948 B11.t415 TOP.t4288 sky130_fd_pr__cap_mim_m3_1 l=3 w=3
X1949 B11.t1297 TOP.t2524 sky130_fd_pr__cap_mim_m3_1 l=3 w=3
X1950 B10.t950 TOP.t5394 sky130_fd_pr__cap_mim_m3_1 l=3 w=3
X1951 B8.t149 TOP.t7508 sky130_fd_pr__cap_mim_m3_1 l=3 w=3
X1952 B11.t1781 TOP.t1556 sky130_fd_pr__cap_mim_m3_1 l=3 w=3
X1953 B10.t591 TOP.t6112 sky130_fd_pr__cap_mim_m3_1 l=3 w=3
X1954 B9.t393 TOP.t236 sky130_fd_pr__cap_mim_m3_1 l=3 w=3
X1955 B11.t1259 TOP.t2600 sky130_fd_pr__cap_mim_m3_1 l=3 w=3
X1956 B7.t110 TOP.t7842 sky130_fd_pr__cap_mim_m3_1 l=3 w=3
X1957 B10.t1 TOP.t7292 sky130_fd_pr__cap_mim_m3_1 l=3 w=3
X1958 B9.t355 TOP.t312 sky130_fd_pr__cap_mim_m3_1 l=3 w=3
X1959 B11.t181 TOP.t4756 sky130_fd_pr__cap_mim_m3_1 l=3 w=3
X1960 B11.t500 TOP.t4118 sky130_fd_pr__cap_mim_m3_1 l=3 w=3
X1961 B11.t528 TOP.t4062 sky130_fd_pr__cap_mim_m3_1 l=3 w=3
X1962 B9.t138 TOP.t746 sky130_fd_pr__cap_mim_m3_1 l=3 w=3
X1963 B10.t452 TOP.t6390 sky130_fd_pr__cap_mim_m3_1 l=3 w=3
X1964 B7.t47 TOP.t7968 sky130_fd_pr__cap_mim_m3_1 l=3 w=3
X1965 B11.t305 TOP.t4508 sky130_fd_pr__cap_mim_m3_1 l=3 w=3
X1966 B11.t770 TOP.t3578 sky130_fd_pr__cap_mim_m3_1 l=3 w=3
X1967 B10.t414 TOP.t6466 sky130_fd_pr__cap_mim_m3_1 l=3 w=3
X1968 B11.t732 TOP.t3654 sky130_fd_pr__cap_mim_m3_1 l=3 w=3
X1969 B11.t694 TOP.t3730 sky130_fd_pr__cap_mim_m3_1 l=3 w=3
X1970 B10.t376 TOP.t6542 sky130_fd_pr__cap_mim_m3_1 l=3 w=3
X1971 B10.t706 TOP.t5882 sky130_fd_pr__cap_mim_m3_1 l=3 w=3
X1972 B9.t379 TOP.t264 sky130_fd_pr__cap_mim_m3_1 l=3 w=3
X1973 B9.t87 TOP.t848 sky130_fd_pr__cap_mim_m3_1 l=3 w=3
X1974 B11.t1214 TOP.t2690 sky130_fd_pr__cap_mim_m3_1 l=3 w=3
X1975 B8.t75 TOP.t7656 sky130_fd_pr__cap_mim_m3_1 l=3 w=3
X1976 B9.t262 TOP.t498 sky130_fd_pr__cap_mim_m3_1 l=3 w=3
X1977 B10.t668 TOP.t5958 sky130_fd_pr__cap_mim_m3_1 l=3 w=3
X1978 B10.t910 TOP.t5474 sky130_fd_pr__cap_mim_m3_1 l=3 w=3
X1979 B8.t37 TOP.t7732 sky130_fd_pr__cap_mim_m3_1 l=3 w=3
X1980 EDGE_BIAS.t36 EDGE_BIAS.t37 sky130_fd_pr__cap_mim_m3_1 l=3 w=3
X1981 B10.t79 TOP.t7136 sky130_fd_pr__cap_mim_m3_1 l=3 w=3
X1982 B10.t630 TOP.t6034 sky130_fd_pr__cap_mim_m3_1 l=3 w=3
X1983 B6.t58 TOP.t5130 sky130_fd_pr__cap_mim_m3_1 l=3 w=3
X1984 B11.t221 TOP.t4676 sky130_fd_pr__cap_mim_m3_1 l=3 w=3
X1985 B11.t885 TOP.t3348 sky130_fd_pr__cap_mim_m3_1 l=3 w=3
X1986 B11.t129 TOP.t4860 sky130_fd_pr__cap_mim_m3_1 l=3 w=3
X1987 EDGE_BIAS.t453 EDGE_BIAS.t454 sky130_fd_pr__cap_mim_m3_1 l=3 w=3
X1988 B6.t19 TOP.t5208 sky130_fd_pr__cap_mim_m3_1 l=3 w=3
X1989 B10.t41 TOP.t7212 sky130_fd_pr__cap_mim_m3_1 l=3 w=3
X1990 B4.t5 TOP.t8172 sky130_fd_pr__cap_mim_m3_1 l=3 w=3
X1991 B11.t847 TOP.t3424 sky130_fd_pr__cap_mim_m3_1 l=3 w=3
X1992 EDGE_BIAS.t615 EDGE_BIAS.t616 sky130_fd_pr__cap_mim_m3_1 l=3 w=3
X1993 B11.t1803 TOP.t1512 sky130_fd_pr__cap_mim_m3_1 l=3 w=3
X1994 EDGE_BIAS.t534 EDGE_BIAS.t535 sky130_fd_pr__cap_mim_m3_1 l=3 w=3
X1995 B11.t809 TOP.t3500 sky130_fd_pr__cap_mim_m3_1 l=3 w=3
X1996 B8.t133 TOP.t7540 sky130_fd_pr__cap_mim_m3_1 l=3 w=3
X1997 B8.t61 TOP.t7684 sky130_fd_pr__cap_mim_m3_1 l=3 w=3
X1998 B11.t1765 TOP.t1588 sky130_fd_pr__cap_mim_m3_1 l=3 w=3
X1999 B10.t575 TOP.t6144 sky130_fd_pr__cap_mim_m3_1 l=3 w=3
X2000 B10.t270 TOP.t6754 sky130_fd_pr__cap_mim_m3_1 l=3 w=3
X2001 B9.t198 TOP.t626 sky130_fd_pr__cap_mim_m3_1 l=3 w=3
X2002 B11.t2007 TOP.t1104 sky130_fd_pr__cap_mim_m3_1 l=3 w=3
X2003 B7.t94 TOP.t7874 sky130_fd_pr__cap_mim_m3_1 l=3 w=3
X2004 B9.t4 TOP.t1014 sky130_fd_pr__cap_mim_m3_1 l=3 w=3
X2005 B9.t339 TOP.t344 sky130_fd_pr__cap_mim_m3_1 l=3 w=3
X2006 B10.t65 TOP.t7164 sky130_fd_pr__cap_mim_m3_1 l=3 w=3
X2007 B10.t232 TOP.t6830 sky130_fd_pr__cap_mim_m3_1 l=3 w=3
X2008 B11.t1969 TOP.t1180 sky130_fd_pr__cap_mim_m3_1 l=3 w=3
X2009 B11.t1533 TOP.t2052 sky130_fd_pr__cap_mim_m3_1 l=3 w=3
X2010 B9.t160 TOP.t702 sky130_fd_pr__cap_mim_m3_1 l=3 w=3
X2011 B10.t474 TOP.t6346 sky130_fd_pr__cap_mim_m3_1 l=3 w=3
X2012 B11.t512 TOP.t4094 sky130_fd_pr__cap_mim_m3_1 l=3 w=3
X2013 B9.t301 TOP.t420 sky130_fd_pr__cap_mim_m3_1 l=3 w=3
X2014 EDGE_BIAS.t507 EDGE_BIAS.t508 sky130_fd_pr__cap_mim_m3_1 l=3 w=3
X2015 B10.t436 TOP.t6422 sky130_fd_pr__cap_mim_m3_1 l=3 w=3
X2016 B11.t41 TOP.t5036 sky130_fd_pr__cap_mim_m3_1 l=3 w=3
X2017 B11.t716 TOP.t3686 sky130_fd_pr__cap_mim_m3_1 l=3 w=3
X2018 B10.t398 TOP.t6498 sky130_fd_pr__cap_mim_m3_1 l=3 w=3
X2019 B11.t165 TOP.t4788 sky130_fd_pr__cap_mim_m3_1 l=3 w=3
X2020 B11.t73 TOP.t4972 sky130_fd_pr__cap_mim_m3_1 l=3 w=3
X2021 B11.t484 TOP.t4150 sky130_fd_pr__cap_mim_m3_1 l=3 w=3
X2022 B11.t1870 TOP.t1378 sky130_fd_pr__cap_mim_m3_1 l=3 w=3
X2023 B10.t360 TOP.t6574 sky130_fd_pr__cap_mim_m3_1 l=3 w=3
X2024 B9.t71 TOP.t880 sky130_fd_pr__cap_mim_m3_1 l=3 w=3
X2025 B11.t346 TOP.t4426 sky130_fd_pr__cap_mim_m3_1 l=3 w=3
X2026 B10.t256 TOP.t6782 sky130_fd_pr__cap_mim_m3_1 l=3 w=3
X2027 B11.t1198 TOP.t2722 sky130_fd_pr__cap_mim_m3_1 l=3 w=3
X2028 B11.t1440 TOP.t2238 sky130_fd_pr__cap_mim_m3_1 l=3 w=3
X2029 B11.t254 TOP.t4610 sky130_fd_pr__cap_mim_m3_1 l=3 w=3
X2030 B11.t945 TOP.t3228 sky130_fd_pr__cap_mim_m3_1 l=3 w=3
X2031 B10.t139 TOP.t7016 sky130_fd_pr__cap_mim_m3_1 l=3 w=3
X2032 B10.t894 TOP.t5506 sky130_fd_pr__cap_mim_m3_1 l=3 w=3
X2033 B8.t21 TOP.t7764 sky130_fd_pr__cap_mim_m3_1 l=3 w=3
X2034 B11.t665 TOP.t3788 sky130_fd_pr__cap_mim_m3_1 l=3 w=3
X2035 B10.t101 TOP.t7092 sky130_fd_pr__cap_mim_m3_1 l=3 w=3
X2036 B11.t1402 TOP.t2314 sky130_fd_pr__cap_mim_m3_1 l=3 w=3
X2037 B6.t42 TOP.t5162 sky130_fd_pr__cap_mim_m3_1 l=3 w=3
X2038 B11.t907 TOP.t3304 sky130_fd_pr__cap_mim_m3_1 l=3 w=3
X2039 B9.t237 TOP.t548 sky130_fd_pr__cap_mim_m3_1 l=3 w=3
X2040 B10.t384 TOP.t6526 sky130_fd_pr__cap_mim_m3_1 l=3 w=3
X2041 B6.t3 TOP.t5240 sky130_fd_pr__cap_mim_m3_1 l=3 w=3
X2042 B11.t869 TOP.t3380 sky130_fd_pr__cap_mim_m3_1 l=3 w=3
X2043 B10.t25 TOP.t7244 sky130_fd_pr__cap_mim_m3_1 l=3 w=3
X2044 B11.t831 TOP.t3456 sky130_fd_pr__cap_mim_m3_1 l=3 w=3
X2045 B11.t400 TOP.t4318 sky130_fd_pr__cap_mim_m3_1 l=3 w=3
X2046 B11.t793 TOP.t3532 sky130_fd_pr__cap_mim_m3_1 l=3 w=3
X2047 B11.t1303 TOP.t2512 sky130_fd_pr__cap_mim_m3_1 l=3 w=3
X2048 B11.t689 TOP.t3740 sky130_fd_pr__cap_mim_m3_1 l=3 w=3
X2049 B10.t70 TOP.t7154 sky130_fd_pr__cap_mim_m3_1 l=3 w=3
X2050 B11.t1545 TOP.t2028 sky130_fd_pr__cap_mim_m3_1 l=3 w=3
X2051 B11.t1265 TOP.t2588 sky130_fd_pr__cap_mim_m3_1 l=3 w=3
X2052 B10.t849 TOP.t5596 sky130_fd_pr__cap_mim_m3_1 l=3 w=3
X2053 B11.t428 TOP.t4262 sky130_fd_pr__cap_mim_m3_1 l=3 w=3
X2054 B11.t572 TOP.t3974 sky130_fd_pr__cap_mim_m3_1 l=3 w=3
X2055 B9.t323 TOP.t376 sky130_fd_pr__cap_mim_m3_1 l=3 w=3
X2056 B6.t27 TOP.t5192 sky130_fd_pr__cap_mim_m3_1 l=3 w=3
X2057 B9.t144 TOP.t734 sky130_fd_pr__cap_mim_m3_1 l=3 w=3
X2058 B11.t290 TOP.t4538 sky130_fd_pr__cap_mim_m3_1 l=3 w=3
X2059 B11.t534 TOP.t4050 sky130_fd_pr__cap_mim_m3_1 l=3 w=3
X2060 B10.t216 TOP.t6862 sky130_fd_pr__cap_mim_m3_1 l=3 w=3
X2061 B10.t811 TOP.t5672 sky130_fd_pr__cap_mim_m3_1 l=3 w=3
X2062 B10.t458 TOP.t6378 sky130_fd_pr__cap_mim_m3_1 l=3 w=3
X2063 EDGE_BIAS.t768 EDGE_BIAS.t769 sky130_fd_pr__cap_mim_m3_1 l=3 w=3
X2064 B11.t198 TOP.t4722 sky130_fd_pr__cap_mim_m3_1 l=3 w=3
X2065 B9.t285 TOP.t452 sky130_fd_pr__cap_mim_m3_1 l=3 w=3
X2066 B11.t817 TOP.t3484 sky130_fd_pr__cap_mim_m3_1 l=3 w=3
X2067 B10.t178 TOP.t6938 sky130_fd_pr__cap_mim_m3_1 l=3 w=3
X2068 B10.t420 TOP.t6454 sky130_fd_pr__cap_mim_m3_1 l=3 w=3
X2069 B11.t123 TOP.t4872 sky130_fd_pr__cap_mim_m3_1 l=3 w=3
X2070 B11.t700 TOP.t3718 sky130_fd_pr__cap_mim_m3_1 l=3 w=3
X2071 EDGE_BIAS.t684 EDGE_BIAS.t685 sky130_fd_pr__cap_mim_m3_1 l=3 w=3
X2072 B11.t1289 TOP.t2540 sky130_fd_pr__cap_mim_m3_1 l=3 w=3
X2073 B10.t712 TOP.t5870 sky130_fd_pr__cap_mim_m3_1 l=3 w=3
X2074 B10.t954 TOP.t5386 sky130_fd_pr__cap_mim_m3_1 l=3 w=3
X2075 B10.t674 TOP.t5946 sky130_fd_pr__cap_mim_m3_1 l=3 w=3
X2076 B10.t916 TOP.t5462 sky130_fd_pr__cap_mim_m3_1 l=3 w=3
X2077 B8.t5 TOP.t7796 sky130_fd_pr__cap_mim_m3_1 l=3 w=3
X2078 B10.t444 TOP.t6406 sky130_fd_pr__cap_mim_m3_1 l=3 w=3
X2079 B11.t649 TOP.t3820 sky130_fd_pr__cap_mim_m3_1 l=3 w=3
X2080 B10.t85 TOP.t7124 sky130_fd_pr__cap_mim_m3_1 l=3 w=3
X2081 B8.t238 TOP.t7330 sky130_fd_pr__cap_mim_m3_1 l=3 w=3
X2082 B11.t891 TOP.t3336 sky130_fd_pr__cap_mim_m3_1 l=3 w=3
X2083 B11.t611 TOP.t3896 sky130_fd_pr__cap_mim_m3_1 l=3 w=3
X2084 B9.t221 TOP.t580 sky130_fd_pr__cap_mim_m3_1 l=3 w=3
X2085 B10.t47 TOP.t7200 sky130_fd_pr__cap_mim_m3_1 l=3 w=3
X2086 B5.t3 TOP.t8122 sky130_fd_pr__cap_mim_m3_1 l=3 w=3
X2087 B11.t853 TOP.t3412 sky130_fd_pr__cap_mim_m3_1 l=3 w=3
X2088 B10.t9 TOP.t7276 sky130_fd_pr__cap_mim_m3_1 l=3 w=3
X2089 B9.t183 TOP.t656 sky130_fd_pr__cap_mim_m3_1 l=3 w=3
X2090 B11.t163 TOP.t4792 sky130_fd_pr__cap_mim_m3_1 l=3 w=3
X2091 B10.t698 TOP.t5898 sky130_fd_pr__cap_mim_m3_1 l=3 w=3
X2092 B11.t461 TOP.t4196 sky130_fd_pr__cap_mim_m3_1 l=3 w=3
X2093 B8.t139 TOP.t7528 sky130_fd_pr__cap_mim_m3_1 l=3 w=3
X2094 B10.t581 TOP.t6132 sky130_fd_pr__cap_mim_m3_1 l=3 w=3
X2095 B9.t383 TOP.t256 sky130_fd_pr__cap_mim_m3_1 l=3 w=3
X2096 B3.t4 TOP.t8136 sky130_fd_pr__cap_mim_m3_1 l=3 w=3
X2097 B11.t323 TOP.t4472 sky130_fd_pr__cap_mim_m3_1 l=3 w=3
X2098 B11.t1249 TOP.t2620 sky130_fd_pr__cap_mim_m3_1 l=3 w=3
X2099 B7.t100 TOP.t7862 sky130_fd_pr__cap_mim_m3_1 l=3 w=3
X2100 B11.t248 TOP.t4622 sky130_fd_pr__cap_mim_m3_1 l=3 w=3
X2101 B9.t345 TOP.t332 sky130_fd_pr__cap_mim_m3_1 l=3 w=3
X2102 EDGE_BIAS.t423 EDGE_BIAS.t424 sky130_fd_pr__cap_mim_m3_1 l=3 w=3
X2103 B11.t518 TOP.t4082 sky130_fd_pr__cap_mim_m3_1 l=3 w=3
X2104 B11.t877 TOP.t3364 sky130_fd_pr__cap_mim_m3_1 l=3 w=3
X2105 B10.t200 TOP.t6894 sky130_fd_pr__cap_mim_m3_1 l=3 w=3
X2106 B9.t307 TOP.t408 sky130_fd_pr__cap_mim_m3_1 l=3 w=3
X2107 B10.t162 TOP.t6970 sky130_fd_pr__cap_mim_m3_1 l=3 w=3
X2108 B9.t269 TOP.t484 sky130_fd_pr__cap_mim_m3_1 l=3 w=3
X2109 B10.t404 TOP.t6486 sky130_fd_pr__cap_mim_m3_1 l=3 w=3
X2110 B11.t79 TOP.t4960 sky130_fd_pr__cap_mim_m3_1 l=3 w=3
X2111 B10.t124 TOP.t7046 sky130_fd_pr__cap_mim_m3_1 l=3 w=3
X2112 B9.t2 TOP.t1018 sky130_fd_pr__cap_mim_m3_1 l=3 w=3
X2113 B7.t124 TOP.t7814 sky130_fd_pr__cap_mim_m3_1 l=3 w=3
X2114 B10.t366 TOP.t6562 sky130_fd_pr__cap_mim_m3_1 l=3 w=3
X2115 B9.t77 TOP.t868 sky130_fd_pr__cap_mim_m3_1 l=3 w=3
X2116 B8.t65 TOP.t7676 sky130_fd_pr__cap_mim_m3_1 l=3 w=3
X2117 B10.t504 TOP.t6286 sky130_fd_pr__cap_mim_m3_1 l=3 w=3
X2118 B11.t107 TOP.t4904 sky130_fd_pr__cap_mim_m3_1 l=3 w=3
X2119 B11.t1848 TOP.t1422 sky130_fd_pr__cap_mim_m3_1 l=3 w=3
X2120 B10.t658 TOP.t5978 sky130_fd_pr__cap_mim_m3_1 l=3 w=3
X2121 B10.t900 TOP.t5494 sky130_fd_pr__cap_mim_m3_1 l=3 w=3
X2122 B8.t27 TOP.t7752 sky130_fd_pr__cap_mim_m3_1 l=3 w=3
X2123 B11.t633 TOP.t3852 sky130_fd_pr__cap_mim_m3_1 l=3 w=3
X2124 EDGE_BIAS.t66 EDGE_BIAS.t67 sky130_fd_pr__cap_mim_m3_1 l=3 w=3
X2125 B6.t48 TOP.t5150 sky130_fd_pr__cap_mim_m3_1 l=3 w=3
X2126 B11.t288 TOP.t4542 sky130_fd_pr__cap_mim_m3_1 l=3 w=3
X2127 EDGE_BIAS.t477 EDGE_BIAS.t478 sky130_fd_pr__cap_mim_m3_1 l=3 w=3
X2128 B10.t620 TOP.t6054 sky130_fd_pr__cap_mim_m3_1 l=3 w=3
X2129 B11.t267 TOP.t4584 sky130_fd_pr__cap_mim_m3_1 l=3 w=3
X2130 B9.t243 TOP.t536 sky130_fd_pr__cap_mim_m3_1 l=3 w=3
X2131 B9.t205 TOP.t612 sky130_fd_pr__cap_mim_m3_1 l=3 w=3
X2132 B9.t49 TOP.t924 sky130_fd_pr__cap_mim_m3_1 l=3 w=3
X2133 B11.t595 TOP.t3928 sky130_fd_pr__cap_mim_m3_1 l=3 w=3
X2134 B6.t9 TOP.t5228 sky130_fd_pr__cap_mim_m3_1 l=3 w=3
X2135 B10.t31 TOP.t7232 sky130_fd_pr__cap_mim_m3_1 l=3 w=3
X2136 B2.t1 TOP.t8188 sky130_fd_pr__cap_mim_m3_1 l=3 w=3
X2137 B11.t837 TOP.t3444 sky130_fd_pr__cap_mim_m3_1 l=3 w=3
X2138 B9.t167 TOP.t688 sky130_fd_pr__cap_mim_m3_1 l=3 w=3
X2139 EDGE_BIAS.t558 EDGE_BIAS.t559 sky130_fd_pr__cap_mim_m3_1 l=3 w=3
X2140 B11.t557 TOP.t4004 sky130_fd_pr__cap_mim_m3_1 l=3 w=3
X2141 B11.t373 TOP.t4372 sky130_fd_pr__cap_mim_m3_1 l=3 w=3
X2142 B11.t799 TOP.t3520 sky130_fd_pr__cap_mim_m3_1 l=3 w=3
X2143 B11.t1668 TOP.t1782 sky130_fd_pr__cap_mim_m3_1 l=3 w=3
X2144 B11.t1755 TOP.t1608 sky130_fd_pr__cap_mim_m3_1 l=3 w=3
X2145 B11.t937 TOP.t3244 sky130_fd_pr__cap_mim_m3_1 l=3 w=3
X2146 B10.t260 TOP.t6774 sky130_fd_pr__cap_mim_m3_1 l=3 w=3
X2147 B11.t1233 TOP.t2652 sky130_fd_pr__cap_mim_m3_1 l=3 w=3
X2148 B7.t84 TOP.t7894 sky130_fd_pr__cap_mim_m3_1 l=3 w=3
X2149 B11.t1717 TOP.t1684 sky130_fd_pr__cap_mim_m3_1 l=3 w=3
X2150 B11.t1523 TOP.t2072 sky130_fd_pr__cap_mim_m3_1 l=3 w=3
X2151 B9.t329 TOP.t364 sky130_fd_pr__cap_mim_m3_1 l=3 w=3
X2152 B10.t222 TOP.t6850 sky130_fd_pr__cap_mim_m3_1 l=3 w=3
X2153 B10.t464 TOP.t6366 sky130_fd_pr__cap_mim_m3_1 l=3 w=3
X2154 EDGE_BIAS.t531 EDGE_BIAS.t532 sky130_fd_pr__cap_mim_m3_1 l=3 w=3
X2155 B9.t191 TOP.t640 sky130_fd_pr__cap_mim_m3_1 l=3 w=3
X2156 B11.t10 TOP.t5098 sky130_fd_pr__cap_mim_m3_1 l=3 w=3
X2157 B9.t291 TOP.t440 sky130_fd_pr__cap_mim_m3_1 l=3 w=3
X2158 B11.t990 TOP.t3138 sky130_fd_pr__cap_mim_m3_1 l=3 w=3
X2159 B10.t146 TOP.t7002 sky130_fd_pr__cap_mim_m3_1 l=3 w=3
X2160 B10.t184 TOP.t6926 sky130_fd_pr__cap_mim_m3_1 l=3 w=3
X2161 B10.t426 TOP.t6442 sky130_fd_pr__cap_mim_m3_1 l=3 w=3
X2162 B11.t232 TOP.t4654 sky130_fd_pr__cap_mim_m3_1 l=3 w=3
X2163 EDGE_BIAS.t729 EDGE_BIAS.t730 sky130_fd_pr__cap_mim_m3_1 l=3 w=3
X2164 B11.t706 TOP.t3706 sky130_fd_pr__cap_mim_m3_1 l=3 w=3
X2165 B10.t388 TOP.t6518 sky130_fd_pr__cap_mim_m3_1 l=3 w=3
X2166 B4.t15 TOP.t8152 sky130_fd_pr__cap_mim_m3_1 l=3 w=3
X2167 B10.t108 TOP.t7078 sky130_fd_pr__cap_mim_m3_1 l=3 w=3
X2168 B11.t1101 TOP.t2916 sky130_fd_pr__cap_mim_m3_1 l=3 w=3
X2169 B11.t377 TOP.t4364 sky130_fd_pr__cap_mim_m3_1 l=3 w=3
X2170 B10.t350 TOP.t6594 sky130_fd_pr__cap_mim_m3_1 l=3 w=3
X2171 B11.t1860 TOP.t1398 sky130_fd_pr__cap_mim_m3_1 l=3 w=3
X2172 B11.t1188 TOP.t2742 sky130_fd_pr__cap_mim_m3_1 l=3 w=3
X2173 B9.t315 TOP.t392 sky130_fd_pr__cap_mim_m3_1 l=3 w=3
X2174 B11.t1628 TOP.t1862 sky130_fd_pr__cap_mim_m3_1 l=3 w=3
X2175 B10.t642 TOP.t6010 sky130_fd_pr__cap_mim_m3_1 l=3 w=3
X2176 B8.t11 TOP.t7784 sky130_fd_pr__cap_mim_m3_1 l=3 w=3
X2177 B11.t655 TOP.t3808 sky130_fd_pr__cap_mim_m3_1 l=3 w=3
X2178 B11.t1590 TOP.t1938 sky130_fd_pr__cap_mim_m3_1 l=3 w=3
X2179 B10.t604 TOP.t6086 sky130_fd_pr__cap_mim_m3_1 l=3 w=3
X2180 B6.t32 TOP.t5182 sky130_fd_pr__cap_mim_m3_1 l=3 w=3
X2181 B11.t897 TOP.t3324 sky130_fd_pr__cap_mim_m3_1 l=3 w=3
X2182 B11.t617 TOP.t3884 sky130_fd_pr__cap_mim_m3_1 l=3 w=3
X2183 B10.t132 TOP.t7030 sky130_fd_pr__cap_mim_m3_1 l=3 w=3
X2184 B9.t227 TOP.t568 sky130_fd_pr__cap_mim_m3_1 l=3 w=3
X2185 B9.t33 TOP.t956 sky130_fd_pr__cap_mim_m3_1 l=3 w=3
X2186 B11.t579 TOP.t3960 sky130_fd_pr__cap_mim_m3_1 l=3 w=3
X2187 B5.t9 TOP.t8110 sky130_fd_pr__cap_mim_m3_1 l=3 w=3
X2188 B11.t148 TOP.t4822 sky130_fd_pr__cap_mim_m3_1 l=3 w=3
X2189 B11.t821 TOP.t3476 sky130_fd_pr__cap_mim_m3_1 l=3 w=3
X2190 B11.t859 TOP.t3400 sky130_fd_pr__cap_mim_m3_1 l=3 w=3
X2191 B10.t15 TOP.t7264 sky130_fd_pr__cap_mim_m3_1 l=3 w=3
X2192 B11.t467 TOP.t4184 sky130_fd_pr__cap_mim_m3_1 l=3 w=3
X2193 B10.t503 TOP.t6288 sky130_fd_pr__cap_mim_m3_1 l=3 w=3
X2194 B11.t446 TOP.t4226 sky130_fd_pr__cap_mim_m3_1 l=3 w=3
X2195 B11.t541 TOP.t4036 sky130_fd_pr__cap_mim_m3_1 l=3 w=3
X2196 B9.t506 TOP.t10 sky130_fd_pr__cap_mim_m3_1 l=3 w=3
X2197 B11.t783 TOP.t3552 sky130_fd_pr__cap_mim_m3_1 l=3 w=3
X2198 B11.t1293 TOP.t2532 sky130_fd_pr__cap_mim_m3_1 l=3 w=3
X2199 B10.t946 TOP.t5402 sky130_fd_pr__cap_mim_m3_1 l=3 w=3
X2200 B11.t176 TOP.t4766 sky130_fd_pr__cap_mim_m3_1 l=3 w=3
X2201 B11.t495 TOP.t4128 sky130_fd_pr__cap_mim_m3_1 l=3 w=3
X2202 B11.t745 TOP.t3628 sky130_fd_pr__cap_mim_m3_1 l=3 w=3
X2203 B11.t1255 TOP.t2608 sky130_fd_pr__cap_mim_m3_1 l=3 w=3
X2204 B7.t68 TOP.t7926 sky130_fd_pr__cap_mim_m3_1 l=3 w=3
X2205 B9.t251 TOP.t520 sky130_fd_pr__cap_mim_m3_1 l=3 w=3
X2206 B11.t1061 TOP.t2996 sky130_fd_pr__cap_mim_m3_1 l=3 w=3
X2207 B11.t357 TOP.t4404 sky130_fd_pr__cap_mim_m3_1 l=3 w=3
X2208 B10.t206 TOP.t6882 sky130_fd_pr__cap_mim_m3_1 l=3 w=3
X2209 B10.t999 TOP.t5296 sky130_fd_pr__cap_mim_m3_1 l=3 w=3
X2210 B11.t1015 TOP.t3088 sky130_fd_pr__cap_mim_m3_1 l=3 w=3
X2211 B11.t565 TOP.t3988 sky130_fd_pr__cap_mim_m3_1 l=3 w=3
X2212 B10.t168 TOP.t6958 sky130_fd_pr__cap_mim_m3_1 l=3 w=3
X2213 B9.t275 TOP.t472 sky130_fd_pr__cap_mim_m3_1 l=3 w=3
X2214 B11.t974 TOP.t3170 sky130_fd_pr__cap_mim_m3_1 l=3 w=3
X2215 B10.t410 TOP.t6474 sky130_fd_pr__cap_mim_m3_1 l=3 w=3
X2216 EDGE_BIAS.t510 EDGE_BIAS.t511 sky130_fd_pr__cap_mim_m3_1 l=3 w=3
X2217 B11.t936 TOP.t3246 sky130_fd_pr__cap_mim_m3_1 l=3 w=3
X2218 B10.t372 TOP.t6550 sky130_fd_pr__cap_mim_m3_1 l=3 w=3
X2219 B7.t61 TOP.t7940 sky130_fd_pr__cap_mim_m3_1 l=3 w=3
X2220 B10.t334 TOP.t6626 sky130_fd_pr__cap_mim_m3_1 l=3 w=3
X2221 B10.t702 TOP.t5890 sky130_fd_pr__cap_mim_m3_1 l=3 w=3
X2222 B9.t375 TOP.t272 sky130_fd_pr__cap_mim_m3_1 l=3 w=3
X2223 B11.t411 TOP.t4296 sky130_fd_pr__cap_mim_m3_1 l=3 w=3
X2224 B10.t664 TOP.t5966 sky130_fd_pr__cap_mim_m3_1 l=3 w=3
X2225 B9.t466 TOP.t90 sky130_fd_pr__cap_mim_m3_1 l=3 w=3
X2226 B10.t192 TOP.t6910 sky130_fd_pr__cap_mim_m3_1 l=3 w=3
X2227 EDGE_BIAS.t48 EDGE_BIAS.t49 sky130_fd_pr__cap_mim_m3_1 l=3 w=3
X2228 B11.t1612 TOP.t1894 sky130_fd_pr__cap_mim_m3_1 l=3 w=3
X2229 B10.t906 TOP.t5482 sky130_fd_pr__cap_mim_m3_1 l=3 w=3
X2230 B11.t273 TOP.t4572 sky130_fd_pr__cap_mim_m3_1 l=3 w=3
X2231 B11.t639 TOP.t3840 sky130_fd_pr__cap_mim_m3_1 l=3 w=3
X2232 B10.t626 TOP.t6042 sky130_fd_pr__cap_mim_m3_1 l=3 w=3
X2233 B11.t1574 TOP.t1970 sky130_fd_pr__cap_mim_m3_1 l=3 w=3
X2234 B10.t588 TOP.t6118 sky130_fd_pr__cap_mim_m3_1 l=3 w=3
X2235 B9.t428 TOP.t166 sky130_fd_pr__cap_mim_m3_1 l=3 w=3
X2236 B10.t6 TOP.t7282 sky130_fd_pr__cap_mim_m3_1 l=3 w=3
X2237 B9.t211 TOP.t600 sky130_fd_pr__cap_mim_m3_1 l=3 w=3
X2238 B11.t496 TOP.t4126 sky130_fd_pr__cap_mim_m3_1 l=3 w=3
X2239 B11.t601 TOP.t3916 sky130_fd_pr__cap_mim_m3_1 l=3 w=3
X2240 B4.t1 TOP.t8180 sky130_fd_pr__cap_mim_m3_1 l=3 w=3
X2241 B11.t301 TOP.t4516 sky130_fd_pr__cap_mim_m3_1 l=3 w=3
X2242 B11.t843 TOP.t3432 sky130_fd_pr__cap_mim_m3_1 l=3 w=3
X2243 B9.t173 TOP.t676 sky130_fd_pr__cap_mim_m3_1 l=3 w=3
X2244 EDGE_BIAS.t735 EDGE_BIAS.t736 sky130_fd_pr__cap_mim_m3_1 l=3 w=3
X2245 B11.t209 TOP.t4700 sky130_fd_pr__cap_mim_m3_1 l=3 w=3
X2246 B11.t805 TOP.t3508 sky130_fd_pr__cap_mim_m3_1 l=3 w=3
X2247 B11.t767 TOP.t3584 sky130_fd_pr__cap_mim_m3_1 l=3 w=3
X2248 B8.t129 TOP.t7548 sky130_fd_pr__cap_mim_m3_1 l=3 w=3
X2249 B8.t57 TOP.t7692 sky130_fd_pr__cap_mim_m3_1 l=3 w=3
X2250 B11.t729 TOP.t3660 sky130_fd_pr__cap_mim_m3_1 l=3 w=3
X2251 B11.t1239 TOP.t2640 sky130_fd_pr__cap_mim_m3_1 l=3 w=3
X2252 B11.t1045 TOP.t3028 sky130_fd_pr__cap_mim_m3_1 l=3 w=3
X2253 B7.t90 TOP.t7882 sky130_fd_pr__cap_mim_m3_1 l=3 w=3
X2254 B7.t21 TOP.t8020 sky130_fd_pr__cap_mim_m3_1 l=3 w=3
X2255 B11.t625 TOP.t3868 sky130_fd_pr__cap_mim_m3_1 l=3 w=3
X2256 B11.t1529 TOP.t2060 sky130_fd_pr__cap_mim_m3_1 l=3 w=3
X2257 B9.t335 TOP.t352 sky130_fd_pr__cap_mim_m3_1 l=3 w=3
X2258 B10.t983 TOP.t5328 sky130_fd_pr__cap_mim_m3_1 l=3 w=3
X2259 B8.t110 TOP.t7586 sky130_fd_pr__cap_mim_m3_1 l=3 w=3
X2260 B9.t297 TOP.t428 sky130_fd_pr__cap_mim_m3_1 l=3 w=3
X2261 B9.t259 TOP.t504 sky130_fd_pr__cap_mim_m3_1 l=3 w=3
X2262 B10.t152 TOP.t6990 sky130_fd_pr__cap_mim_m3_1 l=3 w=3
X2263 B10.t945 TOP.t5404 sky130_fd_pr__cap_mim_m3_1 l=3 w=3
X2264 B8.t0 TOP.t7806 sky130_fd_pr__cap_mim_m3_1 l=3 w=3
X2265 B10.t394 TOP.t6506 sky130_fd_pr__cap_mim_m3_1 l=3 w=3
X2266 B11.t1983 TOP.t1152 sky130_fd_pr__cap_mim_m3_1 l=3 w=3
X2267 B10.t114 TOP.t7066 sky130_fd_pr__cap_mim_m3_1 l=3 w=3
X2268 B11.t444 TOP.t4230 sky130_fd_pr__cap_mim_m3_1 l=3 w=3
X2269 B10.t356 TOP.t6582 sky130_fd_pr__cap_mim_m3_1 l=3 w=3
X2270 EDGE_BIAS.t627 EDGE_BIAS.t628 sky130_fd_pr__cap_mim_m3_1 l=3 w=3
X2271 B10.t252 TOP.t6790 sky130_fd_pr__cap_mim_m3_1 l=3 w=3
X2272 B9.t67 TOP.t888 sky130_fd_pr__cap_mim_m3_1 l=3 w=3
X2273 B11.t1838 TOP.t1442 sky130_fd_pr__cap_mim_m3_1 l=3 w=3
X2274 B10.t648 TOP.t5998 sky130_fd_pr__cap_mim_m3_1 l=3 w=3
X2275 B9.t450 TOP.t122 sky130_fd_pr__cap_mim_m3_1 l=3 w=3
X2276 EDGE_BIAS.t96 EDGE_BIAS.t97 sky130_fd_pr__cap_mim_m3_1 l=3 w=3
X2277 B10.t890 TOP.t5514 sky130_fd_pr__cap_mim_m3_1 l=3 w=3
X2278 B8.t17 TOP.t7772 sky130_fd_pr__cap_mim_m3_1 l=3 w=3
X2279 B10.t610 TOP.t6074 sky130_fd_pr__cap_mim_m3_1 l=3 w=3
X2280 B6.t38 TOP.t5170 sky130_fd_pr__cap_mim_m3_1 l=3 w=3
X2281 B11.t334 TOP.t4450 sky130_fd_pr__cap_mim_m3_1 l=3 w=3
X2282 B9.t412 TOP.t198 sky130_fd_pr__cap_mim_m3_1 l=3 w=3
X2283 B9.t233 TOP.t556 sky130_fd_pr__cap_mim_m3_1 l=3 w=3
X2284 B10.t305 TOP.t6684 sky130_fd_pr__cap_mim_m3_1 l=3 w=3
X2285 B9.t195 TOP.t632 sky130_fd_pr__cap_mim_m3_1 l=3 w=3
X2286 B9.t39 TOP.t944 sky130_fd_pr__cap_mim_m3_1 l=3 w=3
X2287 B11.t585 TOP.t3948 sky130_fd_pr__cap_mim_m3_1 l=3 w=3
X2288 B10.t380 TOP.t6534 sky130_fd_pr__cap_mim_m3_1 l=3 w=3
X2289 B5.t15 TOP.t8098 sky130_fd_pr__cap_mim_m3_1 l=3 w=3
X2290 B11.t827 TOP.t3464 sky130_fd_pr__cap_mim_m3_1 l=3 w=3
X2291 B10.t21 TOP.t7252 sky130_fd_pr__cap_mim_m3_1 l=3 w=3
X2292 B9.t374 TOP.t274 sky130_fd_pr__cap_mim_m3_1 l=3 w=3
X2293 B11.t1416 TOP.t2286 sky130_fd_pr__cap_mim_m3_1 l=3 w=3
X2294 B9.t157 TOP.t708 sky130_fd_pr__cap_mim_m3_1 l=3 w=3
X2295 B11.t547 TOP.t4024 sky130_fd_pr__cap_mim_m3_1 l=3 w=3
X2296 B11.t1 TOP.t5116 sky130_fd_pr__cap_mim_m3_1 l=3 w=3
X2297 B11.t789 TOP.t3540 sky130_fd_pr__cap_mim_m3_1 l=3 w=3
X2298 B11.t685 TOP.t3748 sky130_fd_pr__cap_mim_m3_1 l=3 w=3
X2299 B11.t90 TOP.t4938 sky130_fd_pr__cap_mim_m3_1 l=3 w=3
X2300 B11.t480 TOP.t4158 sky130_fd_pr__cap_mim_m3_1 l=3 w=3
X2301 B11.t1943 TOP.t1232 sky130_fd_pr__cap_mim_m3_1 l=3 w=3
X2302 B10.t634 TOP.t6026 sky130_fd_pr__cap_mim_m3_1 l=3 w=3
X2303 B7.t74 TOP.t7914 sky130_fd_pr__cap_mim_m3_1 l=3 w=3
X2304 B11.t388 TOP.t4342 sky130_fd_pr__cap_mim_m3_1 l=3 w=3
X2305 B7.t5 TOP.t8052 sky130_fd_pr__cap_mim_m3_1 l=3 w=3
X2306 B9.t63 TOP.t896 sky130_fd_pr__cap_mim_m3_1 l=3 w=3
X2307 B11.t1905 TOP.t1308 sky130_fd_pr__cap_mim_m3_1 l=3 w=3
X2308 B11.t1513 TOP.t2092 sky130_fd_pr__cap_mim_m3_1 l=3 w=3
X2309 B9.t319 TOP.t384 sky130_fd_pr__cap_mim_m3_1 l=3 w=3
X2310 EDGE_BIAS.t555 EDGE_BIAS.t556 sky130_fd_pr__cap_mim_m3_1 l=3 w=3
X2311 B10.t212 TOP.t6870 sky130_fd_pr__cap_mim_m3_1 l=3 w=3
X2312 B10.t454 TOP.t6386 sky130_fd_pr__cap_mim_m3_1 l=3 w=3
X2313 B9.t281 TOP.t460 sky130_fd_pr__cap_mim_m3_1 l=3 w=3
X2314 B8.t94 TOP.t7618 sky130_fd_pr__cap_mim_m3_1 l=3 w=3
X2315 B10.t174 TOP.t6946 sky130_fd_pr__cap_mim_m3_1 l=3 w=3
X2316 B11.t813 TOP.t3492 sky130_fd_pr__cap_mim_m3_1 l=3 w=3
X2317 B11.t980 TOP.t3158 sky130_fd_pr__cap_mim_m3_1 l=3 w=3
X2318 B10.t136 TOP.t7022 sky130_fd_pr__cap_mim_m3_1 l=3 w=3
X2319 B10.t416 TOP.t6462 sky130_fd_pr__cap_mim_m3_1 l=3 w=3
X2320 B8.t56 TOP.t7694 sky130_fd_pr__cap_mim_m3_1 l=3 w=3
X2321 B10.t825 TOP.t5644 sky130_fd_pr__cap_mim_m3_1 l=3 w=3
X2322 B5.t29 TOP.t8070 sky130_fd_pr__cap_mim_m3_1 l=3 w=3
X2323 B10.t98 TOP.t7098 sky130_fd_pr__cap_mim_m3_1 l=3 w=3
X2324 B11.t1285 TOP.t2548 sky130_fd_pr__cap_mim_m3_1 l=3 w=3
X2325 B10.t340 TOP.t6614 sky130_fd_pr__cap_mim_m3_1 l=3 w=3
X2326 B10.t60 TOP.t7174 sky130_fd_pr__cap_mim_m3_1 l=3 w=3
X2327 B11.t1376 TOP.t2366 sky130_fd_pr__cap_mim_m3_1 l=3 w=3
X2328 B11.t1618 TOP.t1882 sky130_fd_pr__cap_mim_m3_1 l=3 w=3
X2329 B11.t645 TOP.t3828 sky130_fd_pr__cap_mim_m3_1 l=3 w=3
X2330 B11.t1004 TOP.t3110 sky130_fd_pr__cap_mim_m3_1 l=3 w=3
X2331 B10.t385 TOP.t6524 sky130_fd_pr__cap_mim_m3_1 l=3 w=3
X2332 B11.t1338 TOP.t2442 sky130_fd_pr__cap_mim_m3_1 l=3 w=3
X2333 B11.t1020 TOP.t3078 sky130_fd_pr__cap_mim_m3_1 l=3 w=3
X2334 B11.t1580 TOP.t1958 sky130_fd_pr__cap_mim_m3_1 l=3 w=3
X2335 B10.t594 TOP.t6106 sky130_fd_pr__cap_mim_m3_1 l=3 w=3
X2336 B11.t887 TOP.t3344 sky130_fd_pr__cap_mim_m3_1 l=3 w=3
X2337 B9.t217 TOP.t588 sky130_fd_pr__cap_mim_m3_1 l=3 w=3
X2338 B11.t607 TOP.t3904 sky130_fd_pr__cap_mim_m3_1 l=3 w=3
X2339 B10.t289 TOP.t6716 sky130_fd_pr__cap_mim_m3_1 l=3 w=3
X2340 B9.t23 TOP.t976 sky130_fd_pr__cap_mim_m3_1 l=3 w=3
X2341 B11.t569 TOP.t3980 sky130_fd_pr__cap_mim_m3_1 l=3 w=3
X2342 B11.t849 TOP.t3420 sky130_fd_pr__cap_mim_m3_1 l=3 w=3
X2343 B11.t1150 TOP.t2818 sky130_fd_pr__cap_mim_m3_1 l=3 w=3
X2344 B4.t7 TOP.t8168 sky130_fd_pr__cap_mim_m3_1 l=3 w=3
X2345 B11.t215 TOP.t4688 sky130_fd_pr__cap_mim_m3_1 l=3 w=3
X2346 B11.t194 TOP.t4730 sky130_fd_pr__cap_mim_m3_1 l=3 w=3
X2347 EDGE_BIAS.t480 EDGE_BIAS.t481 sky130_fd_pr__cap_mim_m3_1 l=3 w=3
X2348 B10.t251 TOP.t6792 sky130_fd_pr__cap_mim_m3_1 l=3 w=3
X2349 B9.t179 TOP.t664 sky130_fd_pr__cap_mim_m3_1 l=3 w=3
X2350 B10.t694 TOP.t5906 sky130_fd_pr__cap_mim_m3_1 l=3 w=3
X2351 B8.t252 TOP.t7302 sky130_fd_pr__cap_mim_m3_1 l=3 w=3
X2352 B9.t141 TOP.t740 sky130_fd_pr__cap_mim_m3_1 l=3 w=3
X2353 B10.t493 TOP.t6308 sky130_fd_pr__cap_mim_m3_1 l=3 w=3
X2354 B11.t531 TOP.t4056 sky130_fd_pr__cap_mim_m3_1 l=3 w=3
X2355 B11.t438 TOP.t4242 sky130_fd_pr__cap_mim_m3_1 l=3 w=3
X2356 B11.t773 TOP.t3572 sky130_fd_pr__cap_mim_m3_1 l=3 w=3
X2357 EDGE_BIAS.t696 EDGE_BIAS.t697 sky130_fd_pr__cap_mim_m3_1 l=3 w=3
X2358 B11.t243 TOP.t4632 sky130_fd_pr__cap_mim_m3_1 l=3 w=3
X2359 B11.t1927 TOP.t1264 sky130_fd_pr__cap_mim_m3_1 l=3 w=3
X2360 B11.t1604 TOP.t1910 sky130_fd_pr__cap_mim_m3_1 l=3 w=3
X2361 B10.t785 TOP.t5724 sky130_fd_pr__cap_mim_m3_1 l=3 w=3
X2362 B11.t735 TOP.t3648 sky130_fd_pr__cap_mim_m3_1 l=3 w=3
X2363 B11.t1245 TOP.t2628 sky130_fd_pr__cap_mim_m3_1 l=3 w=3
X2364 B11.t1051 TOP.t3016 sky130_fd_pr__cap_mim_m3_1 l=3 w=3
X2365 B11.t818 TOP.t3482 sky130_fd_pr__cap_mim_m3_1 l=3 w=3
X2366 B11.t1011 TOP.t3096 sky130_fd_pr__cap_mim_m3_1 l=3 w=3
X2367 B11.t1889 TOP.t1340 sky130_fd_pr__cap_mim_m3_1 l=3 w=3
X2368 B10.t747 TOP.t5800 sky130_fd_pr__cap_mim_m3_1 l=3 w=3
X2369 B10.t989 TOP.t5316 sky130_fd_pr__cap_mim_m3_1 l=3 w=3
X2370 B9.t265 TOP.t492 sky130_fd_pr__cap_mim_m3_1 l=3 w=3
X2371 B10.t158 TOP.t6978 sky130_fd_pr__cap_mim_m3_1 l=3 w=3
X2372 B11.t18 TOP.t5082 sky130_fd_pr__cap_mim_m3_1 l=3 w=3
X2373 B11.t964 TOP.t3190 sky130_fd_pr__cap_mim_m3_1 l=3 w=3
X2374 B10.t400 TOP.t6494 sky130_fd_pr__cap_mim_m3_1 l=3 w=3
X2375 B10.t559 TOP.t6176 sky130_fd_pr__cap_mim_m3_1 l=3 w=3
X2376 B11.t684 TOP.t3750 sky130_fd_pr__cap_mim_m3_1 l=3 w=3
X2377 B10.t120 TOP.t7054 sky130_fd_pr__cap_mim_m3_1 l=3 w=3
X2378 B7.t120 TOP.t7822 sky130_fd_pr__cap_mim_m3_1 l=3 w=3
X2379 B6.t61 TOP.t5124 sky130_fd_pr__cap_mim_m3_1 l=3 w=3
X2380 B11.t926 TOP.t3266 sky130_fd_pr__cap_mim_m3_1 l=3 w=3
X2381 B10.t82 TOP.t7130 sky130_fd_pr__cap_mim_m3_1 l=3 w=3
X2382 B10.t362 TOP.t6570 sky130_fd_pr__cap_mim_m3_1 l=3 w=3
X2383 B10.t324 TOP.t6646 sky130_fd_pr__cap_mim_m3_1 l=3 w=3
X2384 B11.t159 TOP.t4800 sky130_fd_pr__cap_mim_m3_1 l=3 w=3
X2385 B10.t44 TOP.t7206 sky130_fd_pr__cap_mim_m3_1 l=3 w=3
X2386 B6.t22 TOP.t5202 sky130_fd_pr__cap_mim_m3_1 l=3 w=3
X2387 B11.t67 TOP.t4984 sky130_fd_pr__cap_mim_m3_1 l=3 w=3
X2388 B11.t478 TOP.t4162 sky130_fd_pr__cap_mim_m3_1 l=3 w=3
X2389 B11.t1360 TOP.t2398 sky130_fd_pr__cap_mim_m3_1 l=3 w=3
X2390 B10.t1013 TOP.t5268 sky130_fd_pr__cap_mim_m3_1 l=3 w=3
X2391 B10.t654 TOP.t5986 sky130_fd_pr__cap_mim_m3_1 l=3 w=3
X2392 B8.t212 TOP.t7382 sky130_fd_pr__cap_mim_m3_1 l=3 w=3
X2393 B11.t1844 TOP.t1430 sky130_fd_pr__cap_mim_m3_1 l=3 w=3
X2394 B9.t456 TOP.t110 sky130_fd_pr__cap_mim_m3_1 l=3 w=3
X2395 B10.t896 TOP.t5502 sky130_fd_pr__cap_mim_m3_1 l=3 w=3
X2396 B10.t2 TOP.t7290 sky130_fd_pr__cap_mim_m3_1 l=3 w=3
X2397 B11.t1322 TOP.t2474 sky130_fd_pr__cap_mim_m3_1 l=3 w=3
X2398 B10.t616 TOP.t6062 sky130_fd_pr__cap_mim_m3_1 l=3 w=3
X2399 B8.t174 TOP.t7458 sky130_fd_pr__cap_mim_m3_1 l=3 w=3
X2400 B11.t244 TOP.t4630 sky130_fd_pr__cap_mim_m3_1 l=3 w=3
X2401 B11.t1564 TOP.t1990 sky130_fd_pr__cap_mim_m3_1 l=3 w=3
X2402 B10.t578 TOP.t6138 sky130_fd_pr__cap_mim_m3_1 l=3 w=3
X2403 B9.t418 TOP.t186 sky130_fd_pr__cap_mim_m3_1 l=3 w=3
X2404 B11.t1284 TOP.t2550 sky130_fd_pr__cap_mim_m3_1 l=3 w=3
X2405 B9.t201 TOP.t620 sky130_fd_pr__cap_mim_m3_1 l=3 w=3
X2406 B11.t591 TOP.t3936 sky130_fd_pr__cap_mim_m3_1 l=3 w=3
X2407 EDGE_BIAS.t393 EDGE_BIAS.t394 sky130_fd_pr__cap_mim_m3_1 l=3 w=3
X2408 B9.t7 TOP.t1008 sky130_fd_pr__cap_mim_m3_1 l=3 w=3
X2409 B11.t58 TOP.t5002 sky130_fd_pr__cap_mim_m3_1 l=3 w=3
X2410 B11.t833 TOP.t3452 sky130_fd_pr__cap_mim_m3_1 l=3 w=3
X2411 B11.t368 TOP.t4382 sky130_fd_pr__cap_mim_m3_1 l=3 w=3
X2412 B9.t163 TOP.t696 sky130_fd_pr__cap_mim_m3_1 l=3 w=3
X2413 B11.t515 TOP.t4088 sky130_fd_pr__cap_mim_m3_1 l=3 w=3
X2414 B11.t553 TOP.t4012 sky130_fd_pr__cap_mim_m3_1 l=3 w=3
X2415 B10.t477 TOP.t6340 sky130_fd_pr__cap_mim_m3_1 l=3 w=3
X2416 B11.t795 TOP.t3528 sky130_fd_pr__cap_mim_m3_1 l=3 w=3
X2417 B11.t757 TOP.t3604 sky130_fd_pr__cap_mim_m3_1 l=3 w=3
X2418 B10.t439 TOP.t6416 sky130_fd_pr__cap_mim_m3_1 l=3 w=3
X2419 B11.t394 TOP.t4330 sky130_fd_pr__cap_mim_m3_1 l=3 w=3
X2420 B11.t1229 TOP.t2660 sky130_fd_pr__cap_mim_m3_1 l=3 w=3
X2421 B10.t769 TOP.t5756 sky130_fd_pr__cap_mim_m3_1 l=3 w=3
X2422 B9.t442 TOP.t138 sky130_fd_pr__cap_mim_m3_1 l=3 w=3
X2423 B7.t80 TOP.t7902 sky130_fd_pr__cap_mim_m3_1 l=3 w=3
X2424 B11.t719 TOP.t3680 sky130_fd_pr__cap_mim_m3_1 l=3 w=3
X2425 B7.t11 TOP.t8040 sky130_fd_pr__cap_mim_m3_1 l=3 w=3
X2426 B9.t325 TOP.t372 sky130_fd_pr__cap_mim_m3_1 l=3 w=3
X2427 B9.t112 TOP.t798 sky130_fd_pr__cap_mim_m3_1 l=3 w=3
X2428 B11.t103 TOP.t4912 sky130_fd_pr__cap_mim_m3_1 l=3 w=3
X2429 B10.t731 TOP.t5832 sky130_fd_pr__cap_mim_m3_1 l=3 w=3
X2430 B11.t422 TOP.t4274 sky130_fd_pr__cap_mim_m3_1 l=3 w=3
X2431 B10.t973 TOP.t5348 sky130_fd_pr__cap_mim_m3_1 l=3 w=3
X2432 B9.t287 TOP.t448 sky130_fd_pr__cap_mim_m3_1 l=3 w=3
X2433 B8.t100 TOP.t7606 sky130_fd_pr__cap_mim_m3_1 l=3 w=3
X2434 B9.t187 TOP.t648 sky130_fd_pr__cap_mim_m3_1 l=3 w=3
X2435 B10.t693 TOP.t5908 sky130_fd_pr__cap_mim_m3_1 l=3 w=3
X2436 B11.t284 TOP.t4550 sky130_fd_pr__cap_mim_m3_1 l=3 w=3
X2437 B10.t142 TOP.t7010 sky130_fd_pr__cap_mim_m3_1 l=3 w=3
X2438 B11.t948 TOP.t3222 sky130_fd_pr__cap_mim_m3_1 l=3 w=3
X2439 EDGE_BIAS.t447 EDGE_BIAS.t448 sky130_fd_pr__cap_mim_m3_1 l=3 w=3
X2440 B11.t1731 TOP.t1656 sky130_fd_pr__cap_mim_m3_1 l=3 w=3
X2441 B10.t935 TOP.t5424 sky130_fd_pr__cap_mim_m3_1 l=3 w=3
X2442 B11.t192 TOP.t4734 sky130_fd_pr__cap_mim_m3_1 l=3 w=3
X2443 B4.t11 TOP.t8160 sky130_fd_pr__cap_mim_m3_1 l=3 w=3
X2444 B11.t910 TOP.t3298 sky130_fd_pr__cap_mim_m3_1 l=3 w=3
X2445 B10.t104 TOP.t7086 sky130_fd_pr__cap_mim_m3_1 l=3 w=3
X2446 B6.t45 TOP.t5156 sky130_fd_pr__cap_mim_m3_1 l=3 w=3
X2447 B10.t346 TOP.t6602 sky130_fd_pr__cap_mim_m3_1 l=3 w=3
X2448 B6.t6 TOP.t5234 sky130_fd_pr__cap_mim_m3_1 l=3 w=3
X2449 B11.t872 TOP.t3374 sky130_fd_pr__cap_mim_m3_1 l=3 w=3
X2450 B8.t124 TOP.t7558 sky130_fd_pr__cap_mim_m3_1 l=3 w=3
X2451 B10.t638 TOP.t6018 sky130_fd_pr__cap_mim_m3_1 l=3 w=3
X2452 B8.t196 TOP.t7414 sky130_fd_pr__cap_mim_m3_1 l=3 w=3
X2453 B11.t1828 TOP.t1462 sky130_fd_pr__cap_mim_m3_1 l=3 w=3
X2454 B8.t7 TOP.t7792 sky130_fd_pr__cap_mim_m3_1 l=3 w=3
X2455 B11.t35 TOP.t5048 sky130_fd_pr__cap_mim_m3_1 l=3 w=3
X2456 EDGE_BIAS.t126 EDGE_BIAS.t127 sky130_fd_pr__cap_mim_m3_1 l=3 w=3
X2457 B8.t158 TOP.t7490 sky130_fd_pr__cap_mim_m3_1 l=3 w=3
X2458 B10.t600 TOP.t6094 sky130_fd_pr__cap_mim_m3_1 l=3 w=3
X2459 B10.t128 TOP.t7038 sky130_fd_pr__cap_mim_m3_1 l=3 w=3
X2460 B11.t1548 TOP.t2022 sky130_fd_pr__cap_mim_m3_1 l=3 w=3
X2461 B9.t402 TOP.t218 sky130_fd_pr__cap_mim_m3_1 l=3 w=3
X2462 B9.t223 TOP.t576 sky130_fd_pr__cap_mim_m3_1 l=3 w=3
X2463 B10.t295 TOP.t6704 sky130_fd_pr__cap_mim_m3_1 l=3 w=3
X2464 B11.t2032 TOP.t1054 sky130_fd_pr__cap_mim_m3_1 l=3 w=3
X2465 B7.t119 TOP.t7824 sky130_fd_pr__cap_mim_m3_1 l=3 w=3
X2466 B9.t29 TOP.t964 sky130_fd_pr__cap_mim_m3_1 l=3 w=3
X2467 B11.t575 TOP.t3968 sky130_fd_pr__cap_mim_m3_1 l=3 w=3
X2468 B9.t364 TOP.t294 sky130_fd_pr__cap_mim_m3_1 l=3 w=3
X2469 EDGE_BIAS.t501 EDGE_BIAS.t502 sky130_fd_pr__cap_mim_m3_1 l=3 w=3
X2470 B6.t30 TOP.t5186 sky130_fd_pr__cap_mim_m3_1 l=3 w=3
X2471 B9.t147 TOP.t728 sky130_fd_pr__cap_mim_m3_1 l=3 w=3
X2472 B10.t499 TOP.t6296 sky130_fd_pr__cap_mim_m3_1 l=3 w=3
X2473 B10.t461 TOP.t6372 sky130_fd_pr__cap_mim_m3_1 l=3 w=3
X2474 EDGE_BIAS.t678 EDGE_BIAS.t679 sky130_fd_pr__cap_mim_m3_1 l=3 w=3
X2475 B11.t537 TOP.t4044 sky130_fd_pr__cap_mim_m3_1 l=3 w=3
X2476 B11.t228 TOP.t4662 sky130_fd_pr__cap_mim_m3_1 l=3 w=3
X2477 EDGE_BIAS.t576 EDGE_BIAS.t577 sky130_fd_pr__cap_mim_m3_1 l=3 w=3
X2478 B11.t779 TOP.t3560 sky130_fd_pr__cap_mim_m3_1 l=3 w=3
X2479 B11.t1691 TOP.t1736 sky130_fd_pr__cap_mim_m3_1 l=3 w=3
X2480 B10.t423 TOP.t6448 sky130_fd_pr__cap_mim_m3_1 l=3 w=3
X2481 B11.t136 TOP.t4846 sky130_fd_pr__cap_mim_m3_1 l=3 w=3
X2482 B11.t1933 TOP.t1252 sky130_fd_pr__cap_mim_m3_1 l=3 w=3
X2483 B11.t741 TOP.t3636 sky130_fd_pr__cap_mim_m3_1 l=3 w=3
X2484 B10.t319 TOP.t6656 sky130_fd_pr__cap_mim_m3_1 l=3 w=3
X2485 B7.t64 TOP.t7934 sky130_fd_pr__cap_mim_m3_1 l=3 w=3
X2486 B9.t192 TOP.t638 sky130_fd_pr__cap_mim_m3_1 l=3 w=3
X2487 B10.t202 TOP.t6890 sky130_fd_pr__cap_mim_m3_1 l=3 w=3
X2488 B11.t1895 TOP.t1328 sky130_fd_pr__cap_mim_m3_1 l=3 w=3
X2489 B11.t1503 TOP.t2112 sky130_fd_pr__cap_mim_m3_1 l=3 w=3
X2490 B9.t96 TOP.t830 sky130_fd_pr__cap_mim_m3_1 l=3 w=3
X2491 B11.t317 TOP.t4484 sky130_fd_pr__cap_mim_m3_1 l=3 w=3
X2492 B11.t561 TOP.t3996 sky130_fd_pr__cap_mim_m3_1 l=3 w=3
X2493 B10.t957 TOP.t5380 sky130_fd_pr__cap_mim_m3_1 l=3 w=3
X2494 B9.t271 TOP.t480 sky130_fd_pr__cap_mim_m3_1 l=3 w=3
X2495 B8.t84 TOP.t7638 sky130_fd_pr__cap_mim_m3_1 l=3 w=3
X2496 B10.t164 TOP.t6966 sky130_fd_pr__cap_mim_m3_1 l=3 w=3
X2497 B11.t1465 TOP.t2188 sky130_fd_pr__cap_mim_m3_1 l=3 w=3
X2498 B11.t970 TOP.t3178 sky130_fd_pr__cap_mim_m3_1 l=3 w=3
X2499 B10.t919 TOP.t5456 sky130_fd_pr__cap_mim_m3_1 l=3 w=3
X2500 B8.t46 TOP.t7714 sky130_fd_pr__cap_mim_m3_1 l=3 w=3
X2501 B10.t447 TOP.t6400 sky130_fd_pr__cap_mim_m3_1 l=3 w=3
X2502 B5.t19 TOP.t8090 sky130_fd_pr__cap_mim_m3_1 l=3 w=3
X2503 B11.t894 TOP.t3330 sky130_fd_pr__cap_mim_m3_1 l=3 w=3
X2504 B11.t932 TOP.t3254 sky130_fd_pr__cap_mim_m3_1 l=3 w=3
X2505 B10.t88 TOP.t7118 sky130_fd_pr__cap_mim_m3_1 l=3 w=3
X2506 B11.t463 TOP.t4192 sky130_fd_pr__cap_mim_m3_1 l=3 w=3
X2507 B10.t330 TOP.t6634 sky130_fd_pr__cap_mim_m3_1 l=3 w=3
X2508 B10.t50 TOP.t7194 sky130_fd_pr__cap_mim_m3_1 l=3 w=3
X2509 B11.t1919 TOP.t1280 sky130_fd_pr__cap_mim_m3_1 l=3 w=3
X2510 B11.t856 TOP.t3406 sky130_fd_pr__cap_mim_m3_1 l=3 w=3
X2511 B11.t1366 TOP.t2386 sky130_fd_pr__cap_mim_m3_1 l=3 w=3
X2512 B11.t1608 TOP.t1902 sky130_fd_pr__cap_mim_m3_1 l=3 w=3
X2513 B10.t133 TOP.t7028 sky130_fd_pr__cap_mim_m3_1 l=3 w=3
X2514 B11.t491 TOP.t4136 sky130_fd_pr__cap_mim_m3_1 l=3 w=3
X2515 B11.t635 TOP.t3848 sky130_fd_pr__cap_mim_m3_1 l=3 w=3
X2516 B11.t1328 TOP.t2462 sky130_fd_pr__cap_mim_m3_1 l=3 w=3
X2517 B11.t1570 TOP.t1978 sky130_fd_pr__cap_mim_m3_1 l=3 w=3
X2518 B10.t584 TOP.t6126 sky130_fd_pr__cap_mim_m3_1 l=3 w=3
X2519 B3.t7 TOP.t8130 sky130_fd_pr__cap_mim_m3_1 l=3 w=3
X2520 B10.t279 TOP.t6736 sky130_fd_pr__cap_mim_m3_1 l=3 w=3
X2521 B9.t386 TOP.t250 sky130_fd_pr__cap_mim_m3_1 l=3 w=3
X2522 B9.t207 TOP.t608 sky130_fd_pr__cap_mim_m3_1 l=3 w=3
X2523 B11.t353 TOP.t4412 sky130_fd_pr__cap_mim_m3_1 l=3 w=3
X2524 B11.t597 TOP.t3924 sky130_fd_pr__cap_mim_m3_1 l=3 w=3
X2525 B10.t874 TOP.t5546 sky130_fd_pr__cap_mim_m3_1 l=3 w=3
X2526 B9.t13 TOP.t996 sky130_fd_pr__cap_mim_m3_1 l=3 w=3
X2527 B11.t14 TOP.t5090 sky130_fd_pr__cap_mim_m3_1 l=3 w=3
X2528 B9.t348 TOP.t326 sky130_fd_pr__cap_mim_m3_1 l=3 w=3
X2529 B11.t261 TOP.t4596 sky130_fd_pr__cap_mim_m3_1 l=3 w=3
X2530 B10.t241 TOP.t6812 sky130_fd_pr__cap_mim_m3_1 l=3 w=3
X2531 B9.t169 TOP.t684 sky130_fd_pr__cap_mim_m3_1 l=3 w=3
X2532 B11.t186 TOP.t4746 sky130_fd_pr__cap_mim_m3_1 l=3 w=3
X2533 B11.t521 TOP.t4076 sky130_fd_pr__cap_mim_m3_1 l=3 w=3
X2534 B11.t880 TOP.t3358 sky130_fd_pr__cap_mim_m3_1 l=3 w=3
X2535 B9.t131 TOP.t760 sky130_fd_pr__cap_mim_m3_1 l=3 w=3
X2536 B10.t483 TOP.t6328 sky130_fd_pr__cap_mim_m3_1 l=3 w=3
X2537 B9.t310 TOP.t402 sky130_fd_pr__cap_mim_m3_1 l=3 w=3
X2538 B11.t763 TOP.t3592 sky130_fd_pr__cap_mim_m3_1 l=3 w=3
X2539 B11.t1352 TOP.t2414 sky130_fd_pr__cap_mim_m3_1 l=3 w=3
X2540 B11.t1675 TOP.t1768 sky130_fd_pr__cap_mim_m3_1 l=3 w=3
X2541 B11.t725 TOP.t3668 sky130_fd_pr__cap_mim_m3_1 l=3 w=3
X2542 B11.t1235 TOP.t2648 sky130_fd_pr__cap_mim_m3_1 l=3 w=3
X2543 B10.t775 TOP.t5744 sky130_fd_pr__cap_mim_m3_1 l=3 w=3
X2544 B11.t109 TOP.t4900 sky130_fd_pr__cap_mim_m3_1 l=3 w=3
X2545 B11.t566 TOP.t3986 sky130_fd_pr__cap_mim_m3_1 l=3 w=3
X2546 B11.t1041 TOP.t3036 sky130_fd_pr__cap_mim_m3_1 l=3 w=3
X2547 B10.t737 TOP.t5820 sky130_fd_pr__cap_mim_m3_1 l=3 w=3
X2548 B11.t1879 TOP.t1360 sky130_fd_pr__cap_mim_m3_1 l=3 w=3
X2549 B10.t979 TOP.t5336 sky130_fd_pr__cap_mim_m3_1 l=3 w=3
X2550 B8.t68 TOP.t7670 sky130_fd_pr__cap_mim_m3_1 l=3 w=3
X2551 B10.t507 TOP.t6280 sky130_fd_pr__cap_mim_m3_1 l=3 w=3
X2552 EDGE_BIAS.t363 EDGE_BIAS.t364 sky130_fd_pr__cap_mim_m3_1 l=3 w=3
X2553 B10.t148 TOP.t6998 sky130_fd_pr__cap_mim_m3_1 l=3 w=3
X2554 B11.t954 TOP.t3210 sky130_fd_pr__cap_mim_m3_1 l=3 w=3
X2555 B10.t941 TOP.t5412 sky130_fd_pr__cap_mim_m3_1 l=3 w=3
X2556 B10.t903 TOP.t5488 sky130_fd_pr__cap_mim_m3_1 l=3 w=3
X2557 B8.t30 TOP.t7746 sky130_fd_pr__cap_mim_m3_1 l=3 w=3
X2558 B11.t674 TOP.t3770 sky130_fd_pr__cap_mim_m3_1 l=3 w=3
X2559 B11.t749 TOP.t3620 sky130_fd_pr__cap_mim_m3_1 l=3 w=3
X2560 B11.t916 TOP.t3286 sky130_fd_pr__cap_mim_m3_1 l=3 w=3
X2561 B10.t72 TOP.t7150 sky130_fd_pr__cap_mim_m3_1 l=3 w=3
X2562 B10.t110 TOP.t7074 sky130_fd_pr__cap_mim_m3_1 l=3 w=3
X2563 B6.t51 TOP.t5144 sky130_fd_pr__cap_mim_m3_1 l=3 w=3
X2564 B9.t246 TOP.t530 sky130_fd_pr__cap_mim_m3_1 l=3 w=3
X2565 B11.t226 TOP.t4666 sky130_fd_pr__cap_mim_m3_1 l=3 w=3
X2566 EDGE_BIAS.t747 EDGE_BIAS.t748 sky130_fd_pr__cap_mim_m3_1 l=3 w=3
X2567 B10.t761 TOP.t5772 sky130_fd_pr__cap_mim_m3_1 l=3 w=3
X2568 B6.t12 TOP.t5222 sky130_fd_pr__cap_mim_m3_1 l=3 w=3
X2569 B10.t34 TOP.t7226 sky130_fd_pr__cap_mim_m3_1 l=3 w=3
X2570 B10.t644 TOP.t6006 sky130_fd_pr__cap_mim_m3_1 l=3 w=3
X2571 B8.t202 TOP.t7402 sky130_fd_pr__cap_mim_m3_1 l=3 w=3
X2572 B9.t446 TOP.t130 sky130_fd_pr__cap_mim_m3_1 l=3 w=3
X2573 B11.t1312 TOP.t2494 sky130_fd_pr__cap_mim_m3_1 l=3 w=3
X2574 B8.t164 TOP.t7478 sky130_fd_pr__cap_mim_m3_1 l=3 w=3
X2575 B10.t606 TOP.t6082 sky130_fd_pr__cap_mim_m3_1 l=3 w=3
X2576 B11.t311 TOP.t4496 sky130_fd_pr__cap_mim_m3_1 l=3 w=3
X2577 B11.t1554 TOP.t2010 sky130_fd_pr__cap_mim_m3_1 l=3 w=3
X2578 B9.t408 TOP.t206 sky130_fd_pr__cap_mim_m3_1 l=3 w=3
X2579 B11.t940 TOP.t3238 sky130_fd_pr__cap_mim_m3_1 l=3 w=3
X2580 B10.t263 TOP.t6768 sky130_fd_pr__cap_mim_m3_1 l=3 w=3
X2581 B11.t1274 TOP.t2570 sky130_fd_pr__cap_mim_m3_1 l=3 w=3
X2582 EDGE_BIAS.t417 EDGE_BIAS.t418 sky130_fd_pr__cap_mim_m3_1 l=3 w=3
X2583 B11.t581 TOP.t3956 sky130_fd_pr__cap_mim_m3_1 l=3 w=3
X2584 B9.t370 TOP.t282 sky130_fd_pr__cap_mim_m3_1 l=3 w=3
X2585 B9.t332 TOP.t358 sky130_fd_pr__cap_mim_m3_1 l=3 w=3
X2586 B11.t543 TOP.t4032 sky130_fd_pr__cap_mim_m3_1 l=3 w=3
X2587 B10.t225 TOP.t6844 sky130_fd_pr__cap_mim_m3_1 l=3 w=3
X2588 B9.t153 TOP.t716 sky130_fd_pr__cap_mim_m3_1 l=3 w=3
X2589 B10.t467 TOP.t6360 sky130_fd_pr__cap_mim_m3_1 l=3 w=3
X2590 B11.t505 TOP.t4108 sky130_fd_pr__cap_mim_m3_1 l=3 w=3
X2591 B11.t142 TOP.t4834 sky130_fd_pr__cap_mim_m3_1 l=3 w=3
X2592 B9.t294 TOP.t434 sky130_fd_pr__cap_mim_m3_1 l=3 w=3
X2593 B10.t187 TOP.t6920 sky130_fd_pr__cap_mim_m3_1 l=3 w=3
X2594 B8.t188 TOP.t7430 sky130_fd_pr__cap_mim_m3_1 l=3 w=3
X2595 B10.t429 TOP.t6436 sky130_fd_pr__cap_mim_m3_1 l=3 w=3
X2596 B9.t3 TOP.t1016 sky130_fd_pr__cap_mim_m3_1 l=3 w=3
X2597 B11.t709 TOP.t3700 sky130_fd_pr__cap_mim_m3_1 l=3 w=3
X2598 B7.t70 TOP.t7922 sky130_fd_pr__cap_mim_m3_1 l=3 w=3
X2599 B7.t1 TOP.t8060 sky130_fd_pr__cap_mim_m3_1 l=3 w=3
X2600 B9.t59 TOP.t904 sky130_fd_pr__cap_mim_m3_1 l=3 w=3
X2601 B11.t170 TOP.t4778 sky130_fd_pr__cap_mim_m3_1 l=3 w=3
X2602 B11.t1863 TOP.t1392 sky130_fd_pr__cap_mim_m3_1 l=3 w=3
X2603 B10.t721 TOP.t5852 sky130_fd_pr__cap_mim_m3_1 l=3 w=3
X2604 B9.t102 TOP.t818 sky130_fd_pr__cap_mim_m3_1 l=3 w=3
X2605 B8.t90 TOP.t7626 sky130_fd_pr__cap_mim_m3_1 l=3 w=3
X2606 B10.t963 TOP.t5368 sky130_fd_pr__cap_mim_m3_1 l=3 w=3
X2607 B10.t683 TOP.t5928 sky130_fd_pr__cap_mim_m3_1 l=3 w=3
X2608 B11.t330 TOP.t4458 sky130_fd_pr__cap_mim_m3_1 l=3 w=3
X2609 B11.t351 TOP.t4416 sky130_fd_pr__cap_mim_m3_1 l=3 w=3
X2610 EDGE_BIAS.t471 EDGE_BIAS.t472 sky130_fd_pr__cap_mim_m3_1 l=3 w=3
X2611 B10.t925 TOP.t5444 sky130_fd_pr__cap_mim_m3_1 l=3 w=3
X2612 B9.t318 TOP.t386 sky130_fd_pr__cap_mim_m3_1 l=3 w=3
X2613 B8.t52 TOP.t7702 sky130_fd_pr__cap_mim_m3_1 l=3 w=3
X2614 EDGE_BIAS.t597 EDGE_BIAS.t598 sky130_fd_pr__cap_mim_m3_1 l=3 w=3
X2615 B11.t26 TOP.t5066 sky130_fd_pr__cap_mim_m3_1 l=3 w=3
X2616 B8.t14 TOP.t7778 sky130_fd_pr__cap_mim_m3_1 l=3 w=3
X2617 B11.t658 TOP.t3802 sky130_fd_pr__cap_mim_m3_1 l=3 w=3
X2618 B10.t94 TOP.t7106 sky130_fd_pr__cap_mim_m3_1 l=3 w=3
X2619 B5.t25 TOP.t8078 sky130_fd_pr__cap_mim_m3_1 l=3 w=3
X2620 B6.t35 TOP.t5176 sky130_fd_pr__cap_mim_m3_1 l=3 w=3
X2621 B11.t900 TOP.t3318 sky130_fd_pr__cap_mim_m3_1 l=3 w=3
X2622 B10.t336 TOP.t6622 sky130_fd_pr__cap_mim_m3_1 l=3 w=3
X2623 B9.t230 TOP.t562 sky130_fd_pr__cap_mim_m3_1 l=3 w=3
X2624 EDGE_BIAS.t552 EDGE_BIAS.t553 sky130_fd_pr__cap_mim_m3_1 l=3 w=3
X2625 B11.t620 TOP.t3878 sky130_fd_pr__cap_mim_m3_1 l=3 w=3
X2626 B10.t56 TOP.t7182 sky130_fd_pr__cap_mim_m3_1 l=3 w=3
X2627 B5.t12 TOP.t8104 sky130_fd_pr__cap_mim_m3_1 l=3 w=3
X2628 B9.t126 TOP.t770 sky130_fd_pr__cap_mim_m3_1 l=3 w=3
X2629 B11.t862 TOP.t3394 sky130_fd_pr__cap_mim_m3_1 l=3 w=3
X2630 B11.t1818 TOP.t1482 sky130_fd_pr__cap_mim_m3_1 l=3 w=3
X2631 B11.t86 TOP.t4946 sky130_fd_pr__cap_mim_m3_1 l=3 w=3
X2632 B11.t1000 TOP.t3118 sky130_fd_pr__cap_mim_m3_1 l=3 w=3
X2633 B11.t405 TOP.t4308 sky130_fd_pr__cap_mim_m3_1 l=3 w=3
X2634 B11.t1296 TOP.t2526 sky130_fd_pr__cap_mim_m3_1 l=3 w=3
X2635 B10.t949 TOP.t5396 sky130_fd_pr__cap_mim_m3_1 l=3 w=3
X2636 B8.t148 TOP.t7510 sky130_fd_pr__cap_mim_m3_1 l=3 w=3
X2637 B11.t1780 TOP.t1558 sky130_fd_pr__cap_mim_m3_1 l=3 w=3
X2638 B10.t590 TOP.t6114 sky130_fd_pr__cap_mim_m3_1 l=3 w=3
X2639 B9.t392 TOP.t238 sky130_fd_pr__cap_mim_m3_1 l=3 w=3
X2640 B10.t285 TOP.t6724 sky130_fd_pr__cap_mim_m3_1 l=3 w=3
X2641 B11.t1258 TOP.t2602 sky130_fd_pr__cap_mim_m3_1 l=3 w=3
X2642 B7.t109 TOP.t7844 sky130_fd_pr__cap_mim_m3_1 l=3 w=3
X2643 B9.t19 TOP.t984 sky130_fd_pr__cap_mim_m3_1 l=3 w=3
X2644 EDGE_BIAS.t525 EDGE_BIAS.t526 sky130_fd_pr__cap_mim_m3_1 l=3 w=3
X2645 B9.t354 TOP.t314 sky130_fd_pr__cap_mim_m3_1 l=3 w=3
X2646 B9.t254 TOP.t514 sky130_fd_pr__cap_mim_m3_1 l=3 w=3
X2647 EDGE_BIAS.t585 EDGE_BIAS.t586 sky130_fd_pr__cap_mim_m3_1 l=3 w=3
X2648 B10.t247 TOP.t6800 sky130_fd_pr__cap_mim_m3_1 l=3 w=3
X2649 B9.t137 TOP.t748 sky130_fd_pr__cap_mim_m3_1 l=3 w=3
X2650 B10.t489 TOP.t6316 sky130_fd_pr__cap_mim_m3_1 l=3 w=3
X2651 B11.t527 TOP.t4064 sky130_fd_pr__cap_mim_m3_1 l=3 w=3
X2652 B10.t209 TOP.t6876 sky130_fd_pr__cap_mim_m3_1 l=3 w=3
X2653 B10.t451 TOP.t6392 sky130_fd_pr__cap_mim_m3_1 l=3 w=3
X2654 B11.t295 TOP.t4528 sky130_fd_pr__cap_mim_m3_1 l=3 w=3
X2655 B11.t769 TOP.t3580 sky130_fd_pr__cap_mim_m3_1 l=3 w=3
X2656 B11.t1681 TOP.t1756 sky130_fd_pr__cap_mim_m3_1 l=3 w=3
X2657 B10.t171 TOP.t6952 sky130_fd_pr__cap_mim_m3_1 l=3 w=3
X2658 B11.t1164 TOP.t2790 sky130_fd_pr__cap_mim_m3_1 l=3 w=3
X2659 B10.t413 TOP.t6468 sky130_fd_pr__cap_mim_m3_1 l=3 w=3
X2660 B11.t731 TOP.t3656 sky130_fd_pr__cap_mim_m3_1 l=3 w=3
X2661 B11.t1923 TOP.t1272 sky130_fd_pr__cap_mim_m3_1 l=3 w=3
X2662 B11.t1600 TOP.t1918 sky130_fd_pr__cap_mim_m3_1 l=3 w=3
X2663 B10.t375 TOP.t6544 sky130_fd_pr__cap_mim_m3_1 l=3 w=3
X2664 B11.t1885 TOP.t1348 sky130_fd_pr__cap_mim_m3_1 l=3 w=3
X2665 B10.t705 TOP.t5884 sky130_fd_pr__cap_mim_m3_1 l=3 w=3
X2666 B9.t378 TOP.t266 sky130_fd_pr__cap_mim_m3_1 l=3 w=3
X2667 B9.t86 TOP.t850 sky130_fd_pr__cap_mim_m3_1 l=3 w=3
X2668 B11.t1213 TOP.t2692 sky130_fd_pr__cap_mim_m3_1 l=3 w=3
X2669 B8.t74 TOP.t7658 sky130_fd_pr__cap_mim_m3_1 l=3 w=3
X2670 B11.t1653 TOP.t1812 sky130_fd_pr__cap_mim_m3_1 l=3 w=3
X2671 B10.t667 TOP.t5960 sky130_fd_pr__cap_mim_m3_1 l=3 w=3
X2672 B11.t960 TOP.t3198 sky130_fd_pr__cap_mim_m3_1 l=3 w=3
X2673 B10.t195 TOP.t6904 sky130_fd_pr__cap_mim_m3_1 l=3 w=3
X2674 B10.t909 TOP.t5476 sky130_fd_pr__cap_mim_m3_1 l=3 w=3
X2675 B8.t36 TOP.t7734 sky130_fd_pr__cap_mim_m3_1 l=3 w=3
X2676 B11.t680 TOP.t3758 sky130_fd_pr__cap_mim_m3_1 l=3 w=3
X2677 B6.t57 TOP.t5132 sky130_fd_pr__cap_mim_m3_1 l=3 w=3
X2678 B11.t642 TOP.t3834 sky130_fd_pr__cap_mim_m3_1 l=3 w=3
X2679 B11.t922 TOP.t3274 sky130_fd_pr__cap_mim_m3_1 l=3 w=3
X2680 B10.t78 TOP.t7138 sky130_fd_pr__cap_mim_m3_1 l=3 w=3
X2681 B10.t629 TOP.t6036 sky130_fd_pr__cap_mim_m3_1 l=3 w=3
X2682 B11.t211 TOP.t4696 sky130_fd_pr__cap_mim_m3_1 l=3 w=3
X2683 B11.t884 TOP.t3350 sky130_fd_pr__cap_mim_m3_1 l=3 w=3
X2684 B11.t604 TOP.t3910 sky130_fd_pr__cap_mim_m3_1 l=3 w=3
X2685 EDGE_BIAS.t450 EDGE_BIAS.t451 sky130_fd_pr__cap_mim_m3_1 l=3 w=3
X2686 B6.t18 TOP.t5210 sky130_fd_pr__cap_mim_m3_1 l=3 w=3
X2687 B9.t58 TOP.t906 sky130_fd_pr__cap_mim_m3_1 l=3 w=3
X2688 B10.t40 TOP.t7214 sky130_fd_pr__cap_mim_m3_1 l=3 w=3
X2689 B10.t573 TOP.t6148 sky130_fd_pr__cap_mim_m3_1 l=3 w=3
X2690 B4.t4 TOP.t8174 sky130_fd_pr__cap_mim_m3_1 l=3 w=3
X2691 B11.t846 TOP.t3426 sky130_fd_pr__cap_mim_m3_1 l=3 w=3
X2692 B11.t1356 TOP.t2406 sky130_fd_pr__cap_mim_m3_1 l=3 w=3
X2693 B10.t1009 TOP.t5276 sky130_fd_pr__cap_mim_m3_1 l=3 w=3
X2694 EDGE_BIAS.t645 EDGE_BIAS.t646 sky130_fd_pr__cap_mim_m3_1 l=3 w=3
X2695 B11.t239 TOP.t4640 sky130_fd_pr__cap_mim_m3_1 l=3 w=3
X2696 B11.t1318 TOP.t2482 sky130_fd_pr__cap_mim_m3_1 l=3 w=3
X2697 B11.t43 TOP.t5032 sky130_fd_pr__cap_mim_m3_1 l=3 w=3
X2698 B11.t808 TOP.t3502 sky130_fd_pr__cap_mim_m3_1 l=3 w=3
X2699 B11.t1124 TOP.t2870 sky130_fd_pr__cap_mim_m3_1 l=3 w=3
X2700 B8.t132 TOP.t7542 sky130_fd_pr__cap_mim_m3_1 l=3 w=3
X2701 B8.t60 TOP.t7686 sky130_fd_pr__cap_mim_m3_1 l=3 w=3
X2702 B11.t1560 TOP.t1998 sky130_fd_pr__cap_mim_m3_1 l=3 w=3
X2703 EDGE_BIAS.t333 EDGE_BIAS.t334 sky130_fd_pr__cap_mim_m3_1 l=3 w=3
X2704 B10.t269 TOP.t6756 sky130_fd_pr__cap_mim_m3_1 l=3 w=3
X2705 B11.t1280 TOP.t2558 sky130_fd_pr__cap_mim_m3_1 l=3 w=3
X2706 B11.t1242 TOP.t2634 sky130_fd_pr__cap_mim_m3_1 l=3 w=3
X2707 B11.t1086 TOP.t2946 sky130_fd_pr__cap_mim_m3_1 l=3 w=3
X2708 B7.t93 TOP.t7876 sky130_fd_pr__cap_mim_m3_1 l=3 w=3
X2709 B11.t1016 TOP.t3086 sky130_fd_pr__cap_mim_m3_1 l=3 w=3
X2710 B11.t628 TOP.t3862 sky130_fd_pr__cap_mim_m3_1 l=3 w=3
X2711 B9.t338 TOP.t346 sky130_fd_pr__cap_mim_m3_1 l=3 w=3
X2712 B10.t64 TOP.t7166 sky130_fd_pr__cap_mim_m3_1 l=3 w=3
X2713 B10.t231 TOP.t6832 sky130_fd_pr__cap_mim_m3_1 l=3 w=3
X2714 B10.t473 TOP.t6348 sky130_fd_pr__cap_mim_m3_1 l=3 w=3
X2715 B11.t511 TOP.t4096 sky130_fd_pr__cap_mim_m3_1 l=3 w=3
X2716 B9.t300 TOP.t422 sky130_fd_pr__cap_mim_m3_1 l=3 w=3
X2717 EDGE_BIAS.t504 EDGE_BIAS.t505 sky130_fd_pr__cap_mim_m3_1 l=3 w=3
X2718 B11.t999 TOP.t3120 sky130_fd_pr__cap_mim_m3_1 l=3 w=3
X2719 B10.t435 TOP.t6424 sky130_fd_pr__cap_mim_m3_1 l=3 w=3
X2720 B10.t765 TOP.t5764 sky130_fd_pr__cap_mim_m3_1 l=3 w=3
X2721 B9.t438 TOP.t146 sky130_fd_pr__cap_mim_m3_1 l=3 w=3
X2722 B11.t715 TOP.t3688 sky130_fd_pr__cap_mim_m3_1 l=3 w=3
X2723 B10.t397 TOP.t6500 sky130_fd_pr__cap_mim_m3_1 l=3 w=3
X2724 B11.t63 TOP.t4992 sky130_fd_pr__cap_mim_m3_1 l=3 w=3
X2725 B11.t474 TOP.t4170 sky130_fd_pr__cap_mim_m3_1 l=3 w=3
X2726 B11.t1869 TOP.t1380 sky130_fd_pr__cap_mim_m3_1 l=3 w=3
X2727 B10.t727 TOP.t5840 sky130_fd_pr__cap_mim_m3_1 l=3 w=3
X2728 B10.t359 TOP.t6576 sky130_fd_pr__cap_mim_m3_1 l=3 w=3
X2729 B10.t533 TOP.t6228 sky130_fd_pr__cap_mim_m3_1 l=3 w=3
X2730 B9.t70 TOP.t882 sky130_fd_pr__cap_mim_m3_1 l=3 w=3
X2731 B11.t336 TOP.t4446 sky130_fd_pr__cap_mim_m3_1 l=3 w=3
X2732 B11.t382 TOP.t4354 sky130_fd_pr__cap_mim_m3_1 l=3 w=3
X2733 B10.t255 TOP.t6784 sky130_fd_pr__cap_mim_m3_1 l=3 w=3
X2734 B10.t969 TOP.t5356 sky130_fd_pr__cap_mim_m3_1 l=3 w=3
X2735 B10.t689 TOP.t5916 sky130_fd_pr__cap_mim_m3_1 l=3 w=3
X2736 B10.t7 TOP.t7280 sky130_fd_pr__cap_mim_m3_1 l=3 w=3
X2737 B11.t1637 TOP.t1844 sky130_fd_pr__cap_mim_m3_1 l=3 w=3
X2738 B10.t931 TOP.t5432 sky130_fd_pr__cap_mim_m3_1 l=3 w=3
X2739 B10.t651 TOP.t5992 sky130_fd_pr__cap_mim_m3_1 l=3 w=3
X2740 B9.t491 TOP.t40 sky130_fd_pr__cap_mim_m3_1 l=3 w=3
X2741 B10.t893 TOP.t5508 sky130_fd_pr__cap_mim_m3_1 l=3 w=3
X2742 B8.t20 TOP.t7766 sky130_fd_pr__cap_mim_m3_1 l=3 w=3
X2743 B11.t664 TOP.t3790 sky130_fd_pr__cap_mim_m3_1 l=3 w=3
X2744 B6.t41 TOP.t5164 sky130_fd_pr__cap_mim_m3_1 l=3 w=3
X2745 B11.t906 TOP.t3306 sky130_fd_pr__cap_mim_m3_1 l=3 w=3
X2746 B11.t1599 TOP.t1920 sky130_fd_pr__cap_mim_m3_1 l=3 w=3
X2747 B10.t613 TOP.t6068 sky130_fd_pr__cap_mim_m3_1 l=3 w=3
X2748 B11.t364 TOP.t4390 sky130_fd_pr__cap_mim_m3_1 l=3 w=3
X2749 B9.t236 TOP.t550 sky130_fd_pr__cap_mim_m3_1 l=3 w=3
X2750 B11.t272 TOP.t4574 sky130_fd_pr__cap_mim_m3_1 l=3 w=3
X2751 B6.t2 TOP.t5242 sky130_fd_pr__cap_mim_m3_1 l=3 w=3
X2752 B11.t868 TOP.t3382 sky130_fd_pr__cap_mim_m3_1 l=3 w=3
X2753 B10.t24 TOP.t7246 sky130_fd_pr__cap_mim_m3_1 l=3 w=3
X2754 B8.t192 TOP.t7422 sky130_fd_pr__cap_mim_m3_1 l=3 w=3
X2755 B8.t120 TOP.t7566 sky130_fd_pr__cap_mim_m3_1 l=3 w=3
X2756 B11.t830 TOP.t3458 sky130_fd_pr__cap_mim_m3_1 l=3 w=3
X2757 B11.t792 TOP.t3534 sky130_fd_pr__cap_mim_m3_1 l=3 w=3
X2758 B11.t1302 TOP.t2514 sky130_fd_pr__cap_mim_m3_1 l=3 w=3
X2759 B8.t154 TOP.t7498 sky130_fd_pr__cap_mim_m3_1 l=3 w=3
X2760 B11.t1108 TOP.t2902 sky130_fd_pr__cap_mim_m3_1 l=3 w=3
X2761 B9.t398 TOP.t226 sky130_fd_pr__cap_mim_m3_1 l=3 w=3
X2762 B11.t688 TOP.t3742 sky130_fd_pr__cap_mim_m3_1 l=3 w=3
X2763 B11.t1544 TOP.t2030 sky130_fd_pr__cap_mim_m3_1 l=3 w=3
X2764 B10.t637 TOP.t6020 sky130_fd_pr__cap_mim_m3_1 l=3 w=3
X2765 B11.t1264 TOP.t2590 sky130_fd_pr__cap_mim_m3_1 l=3 w=3
X2766 B7.t115 TOP.t7832 sky130_fd_pr__cap_mim_m3_1 l=3 w=3
X2767 B11.t418 TOP.t4282 sky130_fd_pr__cap_mim_m3_1 l=3 w=3
X2768 B11.t1070 TOP.t2978 sky130_fd_pr__cap_mim_m3_1 l=3 w=3
X2769 B9.t360 TOP.t302 sky130_fd_pr__cap_mim_m3_1 l=3 w=3
X2770 B7.t77 TOP.t7908 sky130_fd_pr__cap_mim_m3_1 l=3 w=3
X2771 B7.t46 TOP.t7970 sky130_fd_pr__cap_mim_m3_1 l=3 w=3
X2772 B11.t22 TOP.t5074 sky130_fd_pr__cap_mim_m3_1 l=3 w=3
X2773 B9.t322 TOP.t378 sky130_fd_pr__cap_mim_m3_1 l=3 w=3
X2774 B6.t26 TOP.t5194 sky130_fd_pr__cap_mim_m3_1 l=3 w=3
X2775 B9.t143 TOP.t736 sky130_fd_pr__cap_mim_m3_1 l=3 w=3
X2776 B10.t215 TOP.t6864 sky130_fd_pr__cap_mim_m3_1 l=3 w=3
X2777 B10.t1008 TOP.t5278 sky130_fd_pr__cap_mim_m3_1 l=3 w=3
X2778 B10.t457 TOP.t6380 sky130_fd_pr__cap_mim_m3_1 l=3 w=3
X2779 B8.t1 TOP.t7804 sky130_fd_pr__cap_mim_m3_1 l=3 w=3
X2780 B11.t2046 TOP.t1026 sky130_fd_pr__cap_mim_m3_1 l=3 w=3
X2781 B9.t284 TOP.t454 sky130_fd_pr__cap_mim_m3_1 l=3 w=3
X2782 B10.t177 TOP.t6940 sky130_fd_pr__cap_mim_m3_1 l=3 w=3
X2783 B10.t419 TOP.t6456 sky130_fd_pr__cap_mim_m3_1 l=3 w=3
X2784 B11.t699 TOP.t3720 sky130_fd_pr__cap_mim_m3_1 l=3 w=3
X2785 B10.t315 TOP.t6664 sky130_fd_pr__cap_mim_m3_1 l=3 w=3
X2786 EDGE_BIAS.t714 EDGE_BIAS.t715 sky130_fd_pr__cap_mim_m3_1 l=3 w=3
X2787 B11.t1288 TOP.t2542 sky130_fd_pr__cap_mim_m3_1 l=3 w=3
X2788 B10.t711 TOP.t5872 sky130_fd_pr__cap_mim_m3_1 l=3 w=3
X2789 B9.t92 TOP.t838 sky130_fd_pr__cap_mim_m3_1 l=3 w=3
X2790 B10.t953 TOP.t5388 sky130_fd_pr__cap_mim_m3_1 l=3 w=3
X2791 B10.t517 TOP.t6260 sky130_fd_pr__cap_mim_m3_1 l=3 w=3
X2792 B8.t80 TOP.t7646 sky130_fd_pr__cap_mim_m3_1 l=3 w=3
X2793 B10.t673 TOP.t5948 sky130_fd_pr__cap_mim_m3_1 l=3 w=3
X2794 B10.t915 TOP.t5464 sky130_fd_pr__cap_mim_m3_1 l=3 w=3
X2795 B9.t475 TOP.t72 sky130_fd_pr__cap_mim_m3_1 l=3 w=3
X2796 B8.t42 TOP.t7722 sky130_fd_pr__cap_mim_m3_1 l=3 w=3
X2797 DUMMY.t0 TOP.t8150 sky130_fd_pr__cap_mim_m3_1 l=3 w=3
X2798 B8.t4 TOP.t7798 sky130_fd_pr__cap_mim_m3_1 l=3 w=3
X2799 B10.t443 TOP.t6408 sky130_fd_pr__cap_mim_m3_1 l=3 w=3
X2800 B11.t648 TOP.t3822 sky130_fd_pr__cap_mim_m3_1 l=3 w=3
X2801 B10.t84 TOP.t7126 sky130_fd_pr__cap_mim_m3_1 l=3 w=3
X2802 B9.t437 TOP.t148 sky130_fd_pr__cap_mim_m3_1 l=3 w=3
X2803 B11.t890 TOP.t3338 sky130_fd_pr__cap_mim_m3_1 l=3 w=3
X2804 B11.t610 TOP.t3898 sky130_fd_pr__cap_mim_m3_1 l=3 w=3
X2805 B11.t1915 TOP.t1288 sky130_fd_pr__cap_mim_m3_1 l=3 w=3
X2806 B11.t1479 TOP.t2160 sky130_fd_pr__cap_mim_m3_1 l=3 w=3
X2807 B9.t220 TOP.t582 sky130_fd_pr__cap_mim_m3_1 l=3 w=3
X2808 B10.t46 TOP.t7202 sky130_fd_pr__cap_mim_m3_1 l=3 w=3
X2809 B5.t2 TOP.t8124 sky130_fd_pr__cap_mim_m3_1 l=3 w=3
X2810 B11.t852 TOP.t3414 sky130_fd_pr__cap_mim_m3_1 l=3 w=3
X2811 B9.t182 TOP.t658 sky130_fd_pr__cap_mim_m3_1 l=3 w=3
X2812 B11.t153 TOP.t4812 sky130_fd_pr__cap_mim_m3_1 l=3 w=3
X2813 B11.t2006 TOP.t1106 sky130_fd_pr__cap_mim_m3_1 l=3 w=3
X2814 B10.t697 TOP.t5900 sky130_fd_pr__cap_mim_m3_1 l=3 w=3
X2815 B11.t451 TOP.t4216 sky130_fd_pr__cap_mim_m3_1 l=3 w=3
X2816 B8.t138 TOP.t7530 sky130_fd_pr__cap_mim_m3_1 l=3 w=3
X2817 B9.t382 TOP.t258 sky130_fd_pr__cap_mim_m3_1 l=3 w=3
X2818 B6.t31 TOP.t5184 sky130_fd_pr__cap_mim_m3_1 l=3 w=3
X2819 B10.t275 TOP.t6744 sky130_fd_pr__cap_mim_m3_1 l=3 w=3
X2820 B11.t1968 TOP.t1182 sky130_fd_pr__cap_mim_m3_1 l=3 w=3
X2821 B9.t9 TOP.t1004 sky130_fd_pr__cap_mim_m3_1 l=3 w=3
X2822 EDGE_BIAS.t549 EDGE_BIAS.t550 sky130_fd_pr__cap_mim_m3_1 l=3 w=3
X2823 B11.t1248 TOP.t2622 sky130_fd_pr__cap_mim_m3_1 l=3 w=3
X2824 B7.t99 TOP.t7864 sky130_fd_pr__cap_mim_m3_1 l=3 w=3
X2825 B7.t30 TOP.t8002 sky130_fd_pr__cap_mim_m3_1 l=3 w=3
X2826 B9.t344 TOP.t334 sky130_fd_pr__cap_mim_m3_1 l=3 w=3
X2827 B11.t876 TOP.t3366 sky130_fd_pr__cap_mim_m3_1 l=3 w=3
X2828 B10.t237 TOP.t6820 sky130_fd_pr__cap_mim_m3_1 l=3 w=3
X2829 B10.t479 TOP.t6336 sky130_fd_pr__cap_mim_m3_1 l=3 w=3
X2830 B11.t517 TOP.t4084 sky130_fd_pr__cap_mim_m3_1 l=3 w=3
X2831 B10.t199 TOP.t6896 sky130_fd_pr__cap_mim_m3_1 l=3 w=3
X2832 B8.t119 TOP.t7568 sky130_fd_pr__cap_mim_m3_1 l=3 w=3
X2833 EDGE_BIAS.t420 EDGE_BIAS.t421 sky130_fd_pr__cap_mim_m3_1 l=3 w=3
X2834 B10.t888 TOP.t5518 sky130_fd_pr__cap_mim_m3_1 l=3 w=3
X2835 B9.t306 TOP.t410 sky130_fd_pr__cap_mim_m3_1 l=3 w=3
X2836 B10.t161 TOP.t6972 sky130_fd_pr__cap_mim_m3_1 l=3 w=3
X2837 B11.t1671 TOP.t1776 sky130_fd_pr__cap_mim_m3_1 l=3 w=3
X2838 B11.t1348 TOP.t2422 sky130_fd_pr__cap_mim_m3_1 l=3 w=3
X2839 B9.t268 TOP.t486 sky130_fd_pr__cap_mim_m3_1 l=3 w=3
X2840 B10.t403 TOP.t6488 sky130_fd_pr__cap_mim_m3_1 l=3 w=3
X2841 B11.t69 TOP.t4980 sky130_fd_pr__cap_mim_m3_1 l=3 w=3
X2842 B10.t123 TOP.t7048 sky130_fd_pr__cap_mim_m3_1 l=3 w=3
X2843 B7.t123 TOP.t7816 sky130_fd_pr__cap_mim_m3_1 l=3 w=3
X2844 B10.t365 TOP.t6564 sky130_fd_pr__cap_mim_m3_1 l=3 w=3
X2845 B11.t1875 TOP.t1368 sky130_fd_pr__cap_mim_m3_1 l=3 w=3
X2846 B11.t1439 TOP.t2240 sky130_fd_pr__cap_mim_m3_1 l=3 w=3
X2847 B11.t39 TOP.t5040 sky130_fd_pr__cap_mim_m3_1 l=3 w=3
X2848 B9.t76 TOP.t870 sky130_fd_pr__cap_mim_m3_1 l=3 w=3
X2849 B11.t1401 TOP.t2316 sky130_fd_pr__cap_mim_m3_1 l=3 w=3
X2850 B11.t1021 TOP.t3076 sky130_fd_pr__cap_mim_m3_1 l=3 w=3
X2851 B10.t448 TOP.t6398 sky130_fd_pr__cap_mim_m3_1 l=3 w=3
X2852 B11.t97 TOP.t4924 sky130_fd_pr__cap_mim_m3_1 l=3 w=3
X2853 B11.t950 TOP.t3218 sky130_fd_pr__cap_mim_m3_1 l=3 w=3
X2854 B11.t1643 TOP.t1832 sky130_fd_pr__cap_mim_m3_1 l=3 w=3
X2855 B10.t657 TOP.t5980 sky130_fd_pr__cap_mim_m3_1 l=3 w=3
X2856 B10.t899 TOP.t5496 sky130_fd_pr__cap_mim_m3_1 l=3 w=3
X2857 B8.t26 TOP.t7754 sky130_fd_pr__cap_mim_m3_1 l=3 w=3
X2858 B11.t632 TOP.t3854 sky130_fd_pr__cap_mim_m3_1 l=3 w=3
X2859 B11.t670 TOP.t3778 sky130_fd_pr__cap_mim_m3_1 l=3 w=3
X2860 B10.t619 TOP.t6056 sky130_fd_pr__cap_mim_m3_1 l=3 w=3
X2861 B6.t47 TOP.t5152 sky130_fd_pr__cap_mim_m3_1 l=3 w=3
X2862 B11.t278 TOP.t4562 sky130_fd_pr__cap_mim_m3_1 l=3 w=3
X2863 B11.t912 TOP.t3294 sky130_fd_pr__cap_mim_m3_1 l=3 w=3
X2864 B11.t257 TOP.t4604 sky130_fd_pr__cap_mim_m3_1 l=3 w=3
X2865 EDGE_BIAS.t474 EDGE_BIAS.t475 sky130_fd_pr__cap_mim_m3_1 l=3 w=3
X2866 B10.t314 TOP.t6666 sky130_fd_pr__cap_mim_m3_1 l=3 w=3
X2867 B9.t242 TOP.t538 sky130_fd_pr__cap_mim_m3_1 l=3 w=3
X2868 B9.t204 TOP.t614 sky130_fd_pr__cap_mim_m3_1 l=3 w=3
X2869 B9.t48 TOP.t926 sky130_fd_pr__cap_mim_m3_1 l=3 w=3
X2870 B11.t594 TOP.t3930 sky130_fd_pr__cap_mim_m3_1 l=3 w=3
X2871 B10.t757 TOP.t5780 sky130_fd_pr__cap_mim_m3_1 l=3 w=3
X2872 B6.t8 TOP.t5230 sky130_fd_pr__cap_mim_m3_1 l=3 w=3
X2873 B11.t501 TOP.t4116 sky130_fd_pr__cap_mim_m3_1 l=3 w=3
X2874 B10.t30 TOP.t7234 sky130_fd_pr__cap_mim_m3_1 l=3 w=3
X2875 B2.t0 TOP.t8190 sky130_fd_pr__cap_mim_m3_1 l=3 w=3
X2876 B11.t836 TOP.t3446 sky130_fd_pr__cap_mim_m3_1 l=3 w=3
X2877 B9.t166 TOP.t690 sky130_fd_pr__cap_mim_m3_1 l=3 w=3
X2878 B11.t306 TOP.t4506 sky130_fd_pr__cap_mim_m3_1 l=3 w=3
X2879 B11.t556 TOP.t4006 sky130_fd_pr__cap_mim_m3_1 l=3 w=3
X2880 B11.t798 TOP.t3522 sky130_fd_pr__cap_mim_m3_1 l=3 w=3
X2881 B11.t1990 TOP.t1138 sky130_fd_pr__cap_mim_m3_1 l=3 w=3
X2882 B11.t1667 TOP.t1784 sky130_fd_pr__cap_mim_m3_1 l=3 w=3
X2883 B11.t1308 TOP.t2502 sky130_fd_pr__cap_mim_m3_1 l=3 w=3
X2884 B10.t848 TOP.t5598 sky130_fd_pr__cap_mim_m3_1 l=3 w=3
X2885 B11.t1114 TOP.t2890 sky130_fd_pr__cap_mim_m3_1 l=3 w=3
X2886 B11.t424 TOP.t4270 sky130_fd_pr__cap_mim_m3_1 l=3 w=3
X2887 B11.t1952 TOP.t1214 sky130_fd_pr__cap_mim_m3_1 l=3 w=3
X2888 B11.t1550 TOP.t2018 sky130_fd_pr__cap_mim_m3_1 l=3 w=3
X2889 B10.t810 TOP.t5674 sky130_fd_pr__cap_mim_m3_1 l=3 w=3
X2890 B11.t881 TOP.t3356 sky130_fd_pr__cap_mim_m3_1 l=3 w=3
X2891 B11.t1012 TOP.t3094 sky130_fd_pr__cap_mim_m3_1 l=3 w=3
X2892 B11.t1270 TOP.t2578 sky130_fd_pr__cap_mim_m3_1 l=3 w=3
X2893 B11.t1232 TOP.t2654 sky130_fd_pr__cap_mim_m3_1 l=3 w=3
X2894 B11.t1076 TOP.t2966 sky130_fd_pr__cap_mim_m3_1 l=3 w=3
X2895 B7.t83 TOP.t7896 sky130_fd_pr__cap_mim_m3_1 l=3 w=3
X2896 B11.t1914 TOP.t1290 sky130_fd_pr__cap_mim_m3_1 l=3 w=3
X2897 B9.t328 TOP.t366 sky130_fd_pr__cap_mim_m3_1 l=3 w=3
X2898 B10.t221 TOP.t6852 sky130_fd_pr__cap_mim_m3_1 l=3 w=3
X2899 B10.t463 TOP.t6368 sky130_fd_pr__cap_mim_m3_1 l=3 w=3
X2900 B11.t119 TOP.t4880 sky130_fd_pr__cap_mim_m3_1 l=3 w=3
X2901 EDGE_BIAS.t528 EDGE_BIAS.t529 sky130_fd_pr__cap_mim_m3_1 l=3 w=3
X2902 B10.t183 TOP.t6928 sky130_fd_pr__cap_mim_m3_1 l=3 w=3
X2903 B9.t290 TOP.t442 sky130_fd_pr__cap_mim_m3_1 l=3 w=3
X2904 B11.t989 TOP.t3140 sky130_fd_pr__cap_mim_m3_1 l=3 w=3
X2905 B10.t145 TOP.t7004 sky130_fd_pr__cap_mim_m3_1 l=3 w=3
X2906 B8.t184 TOP.t7438 sky130_fd_pr__cap_mim_m3_1 l=3 w=3
X2907 B10.t425 TOP.t6444 sky130_fd_pr__cap_mim_m3_1 l=3 w=3
X2908 B11.t222 TOP.t4674 sky130_fd_pr__cap_mim_m3_1 l=3 w=3
X2909 B10.t387 TOP.t6520 sky130_fd_pr__cap_mim_m3_1 l=3 w=3
X2910 B4.t14 TOP.t8154 sky130_fd_pr__cap_mim_m3_1 l=3 w=3
X2911 B10.t107 TOP.t7080 sky130_fd_pr__cap_mim_m3_1 l=3 w=3
X2912 B11.t1100 TOP.t2918 sky130_fd_pr__cap_mim_m3_1 l=3 w=3
X2913 B11.t130 TOP.t4858 sky130_fd_pr__cap_mim_m3_1 l=3 w=3
X2914 B10.t349 TOP.t6596 sky130_fd_pr__cap_mim_m3_1 l=3 w=3
X2915 B11.t1859 TOP.t1400 sky130_fd_pr__cap_mim_m3_1 l=3 w=3
X2916 B11.t1423 TOP.t2272 sky130_fd_pr__cap_mim_m3_1 l=3 w=3
X2917 B10.t717 TOP.t5860 sky130_fd_pr__cap_mim_m3_1 l=3 w=3
X2918 B10.t959 TOP.t5376 sky130_fd_pr__cap_mim_m3_1 l=3 w=3
X2919 B10.t523 TOP.t6248 sky130_fd_pr__cap_mim_m3_1 l=3 w=3
X2920 B11.t1385 TOP.t2348 sky130_fd_pr__cap_mim_m3_1 l=3 w=3
X2921 B8.t237 TOP.t7332 sky130_fd_pr__cap_mim_m3_1 l=3 w=3
X2922 EDGE_BIAS.t612 EDGE_BIAS.t613 sky130_fd_pr__cap_mim_m3_1 l=3 w=3
X2923 B10.t679 TOP.t5936 sky130_fd_pr__cap_mim_m3_1 l=3 w=3
X2924 B9.t481 TOP.t60 sky130_fd_pr__cap_mim_m3_1 l=3 w=3
X2925 B9.t314 TOP.t394 sky130_fd_pr__cap_mim_m3_1 l=3 w=3
X2926 B11.t307 TOP.t4504 sky130_fd_pr__cap_mim_m3_1 l=3 w=3
X2927 B11.t1627 TOP.t1864 sky130_fd_pr__cap_mim_m3_1 l=3 w=3
X2928 B10.t921 TOP.t5452 sky130_fd_pr__cap_mim_m3_1 l=3 w=3
X2929 B10.t641 TOP.t6012 sky130_fd_pr__cap_mim_m3_1 l=3 w=3
X2930 B11.t1347 TOP.t2424 sky130_fd_pr__cap_mim_m3_1 l=3 w=3
X2931 B8.t10 TOP.t7786 sky130_fd_pr__cap_mim_m3_1 l=3 w=3
X2932 B11.t654 TOP.t3810 sky130_fd_pr__cap_mim_m3_1 l=3 w=3
X2933 B11.t1589 TOP.t1940 sky130_fd_pr__cap_mim_m3_1 l=3 w=3
X2934 B10.t603 TOP.t6088 sky130_fd_pr__cap_mim_m3_1 l=3 w=3
X2935 EDGE_BIAS.t387 EDGE_BIAS.t388 sky130_fd_pr__cap_mim_m3_1 l=3 w=3
X2936 B11.t896 TOP.t3326 sky130_fd_pr__cap_mim_m3_1 l=3 w=3
X2937 B9.t226 TOP.t570 sky130_fd_pr__cap_mim_m3_1 l=3 w=3
X2938 B11.t616 TOP.t3886 sky130_fd_pr__cap_mim_m3_1 l=3 w=3
X2939 B9.t32 TOP.t958 sky130_fd_pr__cap_mim_m3_1 l=3 w=3
X2940 B11.t578 TOP.t3962 sky130_fd_pr__cap_mim_m3_1 l=3 w=3
X2941 B5.t8 TOP.t8112 sky130_fd_pr__cap_mim_m3_1 l=3 w=3
X2942 B9.t122 TOP.t778 sky130_fd_pr__cap_mim_m3_1 l=3 w=3
X2943 B11.t820 TOP.t3478 sky130_fd_pr__cap_mim_m3_1 l=3 w=3
X2944 B11.t858 TOP.t3402 sky130_fd_pr__cap_mim_m3_1 l=3 w=3
X2945 B10.t14 TOP.t7266 sky130_fd_pr__cap_mim_m3_1 l=3 w=3
X2946 B11.t457 TOP.t4204 sky130_fd_pr__cap_mim_m3_1 l=3 w=3
X2947 B10.t502 TOP.t6290 sky130_fd_pr__cap_mim_m3_1 l=3 w=3
X2948 B11.t540 TOP.t4038 sky130_fd_pr__cap_mim_m3_1 l=3 w=3
X2949 B10.t832 TOP.t5630 sky130_fd_pr__cap_mim_m3_1 l=3 w=3
X2950 B9.t505 TOP.t12 sky130_fd_pr__cap_mim_m3_1 l=3 w=3
X2951 B11.t782 TOP.t3554 sky130_fd_pr__cap_mim_m3_1 l=3 w=3
X2952 B11.t1292 TOP.t2534 sky130_fd_pr__cap_mim_m3_1 l=3 w=3
X2953 B8.t144 TOP.t7518 sky130_fd_pr__cap_mim_m3_1 l=3 w=3
X2954 B9.t388 TOP.t246 sky130_fd_pr__cap_mim_m3_1 l=3 w=3
X2955 B11.t166 TOP.t4786 sky130_fd_pr__cap_mim_m3_1 l=3 w=3
X2956 B11.t51 TOP.t5016 sky130_fd_pr__cap_mim_m3_1 l=3 w=3
X2957 B10.t794 TOP.t5706 sky130_fd_pr__cap_mim_m3_1 l=3 w=3
X2958 B11.t485 TOP.t4148 sky130_fd_pr__cap_mim_m3_1 l=3 w=3
X2959 B11.t744 TOP.t3630 sky130_fd_pr__cap_mim_m3_1 l=3 w=3
X2960 B11.t1254 TOP.t2610 sky130_fd_pr__cap_mim_m3_1 l=3 w=3
X2961 B11.t1060 TOP.t2998 sky130_fd_pr__cap_mim_m3_1 l=3 w=3
X2962 B7.t105 TOP.t7852 sky130_fd_pr__cap_mim_m3_1 l=3 w=3
X2963 B7.t67 TOP.t7928 sky130_fd_pr__cap_mim_m3_1 l=3 w=3
X2964 B7.t36 TOP.t7990 sky130_fd_pr__cap_mim_m3_1 l=3 w=3
X2965 B9.t250 TOP.t522 sky130_fd_pr__cap_mim_m3_1 l=3 w=3
X2966 B9.t350 TOP.t322 sky130_fd_pr__cap_mim_m3_1 l=3 w=3
X2967 B10.t756 TOP.t5782 sky130_fd_pr__cap_mim_m3_1 l=3 w=3
X2968 B11.t347 TOP.t4424 sky130_fd_pr__cap_mim_m3_1 l=3 w=3
X2969 B10.t205 TOP.t6884 sky130_fd_pr__cap_mim_m3_1 l=3 w=3
X2970 B11.t1794 TOP.t1530 sky130_fd_pr__cap_mim_m3_1 l=3 w=3
X2971 B10.t998 TOP.t5298 sky130_fd_pr__cap_mim_m3_1 l=3 w=3
X2972 EDGE_BIAS.t441 EDGE_BIAS.t442 sky130_fd_pr__cap_mim_m3_1 l=3 w=3
X2973 B9.t274 TOP.t474 sky130_fd_pr__cap_mim_m3_1 l=3 w=3
X2974 B11.t255 TOP.t4608 sky130_fd_pr__cap_mim_m3_1 l=3 w=3
X2975 B10.t167 TOP.t6960 sky130_fd_pr__cap_mim_m3_1 l=3 w=3
X2976 B11.t973 TOP.t3172 sky130_fd_pr__cap_mim_m3_1 l=3 w=3
X2977 B10.t409 TOP.t6476 sky130_fd_pr__cap_mim_m3_1 l=3 w=3
X2978 B5.t22 TOP.t8084 sky130_fd_pr__cap_mim_m3_1 l=3 w=3
X2979 B11.t935 TOP.t3248 sky130_fd_pr__cap_mim_m3_1 l=3 w=3
X2980 B10.t371 TOP.t6552 sky130_fd_pr__cap_mim_m3_1 l=3 w=3
X2981 B7.t60 TOP.t7942 sky130_fd_pr__cap_mim_m3_1 l=3 w=3
X2982 B10.t701 TOP.t5892 sky130_fd_pr__cap_mim_m3_1 l=3 w=3
X2983 B11.t1028 TOP.t3062 sky130_fd_pr__cap_mim_m3_1 l=3 w=3
X2984 B9.t82 TOP.t858 sky130_fd_pr__cap_mim_m3_1 l=3 w=3
X2985 B8.t70 TOP.t7666 sky130_fd_pr__cap_mim_m3_1 l=3 w=3
X2986 B11.t401 TOP.t4316 sky130_fd_pr__cap_mim_m3_1 l=3 w=3
X2987 B8.t221 TOP.t7364 sky130_fd_pr__cap_mim_m3_1 l=3 w=3
X2988 B11.t1611 TOP.t1896 sky130_fd_pr__cap_mim_m3_1 l=3 w=3
X2989 B10.t663 TOP.t5968 sky130_fd_pr__cap_mim_m3_1 l=3 w=3
X2990 B9.t465 TOP.t92 sky130_fd_pr__cap_mim_m3_1 l=3 w=3
X2991 B10.t191 TOP.t6912 sky130_fd_pr__cap_mim_m3_1 l=3 w=3
X2992 EDGE_BIAS.t51 EDGE_BIAS.t52 sky130_fd_pr__cap_mim_m3_1 l=3 w=3
X2993 B10.t905 TOP.t5484 sky130_fd_pr__cap_mim_m3_1 l=3 w=3
X2994 B8.t32 TOP.t7742 sky130_fd_pr__cap_mim_m3_1 l=3 w=3
X2995 B11.t638 TOP.t3842 sky130_fd_pr__cap_mim_m3_1 l=3 w=3
X2996 B10.t625 TOP.t6044 sky130_fd_pr__cap_mim_m3_1 l=3 w=3
X2997 B8.t183 TOP.t7440 sky130_fd_pr__cap_mim_m3_1 l=3 w=3
X2998 B11.t1573 TOP.t1972 sky130_fd_pr__cap_mim_m3_1 l=3 w=3
X2999 B11.t1227 TOP.t2664 sky130_fd_pr__cap_mim_m3_1 l=3 w=3
X3000 B10.t587 TOP.t6120 sky130_fd_pr__cap_mim_m3_1 l=3 w=3
X3001 B9.t427 TOP.t168 sky130_fd_pr__cap_mim_m3_1 l=3 w=3
X3002 EDGE_BIAS.t495 EDGE_BIAS.t496 sky130_fd_pr__cap_mim_m3_1 l=3 w=3
X3003 B1.t1 TOP.t8146 sky130_fd_pr__cap_mim_m3_1 l=3 w=3
X3004 B9.t210 TOP.t602 sky130_fd_pr__cap_mim_m3_1 l=3 w=3
X3005 B9.t54 TOP.t914 sky130_fd_pr__cap_mim_m3_1 l=3 w=3
X3006 B11.t600 TOP.t3918 sky130_fd_pr__cap_mim_m3_1 l=3 w=3
X3007 B9.t16 TOP.t990 sky130_fd_pr__cap_mim_m3_1 l=3 w=3
X3008 B11.t842 TOP.t3434 sky130_fd_pr__cap_mim_m3_1 l=3 w=3
X3009 B4.t0 TOP.t8182 sky130_fd_pr__cap_mim_m3_1 l=3 w=3
X3010 B11.t291 TOP.t4536 sky130_fd_pr__cap_mim_m3_1 l=3 w=3
X3011 B11.t1754 TOP.t1610 sky130_fd_pr__cap_mim_m3_1 l=3 w=3
X3012 B9.t172 TOP.t678 sky130_fd_pr__cap_mim_m3_1 l=3 w=3
X3013 EDGE_BIAS.t765 EDGE_BIAS.t766 sky130_fd_pr__cap_mim_m3_1 l=3 w=3
X3014 B10.t486 TOP.t6322 sky130_fd_pr__cap_mim_m3_1 l=3 w=3
X3015 B11.t199 TOP.t4720 sky130_fd_pr__cap_mim_m3_1 l=3 w=3
X3016 B11.t804 TOP.t3510 sky130_fd_pr__cap_mim_m3_1 l=3 w=3
X3017 B11.t1996 TOP.t1126 sky130_fd_pr__cap_mim_m3_1 l=3 w=3
X3018 B9.t255 TOP.t512 sky130_fd_pr__cap_mim_m3_1 l=3 w=3
X3019 B11.t1716 TOP.t1686 sky130_fd_pr__cap_mim_m3_1 l=3 w=3
X3020 B8.t128 TOP.t7550 sky130_fd_pr__cap_mim_m3_1 l=3 w=3
X3021 B11.t1958 TOP.t1202 sky130_fd_pr__cap_mim_m3_1 l=3 w=3
X3022 B10.t265 TOP.t6764 sky130_fd_pr__cap_mim_m3_1 l=3 w=3
X3023 B7.t89 TOP.t7884 sky130_fd_pr__cap_mim_m3_1 l=3 w=3
X3024 B11.t1238 TOP.t2642 sky130_fd_pr__cap_mim_m3_1 l=3 w=3
X3025 B11.t1044 TOP.t3030 sky130_fd_pr__cap_mim_m3_1 l=3 w=3
X3026 B7.t20 TOP.t8022 sky130_fd_pr__cap_mim_m3_1 l=3 w=3
X3027 B11.t624 TOP.t3870 sky130_fd_pr__cap_mim_m3_1 l=3 w=3
X3028 B11.t1528 TOP.t2062 sky130_fd_pr__cap_mim_m3_1 l=3 w=3
X3029 B9.t334 TOP.t354 sky130_fd_pr__cap_mim_m3_1 l=3 w=3
X3030 B10.t227 TOP.t6840 sky130_fd_pr__cap_mim_m3_1 l=3 w=3
X3031 B9.t121 TOP.t780 sky130_fd_pr__cap_mim_m3_1 l=3 w=3
X3032 B10.t982 TOP.t5330 sky130_fd_pr__cap_mim_m3_1 l=3 w=3
X3033 B8.t109 TOP.t7588 sky130_fd_pr__cap_mim_m3_1 l=3 w=3
X3034 B10.t510 TOP.t6274 sky130_fd_pr__cap_mim_m3_1 l=3 w=3
X3035 B9.t296 TOP.t430 sky130_fd_pr__cap_mim_m3_1 l=3 w=3
X3036 B9.t258 TOP.t506 sky130_fd_pr__cap_mim_m3_1 l=3 w=3
X3037 B11.t995 TOP.t3128 sky130_fd_pr__cap_mim_m3_1 l=3 w=3
X3038 B10.t151 TOP.t6992 sky130_fd_pr__cap_mim_m3_1 l=3 w=3
X3039 B11.t957 TOP.t3204 sky130_fd_pr__cap_mim_m3_1 l=3 w=3
X3040 B10.t393 TOP.t6508 sky130_fd_pr__cap_mim_m3_1 l=3 w=3
X3041 B10.t944 TOP.t5406 sky130_fd_pr__cap_mim_m3_1 l=3 w=3
X3042 B11.t1982 TOP.t1154 sky130_fd_pr__cap_mim_m3_1 l=3 w=3
X3043 B11.t1187 TOP.t2744 sky130_fd_pr__cap_mim_m3_1 l=3 w=3
X3044 B10.t113 TOP.t7068 sky130_fd_pr__cap_mim_m3_1 l=3 w=3
X3045 B11.t1429 TOP.t2260 sky130_fd_pr__cap_mim_m3_1 l=3 w=3
X3046 B11.t919 TOP.t3280 sky130_fd_pr__cap_mim_m3_1 l=3 w=3
X3047 B10.t355 TOP.t6584 sky130_fd_pr__cap_mim_m3_1 l=3 w=3
X3048 B11.t1865 TOP.t1388 sky130_fd_pr__cap_mim_m3_1 l=3 w=3
X3049 EDGE_BIAS.t657 EDGE_BIAS.t658 sky130_fd_pr__cap_mim_m3_1 l=3 w=3
X3050 B10.t196 TOP.t6902 sky130_fd_pr__cap_mim_m3_1 l=3 w=3
X3051 B11.t1017 TOP.t3084 sky130_fd_pr__cap_mim_m3_1 l=3 w=3
X3052 B11.t1391 TOP.t2336 sky130_fd_pr__cap_mim_m3_1 l=3 w=3
X3053 B11.t3 TOP.t5112 sky130_fd_pr__cap_mim_m3_1 l=3 w=3
X3054 B10.t647 TOP.t6000 sky130_fd_pr__cap_mim_m3_1 l=3 w=3
X3055 B11.t1633 TOP.t1852 sky130_fd_pr__cap_mim_m3_1 l=3 w=3
X3056 B9.t449 TOP.t124 sky130_fd_pr__cap_mim_m3_1 l=3 w=3
X3057 B11.t660 TOP.t3798 sky130_fd_pr__cap_mim_m3_1 l=3 w=3
X3058 EDGE_BIAS.t303 EDGE_BIAS.t304 sky130_fd_pr__cap_mim_m3_1 l=3 w=3
X3059 B8.t16 TOP.t7774 sky130_fd_pr__cap_mim_m3_1 l=3 w=3
X3060 B11.t1595 TOP.t1928 sky130_fd_pr__cap_mim_m3_1 l=3 w=3
X3061 B10.t609 TOP.t6076 sky130_fd_pr__cap_mim_m3_1 l=3 w=3
X3062 B11.t324 TOP.t4470 sky130_fd_pr__cap_mim_m3_1 l=3 w=3
X3063 B11.t1557 TOP.t2004 sky130_fd_pr__cap_mim_m3_1 l=3 w=3
X3064 B9.t411 TOP.t200 sky130_fd_pr__cap_mim_m3_1 l=3 w=3
X3065 B9.t232 TOP.t558 sky130_fd_pr__cap_mim_m3_1 l=3 w=3
X3066 B11.t943 TOP.t3232 sky130_fd_pr__cap_mim_m3_1 l=3 w=3
X3067 B10.t304 TOP.t6686 sky130_fd_pr__cap_mim_m3_1 l=3 w=3
X3068 B9.t194 TOP.t634 sky130_fd_pr__cap_mim_m3_1 l=3 w=3
X3069 B9.t38 TOP.t946 sky130_fd_pr__cap_mim_m3_1 l=3 w=3
X3070 B11.t249 TOP.t4620 sky130_fd_pr__cap_mim_m3_1 l=3 w=3
X3071 B11.t584 TOP.t3950 sky130_fd_pr__cap_mim_m3_1 l=3 w=3
X3072 B10.t379 TOP.t6536 sky130_fd_pr__cap_mim_m3_1 l=3 w=3
X3073 B11.t826 TOP.t3466 sky130_fd_pr__cap_mim_m3_1 l=3 w=3
X3074 B9.t373 TOP.t276 sky130_fd_pr__cap_mim_m3_1 l=3 w=3
X3075 B11.t1738 TOP.t1642 sky130_fd_pr__cap_mim_m3_1 l=3 w=3
X3076 B11.t1415 TOP.t2288 sky130_fd_pr__cap_mim_m3_1 l=3 w=3
X3077 B9.t156 TOP.t710 sky130_fd_pr__cap_mim_m3_1 l=3 w=3
X3078 B11.t546 TOP.t4026 sky130_fd_pr__cap_mim_m3_1 l=3 w=3
X3079 B10.t838 TOP.t5618 sky130_fd_pr__cap_mim_m3_1 l=3 w=3
X3080 B11.t172 TOP.t4774 sky130_fd_pr__cap_mim_m3_1 l=3 w=3
X3081 B11.t788 TOP.t3542 sky130_fd_pr__cap_mim_m3_1 l=3 w=3
X3082 B11.t1298 TOP.t2522 sky130_fd_pr__cap_mim_m3_1 l=3 w=3
X3083 B11.t629 TOP.t3860 sky130_fd_pr__cap_mim_m3_1 l=3 w=3
X3084 B11.t1700 TOP.t1718 sky130_fd_pr__cap_mim_m3_1 l=3 w=3
X3085 B11.t1104 TOP.t2910 sky130_fd_pr__cap_mim_m3_1 l=3 w=3
X3086 B11.t80 TOP.t4958 sky130_fd_pr__cap_mim_m3_1 l=3 w=3
X3087 B11.t1942 TOP.t1234 sky130_fd_pr__cap_mim_m3_1 l=3 w=3
X3088 B10.t800 TOP.t5694 sky130_fd_pr__cap_mim_m3_1 l=3 w=3
X3089 B10.t633 TOP.t6028 sky130_fd_pr__cap_mim_m3_1 l=3 w=3
X3090 B11.t1260 TOP.t2598 sky130_fd_pr__cap_mim_m3_1 l=3 w=3
X3091 B11.t1066 TOP.t2986 sky130_fd_pr__cap_mim_m3_1 l=3 w=3
X3092 B7.t73 TOP.t7916 sky130_fd_pr__cap_mim_m3_1 l=3 w=3
X3093 B11.t378 TOP.t4362 sky130_fd_pr__cap_mim_m3_1 l=3 w=3
X3094 B7.t4 TOP.t8054 sky130_fd_pr__cap_mim_m3_1 l=3 w=3
X3095 B9.t62 TOP.t898 sky130_fd_pr__cap_mim_m3_1 l=3 w=3
X3096 B10.t211 TOP.t6872 sky130_fd_pr__cap_mim_m3_1 l=3 w=3
X3097 B11.t1904 TOP.t1310 sky130_fd_pr__cap_mim_m3_1 l=3 w=3
X3098 EDGE_BIAS.t357 EDGE_BIAS.t358 sky130_fd_pr__cap_mim_m3_1 l=3 w=3
X3099 B10.t1004 TOP.t5286 sky130_fd_pr__cap_mim_m3_1 l=3 w=3
X3100 B11.t108 TOP.t4902 sky130_fd_pr__cap_mim_m3_1 l=3 w=3
X3101 B10.t966 TOP.t5362 sky130_fd_pr__cap_mim_m3_1 l=3 w=3
X3102 B9.t280 TOP.t462 sky130_fd_pr__cap_mim_m3_1 l=3 w=3
X3103 B8.t93 TOP.t7620 sky130_fd_pr__cap_mim_m3_1 l=3 w=3
X3104 B10.t173 TOP.t6948 sky130_fd_pr__cap_mim_m3_1 l=3 w=3
X3105 B11.t812 TOP.t3494 sky130_fd_pr__cap_mim_m3_1 l=3 w=3
X3106 B11.t979 TOP.t3160 sky130_fd_pr__cap_mim_m3_1 l=3 w=3
X3107 B10.t135 TOP.t7024 sky130_fd_pr__cap_mim_m3_1 l=3 w=3
X3108 B8.t55 TOP.t7696 sky130_fd_pr__cap_mim_m3_1 l=3 w=3
X3109 B10.t928 TOP.t5438 sky130_fd_pr__cap_mim_m3_1 l=3 w=3
X3110 B11.t289 TOP.t4540 sky130_fd_pr__cap_mim_m3_1 l=3 w=3
X3111 B11.t1171 TOP.t2776 sky130_fd_pr__cap_mim_m3_1 l=3 w=3
X3112 B10.t824 TOP.t5646 sky130_fd_pr__cap_mim_m3_1 l=3 w=3
X3113 B5.t28 TOP.t8072 sky130_fd_pr__cap_mim_m3_1 l=3 w=3
X3114 B10.t97 TOP.t7100 sky130_fd_pr__cap_mim_m3_1 l=3 w=3
X3115 B10.t339 TOP.t6616 sky130_fd_pr__cap_mim_m3_1 l=3 w=3
X3116 B10.t707 TOP.t5880 sky130_fd_pr__cap_mim_m3_1 l=3 w=3
X3117 B10.t513 TOP.t6268 sky130_fd_pr__cap_mim_m3_1 l=3 w=3
X3118 B10.t59 TOP.t7176 sky130_fd_pr__cap_mim_m3_1 l=3 w=3
X3119 B11.t47 TOP.t5024 sky130_fd_pr__cap_mim_m3_1 l=3 w=3
X3120 B11.t1375 TOP.t2368 sky130_fd_pr__cap_mim_m3_1 l=3 w=3
X3121 B8.t227 TOP.t7352 sky130_fd_pr__cap_mim_m3_1 l=3 w=3
X3122 B11.t374 TOP.t4370 sky130_fd_pr__cap_mim_m3_1 l=3 w=3
X3123 B11.t1617 TOP.t1884 sky130_fd_pr__cap_mim_m3_1 l=3 w=3
X3124 B10.t669 TOP.t5956 sky130_fd_pr__cap_mim_m3_1 l=3 w=3
X3125 B9.t471 TOP.t80 sky130_fd_pr__cap_mim_m3_1 l=3 w=3
X3126 EDGE_BIAS.t411 EDGE_BIAS.t412 sky130_fd_pr__cap_mim_m3_1 l=3 w=3
X3127 B11.t644 TOP.t3830 sky130_fd_pr__cap_mim_m3_1 l=3 w=3
X3128 B11.t1003 TOP.t3112 sky130_fd_pr__cap_mim_m3_1 l=3 w=3
X3129 B11.t1337 TOP.t2444 sky130_fd_pr__cap_mim_m3_1 l=3 w=3
X3130 B10.t952 TOP.t5390 sky130_fd_pr__cap_mim_m3_1 l=3 w=3
X3131 B11.t1579 TOP.t1960 sky130_fd_pr__cap_mim_m3_1 l=3 w=3
X3132 B10.t593 TOP.t6108 sky130_fd_pr__cap_mim_m3_1 l=3 w=3
X3133 B9.t433 TOP.t156 sky130_fd_pr__cap_mim_m3_1 l=3 w=3
X3134 B9.t395 TOP.t232 sky130_fd_pr__cap_mim_m3_1 l=3 w=3
X3135 B9.t216 TOP.t590 sky130_fd_pr__cap_mim_m3_1 l=3 w=3
X3136 B11.t606 TOP.t3906 sky130_fd_pr__cap_mim_m3_1 l=3 w=3
X3137 B10.t288 TOP.t6718 sky130_fd_pr__cap_mim_m3_1 l=3 w=3
X3138 B9.t22 TOP.t978 sky130_fd_pr__cap_mim_m3_1 l=3 w=3
X3139 B11.t568 TOP.t3982 sky130_fd_pr__cap_mim_m3_1 l=3 w=3
X3140 B9.t357 TOP.t308 sky130_fd_pr__cap_mim_m3_1 l=3 w=3
X3141 B4.t6 TOP.t8170 sky130_fd_pr__cap_mim_m3_1 l=3 w=3
X3142 B11.t205 TOP.t4708 sky130_fd_pr__cap_mim_m3_1 l=3 w=3
X3143 B10.t250 TOP.t6794 sky130_fd_pr__cap_mim_m3_1 l=3 w=3
X3144 B9.t178 TOP.t666 sky130_fd_pr__cap_mim_m3_1 l=3 w=3
X3145 B11.t1033 TOP.t3052 sky130_fd_pr__cap_mim_m3_1 l=3 w=3
X3146 B8.t251 TOP.t7304 sky130_fd_pr__cap_mim_m3_1 l=3 w=3
X3147 B10.t492 TOP.t6310 sky130_fd_pr__cap_mim_m3_1 l=3 w=3
X3148 B11.t20 TOP.t5078 sky130_fd_pr__cap_mim_m3_1 l=3 w=3
X3149 B11.t530 TOP.t4058 sky130_fd_pr__cap_mim_m3_1 l=3 w=3
X3150 B11.t772 TOP.t3574 sky130_fd_pr__cap_mim_m3_1 l=3 w=3
X3151 B8.t134 TOP.t7538 sky130_fd_pr__cap_mim_m3_1 l=3 w=3
X3152 EDGE_BIAS.t726 EDGE_BIAS.t727 sky130_fd_pr__cap_mim_m3_1 l=3 w=3
X3153 EDGE_BIAS.t663 EDGE_BIAS.t664 sky130_fd_pr__cap_mim_m3_1 l=3 w=3
X3154 B11.t233 TOP.t4652 sky130_fd_pr__cap_mim_m3_1 l=3 w=3
X3155 B11.t1926 TOP.t1266 sky130_fd_pr__cap_mim_m3_1 l=3 w=3
X3156 B11.t1603 TOP.t1912 sky130_fd_pr__cap_mim_m3_1 l=3 w=3
X3157 B10.t784 TOP.t5726 sky130_fd_pr__cap_mim_m3_1 l=3 w=3
X3158 B7.t95 TOP.t7872 sky130_fd_pr__cap_mim_m3_1 l=3 w=3
X3159 B11.t734 TOP.t3650 sky130_fd_pr__cap_mim_m3_1 l=3 w=3
X3160 B11.t1244 TOP.t2630 sky130_fd_pr__cap_mim_m3_1 l=3 w=3
X3161 B11.t1050 TOP.t3018 sky130_fd_pr__cap_mim_m3_1 l=3 w=3
X3162 B7.t26 TOP.t8010 sky130_fd_pr__cap_mim_m3_1 l=3 w=3
X3163 EDGE_BIAS.t465 EDGE_BIAS.t466 sky130_fd_pr__cap_mim_m3_1 l=3 w=3
X3164 B11.t1888 TOP.t1342 sky130_fd_pr__cap_mim_m3_1 l=3 w=3
X3165 B10.t746 TOP.t5802 sky130_fd_pr__cap_mim_m3_1 l=3 w=3
X3166 B9.t381 TOP.t260 sky130_fd_pr__cap_mim_m3_1 l=3 w=3
X3167 B10.t988 TOP.t5318 sky130_fd_pr__cap_mim_m3_1 l=3 w=3
X3168 B8.t115 TOP.t7576 sky130_fd_pr__cap_mim_m3_1 l=3 w=3
X3169 B9.t264 TOP.t494 sky130_fd_pr__cap_mim_m3_1 l=3 w=3
X3170 B8.t77 TOP.t7652 sky130_fd_pr__cap_mim_m3_1 l=3 w=3
X3171 B10.t157 TOP.t6980 sky130_fd_pr__cap_mim_m3_1 l=3 w=3
X3172 B11.t963 TOP.t3192 sky130_fd_pr__cap_mim_m3_1 l=3 w=3
X3173 B10.t399 TOP.t6496 sky130_fd_pr__cap_mim_m3_1 l=3 w=3
X3174 B8.t39 TOP.t7728 sky130_fd_pr__cap_mim_m3_1 l=3 w=3
X3175 EDGE_BIAS.t546 EDGE_BIAS.t547 sky130_fd_pr__cap_mim_m3_1 l=3 w=3
X3176 B11.t683 TOP.t3752 sky130_fd_pr__cap_mim_m3_1 l=3 w=3
X3177 B10.t119 TOP.t7056 sky130_fd_pr__cap_mim_m3_1 l=3 w=3
X3178 B6.t60 TOP.t5126 sky130_fd_pr__cap_mim_m3_1 l=3 w=3
X3179 B11.t60 TOP.t4998 sky130_fd_pr__cap_mim_m3_1 l=3 w=3
X3180 B11.t925 TOP.t3268 sky130_fd_pr__cap_mim_m3_1 l=3 w=3
X3181 B10.t361 TOP.t6572 sky130_fd_pr__cap_mim_m3_1 l=3 w=3
X3182 B9.t72 TOP.t878 sky130_fd_pr__cap_mim_m3_1 l=3 w=3
X3183 B6.t21 TOP.t5204 sky130_fd_pr__cap_mim_m3_1 l=3 w=3
X3184 B11.t149 TOP.t4820 sky130_fd_pr__cap_mim_m3_1 l=3 w=3
X3185 B11.t468 TOP.t4182 sky130_fd_pr__cap_mim_m3_1 l=3 w=3
X3186 B11.t1359 TOP.t2400 sky130_fd_pr__cap_mim_m3_1 l=3 w=3
X3187 B10.t1012 TOP.t5270 sky130_fd_pr__cap_mim_m3_1 l=3 w=3
X3188 B10.t653 TOP.t5988 sky130_fd_pr__cap_mim_m3_1 l=3 w=3
X3189 B8.t211 TOP.t7384 sky130_fd_pr__cap_mim_m3_1 l=3 w=3
X3190 B11.t1843 TOP.t1432 sky130_fd_pr__cap_mim_m3_1 l=3 w=3
X3191 B9.t455 TOP.t112 sky130_fd_pr__cap_mim_m3_1 l=3 w=3
X3192 B8.t173 TOP.t7460 sky130_fd_pr__cap_mim_m3_1 l=3 w=3
X3193 EDGE_BIAS.t519 EDGE_BIAS.t520 sky130_fd_pr__cap_mim_m3_1 l=3 w=3
X3194 B11.t1321 TOP.t2476 sky130_fd_pr__cap_mim_m3_1 l=3 w=3
X3195 B10.t615 TOP.t6064 sky130_fd_pr__cap_mim_m3_1 l=3 w=3
X3196 B8.t63 TOP.t7680 sky130_fd_pr__cap_mim_m3_1 l=3 w=3
X3197 B11.t1563 TOP.t1992 sky130_fd_pr__cap_mim_m3_1 l=3 w=3
X3198 B10.t577 TOP.t6140 sky130_fd_pr__cap_mim_m3_1 l=3 w=3
X3199 B9.t417 TOP.t188 sky130_fd_pr__cap_mim_m3_1 l=3 w=3
X3200 B10.t272 TOP.t6750 sky130_fd_pr__cap_mim_m3_1 l=3 w=3
X3201 B10.t310 TOP.t6674 sky130_fd_pr__cap_mim_m3_1 l=3 w=3
X3202 B11.t1283 TOP.t2552 sky130_fd_pr__cap_mim_m3_1 l=3 w=3
X3203 B9.t200 TOP.t622 sky130_fd_pr__cap_mim_m3_1 l=3 w=3
X3204 B9.t44 TOP.t934 sky130_fd_pr__cap_mim_m3_1 l=3 w=3
X3205 B11.t590 TOP.t3938 sky130_fd_pr__cap_mim_m3_1 l=3 w=3
X3206 B9.t6 TOP.t1010 sky130_fd_pr__cap_mim_m3_1 l=3 w=3
X3207 B11.t358 TOP.t4402 sky130_fd_pr__cap_mim_m3_1 l=3 w=3
X3208 B11.t832 TOP.t3454 sky130_fd_pr__cap_mim_m3_1 l=3 w=3
X3209 EDGE_BIAS.t390 EDGE_BIAS.t391 sky130_fd_pr__cap_mim_m3_1 l=3 w=3
X3210 B10.t234 TOP.t6826 sky130_fd_pr__cap_mim_m3_1 l=3 w=3
X3211 B11.t1744 TOP.t1630 sky130_fd_pr__cap_mim_m3_1 l=3 w=3
X3212 B9.t162 TOP.t698 sky130_fd_pr__cap_mim_m3_1 l=3 w=3
X3213 B11.t552 TOP.t4014 sky130_fd_pr__cap_mim_m3_1 l=3 w=3
X3214 B11.t1986 TOP.t1146 sky130_fd_pr__cap_mim_m3_1 l=3 w=3
X3215 B11.t1663 TOP.t1792 sky130_fd_pr__cap_mim_m3_1 l=3 w=3
X3216 B10.t476 TOP.t6342 sky130_fd_pr__cap_mim_m3_1 l=3 w=3
X3217 B11.t794 TOP.t3530 sky130_fd_pr__cap_mim_m3_1 l=3 w=3
X3218 B11.t1706 TOP.t1706 sky130_fd_pr__cap_mim_m3_1 l=3 w=3
X3219 B10.t438 TOP.t6418 sky130_fd_pr__cap_mim_m3_1 l=3 w=3
X3220 B11.t384 TOP.t4350 sky130_fd_pr__cap_mim_m3_1 l=3 w=3
X3221 B11.t1948 TOP.t1222 sky130_fd_pr__cap_mim_m3_1 l=3 w=3
X3222 B6.t0 TOP.t5246 sky130_fd_pr__cap_mim_m3_1 l=3 w=3
X3223 EDGE_BIAS.t273 EDGE_BIAS.t274 sky130_fd_pr__cap_mim_m3_1 l=3 w=3
X3224 B10.t768 TOP.t5758 sky130_fd_pr__cap_mim_m3_1 l=3 w=3
X3225 B9.t441 TOP.t140 sky130_fd_pr__cap_mim_m3_1 l=3 w=3
X3226 B7.t79 TOP.t7904 sky130_fd_pr__cap_mim_m3_1 l=3 w=3
X3227 B7.t10 TOP.t8042 sky130_fd_pr__cap_mim_m3_1 l=3 w=3
X3228 B11.t114 TOP.t4890 sky130_fd_pr__cap_mim_m3_1 l=3 w=3
X3229 B11.t1910 TOP.t1298 sky130_fd_pr__cap_mim_m3_1 l=3 w=3
X3230 B10.t730 TOP.t5834 sky130_fd_pr__cap_mim_m3_1 l=3 w=3
X3231 B9.t111 TOP.t800 sky130_fd_pr__cap_mim_m3_1 l=3 w=3
X3232 B11.t93 TOP.t4932 sky130_fd_pr__cap_mim_m3_1 l=3 w=3
X3233 B11.t1872 TOP.t1374 sky130_fd_pr__cap_mim_m3_1 l=3 w=3
X3234 B11.t412 TOP.t4294 sky130_fd_pr__cap_mim_m3_1 l=3 w=3
X3235 B10.t258 TOP.t6778 sky130_fd_pr__cap_mim_m3_1 l=3 w=3
X3236 B10.t972 TOP.t5350 sky130_fd_pr__cap_mim_m3_1 l=3 w=3
X3237 B8.t99 TOP.t7608 sky130_fd_pr__cap_mim_m3_1 l=3 w=3
X3238 B9.t186 TOP.t650 sky130_fd_pr__cap_mim_m3_1 l=3 w=3
X3239 B10.t692 TOP.t5910 sky130_fd_pr__cap_mim_m3_1 l=3 w=3
X3240 B11.t274 TOP.t4570 sky130_fd_pr__cap_mim_m3_1 l=3 w=3
X3241 B11.t985 TOP.t3148 sky130_fd_pr__cap_mim_m3_1 l=3 w=3
X3242 B10.t141 TOP.t7012 sky130_fd_pr__cap_mim_m3_1 l=3 w=3
X3243 B11.t947 TOP.t3224 sky130_fd_pr__cap_mim_m3_1 l=3 w=3
X3244 B11.t1730 TOP.t1658 sky130_fd_pr__cap_mim_m3_1 l=3 w=3
X3245 B10.t934 TOP.t5426 sky130_fd_pr__cap_mim_m3_1 l=3 w=3
X3246 EDGE_BIAS.t444 EDGE_BIAS.t445 sky130_fd_pr__cap_mim_m3_1 l=3 w=3
X3247 B11.t667 TOP.t3784 sky130_fd_pr__cap_mim_m3_1 l=3 w=3
X3248 B11.t1177 TOP.t2764 sky130_fd_pr__cap_mim_m3_1 l=3 w=3
X3249 B4.t10 TOP.t8162 sky130_fd_pr__cap_mim_m3_1 l=3 w=3
X3250 B6.t44 TOP.t5158 sky130_fd_pr__cap_mim_m3_1 l=3 w=3
X3251 B11.t909 TOP.t3300 sky130_fd_pr__cap_mim_m3_1 l=3 w=3
X3252 B10.t103 TOP.t7088 sky130_fd_pr__cap_mim_m3_1 l=3 w=3
X3253 B11.t1419 TOP.t2280 sky130_fd_pr__cap_mim_m3_1 l=3 w=3
X3254 B11.t1096 TOP.t2926 sky130_fd_pr__cap_mim_m3_1 l=3 w=3
X3255 B10.t345 TOP.t6604 sky130_fd_pr__cap_mim_m3_1 l=3 w=3
X3256 B11.t302 TOP.t4514 sky130_fd_pr__cap_mim_m3_1 l=3 w=3
X3257 B6.t5 TOP.t5236 sky130_fd_pr__cap_mim_m3_1 l=3 w=3
X3258 B11.t871 TOP.t3376 sky130_fd_pr__cap_mim_m3_1 l=3 w=3
X3259 B11.t1381 TOP.t2356 sky130_fd_pr__cap_mim_m3_1 l=3 w=3
X3260 B8.t123 TOP.t7560 sky130_fd_pr__cap_mim_m3_1 l=3 w=3
X3261 B11.t1623 TOP.t1872 sky130_fd_pr__cap_mim_m3_1 l=3 w=3
X3262 EDGE_BIAS.t327 EDGE_BIAS.t328 sky130_fd_pr__cap_mim_m3_1 l=3 w=3
X3263 B8.t195 TOP.t7416 sky130_fd_pr__cap_mim_m3_1 l=3 w=3
X3264 B11.t1343 TOP.t2432 sky130_fd_pr__cap_mim_m3_1 l=3 w=3
X3265 B11.t1305 TOP.t2508 sky130_fd_pr__cap_mim_m3_1 l=3 w=3
X3266 B11.t1149 TOP.t2820 sky130_fd_pr__cap_mim_m3_1 l=3 w=3
X3267 B8.t157 TOP.t7492 sky130_fd_pr__cap_mim_m3_1 l=3 w=3
X3268 B11.t1585 TOP.t1948 sky130_fd_pr__cap_mim_m3_1 l=3 w=3
X3269 B10.t599 TOP.t6096 sky130_fd_pr__cap_mim_m3_1 l=3 w=3
X3270 B11.t691 TOP.t3736 sky130_fd_pr__cap_mim_m3_1 l=3 w=3
X3271 B10.t127 TOP.t7040 sky130_fd_pr__cap_mim_m3_1 l=3 w=3
X3272 B10.t294 TOP.t6706 sky130_fd_pr__cap_mim_m3_1 l=3 w=3
X3273 B11.t1547 TOP.t2024 sky130_fd_pr__cap_mim_m3_1 l=3 w=3
X3274 B9.t401 TOP.t220 sky130_fd_pr__cap_mim_m3_1 l=3 w=3
X3275 B11.t1267 TOP.t2584 sky130_fd_pr__cap_mim_m3_1 l=3 w=3
X3276 B7.t118 TOP.t7826 sky130_fd_pr__cap_mim_m3_1 l=3 w=3
X3277 B9.t28 TOP.t966 sky130_fd_pr__cap_mim_m3_1 l=3 w=3
X3278 B11.t574 TOP.t3970 sky130_fd_pr__cap_mim_m3_1 l=3 w=3
X3279 B9.t363 TOP.t296 sky130_fd_pr__cap_mim_m3_1 l=3 w=3
X3280 B11.t434 TOP.t4250 sky130_fd_pr__cap_mim_m3_1 l=3 w=3
X3281 B11.t536 TOP.t4046 sky130_fd_pr__cap_mim_m3_1 l=3 w=3
X3282 EDGE_BIAS.t498 EDGE_BIAS.t499 sky130_fd_pr__cap_mim_m3_1 l=3 w=3
X3283 B9.t146 TOP.t730 sky130_fd_pr__cap_mim_m3_1 l=3 w=3
X3284 B10.t498 TOP.t6298 sky130_fd_pr__cap_mim_m3_1 l=3 w=3
X3285 B10.t460 TOP.t6374 sky130_fd_pr__cap_mim_m3_1 l=3 w=3
X3286 EDGE_BIAS.t708 EDGE_BIAS.t709 sky130_fd_pr__cap_mim_m3_1 l=3 w=3
X3287 B10.t828 TOP.t5638 sky130_fd_pr__cap_mim_m3_1 l=3 w=3
X3288 B9.t501 TOP.t20 sky130_fd_pr__cap_mim_m3_1 l=3 w=3
X3289 B11.t778 TOP.t3562 sky130_fd_pr__cap_mim_m3_1 l=3 w=3
X3290 B11.t1690 TOP.t1738 sky130_fd_pr__cap_mim_m3_1 l=3 w=3
X3291 B10.t422 TOP.t6450 sky130_fd_pr__cap_mim_m3_1 l=3 w=3
X3292 B11.t126 TOP.t4866 sky130_fd_pr__cap_mim_m3_1 l=3 w=3
X3293 B11.t1932 TOP.t1254 sky130_fd_pr__cap_mim_m3_1 l=3 w=3
X3294 B10.t790 TOP.t5714 sky130_fd_pr__cap_mim_m3_1 l=3 w=3
X3295 B11.t445 TOP.t4228 sky130_fd_pr__cap_mim_m3_1 l=3 w=3
X3296 B11.t740 TOP.t3638 sky130_fd_pr__cap_mim_m3_1 l=3 w=3
X3297 B10.t318 TOP.t6658 sky130_fd_pr__cap_mim_m3_1 l=3 w=3
X3298 B11.t1056 TOP.t3006 sky130_fd_pr__cap_mim_m3_1 l=3 w=3
X3299 EDGE_BIAS.t381 EDGE_BIAS.t382 sky130_fd_pr__cap_mim_m3_1 l=3 w=3
X3300 B11.t1291 TOP.t2536 sky130_fd_pr__cap_mim_m3_1 l=3 w=3
X3301 EDGE_BIAS.t624 EDGE_BIAS.t625 sky130_fd_pr__cap_mim_m3_1 l=3 w=3
X3302 B11.t1894 TOP.t1330 sky130_fd_pr__cap_mim_m3_1 l=3 w=3
X3303 B10.t752 TOP.t5790 sky130_fd_pr__cap_mim_m3_1 l=3 w=3
X3304 B10.t714 TOP.t5866 sky130_fd_pr__cap_mim_m3_1 l=3 w=3
X3305 B10.t558 TOP.t6178 sky130_fd_pr__cap_mim_m3_1 l=3 w=3
X3306 B9.t95 TOP.t832 sky130_fd_pr__cap_mim_m3_1 l=3 w=3
X3307 B10.t994 TOP.t5306 sky130_fd_pr__cap_mim_m3_1 l=3 w=3
X3308 B8.t83 TOP.t7640 sky130_fd_pr__cap_mim_m3_1 l=3 w=3
X3309 B11.t560 TOP.t3998 sky130_fd_pr__cap_mim_m3_1 l=3 w=3
X3310 B10.t956 TOP.t5382 sky130_fd_pr__cap_mim_m3_1 l=3 w=3
X3311 B9.t270 TOP.t482 sky130_fd_pr__cap_mim_m3_1 l=3 w=3
X3312 B11.t1662 TOP.t1794 sky130_fd_pr__cap_mim_m3_1 l=3 w=3
X3313 B10.t676 TOP.t5942 sky130_fd_pr__cap_mim_m3_1 l=3 w=3
X3314 B11.t969 TOP.t3180 sky130_fd_pr__cap_mim_m3_1 l=3 w=3
X3315 B10.t918 TOP.t5458 sky130_fd_pr__cap_mim_m3_1 l=3 w=3
X3316 B8.t45 TOP.t7716 sky130_fd_pr__cap_mim_m3_1 l=3 w=3
X3317 B11.t335 TOP.t4448 sky130_fd_pr__cap_mim_m3_1 l=3 w=3
X3318 B11.t931 TOP.t3256 sky130_fd_pr__cap_mim_m3_1 l=3 w=3
X3319 B10.t87 TOP.t7120 sky130_fd_pr__cap_mim_m3_1 l=3 w=3
X3320 B5.t18 TOP.t8092 sky130_fd_pr__cap_mim_m3_1 l=3 w=3
X3321 B11.t893 TOP.t3332 sky130_fd_pr__cap_mim_m3_1 l=3 w=3
X3322 B7.t56 TOP.t7950 sky130_fd_pr__cap_mim_m3_1 l=3 w=3
X3323 B10.t329 TOP.t6636 sky130_fd_pr__cap_mim_m3_1 l=3 w=3
X3324 B10.t49 TOP.t7196 sky130_fd_pr__cap_mim_m3_1 l=3 w=3
X3325 B11.t1918 TOP.t1282 sky130_fd_pr__cap_mim_m3_1 l=3 w=3
X3326 B11.t855 TOP.t3408 sky130_fd_pr__cap_mim_m3_1 l=3 w=3
X3327 B11.t1365 TOP.t2388 sky130_fd_pr__cap_mim_m3_1 l=3 w=3
X3328 B8.t217 TOP.t7372 sky130_fd_pr__cap_mim_m3_1 l=3 w=3
X3329 B11.t1607 TOP.t1904 sky130_fd_pr__cap_mim_m3_1 l=3 w=3
X3330 B9.t461 TOP.t100 sky130_fd_pr__cap_mim_m3_1 l=3 w=3
X3331 B11.t11 TOP.t5096 sky130_fd_pr__cap_mim_m3_1 l=3 w=3
X3332 B10.t700 TOP.t5894 sky130_fd_pr__cap_mim_m3_1 l=3 w=3
X3333 B8.t179 TOP.t7448 sky130_fd_pr__cap_mim_m3_1 l=3 w=3
X3334 B11.t481 TOP.t4156 sky130_fd_pr__cap_mim_m3_1 l=3 w=3
X3335 B11.t1327 TOP.t2464 sky130_fd_pr__cap_mim_m3_1 l=3 w=3
X3336 B11.t1133 TOP.t2852 sky130_fd_pr__cap_mim_m3_1 l=3 w=3
X3337 B8.t141 TOP.t7524 sky130_fd_pr__cap_mim_m3_1 l=3 w=3
X3338 B11.t91 TOP.t4936 sky130_fd_pr__cap_mim_m3_1 l=3 w=3
X3339 B11.t1569 TOP.t1980 sky130_fd_pr__cap_mim_m3_1 l=3 w=3
X3340 B10.t583 TOP.t6128 sky130_fd_pr__cap_mim_m3_1 l=3 w=3
X3341 B9.t423 TOP.t176 sky130_fd_pr__cap_mim_m3_1 l=3 w=3
X3342 B9.t385 TOP.t252 sky130_fd_pr__cap_mim_m3_1 l=3 w=3
X3343 B3.t6 TOP.t8132 sky130_fd_pr__cap_mim_m3_1 l=3 w=3
X3344 B10.t278 TOP.t6738 sky130_fd_pr__cap_mim_m3_1 l=3 w=3
X3345 B9.t206 TOP.t610 sky130_fd_pr__cap_mim_m3_1 l=3 w=3
X3346 B11.t1095 TOP.t2928 sky130_fd_pr__cap_mim_m3_1 l=3 w=3
X3347 B7.t102 TOP.t7858 sky130_fd_pr__cap_mim_m3_1 l=3 w=3
X3348 B9.t12 TOP.t998 sky130_fd_pr__cap_mim_m3_1 l=3 w=3
X3349 EDGE_BIAS.t9 EDGE_BIAS.t10 sky130_fd_pr__cap_mim_m3_1 l=3 w=3
X3350 B9.t347 TOP.t328 sky130_fd_pr__cap_mim_m3_1 l=3 w=3
X3351 B9.t0 TOP.t1022 sky130_fd_pr__cap_mim_m3_1 l=3 w=3
X3352 B10.t240 TOP.t6814 sky130_fd_pr__cap_mim_m3_1 l=3 w=3
X3353 B9.t168 TOP.t686 sky130_fd_pr__cap_mim_m3_1 l=3 w=3
X3354 B10.t482 TOP.t6330 sky130_fd_pr__cap_mim_m3_1 l=3 w=3
X3355 B11.t520 TOP.t4078 sky130_fd_pr__cap_mim_m3_1 l=3 w=3
X3356 B9.t309 TOP.t404 sky130_fd_pr__cap_mim_m3_1 l=3 w=3
X3357 B11.t762 TOP.t3594 sky130_fd_pr__cap_mim_m3_1 l=3 w=3
X3358 B11.t1674 TOP.t1770 sky130_fd_pr__cap_mim_m3_1 l=3 w=3
X3359 B11.t1351 TOP.t2416 sky130_fd_pr__cap_mim_m3_1 l=3 w=3
X3360 B11.t724 TOP.t3670 sky130_fd_pr__cap_mim_m3_1 l=3 w=3
X3361 B10.t774 TOP.t5746 sky130_fd_pr__cap_mim_m3_1 l=3 w=3
X3362 B11.t1040 TOP.t3038 sky130_fd_pr__cap_mim_m3_1 l=3 w=3
X3363 B7.t16 TOP.t8030 sky130_fd_pr__cap_mim_m3_1 l=3 w=3
X3364 B10.t736 TOP.t5822 sky130_fd_pr__cap_mim_m3_1 l=3 w=3
X3365 B7.t126 TOP.t7810 sky130_fd_pr__cap_mim_m3_1 l=3 w=3
X3366 B9.t117 TOP.t788 sky130_fd_pr__cap_mim_m3_1 l=3 w=3
X3367 B11.t1878 TOP.t1362 sky130_fd_pr__cap_mim_m3_1 l=3 w=3
X3368 B10.t542 TOP.t6210 sky130_fd_pr__cap_mim_m3_1 l=3 w=3
X3369 B9.t79 TOP.t864 sky130_fd_pr__cap_mim_m3_1 l=3 w=3
X3370 B10.t978 TOP.t5338 sky130_fd_pr__cap_mim_m3_1 l=3 w=3
X3371 B8.t105 TOP.t7596 sky130_fd_pr__cap_mim_m3_1 l=3 w=3
X3372 B8.t67 TOP.t7672 sky130_fd_pr__cap_mim_m3_1 l=3 w=3
X3373 B10.t506 TOP.t6282 sky130_fd_pr__cap_mim_m3_1 l=3 w=3
X3374 B10.t147 TOP.t7000 sky130_fd_pr__cap_mim_m3_1 l=3 w=3
X3375 B9.t500 TOP.t22 sky130_fd_pr__cap_mim_m3_1 l=3 w=3
X3376 EDGE_BIAS.t360 EDGE_BIAS.t361 sky130_fd_pr__cap_mim_m3_1 l=3 w=3
X3377 B11.t953 TOP.t3212 sky130_fd_pr__cap_mim_m3_1 l=3 w=3
X3378 B11.t1542 TOP.t2034 sky130_fd_pr__cap_mim_m3_1 l=3 w=3
X3379 B10.t940 TOP.t5414 sky130_fd_pr__cap_mim_m3_1 l=3 w=3
X3380 B10.t902 TOP.t5490 sky130_fd_pr__cap_mim_m3_1 l=3 w=3
X3381 B8.t29 TOP.t7748 sky130_fd_pr__cap_mim_m3_1 l=3 w=3
X3382 B11.t673 TOP.t3772 sky130_fd_pr__cap_mim_m3_1 l=3 w=3
X3383 B11.t1978 TOP.t1162 sky130_fd_pr__cap_mim_m3_1 l=3 w=3
X3384 B6.t50 TOP.t5146 sky130_fd_pr__cap_mim_m3_1 l=3 w=3
X3385 B11.t915 TOP.t3288 sky130_fd_pr__cap_mim_m3_1 l=3 w=3
X3386 B10.t109 TOP.t7076 sky130_fd_pr__cap_mim_m3_1 l=3 w=3
X3387 B9.t245 TOP.t532 sky130_fd_pr__cap_mim_m3_1 l=3 w=3
X3388 B11.t216 TOP.t4686 sky130_fd_pr__cap_mim_m3_1 l=3 w=3
X3389 EDGE_BIAS.t777 EDGE_BIAS.t778 sky130_fd_pr__cap_mim_m3_1 l=3 w=3
X3390 EDGE_BIAS.t129 EDGE_BIAS.t130 sky130_fd_pr__cap_mim_m3_1 l=3 w=3
X3391 B10.t760 TOP.t5774 sky130_fd_pr__cap_mim_m3_1 l=3 w=3
X3392 B6.t11 TOP.t5224 sky130_fd_pr__cap_mim_m3_1 l=3 w=3
X3393 B8.t201 TOP.t7404 sky130_fd_pr__cap_mim_m3_1 l=3 w=3
X3394 B11.t2031 TOP.t1056 sky130_fd_pr__cap_mim_m3_1 l=3 w=3
X3395 B9.t445 TOP.t132 sky130_fd_pr__cap_mim_m3_1 l=3 w=3
X3396 B11.t1024 TOP.t3070 sky130_fd_pr__cap_mim_m3_1 l=3 w=3
X3397 B11.t1311 TOP.t2496 sky130_fd_pr__cap_mim_m3_1 l=3 w=3
X3398 B8.t163 TOP.t7480 sky130_fd_pr__cap_mim_m3_1 l=3 w=3
X3399 B10.t300 TOP.t6694 sky130_fd_pr__cap_mim_m3_1 l=3 w=3
X3400 B11.t1553 TOP.t2012 sky130_fd_pr__cap_mim_m3_1 l=3 w=3
X3401 B9.t407 TOP.t208 sky130_fd_pr__cap_mim_m3_1 l=3 w=3
X3402 B11.t939 TOP.t3240 sky130_fd_pr__cap_mim_m3_1 l=3 w=3
X3403 B10.t262 TOP.t6770 sky130_fd_pr__cap_mim_m3_1 l=3 w=3
X3404 B11.t1273 TOP.t2572 sky130_fd_pr__cap_mim_m3_1 l=3 w=3
X3405 B9.t34 TOP.t954 sky130_fd_pr__cap_mim_m3_1 l=3 w=3
X3406 B11.t580 TOP.t3958 sky130_fd_pr__cap_mim_m3_1 l=3 w=3
X3407 B9.t369 TOP.t284 sky130_fd_pr__cap_mim_m3_1 l=3 w=3
X3408 B7.t55 TOP.t7952 sky130_fd_pr__cap_mim_m3_1 l=3 w=3
X3409 EDGE_BIAS.t414 EDGE_BIAS.t415 sky130_fd_pr__cap_mim_m3_1 l=3 w=3
X3410 B9.t331 TOP.t360 sky130_fd_pr__cap_mim_m3_1 l=3 w=3
X3411 B11.t542 TOP.t4034 sky130_fd_pr__cap_mim_m3_1 l=3 w=3
X3412 B10.t224 TOP.t6846 sky130_fd_pr__cap_mim_m3_1 l=3 w=3
X3413 B11.t1734 TOP.t1650 sky130_fd_pr__cap_mim_m3_1 l=3 w=3
X3414 B11.t1411 TOP.t2296 sky130_fd_pr__cap_mim_m3_1 l=3 w=3
X3415 B9.t152 TOP.t718 sky130_fd_pr__cap_mim_m3_1 l=3 w=3
X3416 B10.t466 TOP.t6362 sky130_fd_pr__cap_mim_m3_1 l=3 w=3
X3417 B11.t132 TOP.t4854 sky130_fd_pr__cap_mim_m3_1 l=3 w=3
X3418 B11.t28 TOP.t5062 sky130_fd_pr__cap_mim_m3_1 l=3 w=3
X3419 B9.t293 TOP.t436 sky130_fd_pr__cap_mim_m3_1 l=3 w=3
X3420 B10.t186 TOP.t6922 sky130_fd_pr__cap_mim_m3_1 l=3 w=3
X3421 B11.t1696 TOP.t1726 sky130_fd_pr__cap_mim_m3_1 l=3 w=3
X3422 B11.t1502 TOP.t2114 sky130_fd_pr__cap_mim_m3_1 l=3 w=3
X3423 B8.t187 TOP.t7432 sky130_fd_pr__cap_mim_m3_1 l=3 w=3
X3424 B10.t428 TOP.t6438 sky130_fd_pr__cap_mim_m3_1 l=3 w=3
X3425 B11.t1938 TOP.t1242 sky130_fd_pr__cap_mim_m3_1 l=3 w=3
X3426 B10.t511 TOP.t6272 sky130_fd_pr__cap_mim_m3_1 l=3 w=3
X3427 B11.t1464 TOP.t2190 sky130_fd_pr__cap_mim_m3_1 l=3 w=3
X3428 B11.t1022 TOP.t3074 sky130_fd_pr__cap_mim_m3_1 l=3 w=3
X3429 B11.t160 TOP.t4798 sky130_fd_pr__cap_mim_m3_1 l=3 w=3
X3430 B11.t1900 TOP.t1318 sky130_fd_pr__cap_mim_m3_1 l=3 w=3
X3431 B11.t1862 TOP.t1394 sky130_fd_pr__cap_mim_m3_1 l=3 w=3
X3432 B10.t720 TOP.t5854 sky130_fd_pr__cap_mim_m3_1 l=3 w=3
X3433 B9.t101 TOP.t820 sky130_fd_pr__cap_mim_m3_1 l=3 w=3
X3434 B8.t89 TOP.t7628 sky130_fd_pr__cap_mim_m3_1 l=3 w=3
X3435 B10.t962 TOP.t5370 sky130_fd_pr__cap_mim_m3_1 l=3 w=3
X3436 B10.t682 TOP.t5930 sky130_fd_pr__cap_mim_m3_1 l=3 w=3
X3437 B11.t320 TOP.t4478 sky130_fd_pr__cap_mim_m3_1 l=3 w=3
X3438 B11.t341 TOP.t4436 sky130_fd_pr__cap_mim_m3_1 l=3 w=3
X3439 B11.t975 TOP.t3168 sky130_fd_pr__cap_mim_m3_1 l=3 w=3
X3440 EDGE_BIAS.t468 EDGE_BIAS.t469 sky130_fd_pr__cap_mim_m3_1 l=3 w=3
X3441 B10.t924 TOP.t5446 sky130_fd_pr__cap_mim_m3_1 l=3 w=3
X3442 B8.t51 TOP.t7704 sky130_fd_pr__cap_mim_m3_1 l=3 w=3
X3443 B8.t13 TOP.t7780 sky130_fd_pr__cap_mim_m3_1 l=3 w=3
X3444 B11.t657 TOP.t3804 sky130_fd_pr__cap_mim_m3_1 l=3 w=3
X3445 B10.t93 TOP.t7108 sky130_fd_pr__cap_mim_m3_1 l=3 w=3
X3446 B11.t1167 TOP.t2784 sky130_fd_pr__cap_mim_m3_1 l=3 w=3
X3447 B10.t820 TOP.t5654 sky130_fd_pr__cap_mim_m3_1 l=3 w=3
X3448 B5.t24 TOP.t8080 sky130_fd_pr__cap_mim_m3_1 l=3 w=3
X3449 B6.t34 TOP.t5178 sky130_fd_pr__cap_mim_m3_1 l=3 w=3
X3450 B11.t899 TOP.t3320 sky130_fd_pr__cap_mim_m3_1 l=3 w=3
X3451 B9.t229 TOP.t564 sky130_fd_pr__cap_mim_m3_1 l=3 w=3
X3452 B11.t369 TOP.t4380 sky130_fd_pr__cap_mim_m3_1 l=3 w=3
X3453 B11.t619 TOP.t3880 sky130_fd_pr__cap_mim_m3_1 l=3 w=3
X3454 B10.t55 TOP.t7184 sky130_fd_pr__cap_mim_m3_1 l=3 w=3
X3455 EDGE_BIAS.t177 EDGE_BIAS.t178 sky130_fd_pr__cap_mim_m3_1 l=3 w=3
X3456 B5.t11 TOP.t8106 sky130_fd_pr__cap_mim_m3_1 l=3 w=3
X3457 B9.t125 TOP.t772 sky130_fd_pr__cap_mim_m3_1 l=3 w=3
X3458 B11.t861 TOP.t3396 sky130_fd_pr__cap_mim_m3_1 l=3 w=3
X3459 B11.t1371 TOP.t2376 sky130_fd_pr__cap_mim_m3_1 l=3 w=3
X3460 B11.t487 TOP.t4144 sky130_fd_pr__cap_mim_m3_1 l=3 w=3
X3461 B11.t1613 TOP.t1892 sky130_fd_pr__cap_mim_m3_1 l=3 w=3
X3462 B11.t76 TOP.t4966 sky130_fd_pr__cap_mim_m3_1 l=3 w=3
X3463 B11.t944 TOP.t3230 sky130_fd_pr__cap_mim_m3_1 l=3 w=3
X3464 B11.t2015 TOP.t1088 sky130_fd_pr__cap_mim_m3_1 l=3 w=3
X3465 B10.t873 TOP.t5548 sky130_fd_pr__cap_mim_m3_1 l=3 w=3
X3466 B11.t395 TOP.t4328 sky130_fd_pr__cap_mim_m3_1 l=3 w=3
X3467 B11.t1333 TOP.t2452 sky130_fd_pr__cap_mim_m3_1 l=3 w=3
X3468 B11.t1295 TOP.t2528 sky130_fd_pr__cap_mim_m3_1 l=3 w=3
X3469 B11.t1139 TOP.t2840 sky130_fd_pr__cap_mim_m3_1 l=3 w=3
X3470 B10.t948 TOP.t5398 sky130_fd_pr__cap_mim_m3_1 l=3 w=3
X3471 B8.t147 TOP.t7512 sky130_fd_pr__cap_mim_m3_1 l=3 w=3
X3472 B11.t1575 TOP.t1968 sky130_fd_pr__cap_mim_m3_1 l=3 w=3
X3473 B10.t589 TOP.t6116 sky130_fd_pr__cap_mim_m3_1 l=3 w=3
X3474 B9.t391 TOP.t240 sky130_fd_pr__cap_mim_m3_1 l=3 w=3
X3475 B10.t284 TOP.t6726 sky130_fd_pr__cap_mim_m3_1 l=3 w=3
X3476 B11.t1977 TOP.t1164 sky130_fd_pr__cap_mim_m3_1 l=3 w=3
X3477 B11.t1257 TOP.t2604 sky130_fd_pr__cap_mim_m3_1 l=3 w=3
X3478 B7.t108 TOP.t7846 sky130_fd_pr__cap_mim_m3_1 l=3 w=3
X3479 B9.t18 TOP.t986 sky130_fd_pr__cap_mim_m3_1 l=3 w=3
X3480 B11.t182 TOP.t4754 sky130_fd_pr__cap_mim_m3_1 l=3 w=3
X3481 EDGE_BIAS.t522 EDGE_BIAS.t523 sky130_fd_pr__cap_mim_m3_1 l=3 w=3
X3482 B9.t353 TOP.t316 sky130_fd_pr__cap_mim_m3_1 l=3 w=3
X3483 B11.t423 TOP.t4272 sky130_fd_pr__cap_mim_m3_1 l=3 w=3
X3484 B10.t246 TOP.t6802 sky130_fd_pr__cap_mim_m3_1 l=3 w=3
X3485 B8.t247 TOP.t7312 sky130_fd_pr__cap_mim_m3_1 l=3 w=3
X3486 B9.t136 TOP.t750 sky130_fd_pr__cap_mim_m3_1 l=3 w=3
X3487 B10.t488 TOP.t6318 sky130_fd_pr__cap_mim_m3_1 l=3 w=3
X3488 B11.t526 TOP.t4066 sky130_fd_pr__cap_mim_m3_1 l=3 w=3
X3489 B10.t208 TOP.t6878 sky130_fd_pr__cap_mim_m3_1 l=3 w=3
X3490 B10.t450 TOP.t6394 sky130_fd_pr__cap_mim_m3_1 l=3 w=3
X3491 B11.t285 TOP.t4548 sky130_fd_pr__cap_mim_m3_1 l=3 w=3
X3492 B11.t1680 TOP.t1758 sky130_fd_pr__cap_mim_m3_1 l=3 w=3
X3493 B10.t170 TOP.t6954 sky130_fd_pr__cap_mim_m3_1 l=3 w=3
X3494 B11.t1486 TOP.t2146 sky130_fd_pr__cap_mim_m3_1 l=3 w=3
X3495 B11.t1163 TOP.t2792 sky130_fd_pr__cap_mim_m3_1 l=3 w=3
X3496 B10.t412 TOP.t6470 sky130_fd_pr__cap_mim_m3_1 l=3 w=3
X3497 B11.t193 TOP.t4732 sky130_fd_pr__cap_mim_m3_1 l=3 w=3
X3498 B11.t1922 TOP.t1274 sky130_fd_pr__cap_mim_m3_1 l=3 w=3
X3499 B10.t780 TOP.t5734 sky130_fd_pr__cap_mim_m3_1 l=3 w=3
X3500 B11.t1046 TOP.t3026 sky130_fd_pr__cap_mim_m3_1 l=3 w=3
X3501 B11.t7 TOP.t5104 sky130_fd_pr__cap_mim_m3_1 l=3 w=3
X3502 B11.t1448 TOP.t2222 sky130_fd_pr__cap_mim_m3_1 l=3 w=3
X3503 B10.t742 TOP.t5810 sky130_fd_pr__cap_mim_m3_1 l=3 w=3
X3504 B11.t370 TOP.t4378 sky130_fd_pr__cap_mim_m3_1 l=3 w=3
X3505 B10.t374 TOP.t6546 sky130_fd_pr__cap_mim_m3_1 l=3 w=3
X3506 B11.t1884 TOP.t1350 sky130_fd_pr__cap_mim_m3_1 l=3 w=3
X3507 B10.t704 TOP.t5886 sky130_fd_pr__cap_mim_m3_1 l=3 w=3
X3508 B10.t548 TOP.t6198 sky130_fd_pr__cap_mim_m3_1 l=3 w=3
X3509 B9.t377 TOP.t268 sky130_fd_pr__cap_mim_m3_1 l=3 w=3
X3510 B9.t85 TOP.t852 sky130_fd_pr__cap_mim_m3_1 l=3 w=3
X3511 B10.t984 TOP.t5326 sky130_fd_pr__cap_mim_m3_1 l=3 w=3
X3512 B8.t73 TOP.t7660 sky130_fd_pr__cap_mim_m3_1 l=3 w=3
X3513 B11.t1410 TOP.t2298 sky130_fd_pr__cap_mim_m3_1 l=3 w=3
X3514 B11.t959 TOP.t3200 sky130_fd_pr__cap_mim_m3_1 l=3 w=3
X3515 B11.t1652 TOP.t1814 sky130_fd_pr__cap_mim_m3_1 l=3 w=3
X3516 B10.t666 TOP.t5962 sky130_fd_pr__cap_mim_m3_1 l=3 w=3
X3517 B11.t45 TOP.t5028 sky130_fd_pr__cap_mim_m3_1 l=3 w=3
X3518 B10.t908 TOP.t5478 sky130_fd_pr__cap_mim_m3_1 l=3 w=3
X3519 B8.t35 TOP.t7736 sky130_fd_pr__cap_mim_m3_1 l=3 w=3
X3520 B11.t679 TOP.t3760 sky130_fd_pr__cap_mim_m3_1 l=3 w=3
X3521 B6.t56 TOP.t5134 sky130_fd_pr__cap_mim_m3_1 l=3 w=3
X3522 B11.t641 TOP.t3836 sky130_fd_pr__cap_mim_m3_1 l=3 w=3
X3523 B11.t921 TOP.t3276 sky130_fd_pr__cap_mim_m3_1 l=3 w=3
X3524 B10.t77 TOP.t7140 sky130_fd_pr__cap_mim_m3_1 l=3 w=3
X3525 B10.t628 TOP.t6038 sky130_fd_pr__cap_mim_m3_1 l=3 w=3
X3526 B11.t883 TOP.t3352 sky130_fd_pr__cap_mim_m3_1 l=3 w=3
X3527 B9.t57 TOP.t908 sky130_fd_pr__cap_mim_m3_1 l=3 w=3
X3528 B11.t603 TOP.t3912 sky130_fd_pr__cap_mim_m3_1 l=3 w=3
X3529 B6.t17 TOP.t5212 sky130_fd_pr__cap_mim_m3_1 l=3 w=3
X3530 B10.t39 TOP.t7216 sky130_fd_pr__cap_mim_m3_1 l=3 w=3
X3531 B11.t1038 TOP.t3042 sky130_fd_pr__cap_mim_m3_1 l=3 w=3
X3532 B10.t572 TOP.t6150 sky130_fd_pr__cap_mim_m3_1 l=3 w=3
X3533 B8.t207 TOP.t7392 sky130_fd_pr__cap_mim_m3_1 l=3 w=3
X3534 B11.t845 TOP.t3428 sky130_fd_pr__cap_mim_m3_1 l=3 w=3
X3535 B11.t1355 TOP.t2408 sky130_fd_pr__cap_mim_m3_1 l=3 w=3
X3536 EDGE_BIAS.t675 EDGE_BIAS.t676 sky130_fd_pr__cap_mim_m3_1 l=3 w=3
X3537 B9.t451 TOP.t120 sky130_fd_pr__cap_mim_m3_1 l=3 w=3
X3538 B11.t229 TOP.t4660 sky130_fd_pr__cap_mim_m3_1 l=3 w=3
X3539 B11.t807 TOP.t3504 sky130_fd_pr__cap_mim_m3_1 l=3 w=3
X3540 B11.t1317 TOP.t2484 sky130_fd_pr__cap_mim_m3_1 l=3 w=3
X3541 B10.t857 TOP.t5580 sky130_fd_pr__cap_mim_m3_1 l=3 w=3
X3542 B8.t169 TOP.t7468 sky130_fd_pr__cap_mim_m3_1 l=3 w=3
X3543 B11.t1123 TOP.t2872 sky130_fd_pr__cap_mim_m3_1 l=3 w=3
X3544 B8.t131 TOP.t7544 sky130_fd_pr__cap_mim_m3_1 l=3 w=3
X3545 B8.t59 TOP.t7688 sky130_fd_pr__cap_mim_m3_1 l=3 w=3
X3546 B11.t1559 TOP.t2000 sky130_fd_pr__cap_mim_m3_1 l=3 w=3
X3547 B10.t819 TOP.t5656 sky130_fd_pr__cap_mim_m3_1 l=3 w=3
X3548 EDGE_BIAS.t330 EDGE_BIAS.t331 sky130_fd_pr__cap_mim_m3_1 l=3 w=3
X3549 B9.t413 TOP.t196 sky130_fd_pr__cap_mim_m3_1 l=3 w=3
X3550 B10.t268 TOP.t6758 sky130_fd_pr__cap_mim_m3_1 l=3 w=3
X3551 B11.t1279 TOP.t2560 sky130_fd_pr__cap_mim_m3_1 l=3 w=3
X3552 EDGE_BIAS.t435 EDGE_BIAS.t436 sky130_fd_pr__cap_mim_m3_1 l=3 w=3
X3553 B11.t1857 TOP.t1404 sky130_fd_pr__cap_mim_m3_1 l=3 w=3
X3554 B11.t1241 TOP.t2636 sky130_fd_pr__cap_mim_m3_1 l=3 w=3
X3555 B11.t1085 TOP.t2948 sky130_fd_pr__cap_mim_m3_1 l=3 w=3
X3556 B7.t92 TOP.t7878 sky130_fd_pr__cap_mim_m3_1 l=3 w=3
X3557 B11.t318 TOP.t4482 sky130_fd_pr__cap_mim_m3_1 l=3 w=3
X3558 B9.t337 TOP.t348 sky130_fd_pr__cap_mim_m3_1 l=3 w=3
X3559 B10.t230 TOP.t6834 sky130_fd_pr__cap_mim_m3_1 l=3 w=3
X3560 B10.t472 TOP.t6350 sky130_fd_pr__cap_mim_m3_1 l=3 w=3
X3561 B11.t510 TOP.t4098 sky130_fd_pr__cap_mim_m3_1 l=3 w=3
X3562 B9.t299 TOP.t424 sky130_fd_pr__cap_mim_m3_1 l=3 w=3
X3563 B11.t998 TOP.t3122 sky130_fd_pr__cap_mim_m3_1 l=3 w=3
X3564 B10.t434 TOP.t6426 sky130_fd_pr__cap_mim_m3_1 l=3 w=3
X3565 B10.t764 TOP.t5766 sky130_fd_pr__cap_mim_m3_1 l=3 w=3
X3566 B11.t1029 TOP.t3060 sky130_fd_pr__cap_mim_m3_1 l=3 w=3
X3567 B11.t714 TOP.t3690 sky130_fd_pr__cap_mim_m3_1 l=3 w=3
X3568 B7.t6 TOP.t8050 sky130_fd_pr__cap_mim_m3_1 l=3 w=3
X3569 B11.t74 TOP.t4970 sky130_fd_pr__cap_mim_m3_1 l=3 w=3
X3570 B11.t464 TOP.t4190 sky130_fd_pr__cap_mim_m3_1 l=3 w=3
X3571 B11.t1868 TOP.t1382 sky130_fd_pr__cap_mim_m3_1 l=3 w=3
X3572 B10.t726 TOP.t5842 sky130_fd_pr__cap_mim_m3_1 l=3 w=3
X3573 B9.t107 TOP.t808 sky130_fd_pr__cap_mim_m3_1 l=3 w=3
X3574 B10.t532 TOP.t6230 sky130_fd_pr__cap_mim_m3_1 l=3 w=3
X3575 B8.t95 TOP.t7616 sky130_fd_pr__cap_mim_m3_1 l=3 w=3
X3576 B9.t69 TOP.t884 sky130_fd_pr__cap_mim_m3_1 l=3 w=3
X3577 B10.t254 TOP.t6786 sky130_fd_pr__cap_mim_m3_1 l=3 w=3
X3578 B10.t968 TOP.t5358 sky130_fd_pr__cap_mim_m3_1 l=3 w=3
X3579 B8.t246 TOP.t7314 sky130_fd_pr__cap_mim_m3_1 l=3 w=3
X3580 B10.t688 TOP.t5918 sky130_fd_pr__cap_mim_m3_1 l=3 w=3
X3581 EDGE_BIAS.t489 EDGE_BIAS.t490 sky130_fd_pr__cap_mim_m3_1 l=3 w=3
X3582 B11.t1726 TOP.t1666 sky130_fd_pr__cap_mim_m3_1 l=3 w=3
X3583 B11.t1636 TOP.t1846 sky130_fd_pr__cap_mim_m3_1 l=3 w=3
X3584 B10.t930 TOP.t5434 sky130_fd_pr__cap_mim_m3_1 l=3 w=3
X3585 B10.t650 TOP.t5994 sky130_fd_pr__cap_mim_m3_1 l=3 w=3
X3586 B9.t490 TOP.t42 sky130_fd_pr__cap_mim_m3_1 l=3 w=3
X3587 B10.t892 TOP.t5510 sky130_fd_pr__cap_mim_m3_1 l=3 w=3
X3588 B8.t19 TOP.t7768 sky130_fd_pr__cap_mim_m3_1 l=3 w=3
X3589 B11.t663 TOP.t3792 sky130_fd_pr__cap_mim_m3_1 l=3 w=3
X3590 B10.t612 TOP.t6070 sky130_fd_pr__cap_mim_m3_1 l=3 w=3
X3591 B6.t40 TOP.t5166 sky130_fd_pr__cap_mim_m3_1 l=3 w=3
X3592 B11.t354 TOP.t4410 sky130_fd_pr__cap_mim_m3_1 l=3 w=3
X3593 B11.t905 TOP.t3308 sky130_fd_pr__cap_mim_m3_1 l=3 w=3
X3594 B11.t1598 TOP.t1922 sky130_fd_pr__cap_mim_m3_1 l=3 w=3
X3595 B11.t24 TOP.t5070 sky130_fd_pr__cap_mim_m3_1 l=3 w=3
X3596 B11.t1817 TOP.t1484 sky130_fd_pr__cap_mim_m3_1 l=3 w=3
X3597 B9.t235 TOP.t552 sky130_fd_pr__cap_mim_m3_1 l=3 w=3
X3598 B9.t41 TOP.t940 sky130_fd_pr__cap_mim_m3_1 l=3 w=3
X3599 B11.t262 TOP.t4594 sky130_fd_pr__cap_mim_m3_1 l=3 w=3
X3600 EDGE_BIAS.t159 EDGE_BIAS.t160 sky130_fd_pr__cap_mim_m3_1 l=3 w=3
X3601 B6.t1 TOP.t5244 sky130_fd_pr__cap_mim_m3_1 l=3 w=3
X3602 B11.t867 TOP.t3384 sky130_fd_pr__cap_mim_m3_1 l=3 w=3
X3603 B8.t191 TOP.t7424 sky130_fd_pr__cap_mim_m3_1 l=3 w=3
X3604 B8.t64 TOP.t7678 sky130_fd_pr__cap_mim_m3_1 l=3 w=3
X3605 B11.t1779 TOP.t1560 sky130_fd_pr__cap_mim_m3_1 l=3 w=3
X3606 B11.t2021 TOP.t1076 sky130_fd_pr__cap_mim_m3_1 l=3 w=3
X3607 B11.t1301 TOP.t2516 sky130_fd_pr__cap_mim_m3_1 l=3 w=3
X3608 B8.t153 TOP.t7500 sky130_fd_pr__cap_mim_m3_1 l=3 w=3
X3609 B11.t687 TOP.t3744 sky130_fd_pr__cap_mim_m3_1 l=3 w=3
X3610 B11.t1107 TOP.t2904 sky130_fd_pr__cap_mim_m3_1 l=3 w=3
X3611 B9.t397 TOP.t228 sky130_fd_pr__cap_mim_m3_1 l=3 w=3
X3612 B11.t110 TOP.t4898 sky130_fd_pr__cap_mim_m3_1 l=3 w=3
X3613 B10.t290 TOP.t6714 sky130_fd_pr__cap_mim_m3_1 l=3 w=3
X3614 EDGE_BIAS.t243 EDGE_BIAS.t244 sky130_fd_pr__cap_mim_m3_1 l=3 w=3
X3615 B11.t429 TOP.t4260 sky130_fd_pr__cap_mim_m3_1 l=3 w=3
X3616 B11.t1263 TOP.t2592 sky130_fd_pr__cap_mim_m3_1 l=3 w=3
X3617 B7.t114 TOP.t7834 sky130_fd_pr__cap_mim_m3_1 l=3 w=3
X3618 B7.t45 TOP.t7972 sky130_fd_pr__cap_mim_m3_1 l=3 w=3
X3619 B11.t408 TOP.t4302 sky130_fd_pr__cap_mim_m3_1 l=3 w=3
X3620 B11.t1069 TOP.t2980 sky130_fd_pr__cap_mim_m3_1 l=3 w=3
X3621 B9.t359 TOP.t304 sky130_fd_pr__cap_mim_m3_1 l=3 w=3
X3622 B7.t76 TOP.t7910 sky130_fd_pr__cap_mim_m3_1 l=3 w=3
X3623 B9.t65 TOP.t892 sky130_fd_pr__cap_mim_m3_1 l=3 w=3
X3624 B9.t321 TOP.t380 sky130_fd_pr__cap_mim_m3_1 l=3 w=3
X3625 B6.t25 TOP.t5196 sky130_fd_pr__cap_mim_m3_1 l=3 w=3
X3626 B10.t214 TOP.t6866 sky130_fd_pr__cap_mim_m3_1 l=3 w=3
X3627 B10.t1007 TOP.t5280 sky130_fd_pr__cap_mim_m3_1 l=3 w=3
X3628 B10.t456 TOP.t6382 sky130_fd_pr__cap_mim_m3_1 l=3 w=3
X3629 B10.t176 TOP.t6942 sky130_fd_pr__cap_mim_m3_1 l=3 w=3
X3630 B11.t2045 TOP.t1028 sky130_fd_pr__cap_mim_m3_1 l=3 w=3
X3631 B11.t1686 TOP.t1746 sky130_fd_pr__cap_mim_m3_1 l=3 w=3
X3632 B9.t283 TOP.t456 sky130_fd_pr__cap_mim_m3_1 l=3 w=3
X3633 B11.t124 TOP.t4870 sky130_fd_pr__cap_mim_m3_1 l=3 w=3
X3634 B11.t982 TOP.t3154 sky130_fd_pr__cap_mim_m3_1 l=3 w=3
X3635 B11.t1492 TOP.t2134 sky130_fd_pr__cap_mim_m3_1 l=3 w=3
X3636 B10.t418 TOP.t6458 sky130_fd_pr__cap_mim_m3_1 l=3 w=3
X3637 B11.t1928 TOP.t1262 sky130_fd_pr__cap_mim_m3_1 l=3 w=3
X3638 B11.t1212 TOP.t2694 sky130_fd_pr__cap_mim_m3_1 l=3 w=3
X3639 B10.t259 TOP.t6776 sky130_fd_pr__cap_mim_m3_1 l=3 w=3
X3640 EDGE_BIAS.t744 EDGE_BIAS.t745 sky130_fd_pr__cap_mim_m3_1 l=3 w=3
X3641 B11.t1890 TOP.t1338 sky130_fd_pr__cap_mim_m3_1 l=3 w=3
X3642 B11.t1454 TOP.t2210 sky130_fd_pr__cap_mim_m3_1 l=3 w=3
X3643 B11.t1287 TOP.t2544 sky130_fd_pr__cap_mim_m3_1 l=3 w=3
X3644 B10.t710 TOP.t5874 sky130_fd_pr__cap_mim_m3_1 l=3 w=3
X3645 B9.t91 TOP.t840 sky130_fd_pr__cap_mim_m3_1 l=3 w=3
X3646 EDGE_BIAS.t297 EDGE_BIAS.t298 sky130_fd_pr__cap_mim_m3_1 l=3 w=3
X3647 B10.t516 TOP.t6262 sky130_fd_pr__cap_mim_m3_1 l=3 w=3
X3648 B8.t79 TOP.t7648 sky130_fd_pr__cap_mim_m3_1 l=3 w=3
X3649 B11.t1658 TOP.t1802 sky130_fd_pr__cap_mim_m3_1 l=3 w=3
X3650 B10.t672 TOP.t5950 sky130_fd_pr__cap_mim_m3_1 l=3 w=3
X3651 B9.t474 TOP.t74 sky130_fd_pr__cap_mim_m3_1 l=3 w=3
X3652 B11.t1620 TOP.t1878 sky130_fd_pr__cap_mim_m3_1 l=3 w=3
X3653 B10.t914 TOP.t5466 sky130_fd_pr__cap_mim_m3_1 l=3 w=3
X3654 B8.t41 TOP.t7724 sky130_fd_pr__cap_mim_m3_1 l=3 w=3
X3655 B11.t312 TOP.t4494 sky130_fd_pr__cap_mim_m3_1 l=3 w=3
X3656 B11.t1006 TOP.t3106 sky130_fd_pr__cap_mim_m3_1 l=3 w=3
X3657 B8.t3 TOP.t7800 sky130_fd_pr__cap_mim_m3_1 l=3 w=3
X3658 B10.t442 TOP.t6410 sky130_fd_pr__cap_mim_m3_1 l=3 w=3
X3659 B11.t647 TOP.t3824 sky130_fd_pr__cap_mim_m3_1 l=3 w=3
X3660 B11.t1582 TOP.t1954 sky130_fd_pr__cap_mim_m3_1 l=3 w=3
X3661 B9.t436 TOP.t150 sky130_fd_pr__cap_mim_m3_1 l=3 w=3
X3662 B11.t889 TOP.t3340 sky130_fd_pr__cap_mim_m3_1 l=3 w=3
X3663 B9.t219 TOP.t584 sky130_fd_pr__cap_mim_m3_1 l=3 w=3
X3664 B11.t609 TOP.t3900 sky130_fd_pr__cap_mim_m3_1 l=3 w=3
X3665 B11.t1801 TOP.t1516 sky130_fd_pr__cap_mim_m3_1 l=3 w=3
X3666 B11.t1478 TOP.t2162 sky130_fd_pr__cap_mim_m3_1 l=3 w=3
X3667 B5.t1 TOP.t8126 sky130_fd_pr__cap_mim_m3_1 l=3 w=3
X3668 B11.t235 TOP.t4648 sky130_fd_pr__cap_mim_m3_1 l=3 w=3
X3669 B11.t851 TOP.t3416 sky130_fd_pr__cap_mim_m3_1 l=3 w=3
X3670 B11.t1763 TOP.t1592 sky130_fd_pr__cap_mim_m3_1 l=3 w=3
X3671 B11.t1361 TOP.t2396 sky130_fd_pr__cap_mim_m3_1 l=3 w=3
X3672 B9.t181 TOP.t660 sky130_fd_pr__cap_mim_m3_1 l=3 w=3
X3673 B11.t692 TOP.t3734 sky130_fd_pr__cap_mim_m3_1 l=3 w=3
X3674 B11.t143 TOP.t4832 sky130_fd_pr__cap_mim_m3_1 l=3 w=3
X3675 B11.t2005 TOP.t1108 sky130_fd_pr__cap_mim_m3_1 l=3 w=3
X3676 B11.t1323 TOP.t2472 sky130_fd_pr__cap_mim_m3_1 l=3 w=3
X3677 B10.t863 TOP.t5568 sky130_fd_pr__cap_mim_m3_1 l=3 w=3
X3678 B10.t696 TOP.t5902 sky130_fd_pr__cap_mim_m3_1 l=3 w=3
X3679 B11.t441 TOP.t4236 sky130_fd_pr__cap_mim_m3_1 l=3 w=3
X3680 B11.t1725 TOP.t1668 sky130_fd_pr__cap_mim_m3_1 l=3 w=3
X3681 B11.t1129 TOP.t2860 sky130_fd_pr__cap_mim_m3_1 l=3 w=3
X3682 B8.t137 TOP.t7532 sky130_fd_pr__cap_mim_m3_1 l=3 w=3
X3683 EDGE_BIAS.t351 EDGE_BIAS.t352 sky130_fd_pr__cap_mim_m3_1 l=3 w=3
X3684 B10.t274 TOP.t6746 sky130_fd_pr__cap_mim_m3_1 l=3 w=3
X3685 B11.t1967 TOP.t1184 sky130_fd_pr__cap_mim_m3_1 l=3 w=3
X3686 B11.t1606 TOP.t1906 sky130_fd_pr__cap_mim_m3_1 l=3 w=3
X3687 B11.t1247 TOP.t2624 sky130_fd_pr__cap_mim_m3_1 l=3 w=3
X3688 B11.t1091 TOP.t2936 sky130_fd_pr__cap_mim_m3_1 l=3 w=3
X3689 B11.t1053 TOP.t3012 sky130_fd_pr__cap_mim_m3_1 l=3 w=3
X3690 B7.t98 TOP.t7866 sky130_fd_pr__cap_mim_m3_1 l=3 w=3
X3691 B7.t29 TOP.t8004 sky130_fd_pr__cap_mim_m3_1 l=3 w=3
X3692 B11.t171 TOP.t4776 sky130_fd_pr__cap_mim_m3_1 l=3 w=3
X3693 B9.t343 TOP.t336 sky130_fd_pr__cap_mim_m3_1 l=3 w=3
X3694 B11.t875 TOP.t3368 sky130_fd_pr__cap_mim_m3_1 l=3 w=3
X3695 B10.t236 TOP.t6822 sky130_fd_pr__cap_mim_m3_1 l=3 w=3
X3696 B10.t198 TOP.t6898 sky130_fd_pr__cap_mim_m3_1 l=3 w=3
X3697 B10.t991 TOP.t5312 sky130_fd_pr__cap_mim_m3_1 l=3 w=3
X3698 B8.t118 TOP.t7570 sky130_fd_pr__cap_mim_m3_1 l=3 w=3
X3699 B11.t352 TOP.t4414 sky130_fd_pr__cap_mim_m3_1 l=3 w=3
X3700 B10.t887 TOP.t5520 sky130_fd_pr__cap_mim_m3_1 l=3 w=3
X3701 B9.t305 TOP.t412 sky130_fd_pr__cap_mim_m3_1 l=3 w=3
X3702 B11.t36 TOP.t5046 sky130_fd_pr__cap_mim_m3_1 l=3 w=3
X3703 EDGE_BIAS.t594 EDGE_BIAS.t595 sky130_fd_pr__cap_mim_m3_1 l=3 w=3
X3704 B10.t160 TOP.t6974 sky130_fd_pr__cap_mim_m3_1 l=3 w=3
X3705 B11.t1670 TOP.t1778 sky130_fd_pr__cap_mim_m3_1 l=3 w=3
X3706 B10.t1019 TOP.t5256 sky130_fd_pr__cap_mim_m3_1 l=3 w=3
X3707 B10.t770 TOP.t5754 sky130_fd_pr__cap_mim_m3_1 l=3 w=3
X3708 B10.t402 TOP.t6490 sky130_fd_pr__cap_mim_m3_1 l=3 w=3
X3709 B11.t1196 TOP.t2726 sky130_fd_pr__cap_mim_m3_1 l=3 w=3
X3710 B10.t122 TOP.t7050 sky130_fd_pr__cap_mim_m3_1 l=3 w=3
X3711 B7.t122 TOP.t7818 sky130_fd_pr__cap_mim_m3_1 l=3 w=3
X3712 B10.t364 TOP.t6566 sky130_fd_pr__cap_mim_m3_1 l=3 w=3
X3713 B11.t1874 TOP.t1370 sky130_fd_pr__cap_mim_m3_1 l=3 w=3
X3714 B11.t1438 TOP.t2242 sky130_fd_pr__cap_mim_m3_1 l=3 w=3
X3715 B10.t732 TOP.t5830 sky130_fd_pr__cap_mim_m3_1 l=3 w=3
X3716 B10.t538 TOP.t6218 sky130_fd_pr__cap_mim_m3_1 l=3 w=3
X3717 B9.t75 TOP.t872 sky130_fd_pr__cap_mim_m3_1 l=3 w=3
X3718 B11.t1400 TOP.t2318 sky130_fd_pr__cap_mim_m3_1 l=3 w=3
X3719 EDGE_BIAS.t405 EDGE_BIAS.t406 sky130_fd_pr__cap_mim_m3_1 l=3 w=3
X3720 B10.t1015 TOP.t5264 sky130_fd_pr__cap_mim_m3_1 l=3 w=3
X3721 B11.t87 TOP.t4944 sky130_fd_pr__cap_mim_m3_1 l=3 w=3
X3722 B11.t1642 TOP.t1834 sky130_fd_pr__cap_mim_m3_1 l=3 w=3
X3723 B10.t656 TOP.t5982 sky130_fd_pr__cap_mim_m3_1 l=3 w=3
X3724 B9.t496 TOP.t30 sky130_fd_pr__cap_mim_m3_1 l=3 w=3
X3725 B9.t458 TOP.t106 sky130_fd_pr__cap_mim_m3_1 l=3 w=3
X3726 B11.t406 TOP.t4306 sky130_fd_pr__cap_mim_m3_1 l=3 w=3
X3727 B10.t898 TOP.t5498 sky130_fd_pr__cap_mim_m3_1 l=3 w=3
X3728 B8.t25 TOP.t7756 sky130_fd_pr__cap_mim_m3_1 l=3 w=3
X3729 B11.t631 TOP.t3856 sky130_fd_pr__cap_mim_m3_1 l=3 w=3
X3730 B11.t669 TOP.t3780 sky130_fd_pr__cap_mim_m3_1 l=3 w=3
X3731 B10.t618 TOP.t6058 sky130_fd_pr__cap_mim_m3_1 l=3 w=3
X3732 B6.t46 TOP.t5154 sky130_fd_pr__cap_mim_m3_1 l=3 w=3
X3733 B11.t268 TOP.t4582 sky130_fd_pr__cap_mim_m3_1 l=3 w=3
X3734 B9.t420 TOP.t182 sky130_fd_pr__cap_mim_m3_1 l=3 w=3
X3735 B10.t313 TOP.t6668 sky130_fd_pr__cap_mim_m3_1 l=3 w=3
X3736 B9.t241 TOP.t540 sky130_fd_pr__cap_mim_m3_1 l=3 w=3
X3737 B9.t47 TOP.t928 sky130_fd_pr__cap_mim_m3_1 l=3 w=3
X3738 B11.t593 TOP.t3932 sky130_fd_pr__cap_mim_m3_1 l=3 w=3
X3739 B11.t1034 TOP.t3050 sky130_fd_pr__cap_mim_m3_1 l=3 w=3
X3740 B6.t7 TOP.t5232 sky130_fd_pr__cap_mim_m3_1 l=3 w=3
X3741 B11.t835 TOP.t3448 sky130_fd_pr__cap_mim_m3_1 l=3 w=3
X3742 B10.t29 TOP.t7236 sky130_fd_pr__cap_mim_m3_1 l=3 w=3
X3743 B8.t197 TOP.t7412 sky130_fd_pr__cap_mim_m3_1 l=3 w=3
X3744 B11.t296 TOP.t4526 sky130_fd_pr__cap_mim_m3_1 l=3 w=3
X3745 B11.t555 TOP.t4008 sky130_fd_pr__cap_mim_m3_1 l=3 w=3
X3746 B10.t847 TOP.t5600 sky130_fd_pr__cap_mim_m3_1 l=3 w=3
X3747 B11.t797 TOP.t3524 sky130_fd_pr__cap_mim_m3_1 l=3 w=3
X3748 B11.t1989 TOP.t1140 sky130_fd_pr__cap_mim_m3_1 l=3 w=3
X3749 B11.t1666 TOP.t1786 sky130_fd_pr__cap_mim_m3_1 l=3 w=3
X3750 B11.t1307 TOP.t2504 sky130_fd_pr__cap_mim_m3_1 l=3 w=3
X3751 B8.t159 TOP.t7488 sky130_fd_pr__cap_mim_m3_1 l=3 w=3
X3752 B11.t1113 TOP.t2892 sky130_fd_pr__cap_mim_m3_1 l=3 w=3
X3753 B11.t1951 TOP.t1216 sky130_fd_pr__cap_mim_m3_1 l=3 w=3
X3754 B10.t809 TOP.t5676 sky130_fd_pr__cap_mim_m3_1 l=3 w=3
X3755 EDGE_BIAS.t582 EDGE_BIAS.t583 sky130_fd_pr__cap_mim_m3_1 l=3 w=3
X3756 EDGE_BIAS.t459 EDGE_BIAS.t460 sky130_fd_pr__cap_mim_m3_1 l=3 w=3
X3757 B11.t1269 TOP.t2580 sky130_fd_pr__cap_mim_m3_1 l=3 w=3
X3758 B9.t444 TOP.t134 sky130_fd_pr__cap_mim_m3_1 l=3 w=3
X3759 B7.t82 TOP.t7898 sky130_fd_pr__cap_mim_m3_1 l=3 w=3
X3760 B7.t51 TOP.t7960 sky130_fd_pr__cap_mim_m3_1 l=3 w=3
X3761 B11.t1231 TOP.t2656 sky130_fd_pr__cap_mim_m3_1 l=3 w=3
X3762 B11.t1075 TOP.t2968 sky130_fd_pr__cap_mim_m3_1 l=3 w=3
X3763 B7.t13 TOP.t8036 sky130_fd_pr__cap_mim_m3_1 l=3 w=3
X3764 B11.t1913 TOP.t1292 sky130_fd_pr__cap_mim_m3_1 l=3 w=3
X3765 B9.t327 TOP.t368 sky130_fd_pr__cap_mim_m3_1 l=3 w=3
X3766 B10.t220 TOP.t6854 sky130_fd_pr__cap_mim_m3_1 l=3 w=3
X3767 B10.t462 TOP.t6370 sky130_fd_pr__cap_mim_m3_1 l=3 w=3
X3768 B8.t102 TOP.t7602 sky130_fd_pr__cap_mim_m3_1 l=3 w=3
X3769 B10.t182 TOP.t6930 sky130_fd_pr__cap_mim_m3_1 l=3 w=3
X3770 B9.t289 TOP.t444 sky130_fd_pr__cap_mim_m3_1 l=3 w=3
X3771 B11.t988 TOP.t3142 sky130_fd_pr__cap_mim_m3_1 l=3 w=3
X3772 B11.t1025 TOP.t3068 sky130_fd_pr__cap_mim_m3_1 l=3 w=3
X3773 B10.t424 TOP.t6446 sky130_fd_pr__cap_mim_m3_1 l=3 w=3
X3774 B11.t212 TOP.t4694 sky130_fd_pr__cap_mim_m3_1 l=3 w=3
X3775 B4.t13 TOP.t8156 sky130_fd_pr__cap_mim_m3_1 l=3 w=3
X3776 B11.t1422 TOP.t2274 sky130_fd_pr__cap_mim_m3_1 l=3 w=3
X3777 B11.t1099 TOP.t2920 sky130_fd_pr__cap_mim_m3_1 l=3 w=3
X3778 EDGE_BIAS.t213 EDGE_BIAS.t214 sky130_fd_pr__cap_mim_m3_1 l=3 w=3
X3779 B10.t716 TOP.t5862 sky130_fd_pr__cap_mim_m3_1 l=3 w=3
X3780 B9.t97 TOP.t828 sky130_fd_pr__cap_mim_m3_1 l=3 w=3
X3781 B10.t522 TOP.t6250 sky130_fd_pr__cap_mim_m3_1 l=3 w=3
X3782 B11.t1384 TOP.t2350 sky130_fd_pr__cap_mim_m3_1 l=3 w=3
X3783 B8.t236 TOP.t7334 sky130_fd_pr__cap_mim_m3_1 l=3 w=3
X3784 EDGE_BIAS.t642 EDGE_BIAS.t643 sky130_fd_pr__cap_mim_m3_1 l=3 w=3
X3785 B10.t678 TOP.t5938 sky130_fd_pr__cap_mim_m3_1 l=3 w=3
X3786 B10.t640 TOP.t6014 sky130_fd_pr__cap_mim_m3_1 l=3 w=3
X3787 B9.t480 TOP.t62 sky130_fd_pr__cap_mim_m3_1 l=3 w=3
X3788 B9.t313 TOP.t396 sky130_fd_pr__cap_mim_m3_1 l=3 w=3
X3789 B8.t126 TOP.t7554 sky130_fd_pr__cap_mim_m3_1 l=3 w=3
X3790 B11.t1626 TOP.t1866 sky130_fd_pr__cap_mim_m3_1 l=3 w=3
X3791 B11.t53 TOP.t5012 sky130_fd_pr__cap_mim_m3_1 l=3 w=3
X3792 B11.t653 TOP.t3812 sky130_fd_pr__cap_mim_m3_1 l=3 w=3
X3793 B11.t1346 TOP.t2426 sky130_fd_pr__cap_mim_m3_1 l=3 w=3
X3794 B8.t9 TOP.t7788 sky130_fd_pr__cap_mim_m3_1 l=3 w=3
X3795 B11.t1588 TOP.t1942 sky130_fd_pr__cap_mim_m3_1 l=3 w=3
X3796 B10.t602 TOP.t6090 sky130_fd_pr__cap_mim_m3_1 l=3 w=3
X3797 B11.t895 TOP.t3328 sky130_fd_pr__cap_mim_m3_1 l=3 w=3
X3798 EDGE_BIAS.t384 EDGE_BIAS.t385 sky130_fd_pr__cap_mim_m3_1 l=3 w=3
X3799 B9.t225 TOP.t572 sky130_fd_pr__cap_mim_m3_1 l=3 w=3
X3800 B11.t615 TOP.t3888 sky130_fd_pr__cap_mim_m3_1 l=3 w=3
X3801 B10.t297 TOP.t6700 sky130_fd_pr__cap_mim_m3_1 l=3 w=3
X3802 B11.t1807 TOP.t1504 sky130_fd_pr__cap_mim_m3_1 l=3 w=3
X3803 B9.t31 TOP.t960 sky130_fd_pr__cap_mim_m3_1 l=3 w=3
X3804 EDGE_BIAS.t189 EDGE_BIAS.t190 sky130_fd_pr__cap_mim_m3_1 l=3 w=3
X3805 B5.t7 TOP.t8114 sky130_fd_pr__cap_mim_m3_1 l=3 w=3
X3806 B11.t857 TOP.t3404 sky130_fd_pr__cap_mim_m3_1 l=3 w=3
X3807 B11.t1769 TOP.t1580 sky130_fd_pr__cap_mim_m3_1 l=3 w=3
X3808 B11.t447 TOP.t4224 sky130_fd_pr__cap_mim_m3_1 l=3 w=3
X3809 B10.t501 TOP.t6292 sky130_fd_pr__cap_mim_m3_1 l=3 w=3
X3810 B11.t2011 TOP.t1096 sky130_fd_pr__cap_mim_m3_1 l=3 w=3
X3811 B10.t831 TOP.t5632 sky130_fd_pr__cap_mim_m3_1 l=3 w=3
X3812 B9.t504 TOP.t14 sky130_fd_pr__cap_mim_m3_1 l=3 w=3
X3813 EDGE_BIAS.t267 EDGE_BIAS.t268 sky130_fd_pr__cap_mim_m3_1 l=3 w=3
X3814 B8.t143 TOP.t7520 sky130_fd_pr__cap_mim_m3_1 l=3 w=3
X3815 B11.t177 TOP.t4764 sky130_fd_pr__cap_mim_m3_1 l=3 w=3
X3816 B11.t156 TOP.t4806 sky130_fd_pr__cap_mim_m3_1 l=3 w=3
X3817 B11.t1973 TOP.t1172 sky130_fd_pr__cap_mim_m3_1 l=3 w=3
X3818 B11.t1935 TOP.t1248 sky130_fd_pr__cap_mim_m3_1 l=3 w=3
X3819 B10.t793 TOP.t5708 sky130_fd_pr__cap_mim_m3_1 l=3 w=3
X3820 B11.t475 TOP.t4168 sky130_fd_pr__cap_mim_m3_1 l=3 w=3
X3821 B10.t321 TOP.t6652 sky130_fd_pr__cap_mim_m3_1 l=3 w=3
X3822 B11.t1253 TOP.t2612 sky130_fd_pr__cap_mim_m3_1 l=3 w=3
X3823 B11.t1059 TOP.t3000 sky130_fd_pr__cap_mim_m3_1 l=3 w=3
X3824 B7.t104 TOP.t7854 sky130_fd_pr__cap_mim_m3_1 l=3 w=3
X3825 B7.t66 TOP.t7930 sky130_fd_pr__cap_mim_m3_1 l=3 w=3
X3826 B7.t35 TOP.t7992 sky130_fd_pr__cap_mim_m3_1 l=3 w=3
X3827 B9.t249 TOP.t524 sky130_fd_pr__cap_mim_m3_1 l=3 w=3
X3828 B10.t204 TOP.t6886 sky130_fd_pr__cap_mim_m3_1 l=3 w=3
X3829 B11.t1897 TOP.t1324 sky130_fd_pr__cap_mim_m3_1 l=3 w=3
X3830 B10.t755 TOP.t5784 sky130_fd_pr__cap_mim_m3_1 l=3 w=3
X3831 B11.t337 TOP.t4444 sky130_fd_pr__cap_mim_m3_1 l=3 w=3
X3832 B11.t1793 TOP.t1532 sky130_fd_pr__cap_mim_m3_1 l=3 w=3
X3833 B10.t997 TOP.t5300 sky130_fd_pr__cap_mim_m3_1 l=3 w=3
X3834 B9.t273 TOP.t476 sky130_fd_pr__cap_mim_m3_1 l=3 w=3
X3835 EDGE_BIAS.t438 EDGE_BIAS.t439 sky130_fd_pr__cap_mim_m3_1 l=3 w=3
X3836 B10.t166 TOP.t6962 sky130_fd_pr__cap_mim_m3_1 l=3 w=3
X3837 B11.t1676 TOP.t1766 sky130_fd_pr__cap_mim_m3_1 l=3 w=3
X3838 B11.t972 TOP.t3174 sky130_fd_pr__cap_mim_m3_1 l=3 w=3
X3839 B11.t1482 TOP.t2154 sky130_fd_pr__cap_mim_m3_1 l=3 w=3
X3840 B11.t1159 TOP.t2800 sky130_fd_pr__cap_mim_m3_1 l=3 w=3
X3841 B10.t408 TOP.t6478 sky130_fd_pr__cap_mim_m3_1 l=3 w=3
X3842 B11.t1202 TOP.t2714 sky130_fd_pr__cap_mim_m3_1 l=3 w=3
X3843 B11.t365 TOP.t4388 sky130_fd_pr__cap_mim_m3_1 l=3 w=3
X3844 B5.t21 TOP.t8086 sky130_fd_pr__cap_mim_m3_1 l=3 w=3
X3845 B11.t934 TOP.t3250 sky130_fd_pr__cap_mim_m3_1 l=3 w=3
X3846 B10.t370 TOP.t6554 sky130_fd_pr__cap_mim_m3_1 l=3 w=3
X3847 B11.t1444 TOP.t2230 sky130_fd_pr__cap_mim_m3_1 l=3 w=3
X3848 B7.t59 TOP.t7944 sky130_fd_pr__cap_mim_m3_1 l=3 w=3
X3849 EDGE_BIAS.t321 EDGE_BIAS.t322 sky130_fd_pr__cap_mim_m3_1 l=3 w=3
X3850 B9.t81 TOP.t860 sky130_fd_pr__cap_mim_m3_1 l=3 w=3
X3851 B11.t1921 TOP.t1276 sky130_fd_pr__cap_mim_m3_1 l=3 w=3
X3852 B11.t1406 TOP.t2306 sky130_fd_pr__cap_mim_m3_1 l=3 w=3
X3853 B11.t391 TOP.t4336 sky130_fd_pr__cap_mim_m3_1 l=3 w=3
X3854 B11.t1368 TOP.t2382 sky130_fd_pr__cap_mim_m3_1 l=3 w=3
X3855 B8.t220 TOP.t7366 sky130_fd_pr__cap_mim_m3_1 l=3 w=3
X3856 B11.t1648 TOP.t1822 sky130_fd_pr__cap_mim_m3_1 l=3 w=3
X3857 B11.t1610 TOP.t1898 sky130_fd_pr__cap_mim_m3_1 l=3 w=3
X3858 B10.t662 TOP.t5970 sky130_fd_pr__cap_mim_m3_1 l=3 w=3
X3859 B9.t464 TOP.t94 sky130_fd_pr__cap_mim_m3_1 l=3 w=3
X3860 B10.t190 TOP.t6914 sky130_fd_pr__cap_mim_m3_1 l=3 w=3
X3861 B10.t904 TOP.t5486 sky130_fd_pr__cap_mim_m3_1 l=3 w=3
X3862 B11.t637 TOP.t3844 sky130_fd_pr__cap_mim_m3_1 l=3 w=3
X3863 B11.t1330 TOP.t2458 sky130_fd_pr__cap_mim_m3_1 l=3 w=3
X3864 B10.t624 TOP.t6046 sky130_fd_pr__cap_mim_m3_1 l=3 w=3
X3865 B8.t182 TOP.t7442 sky130_fd_pr__cap_mim_m3_1 l=3 w=3
X3866 B11.t1572 TOP.t1974 sky130_fd_pr__cap_mim_m3_1 l=3 w=3
X3867 B11.t1226 TOP.t2666 sky130_fd_pr__cap_mim_m3_1 l=3 w=3
X3868 B9.t426 TOP.t170 sky130_fd_pr__cap_mim_m3_1 l=3 w=3
X3869 B11.t497 TOP.t4124 sky130_fd_pr__cap_mim_m3_1 l=3 w=3
X3870 EDGE_BIAS.t492 EDGE_BIAS.t493 sky130_fd_pr__cap_mim_m3_1 l=3 w=3
X3871 B9.t209 TOP.t604 sky130_fd_pr__cap_mim_m3_1 l=3 w=3
X3872 B9.t53 TOP.t916 sky130_fd_pr__cap_mim_m3_1 l=3 w=3
X3873 B11.t32 TOP.t5054 sky130_fd_pr__cap_mim_m3_1 l=3 w=3
X3874 B11.t599 TOP.t3920 sky130_fd_pr__cap_mim_m3_1 l=3 w=3
X3875 B9.t15 TOP.t992 sky130_fd_pr__cap_mim_m3_1 l=3 w=3
X3876 B11.t841 TOP.t3436 sky130_fd_pr__cap_mim_m3_1 l=3 w=3
X3877 B10.t568 TOP.t6158 sky130_fd_pr__cap_mim_m3_1 l=3 w=3
X3878 B3.t3 TOP.t8138 sky130_fd_pr__cap_mim_m3_1 l=3 w=3
X3879 B11.t1753 TOP.t1612 sky130_fd_pr__cap_mim_m3_1 l=3 w=3
X3880 B9.t171 TOP.t680 sky130_fd_pr__cap_mim_m3_1 l=3 w=3
X3881 B10.t853 TOP.t5588 sky130_fd_pr__cap_mim_m3_1 l=3 w=3
X3882 B10.t485 TOP.t6324 sky130_fd_pr__cap_mim_m3_1 l=3 w=3
X3883 B11.t189 TOP.t4740 sky130_fd_pr__cap_mim_m3_1 l=3 w=3
X3884 B11.t803 TOP.t3512 sky130_fd_pr__cap_mim_m3_1 l=3 w=3
X3885 B11.t1995 TOP.t1128 sky130_fd_pr__cap_mim_m3_1 l=3 w=3
X3886 B11.t1715 TOP.t1688 sky130_fd_pr__cap_mim_m3_1 l=3 w=3
X3887 B11.t1119 TOP.t2880 sky130_fd_pr__cap_mim_m3_1 l=3 w=3
X3888 EDGE_BIAS.t375 EDGE_BIAS.t376 sky130_fd_pr__cap_mim_m3_1 l=3 w=3
X3889 B11.t1957 TOP.t1204 sky130_fd_pr__cap_mim_m3_1 l=3 w=3
X3890 B11.t1354 TOP.t2410 sky130_fd_pr__cap_mim_m3_1 l=3 w=3
X3891 B10.t815 TOP.t5664 sky130_fd_pr__cap_mim_m3_1 l=3 w=3
X3892 B10.t777 TOP.t5740 sky130_fd_pr__cap_mim_m3_1 l=3 w=3
X3893 B7.t88 TOP.t7886 sky130_fd_pr__cap_mim_m3_1 l=3 w=3
X3894 EDGE_BIAS.t711 EDGE_BIAS.t712 sky130_fd_pr__cap_mim_m3_1 l=3 w=3
X3895 B11.t1237 TOP.t2644 sky130_fd_pr__cap_mim_m3_1 l=3 w=3
X3896 B11.t1081 TOP.t2956 sky130_fd_pr__cap_mim_m3_1 l=3 w=3
X3897 B11.t1043 TOP.t3032 sky130_fd_pr__cap_mim_m3_1 l=3 w=3
X3898 B7.t19 TOP.t8024 sky130_fd_pr__cap_mim_m3_1 l=3 w=3
X3899 B11.t623 TOP.t3872 sky130_fd_pr__cap_mim_m3_1 l=3 w=3
X3900 B9.t333 TOP.t356 sky130_fd_pr__cap_mim_m3_1 l=3 w=3
X3901 B9.t120 TOP.t782 sky130_fd_pr__cap_mim_m3_1 l=3 w=3
X3902 B10.t739 TOP.t5816 sky130_fd_pr__cap_mim_m3_1 l=3 w=3
X3903 B10.t981 TOP.t5332 sky130_fd_pr__cap_mim_m3_1 l=3 w=3
X3904 B8.t108 TOP.t7590 sky130_fd_pr__cap_mim_m3_1 l=3 w=3
X3905 B9.t295 TOP.t432 sky130_fd_pr__cap_mim_m3_1 l=3 w=3
X3906 B11.t994 TOP.t3130 sky130_fd_pr__cap_mim_m3_1 l=3 w=3
X3907 B10.t150 TOP.t6994 sky130_fd_pr__cap_mim_m3_1 l=3 w=3
X3908 B11.t956 TOP.t3206 sky130_fd_pr__cap_mim_m3_1 l=3 w=3
X3909 B10.t392 TOP.t6510 sky130_fd_pr__cap_mim_m3_1 l=3 w=3
X3910 B10.t943 TOP.t5408 sky130_fd_pr__cap_mim_m3_1 l=3 w=3
X3911 B11.t1981 TOP.t1156 sky130_fd_pr__cap_mim_m3_1 l=3 w=3
X3912 B11.t1186 TOP.t2746 sky130_fd_pr__cap_mim_m3_1 l=3 w=3
X3913 B11.t918 TOP.t3282 sky130_fd_pr__cap_mim_m3_1 l=3 w=3
X3914 B10.t112 TOP.t7070 sky130_fd_pr__cap_mim_m3_1 l=3 w=3
X3915 B11.t1428 TOP.t2262 sky130_fd_pr__cap_mim_m3_1 l=3 w=3
X3916 B10.t354 TOP.t6586 sky130_fd_pr__cap_mim_m3_1 l=3 w=3
X3917 EDGE_BIAS.t429 EDGE_BIAS.t430 sky130_fd_pr__cap_mim_m3_1 l=3 w=3
X3918 B10.t763 TOP.t5768 sky130_fd_pr__cap_mim_m3_1 l=3 w=3
X3919 B10.t528 TOP.t6238 sky130_fd_pr__cap_mim_m3_1 l=3 w=3
X3920 B11.t1390 TOP.t2338 sky130_fd_pr__cap_mim_m3_1 l=3 w=3
X3921 B8.t242 TOP.t7322 sky130_fd_pr__cap_mim_m3_1 l=3 w=3
X3922 B11.t154 TOP.t4810 sky130_fd_pr__cap_mim_m3_1 l=3 w=3
X3923 B10.t646 TOP.t6002 sky130_fd_pr__cap_mim_m3_1 l=3 w=3
X3924 B9.t486 TOP.t50 sky130_fd_pr__cap_mim_m3_1 l=3 w=3
X3925 B8.t204 TOP.t7398 sky130_fd_pr__cap_mim_m3_1 l=3 w=3
X3926 B11.t1632 TOP.t1854 sky130_fd_pr__cap_mim_m3_1 l=3 w=3
X3927 B9.t448 TOP.t126 sky130_fd_pr__cap_mim_m3_1 l=3 w=3
X3928 B8.t166 TOP.t7474 sky130_fd_pr__cap_mim_m3_1 l=3 w=3
X3929 B8.t15 TOP.t7776 sky130_fd_pr__cap_mim_m3_1 l=3 w=3
X3930 B11.t1594 TOP.t1930 sky130_fd_pr__cap_mim_m3_1 l=3 w=3
X3931 B11.t1158 TOP.t2802 sky130_fd_pr__cap_mim_m3_1 l=3 w=3
X3932 EDGE_BIAS.t300 EDGE_BIAS.t301 sky130_fd_pr__cap_mim_m3_1 l=3 w=3
X3933 B10.t608 TOP.t6078 sky130_fd_pr__cap_mim_m3_1 l=3 w=3
X3934 B9.t1 TOP.t1020 sky130_fd_pr__cap_mim_m3_1 l=3 w=3
X3935 B11.t1556 TOP.t2006 sky130_fd_pr__cap_mim_m3_1 l=3 w=3
X3936 B9.t410 TOP.t202 sky130_fd_pr__cap_mim_m3_1 l=3 w=3
X3937 B9.t231 TOP.t560 sky130_fd_pr__cap_mim_m3_1 l=3 w=3
X3938 B10.t303 TOP.t6688 sky130_fd_pr__cap_mim_m3_1 l=3 w=3
X3939 B9.t37 TOP.t948 sky130_fd_pr__cap_mim_m3_1 l=3 w=3
X3940 B11.t583 TOP.t3952 sky130_fd_pr__cap_mim_m3_1 l=3 w=3
X3941 B11.t825 TOP.t3468 sky130_fd_pr__cap_mim_m3_1 l=3 w=3
X3942 B9.t372 TOP.t278 sky130_fd_pr__cap_mim_m3_1 l=3 w=3
X3943 B11.t1737 TOP.t1644 sky130_fd_pr__cap_mim_m3_1 l=3 w=3
X3944 B11.t1414 TOP.t2290 sky130_fd_pr__cap_mim_m3_1 l=3 w=3
X3945 B11.t545 TOP.t4028 sky130_fd_pr__cap_mim_m3_1 l=3 w=3
X3946 B10.t837 TOP.t5620 sky130_fd_pr__cap_mim_m3_1 l=3 w=3
X3947 B11.t787 TOP.t3544 sky130_fd_pr__cap_mim_m3_1 l=3 w=3
X3948 B11.t1699 TOP.t1720 sky130_fd_pr__cap_mim_m3_1 l=3 w=3
X3949 B11.t1103 TOP.t2912 sky130_fd_pr__cap_mim_m3_1 l=3 w=3
X3950 B8.t190 TOP.t7426 sky130_fd_pr__cap_mim_m3_1 l=3 w=3
X3951 B11.t70 TOP.t4978 sky130_fd_pr__cap_mim_m3_1 l=3 w=3
X3952 B11.t1941 TOP.t1236 sky130_fd_pr__cap_mim_m3_1 l=3 w=3
X3953 B10.t799 TOP.t5696 sky130_fd_pr__cap_mim_m3_1 l=3 w=3
X3954 B10.t632 TOP.t6030 sky130_fd_pr__cap_mim_m3_1 l=3 w=3
X3955 B11.t389 TOP.t4340 sky130_fd_pr__cap_mim_m3_1 l=3 w=3
X3956 B11.t1065 TOP.t2988 sky130_fd_pr__cap_mim_m3_1 l=3 w=3
X3957 B7.t72 TOP.t7918 sky130_fd_pr__cap_mim_m3_1 l=3 w=3
X3958 B7.t41 TOP.t7980 sky130_fd_pr__cap_mim_m3_1 l=3 w=3
X3959 B7.t3 TOP.t8056 sky130_fd_pr__cap_mim_m3_1 l=3 w=3
X3960 B9.t61 TOP.t900 sky130_fd_pr__cap_mim_m3_1 l=3 w=3
X3961 B11.t49 TOP.t5020 sky130_fd_pr__cap_mim_m3_1 l=3 w=3
X3962 B10.t210 TOP.t6874 sky130_fd_pr__cap_mim_m3_1 l=3 w=3
X3963 B11.t1903 TOP.t1312 sky130_fd_pr__cap_mim_m3_1 l=3 w=3
X3964 B10.t567 TOP.t6160 sky130_fd_pr__cap_mim_m3_1 l=3 w=3
X3965 EDGE_BIAS.t354 EDGE_BIAS.t355 sky130_fd_pr__cap_mim_m3_1 l=3 w=3
X3966 B9.t104 TOP.t814 sky130_fd_pr__cap_mim_m3_1 l=3 w=3
X3967 B10.t1003 TOP.t5288 sky130_fd_pr__cap_mim_m3_1 l=3 w=3
X3968 B11.t98 TOP.t4922 sky130_fd_pr__cap_mim_m3_1 l=3 w=3
X3969 B11.t2041 TOP.t1036 sky130_fd_pr__cap_mim_m3_1 l=3 w=3
X3970 B10.t965 TOP.t5364 sky130_fd_pr__cap_mim_m3_1 l=3 w=3
X3971 B9.t279 TOP.t464 sky130_fd_pr__cap_mim_m3_1 l=3 w=3
X3972 B8.t92 TOP.t7622 sky130_fd_pr__cap_mim_m3_1 l=3 w=3
X3973 B10.t172 TOP.t6950 sky130_fd_pr__cap_mim_m3_1 l=3 w=3
X3974 B11.t978 TOP.t3162 sky130_fd_pr__cap_mim_m3_1 l=3 w=3
X3975 B8.t54 TOP.t7698 sky130_fd_pr__cap_mim_m3_1 l=3 w=3
X3976 B10.t927 TOP.t5440 sky130_fd_pr__cap_mim_m3_1 l=3 w=3
X3977 B11.t279 TOP.t4560 sky130_fd_pr__cap_mim_m3_1 l=3 w=3
X3978 B11.t1170 TOP.t2778 sky130_fd_pr__cap_mim_m3_1 l=3 w=3
X3979 B10.t823 TOP.t5648 sky130_fd_pr__cap_mim_m3_1 l=3 w=3
X3980 B5.t27 TOP.t8074 sky130_fd_pr__cap_mim_m3_1 l=3 w=3
X3981 B10.t512 TOP.t6270 sky130_fd_pr__cap_mim_m3_1 l=3 w=3
X3982 EDGE_BIAS.t54 EDGE_BIAS.t55 sky130_fd_pr__cap_mim_m3_1 l=3 w=3
X3983 B9.t128 TOP.t766 sky130_fd_pr__cap_mim_m3_1 l=3 w=3
X3984 B11.t1374 TOP.t2370 sky130_fd_pr__cap_mim_m3_1 l=3 w=3
X3985 B8.t226 TOP.t7354 sky130_fd_pr__cap_mim_m3_1 l=3 w=3
X3986 B11.t1616 TOP.t1886 sky130_fd_pr__cap_mim_m3_1 l=3 w=3
X3987 B9.t470 TOP.t82 sky130_fd_pr__cap_mim_m3_1 l=3 w=3
X3988 B11.t425 TOP.t4268 sky130_fd_pr__cap_mim_m3_1 l=3 w=3
X3989 B11.t643 TOP.t3832 sky130_fd_pr__cap_mim_m3_1 l=3 w=3
X3990 B11.t1002 TOP.t3114 sky130_fd_pr__cap_mim_m3_1 l=3 w=3
X3991 B11.t1336 TOP.t2446 sky130_fd_pr__cap_mim_m3_1 l=3 w=3
X3992 EDGE_BIAS.t408 EDGE_BIAS.t409 sky130_fd_pr__cap_mim_m3_1 l=3 w=3
X3993 B11.t1578 TOP.t1962 sky130_fd_pr__cap_mim_m3_1 l=3 w=3
X3994 B10.t592 TOP.t6110 sky130_fd_pr__cap_mim_m3_1 l=3 w=3
X3995 B9.t432 TOP.t158 sky130_fd_pr__cap_mim_m3_1 l=3 w=3
X3996 B10.t287 TOP.t6720 sky130_fd_pr__cap_mim_m3_1 l=3 w=3
X3997 B11.t1797 TOP.t1524 sky130_fd_pr__cap_mim_m3_1 l=3 w=3
X3998 B11.t1474 TOP.t2170 sky130_fd_pr__cap_mim_m3_1 l=3 w=3
X3999 B9.t394 TOP.t234 sky130_fd_pr__cap_mim_m3_1 l=3 w=3
X4000 B9.t215 TOP.t592 sky130_fd_pr__cap_mim_m3_1 l=3 w=3
X4001 B11.t605 TOP.t3908 sky130_fd_pr__cap_mim_m3_1 l=3 w=3
X4002 B9.t21 TOP.t980 sky130_fd_pr__cap_mim_m3_1 l=3 w=3
X4003 B9.t356 TOP.t310 sky130_fd_pr__cap_mim_m3_1 l=3 w=3
X4004 B11.t195 TOP.t4728 sky130_fd_pr__cap_mim_m3_1 l=3 w=3
X4005 B10.t249 TOP.t6796 sky130_fd_pr__cap_mim_m3_1 l=3 w=3
X4006 B11.t1759 TOP.t1600 sky130_fd_pr__cap_mim_m3_1 l=3 w=3
X4007 B9.t177 TOP.t668 sky130_fd_pr__cap_mim_m3_1 l=3 w=3
X4008 B11.t120 TOP.t4878 sky130_fd_pr__cap_mim_m3_1 l=3 w=3
X4009 B8.t250 TOP.t7306 sky130_fd_pr__cap_mim_m3_1 l=3 w=3
X4010 B10.t491 TOP.t6312 sky130_fd_pr__cap_mim_m3_1 l=3 w=3
X4011 B11.t439 TOP.t4240 sky130_fd_pr__cap_mim_m3_1 l=3 w=3
X4012 B11.t2001 TOP.t1116 sky130_fd_pr__cap_mim_m3_1 l=3 w=3
X4013 B11.t1721 TOP.t1676 sky130_fd_pr__cap_mim_m3_1 l=3 w=3
X4014 B9.t66 TOP.t890 sky130_fd_pr__cap_mim_m3_1 l=3 w=3
X4015 EDGE_BIAS.t756 EDGE_BIAS.t757 sky130_fd_pr__cap_mim_m3_1 l=3 w=3
X4016 EDGE_BIAS.t693 EDGE_BIAS.t694 sky130_fd_pr__cap_mim_m3_1 l=3 w=3
X4017 B11.t1963 TOP.t1192 sky130_fd_pr__cap_mim_m3_1 l=3 w=3
X4018 B11.t1683 TOP.t1752 sky130_fd_pr__cap_mim_m3_1 l=3 w=3
X4019 B11.t1527 TOP.t2064 sky130_fd_pr__cap_mim_m3_1 l=3 w=3
X4020 B11.t223 TOP.t4672 sky130_fd_pr__cap_mim_m3_1 l=3 w=3
X4021 B11.t1925 TOP.t1268 sky130_fd_pr__cap_mim_m3_1 l=3 w=3
X4022 B11.t1602 TOP.t1914 sky130_fd_pr__cap_mim_m3_1 l=3 w=3
X4023 B10.t783 TOP.t5728 sky130_fd_pr__cap_mim_m3_1 l=3 w=3
X4024 B11.t1243 TOP.t2632 sky130_fd_pr__cap_mim_m3_1 l=3 w=3
X4025 B11.t1049 TOP.t3020 sky130_fd_pr__cap_mim_m3_1 l=3 w=3
X4026 B7.t25 TOP.t8012 sky130_fd_pr__cap_mim_m3_1 l=3 w=3
X4027 B11.t1887 TOP.t1344 sky130_fd_pr__cap_mim_m3_1 l=3 w=3
X4028 B10.t745 TOP.t5804 sky130_fd_pr__cap_mim_m3_1 l=3 w=3
X4029 EDGE_BIAS.t609 EDGE_BIAS.t610 sky130_fd_pr__cap_mim_m3_1 l=3 w=3
X4030 EDGE_BIAS.t462 EDGE_BIAS.t463 sky130_fd_pr__cap_mim_m3_1 l=3 w=3
X4031 B10.t987 TOP.t5320 sky130_fd_pr__cap_mim_m3_1 l=3 w=3
X4032 B8.t114 TOP.t7578 sky130_fd_pr__cap_mim_m3_1 l=3 w=3
X4033 B8.t76 TOP.t7654 sky130_fd_pr__cap_mim_m3_1 l=3 w=3
X4034 B10.t883 TOP.t5528 sky130_fd_pr__cap_mim_m3_1 l=3 w=3
X4035 B9.t263 TOP.t496 sky130_fd_pr__cap_mim_m3_1 l=3 w=3
X4036 B10.t156 TOP.t6982 sky130_fd_pr__cap_mim_m3_1 l=3 w=3
X4037 B11.t962 TOP.t3194 sky130_fd_pr__cap_mim_m3_1 l=3 w=3
X4038 B8.t38 TOP.t7730 sky130_fd_pr__cap_mim_m3_1 l=3 w=3
X4039 B11.t682 TOP.t3754 sky130_fd_pr__cap_mim_m3_1 l=3 w=3
X4040 B11.t1192 TOP.t2734 sky130_fd_pr__cap_mim_m3_1 l=3 w=3
X4041 B11.t924 TOP.t3270 sky130_fd_pr__cap_mim_m3_1 l=3 w=3
X4042 B10.t118 TOP.t7058 sky130_fd_pr__cap_mim_m3_1 l=3 w=3
X4043 B11.t1434 TOP.t2250 sky130_fd_pr__cap_mim_m3_1 l=3 w=3
X4044 B6.t59 TOP.t5128 sky130_fd_pr__cap_mim_m3_1 l=3 w=3
X4045 B6.t20 TOP.t5206 sky130_fd_pr__cap_mim_m3_1 l=3 w=3
X4046 B11.t139 TOP.t4840 sky130_fd_pr__cap_mim_m3_1 l=3 w=3
X4047 B11.t1007 TOP.t3104 sky130_fd_pr__cap_mim_m3_1 l=3 w=3
X4048 EDGE_BIAS.t102 EDGE_BIAS.t103 sky130_fd_pr__cap_mim_m3_1 l=3 w=3
X4049 B11.t1396 TOP.t2326 sky130_fd_pr__cap_mim_m3_1 l=3 w=3
X4050 B11.t458 TOP.t4202 sky130_fd_pr__cap_mim_m3_1 l=3 w=3
X4051 B11.t1638 TOP.t1842 sky130_fd_pr__cap_mim_m3_1 l=3 w=3
X4052 B11.t1358 TOP.t2402 sky130_fd_pr__cap_mim_m3_1 l=3 w=3
X4053 B10.t1011 TOP.t5272 sky130_fd_pr__cap_mim_m3_1 l=3 w=3
X4054 B10.t652 TOP.t5990 sky130_fd_pr__cap_mim_m3_1 l=3 w=3
X4055 B8.t210 TOP.t7386 sky130_fd_pr__cap_mim_m3_1 l=3 w=3
X4056 B11.t2040 TOP.t1038 sky130_fd_pr__cap_mim_m3_1 l=3 w=3
X4057 B9.t454 TOP.t114 sky130_fd_pr__cap_mim_m3_1 l=3 w=3
X4058 B8.t172 TOP.t7462 sky130_fd_pr__cap_mim_m3_1 l=3 w=3
X4059 B11.t1320 TOP.t2478 sky130_fd_pr__cap_mim_m3_1 l=3 w=3
X4060 B10.t614 TOP.t6066 sky130_fd_pr__cap_mim_m3_1 l=3 w=3
X4061 B11.t245 TOP.t4628 sky130_fd_pr__cap_mim_m3_1 l=3 w=3
X4062 EDGE_BIAS.t516 EDGE_BIAS.t517 sky130_fd_pr__cap_mim_m3_1 l=3 w=3
X4063 B11.t1562 TOP.t1994 sky130_fd_pr__cap_mim_m3_1 l=3 w=3
X4064 B9.t416 TOP.t190 sky130_fd_pr__cap_mim_m3_1 l=3 w=3
X4065 B11.t486 TOP.t4146 sky130_fd_pr__cap_mim_m3_1 l=3 w=3
X4066 B10.t271 TOP.t6752 sky130_fd_pr__cap_mim_m3_1 l=3 w=3
X4067 B10.t309 TOP.t6676 sky130_fd_pr__cap_mim_m3_1 l=3 w=3
X4068 B11.t1282 TOP.t2554 sky130_fd_pr__cap_mim_m3_1 l=3 w=3
X4069 B9.t199 TOP.t624 sky130_fd_pr__cap_mim_m3_1 l=3 w=3
X4070 B9.t43 TOP.t936 sky130_fd_pr__cap_mim_m3_1 l=3 w=3
X4071 B11.t589 TOP.t3940 sky130_fd_pr__cap_mim_m3_1 l=3 w=3
X4072 B9.t5 TOP.t1012 sky130_fd_pr__cap_mim_m3_1 l=3 w=3
X4073 B11.t348 TOP.t4422 sky130_fd_pr__cap_mim_m3_1 l=3 w=3
X4074 EDGE_BIAS.t606 EDGE_BIAS.t607 sky130_fd_pr__cap_mim_m3_1 l=3 w=3
X4075 B10.t233 TOP.t6828 sky130_fd_pr__cap_mim_m3_1 l=3 w=3
X4076 B11.t1743 TOP.t1632 sky130_fd_pr__cap_mim_m3_1 l=3 w=3
X4077 B9.t161 TOP.t700 sky130_fd_pr__cap_mim_m3_1 l=3 w=3
X4078 B10.t475 TOP.t6344 sky130_fd_pr__cap_mim_m3_1 l=3 w=3
X4079 B11.t256 TOP.t4606 sky130_fd_pr__cap_mim_m3_1 l=3 w=3
X4080 B11.t551 TOP.t4016 sky130_fd_pr__cap_mim_m3_1 l=3 w=3
X4081 B11.t1985 TOP.t1148 sky130_fd_pr__cap_mim_m3_1 l=3 w=3
X4082 B9.t508 TOP.t6 sky130_fd_pr__cap_mim_m3_1 l=3 w=3
X4083 B10.t843 TOP.t5608 sky130_fd_pr__cap_mim_m3_1 l=3 w=3
X4084 B11.t1705 TOP.t1708 sky130_fd_pr__cap_mim_m3_1 l=3 w=3
X4085 B11.t1511 TOP.t2096 sky130_fd_pr__cap_mim_m3_1 l=3 w=3
X4086 B11.t1109 TOP.t2900 sky130_fd_pr__cap_mim_m3_1 l=3 w=3
X4087 B10.t437 TOP.t6420 sky130_fd_pr__cap_mim_m3_1 l=3 w=3
X4088 B11.t1947 TOP.t1224 sky130_fd_pr__cap_mim_m3_1 l=3 w=3
X4089 B10.t805 TOP.t5684 sky130_fd_pr__cap_mim_m3_1 l=3 w=3
X4090 B11.t1071 TOP.t2976 sky130_fd_pr__cap_mim_m3_1 l=3 w=3
X4091 B10.t767 TOP.t5760 sky130_fd_pr__cap_mim_m3_1 l=3 w=3
X4092 B9.t440 TOP.t142 sky130_fd_pr__cap_mim_m3_1 l=3 w=3
X4093 B7.t78 TOP.t7906 sky130_fd_pr__cap_mim_m3_1 l=3 w=3
X4094 B11.t1473 TOP.t2172 sky130_fd_pr__cap_mim_m3_1 l=3 w=3
X4095 EDGE_BIAS.t270 EDGE_BIAS.t271 sky130_fd_pr__cap_mim_m3_1 l=3 w=3
X4096 B7.t9 TOP.t8044 sky130_fd_pr__cap_mim_m3_1 l=3 w=3
X4097 B11.t104 TOP.t4910 sky130_fd_pr__cap_mim_m3_1 l=3 w=3
X4098 B11.t1909 TOP.t1300 sky130_fd_pr__cap_mim_m3_1 l=3 w=3
X4099 B10.t729 TOP.t5836 sky130_fd_pr__cap_mim_m3_1 l=3 w=3
X4100 B9.t110 TOP.t802 sky130_fd_pr__cap_mim_m3_1 l=3 w=3
X4101 B11.t1871 TOP.t1376 sky130_fd_pr__cap_mim_m3_1 l=3 w=3
X4102 B11.t402 TOP.t4314 sky130_fd_pr__cap_mim_m3_1 l=3 w=3
X4103 B10.t971 TOP.t5352 sky130_fd_pr__cap_mim_m3_1 l=3 w=3
X4104 B8.t98 TOP.t7610 sky130_fd_pr__cap_mim_m3_1 l=3 w=3
X4105 B10.t691 TOP.t5912 sky130_fd_pr__cap_mim_m3_1 l=3 w=3
X4106 B11.t984 TOP.t3150 sky130_fd_pr__cap_mim_m3_1 l=3 w=3
X4107 B10.t140 TOP.t7014 sky130_fd_pr__cap_mim_m3_1 l=3 w=3
X4108 B11.t946 TOP.t3226 sky130_fd_pr__cap_mim_m3_1 l=3 w=3
X4109 B11.t1729 TOP.t1660 sky130_fd_pr__cap_mim_m3_1 l=3 w=3
X4110 B10.t933 TOP.t5428 sky130_fd_pr__cap_mim_m3_1 l=3 w=3
X4111 B11.t666 TOP.t3786 sky130_fd_pr__cap_mim_m3_1 l=3 w=3
X4112 B11.t1176 TOP.t2766 sky130_fd_pr__cap_mim_m3_1 l=3 w=3
X4113 B4.t9 TOP.t8164 sky130_fd_pr__cap_mim_m3_1 l=3 w=3
X4114 B11.t908 TOP.t3302 sky130_fd_pr__cap_mim_m3_1 l=3 w=3
X4115 B10.t102 TOP.t7090 sky130_fd_pr__cap_mim_m3_1 l=3 w=3
X4116 B11.t1418 TOP.t2282 sky130_fd_pr__cap_mim_m3_1 l=3 w=3
X4117 B11.t1039 TOP.t3040 sky130_fd_pr__cap_mim_m3_1 l=3 w=3
X4118 B10.t344 TOP.t6606 sky130_fd_pr__cap_mim_m3_1 l=3 w=3
X4119 B10.t518 TOP.t6258 sky130_fd_pr__cap_mim_m3_1 l=3 w=3
X4120 B11.t292 TOP.t4534 sky130_fd_pr__cap_mim_m3_1 l=3 w=3
X4121 EDGE_BIAS.t762 EDGE_BIAS.t763 sky130_fd_pr__cap_mim_m3_1 l=3 w=3
X4122 B11.t870 TOP.t3378 sky130_fd_pr__cap_mim_m3_1 l=3 w=3
X4123 B11.t1380 TOP.t2358 sky130_fd_pr__cap_mim_m3_1 l=3 w=3
X4124 B8.t232 TOP.t7342 sky130_fd_pr__cap_mim_m3_1 l=3 w=3
X4125 B8.t194 TOP.t7418 sky130_fd_pr__cap_mim_m3_1 l=3 w=3
X4126 B8.t122 TOP.t7562 sky130_fd_pr__cap_mim_m3_1 l=3 w=3
X4127 B11.t1622 TOP.t1874 sky130_fd_pr__cap_mim_m3_1 l=3 w=3
X4128 B9.t476 TOP.t70 sky130_fd_pr__cap_mim_m3_1 l=3 w=3
X4129 B10.t882 TOP.t5530 sky130_fd_pr__cap_mim_m3_1 l=3 w=3
X4130 EDGE_BIAS.t324 EDGE_BIAS.t325 sky130_fd_pr__cap_mim_m3_1 l=3 w=3
X4131 B11.t1342 TOP.t2434 sky130_fd_pr__cap_mim_m3_1 l=3 w=3
X4132 B11.t1304 TOP.t2510 sky130_fd_pr__cap_mim_m3_1 l=3 w=3
X4133 B11.t1148 TOP.t2822 sky130_fd_pr__cap_mim_m3_1 l=3 w=3
X4134 B8.t156 TOP.t7494 sky130_fd_pr__cap_mim_m3_1 l=3 w=3
X4135 B11.t1584 TOP.t1950 sky130_fd_pr__cap_mim_m3_1 l=3 w=3
X4136 B10.t598 TOP.t6098 sky130_fd_pr__cap_mim_m3_1 l=3 w=3
X4137 B10.t293 TOP.t6708 sky130_fd_pr__cap_mim_m3_1 l=3 w=3
X4138 B11.t1546 TOP.t2026 sky130_fd_pr__cap_mim_m3_1 l=3 w=3
X4139 B9.t400 TOP.t222 sky130_fd_pr__cap_mim_m3_1 l=3 w=3
X4140 B11.t1266 TOP.t2586 sky130_fd_pr__cap_mim_m3_1 l=3 w=3
X4141 B7.t117 TOP.t7828 sky130_fd_pr__cap_mim_m3_1 l=3 w=3
X4142 B9.t27 TOP.t968 sky130_fd_pr__cap_mim_m3_1 l=3 w=3
X4143 B11.t573 TOP.t3972 sky130_fd_pr__cap_mim_m3_1 l=3 w=3
X4144 B9.t362 TOP.t298 sky130_fd_pr__cap_mim_m3_1 l=3 w=3
X4145 B11.t535 TOP.t4048 sky130_fd_pr__cap_mim_m3_1 l=3 w=3
X4146 B10.t497 TOP.t6300 sky130_fd_pr__cap_mim_m3_1 l=3 w=3
X4147 B10.t827 TOP.t5640 sky130_fd_pr__cap_mim_m3_1 l=3 w=3
X4148 B11.t1030 TOP.t3058 sky130_fd_pr__cap_mim_m3_1 l=3 w=3
X4149 B11.t777 TOP.t3564 sky130_fd_pr__cap_mim_m3_1 l=3 w=3
X4150 B11.t1689 TOP.t1740 sky130_fd_pr__cap_mim_m3_1 l=3 w=3
X4151 B11.t137 TOP.t4844 sky130_fd_pr__cap_mim_m3_1 l=3 w=3
X4152 B11.t1931 TOP.t1256 sky130_fd_pr__cap_mim_m3_1 l=3 w=3
X4153 B10.t789 TOP.t5716 sky130_fd_pr__cap_mim_m3_1 l=3 w=3
X4154 B11.t739 TOP.t3640 sky130_fd_pr__cap_mim_m3_1 l=3 w=3
X4155 B10.t317 TOP.t6660 sky130_fd_pr__cap_mim_m3_1 l=3 w=3
X4156 B11.t1055 TOP.t3008 sky130_fd_pr__cap_mim_m3_1 l=3 w=3
X4157 B7.t31 TOP.t8000 sky130_fd_pr__cap_mim_m3_1 l=3 w=3
X4158 EDGE_BIAS.t654 EDGE_BIAS.t655 sky130_fd_pr__cap_mim_m3_1 l=3 w=3
X4159 EDGE_BIAS.t378 EDGE_BIAS.t379 sky130_fd_pr__cap_mim_m3_1 l=3 w=3
X4160 B11.t1893 TOP.t1332 sky130_fd_pr__cap_mim_m3_1 l=3 w=3
X4161 B10.t751 TOP.t5792 sky130_fd_pr__cap_mim_m3_1 l=3 w=3
X4162 B10.t713 TOP.t5868 sky130_fd_pr__cap_mim_m3_1 l=3 w=3
X4163 B10.t557 TOP.t6180 sky130_fd_pr__cap_mim_m3_1 l=3 w=3
X4164 B9.t94 TOP.t834 sky130_fd_pr__cap_mim_m3_1 l=3 w=3
X4165 B11.t1789 TOP.t1540 sky130_fd_pr__cap_mim_m3_1 l=3 w=3
X4166 B10.t993 TOP.t5308 sky130_fd_pr__cap_mim_m3_1 l=3 w=3
X4167 B8.t82 TOP.t7642 sky130_fd_pr__cap_mim_m3_1 l=3 w=3
X4168 B11.t62 TOP.t4994 sky130_fd_pr__cap_mim_m3_1 l=3 w=3
X4169 B10.t955 TOP.t5384 sky130_fd_pr__cap_mim_m3_1 l=3 w=3
X4170 B11.t1661 TOP.t1796 sky130_fd_pr__cap_mim_m3_1 l=3 w=3
X4171 B10.t675 TOP.t5944 sky130_fd_pr__cap_mim_m3_1 l=3 w=3
X4172 B11.t968 TOP.t3182 sky130_fd_pr__cap_mim_m3_1 l=3 w=3
X4173 B10.t917 TOP.t5460 sky130_fd_pr__cap_mim_m3_1 l=3 w=3
X4174 B8.t44 TOP.t7718 sky130_fd_pr__cap_mim_m3_1 l=3 w=3
X4175 B11.t325 TOP.t4468 sky130_fd_pr__cap_mim_m3_1 l=3 w=3
X4176 B11.t930 TOP.t3258 sky130_fd_pr__cap_mim_m3_1 l=3 w=3
X4177 B5.t17 TOP.t8094 sky130_fd_pr__cap_mim_m3_1 l=3 w=3
X4178 B8.t127 TOP.t7552 sky130_fd_pr__cap_mim_m3_1 l=3 w=3
X4179 B11.t1842 TOP.t1434 sky130_fd_pr__cap_mim_m3_1 l=3 w=3
X4180 B11.t1917 TOP.t1284 sky130_fd_pr__cap_mim_m3_1 l=3 w=3
X4181 EDGE_BIAS.t84 EDGE_BIAS.t85 sky130_fd_pr__cap_mim_m3_1 l=3 w=3
X4182 B11.t1364 TOP.t2390 sky130_fd_pr__cap_mim_m3_1 l=3 w=3
X4183 B8.t216 TOP.t7374 sky130_fd_pr__cap_mim_m3_1 l=3 w=3
X4184 EDGE_BIAS.t237 EDGE_BIAS.t238 sky130_fd_pr__cap_mim_m3_1 l=3 w=3
X4185 B9.t460 TOP.t102 sky130_fd_pr__cap_mim_m3_1 l=3 w=3
X4186 B11.t173 TOP.t4772 sky130_fd_pr__cap_mim_m3_1 l=3 w=3
X4187 B8.t178 TOP.t7450 sky130_fd_pr__cap_mim_m3_1 l=3 w=3
X4188 B11.t81 TOP.t4956 sky130_fd_pr__cap_mim_m3_1 l=3 w=3
X4189 B11.t471 TOP.t4176 sky130_fd_pr__cap_mim_m3_1 l=3 w=3
X4190 B11.t492 TOP.t4134 sky130_fd_pr__cap_mim_m3_1 l=3 w=3
X4191 B11.t1326 TOP.t2466 sky130_fd_pr__cap_mim_m3_1 l=3 w=3
X4192 B11.t1132 TOP.t2854 sky130_fd_pr__cap_mim_m3_1 l=3 w=3
X4193 B8.t140 TOP.t7526 sky130_fd_pr__cap_mim_m3_1 l=3 w=3
X4194 B11.t1568 TOP.t1982 sky130_fd_pr__cap_mim_m3_1 l=3 w=3
X4195 B11.t1222 TOP.t2674 sky130_fd_pr__cap_mim_m3_1 l=3 w=3
X4196 B10.t582 TOP.t6130 sky130_fd_pr__cap_mim_m3_1 l=3 w=3
X4197 B9.t422 TOP.t178 sky130_fd_pr__cap_mim_m3_1 l=3 w=3
X4198 B9.t384 TOP.t254 sky130_fd_pr__cap_mim_m3_1 l=3 w=3
X4199 B3.t5 TOP.t8134 sky130_fd_pr__cap_mim_m3_1 l=3 w=3
X4200 B10.t277 TOP.t6740 sky130_fd_pr__cap_mim_m3_1 l=3 w=3
X4201 B11.t1094 TOP.t2930 sky130_fd_pr__cap_mim_m3_1 l=3 w=3
X4202 B7.t101 TOP.t7860 sky130_fd_pr__cap_mim_m3_1 l=3 w=3
X4203 B9.t11 TOP.t1000 sky130_fd_pr__cap_mim_m3_1 l=3 w=3
X4204 EDGE_BIAS.t12 EDGE_BIAS.t13 sky130_fd_pr__cap_mim_m3_1 l=3 w=3
X4205 B9.t346 TOP.t330 sky130_fd_pr__cap_mim_m3_1 l=3 w=3
X4206 B10.t239 TOP.t6816 sky130_fd_pr__cap_mim_m3_1 l=3 w=3
X4207 B11.t1749 TOP.t1620 sky130_fd_pr__cap_mim_m3_1 l=3 w=3
X4208 B10.t481 TOP.t6332 sky130_fd_pr__cap_mim_m3_1 l=3 w=3
X4209 B11.t187 TOP.t4744 sky130_fd_pr__cap_mim_m3_1 l=3 w=3
X4210 B11.t1991 TOP.t1136 sky130_fd_pr__cap_mim_m3_1 l=3 w=3
X4211 B10.t322 TOP.t6650 sky130_fd_pr__cap_mim_m3_1 l=3 w=3
X4212 B9.t308 TOP.t406 sky130_fd_pr__cap_mim_m3_1 l=3 w=3
X4213 B11.t1711 TOP.t1696 sky130_fd_pr__cap_mim_m3_1 l=3 w=3
X4214 B11.t1673 TOP.t1772 sky130_fd_pr__cap_mim_m3_1 l=3 w=3
X4215 B11.t1517 TOP.t2084 sky130_fd_pr__cap_mim_m3_1 l=3 w=3
X4216 B11.t1350 TOP.t2418 sky130_fd_pr__cap_mim_m3_1 l=3 w=3
X4217 B11.t1953 TOP.t1212 sky130_fd_pr__cap_mim_m3_1 l=3 w=3
X4218 B10.t773 TOP.t5748 sky130_fd_pr__cap_mim_m3_1 l=3 w=3
X4219 EDGE_BIAS.t291 EDGE_BIAS.t292 sky130_fd_pr__cap_mim_m3_1 l=3 w=3
X4220 B7.t15 TOP.t8032 sky130_fd_pr__cap_mim_m3_1 l=3 w=3
X4221 B10.t735 TOP.t5824 sky130_fd_pr__cap_mim_m3_1 l=3 w=3
X4222 B9.t116 TOP.t790 sky130_fd_pr__cap_mim_m3_1 l=3 w=3
X4223 B11.t1877 TOP.t1364 sky130_fd_pr__cap_mim_m3_1 l=3 w=3
X4224 B10.t541 TOP.t6212 sky130_fd_pr__cap_mim_m3_1 l=3 w=3
X4225 B9.t78 TOP.t866 sky130_fd_pr__cap_mim_m3_1 l=3 w=3
X4226 B10.t977 TOP.t5340 sky130_fd_pr__cap_mim_m3_1 l=3 w=3
X4227 B8.t104 TOP.t7598 sky130_fd_pr__cap_mim_m3_1 l=3 w=3
X4228 B8.t66 TOP.t7674 sky130_fd_pr__cap_mim_m3_1 l=3 w=3
X4229 B10.t505 TOP.t6284 sky130_fd_pr__cap_mim_m3_1 l=3 w=3
X4230 B11.t375 TOP.t4368 sky130_fd_pr__cap_mim_m3_1 l=3 w=3
X4231 B11.t952 TOP.t3214 sky130_fd_pr__cap_mim_m3_1 l=3 w=3
X4232 B11.t1645 TOP.t1828 sky130_fd_pr__cap_mim_m3_1 l=3 w=3
X4233 B10.t939 TOP.t5416 sky130_fd_pr__cap_mim_m3_1 l=3 w=3
X4234 B9.t499 TOP.t24 sky130_fd_pr__cap_mim_m3_1 l=3 w=3
X4235 B11.t1541 TOP.t2036 sky130_fd_pr__cap_mim_m3_1 l=3 w=3
X4236 B8.t28 TOP.t7750 sky130_fd_pr__cap_mim_m3_1 l=3 w=3
X4237 B11.t672 TOP.t3774 sky130_fd_pr__cap_mim_m3_1 l=3 w=3
X4238 B8.t255 TOP.t7296 sky130_fd_pr__cap_mim_m3_1 l=3 w=3
X4239 B11.t1182 TOP.t2754 sky130_fd_pr__cap_mim_m3_1 l=3 w=3
X4240 B6.t49 TOP.t5148 sky130_fd_pr__cap_mim_m3_1 l=3 w=3
X4241 B11.t298 TOP.t4522 sky130_fd_pr__cap_mim_m3_1 l=3 w=3
X4242 B11.t914 TOP.t3290 sky130_fd_pr__cap_mim_m3_1 l=3 w=3
X4243 B11.t1424 TOP.t2270 sky130_fd_pr__cap_mim_m3_1 l=3 w=3
X4244 B11.t1826 TOP.t1466 sky130_fd_pr__cap_mim_m3_1 l=3 w=3
X4245 B9.t244 TOP.t534 sky130_fd_pr__cap_mim_m3_1 l=3 w=3
X4246 B11.t206 TOP.t4706 sky130_fd_pr__cap_mim_m3_1 l=3 w=3
X4247 EDGE_BIAS.t132 EDGE_BIAS.t133 sky130_fd_pr__cap_mim_m3_1 l=3 w=3
X4248 B10.t759 TOP.t5776 sky130_fd_pr__cap_mim_m3_1 l=3 w=3
X4249 B6.t10 TOP.t5226 sky130_fd_pr__cap_mim_m3_1 l=3 w=3
X4250 B11.t1386 TOP.t2346 sky130_fd_pr__cap_mim_m3_1 l=3 w=3
X4251 B8.t200 TOP.t7406 sky130_fd_pr__cap_mim_m3_1 l=3 w=3
X4252 B11.t1788 TOP.t1542 sky130_fd_pr__cap_mim_m3_1 l=3 w=3
X4253 B11.t2030 TOP.t1058 sky130_fd_pr__cap_mim_m3_1 l=3 w=3
X4254 EDGE_BIAS.t345 EDGE_BIAS.t346 sky130_fd_pr__cap_mim_m3_1 l=3 w=3
X4255 EDGE_BIAS.t660 EDGE_BIAS.t661 sky130_fd_pr__cap_mim_m3_1 l=3 w=3
X4256 B11.t1669 TOP.t1780 sky130_fd_pr__cap_mim_m3_1 l=3 w=3
X4257 B11.t1310 TOP.t2498 sky130_fd_pr__cap_mim_m3_1 l=3 w=3
X4258 B11.t1154 TOP.t2810 sky130_fd_pr__cap_mim_m3_1 l=3 w=3
X4259 B8.t162 TOP.t7482 sky130_fd_pr__cap_mim_m3_1 l=3 w=3
X4260 B11.t234 TOP.t4650 sky130_fd_pr__cap_mim_m3_1 l=3 w=3
X4261 B11.t1116 TOP.t2886 sky130_fd_pr__cap_mim_m3_1 l=3 w=3
X4262 B10.t299 TOP.t6696 sky130_fd_pr__cap_mim_m3_1 l=3 w=3
X4263 B11.t1552 TOP.t2014 sky130_fd_pr__cap_mim_m3_1 l=3 w=3
X4264 B9.t406 TOP.t210 sky130_fd_pr__cap_mim_m3_1 l=3 w=3
X4265 B11.t938 TOP.t3242 sky130_fd_pr__cap_mim_m3_1 l=3 w=3
X4266 B10.t261 TOP.t6772 sky130_fd_pr__cap_mim_m3_1 l=3 w=3
X4267 B11.t1272 TOP.t2574 sky130_fd_pr__cap_mim_m3_1 l=3 w=3
X4268 B11.t1078 TOP.t2962 sky130_fd_pr__cap_mim_m3_1 l=3 w=3
X4269 B9.t368 TOP.t286 sky130_fd_pr__cap_mim_m3_1 l=3 w=3
X4270 B7.t54 TOP.t7954 sky130_fd_pr__cap_mim_m3_1 l=3 w=3
X4271 B10.t1020 TOP.t5254 sky130_fd_pr__cap_mim_m3_1 l=3 w=3
X4272 B10.t223 TOP.t6848 sky130_fd_pr__cap_mim_m3_1 l=3 w=3
X4273 B11.t1733 TOP.t1652 sky130_fd_pr__cap_mim_m3_1 l=3 w=3
X4274 B9.t151 TOP.t720 sky130_fd_pr__cap_mim_m3_1 l=3 w=3
X4275 B10.t465 TOP.t6364 sky130_fd_pr__cap_mim_m3_1 l=3 w=3
X4276 B10.t833 TOP.t5628 sky130_fd_pr__cap_mim_m3_1 l=3 w=3
X4277 B10.t185 TOP.t6924 sky130_fd_pr__cap_mim_m3_1 l=3 w=3
X4278 B11.t1695 TOP.t1728 sky130_fd_pr__cap_mim_m3_1 l=3 w=3
X4279 B11.t1501 TOP.t2116 sky130_fd_pr__cap_mim_m3_1 l=3 w=3
X4280 B8.t186 TOP.t7434 sky130_fd_pr__cap_mim_m3_1 l=3 w=3
X4281 B10.t427 TOP.t6440 sky130_fd_pr__cap_mim_m3_1 l=3 w=3
X4282 B11.t1937 TOP.t1244 sky130_fd_pr__cap_mim_m3_1 l=3 w=3
X4283 B10.t795 TOP.t5704 sky130_fd_pr__cap_mim_m3_1 l=3 w=3
X4284 B11.t1221 TOP.t2676 sky130_fd_pr__cap_mim_m3_1 l=3 w=3
X4285 B11.t1463 TOP.t2192 sky130_fd_pr__cap_mim_m3_1 l=3 w=3
X4286 EDGE_BIAS.t399 EDGE_BIAS.t400 sky130_fd_pr__cap_mim_m3_1 l=3 w=3
X4287 B11.t150 TOP.t4818 sky130_fd_pr__cap_mim_m3_1 l=3 w=3
X4288 B11.t1899 TOP.t1320 sky130_fd_pr__cap_mim_m3_1 l=3 w=3
X4289 B11.t1861 TOP.t1396 sky130_fd_pr__cap_mim_m3_1 l=3 w=3
X4290 B11.t1102 TOP.t2914 sky130_fd_pr__cap_mim_m3_1 l=3 w=3
X4291 B10.t719 TOP.t5856 sky130_fd_pr__cap_mim_m3_1 l=3 w=3
X4292 B10.t563 TOP.t6168 sky130_fd_pr__cap_mim_m3_1 l=3 w=3
X4293 B9.t100 TOP.t822 sky130_fd_pr__cap_mim_m3_1 l=3 w=3
X4294 B11.t469 TOP.t4180 sky130_fd_pr__cap_mim_m3_1 l=3 w=3
X4295 B10.t525 TOP.t6244 sky130_fd_pr__cap_mim_m3_1 l=3 w=3
X4296 B8.t88 TOP.t7630 sky130_fd_pr__cap_mim_m3_1 l=3 w=3
X4297 B10.t961 TOP.t5372 sky130_fd_pr__cap_mim_m3_1 l=3 w=3
X4298 B10.t681 TOP.t5932 sky130_fd_pr__cap_mim_m3_1 l=3 w=3
X4299 B11.t331 TOP.t4456 sky130_fd_pr__cap_mim_m3_1 l=3 w=3
X4300 B10.t923 TOP.t5448 sky130_fd_pr__cap_mim_m3_1 l=3 w=3
X4301 B9.t483 TOP.t56 sky130_fd_pr__cap_mim_m3_1 l=3 w=3
X4302 B8.t50 TOP.t7706 sky130_fd_pr__cap_mim_m3_1 l=3 w=3
X4303 B11.t1035 TOP.t3048 sky130_fd_pr__cap_mim_m3_1 l=3 w=3
X4304 B5.t23 TOP.t8082 sky130_fd_pr__cap_mim_m3_1 l=3 w=3
X4305 B11.t656 TOP.t3806 sky130_fd_pr__cap_mim_m3_1 l=3 w=3
X4306 B10.t92 TOP.t7110 sky130_fd_pr__cap_mim_m3_1 l=3 w=3
X4307 B11.t1166 TOP.t2786 sky130_fd_pr__cap_mim_m3_1 l=3 w=3
X4308 B11.t898 TOP.t3322 sky130_fd_pr__cap_mim_m3_1 l=3 w=3
X4309 B11.t618 TOP.t3882 sky130_fd_pr__cap_mim_m3_1 l=3 w=3
X4310 B11.t359 TOP.t4400 sky130_fd_pr__cap_mim_m3_1 l=3 w=3
X4311 B10.t54 TOP.t7186 sky130_fd_pr__cap_mim_m3_1 l=3 w=3
X4312 EDGE_BIAS.t180 EDGE_BIAS.t181 sky130_fd_pr__cap_mim_m3_1 l=3 w=3
X4313 B9.t124 TOP.t774 sky130_fd_pr__cap_mim_m3_1 l=3 w=3
X4314 B11.t860 TOP.t3398 sky130_fd_pr__cap_mim_m3_1 l=3 w=3
X4315 B11.t1370 TOP.t2378 sky130_fd_pr__cap_mim_m3_1 l=3 w=3
X4316 B8.t222 TOP.t7362 sky130_fd_pr__cap_mim_m3_1 l=3 w=3
X4317 B11.t2014 TOP.t1090 sky130_fd_pr__cap_mim_m3_1 l=3 w=3
X4318 B11.t1332 TOP.t2454 sky130_fd_pr__cap_mim_m3_1 l=3 w=3
X4319 B10.t872 TOP.t5550 sky130_fd_pr__cap_mim_m3_1 l=3 w=3
X4320 B9.t507 TOP.t8 sky130_fd_pr__cap_mim_m3_1 l=3 w=3
X4321 B11.t385 TOP.t4348 sky130_fd_pr__cap_mim_m3_1 l=3 w=3
X4322 B11.t1294 TOP.t2530 sky130_fd_pr__cap_mim_m3_1 l=3 w=3
X4323 B11.t1138 TOP.t2842 sky130_fd_pr__cap_mim_m3_1 l=3 w=3
X4324 B10.t947 TOP.t5400 sky130_fd_pr__cap_mim_m3_1 l=3 w=3
X4325 B8.t146 TOP.t7514 sky130_fd_pr__cap_mim_m3_1 l=3 w=3
X4326 B9.t390 TOP.t242 sky130_fd_pr__cap_mim_m3_1 l=3 w=3
X4327 B11.t9 TOP.t5100 sky130_fd_pr__cap_mim_m3_1 l=3 w=3
X4328 B10.t283 TOP.t6728 sky130_fd_pr__cap_mim_m3_1 l=3 w=3
X4329 B11.t1976 TOP.t1166 sky130_fd_pr__cap_mim_m3_1 l=3 w=3
X4330 B11.t1256 TOP.t2606 sky130_fd_pr__cap_mim_m3_1 l=3 w=3
X4331 B7.t107 TOP.t7848 sky130_fd_pr__cap_mim_m3_1 l=3 w=3
X4332 B7.t38 TOP.t7986 sky130_fd_pr__cap_mim_m3_1 l=3 w=3
X4333 B9.t17 TOP.t988 sky130_fd_pr__cap_mim_m3_1 l=3 w=3
X4334 B11.t115 TOP.t4888 sky130_fd_pr__cap_mim_m3_1 l=3 w=3
X4335 B9.t352 TOP.t318 sky130_fd_pr__cap_mim_m3_1 l=3 w=3
X4336 B11.t413 TOP.t4292 sky130_fd_pr__cap_mim_m3_1 l=3 w=3
X4337 B10.t245 TOP.t6804 sky130_fd_pr__cap_mim_m3_1 l=3 w=3
X4338 B11.t1026 TOP.t3066 sky130_fd_pr__cap_mim_m3_1 l=3 w=3
X4339 B10.t487 TOP.t6320 sky130_fd_pr__cap_mim_m3_1 l=3 w=3
X4340 B11.t525 TOP.t4068 sky130_fd_pr__cap_mim_m3_1 l=3 w=3
X4341 B11.t275 TOP.t4568 sky130_fd_pr__cap_mim_m3_1 l=3 w=3
X4342 B11.t1679 TOP.t1760 sky130_fd_pr__cap_mim_m3_1 l=3 w=3
X4343 B11.t1485 TOP.t2148 sky130_fd_pr__cap_mim_m3_1 l=3 w=3
X4344 B11.t1162 TOP.t2794 sky130_fd_pr__cap_mim_m3_1 l=3 w=3
X4345 EDGE_BIAS.t207 EDGE_BIAS.t208 sky130_fd_pr__cap_mim_m3_1 l=3 w=3
X4346 B10.t779 TOP.t5736 sky130_fd_pr__cap_mim_m3_1 l=3 w=3
X4347 B11.t1883 TOP.t1352 sky130_fd_pr__cap_mim_m3_1 l=3 w=3
X4348 B11.t1447 TOP.t2224 sky130_fd_pr__cap_mim_m3_1 l=3 w=3
X4349 B10.t741 TOP.t5812 sky130_fd_pr__cap_mim_m3_1 l=3 w=3
X4350 B7.t62 TOP.t7938 sky130_fd_pr__cap_mim_m3_1 l=3 w=3
X4351 B10.t703 TOP.t5888 sky130_fd_pr__cap_mim_m3_1 l=3 w=3
X4352 B10.t547 TOP.t6200 sky130_fd_pr__cap_mim_m3_1 l=3 w=3
X4353 B9.t376 TOP.t270 sky130_fd_pr__cap_mim_m3_1 l=3 w=3
X4354 B9.t84 TOP.t854 sky130_fd_pr__cap_mim_m3_1 l=3 w=3
X4355 B8.t72 TOP.t7662 sky130_fd_pr__cap_mim_m3_1 l=3 w=3
R0 B0 B0.t0 8.41066
R1 DUMMY DUMMY.t0 7.63316
R2 B5 B5.n27 13.4588
R3 B5 B5.n13 6.86302
R4 B5.n0 B5.t0 1.02966
R5 B5.n7 B5.t15 1.02966
R6 B5.n14 B5.t16 1.02966
R7 B5.n21 B5.t31 1.02966
R8 B5.n6 B5.n5 0.7055
R9 B5.n5 B5.n4 0.7055
R10 B5.n4 B5.n3 0.7055
R11 B5.n3 B5.n2 0.7055
R12 B5.n2 B5.n1 0.7055
R13 B5.n1 B5.n0 0.7055
R14 B5.n8 B5.n7 0.7055
R15 B5.n9 B5.n8 0.7055
R16 B5.n10 B5.n9 0.7055
R17 B5.n11 B5.n10 0.7055
R18 B5.n12 B5.n11 0.7055
R19 B5.n20 B5.n19 0.7055
R20 B5.n19 B5.n18 0.7055
R21 B5.n18 B5.n17 0.7055
R22 B5.n17 B5.n16 0.7055
R23 B5.n16 B5.n15 0.7055
R24 B5.n15 B5.n14 0.7055
R25 B5.n22 B5.n21 0.7055
R26 B5.n23 B5.n22 0.7055
R27 B5.n24 B5.n23 0.7055
R28 B5.n25 B5.n24 0.7055
R29 B5.n26 B5.n25 0.7055
R30 B5.n13 B5.n6 0.659675
R31 B5.n13 B5.n12 0.659675
R32 B5.n27 B5.n20 0.659675
R33 B5.n27 B5.n26 0.659675
R34 B5.n0 B5.t1 0.324663
R35 B5.n1 B5.t2 0.324663
R36 B5.n2 B5.t3 0.324663
R37 B5.n3 B5.t4 0.324663
R38 B5.n4 B5.t5 0.324663
R39 B5.n5 B5.t6 0.324663
R40 B5.n6 B5.t7 0.324663
R41 B5.n12 B5.t9 0.324663
R42 B5.n11 B5.t10 0.324663
R43 B5.n10 B5.t11 0.324663
R44 B5.n9 B5.t12 0.324663
R45 B5.n8 B5.t13 0.324663
R46 B5.n7 B5.t14 0.324663
R47 B5.n14 B5.t17 0.324663
R48 B5.n15 B5.t18 0.324663
R49 B5.n16 B5.t19 0.324663
R50 B5.n17 B5.t20 0.324663
R51 B5.n18 B5.t21 0.324663
R52 B5.n19 B5.t22 0.324663
R53 B5.n20 B5.t23 0.324663
R54 B5.n26 B5.t25 0.324663
R55 B5.n25 B5.t26 0.324663
R56 B5.n24 B5.t27 0.324663
R57 B5.n23 B5.t28 0.324663
R58 B5.n22 B5.t29 0.324663
R59 B5.n21 B5.t30 0.324663
R60 B5.n13 B5.t8 0.278838
R61 B5.n27 B5.t24 0.278838
R62 B4 B4.n11 21.9551
R63 B4 B4.n5 15.3593
R64 B4.n0 B4.t0 1.02966
R65 B4.n3 B4.t7 1.02966
R66 B4.n6 B4.t8 1.02966
R67 B4.n9 B4.t15 1.02966
R68 B4.n2 B4.n1 0.7055
R69 B4.n1 B4.n0 0.7055
R70 B4.n4 B4.n3 0.7055
R71 B4.n8 B4.n7 0.7055
R72 B4.n7 B4.n6 0.7055
R73 B4.n10 B4.n9 0.7055
R74 B4.n5 B4.n2 0.659675
R75 B4.n5 B4.n4 0.659675
R76 B4.n11 B4.n8 0.659675
R77 B4.n11 B4.n10 0.659675
R78 B4.n0 B4.t1 0.324663
R79 B4.n1 B4.t2 0.324663
R80 B4.n2 B4.t3 0.324663
R81 B4.n4 B4.t5 0.324663
R82 B4.n3 B4.t6 0.324663
R83 B4.n6 B4.t9 0.324663
R84 B4.n7 B4.t10 0.324663
R85 B4.n8 B4.t11 0.324663
R86 B4.n10 B4.t13 0.324663
R87 B4.n9 B4.t14 0.324663
R88 B4.n5 B4.t4 0.278838
R89 B4.n11 B4.t12 0.278838
R90 B3 B3.n3 26.2213
R91 B3 B3.n1 19.6255
R92 B3.n0 B3.t0 1.02966
R93 B3.n2 B3.t4 1.02966
R94 B3.n1 B3.t3 0.983838
R95 B3.n3 B3.t7 0.983838
R96 B3.n1 B3.n0 0.659675
R97 B3.n3 B3.n2 0.659675
R98 B3.n0 B3.t1 0.324663
R99 B3.n2 B3.t5 0.324663
R100 B3.n1 B3.t2 0.278838
R101 B3.n3 B3.t6 0.278838
R102 B2 B2.n1 28.3726
R103 B2 B2.n0 21.7768
R104 B2.n1 B2.t2 0.983838
R105 B2.n0 B2.t0 0.983838
R106 B2.n1 B2.t3 0.278838
R107 B2.n0 B2.t1 0.278838
R108 B1 B1.t1 29.4157
R109 B1 B1.t0 23.5249
R110 B10 B10.n1021 29.2046
R111 B10 B10.n510 24.2465
R112 B10.n0 B10.t0 3.53236
R113 B10.n0 B10.t1 3.42361
R114 B10.n1 B10.t2 3.42361
R115 B10.n2 B10.t3 3.42361
R116 B10.n3 B10.t4 3.42361
R117 B10.n4 B10.t5 3.42361
R118 B10.n5 B10.t6 3.42361
R119 B10.n6 B10.t7 3.42361
R120 B10.n1014 B10.t1016 3.25206
R121 B10.n1015 B10.t1017 3.25206
R122 B10.n1016 B10.t1018 3.25206
R123 B10.n1017 B10.t1019 3.25206
R124 B10.n1018 B10.t1020 3.25206
R125 B10.n1019 B10.t1021 3.25206
R126 B10.n1020 B10.t1022 3.25206
R127 B10.n1021 B10.t1023 3.25206
R128 B10.n69 B10.n68 3.09945
R129 B10.n132 B10.n131 3.09945
R130 B10.n195 B10.n194 3.09945
R131 B10.n258 B10.n257 3.09945
R132 B10.n321 B10.n320 3.09945
R133 B10.n384 B10.n383 3.09945
R134 B10.n447 B10.n446 3.09945
R135 B10.n510 B10.n509 3.09945
R136 B10.n635 B10.n572 3.03665
R137 B10.n635 B10.n634 2.9279
R138 B10.n698 B10.n697 2.9279
R139 B10.n761 B10.n760 2.9279
R140 B10.n824 B10.n823 2.9279
R141 B10.n887 B10.n886 2.9279
R142 B10.n950 B10.n949 2.9279
R143 B10.n1013 B10.n1012 2.9279
R144 B10.n69 B10.n6 2.71925
R145 B10.n1014 B10.n1013 2.71925
R146 B10.n7 B10.t574 1.02966
R147 B10.n70 B10.t637 1.02966
R148 B10.n133 B10.t700 1.02966
R149 B10.n196 B10.t763 1.02966
R150 B10.n259 B10.t826 1.02966
R151 B10.n322 B10.t889 1.02966
R152 B10.n385 B10.t952 1.02966
R153 B10.n448 B10.t1015 1.02966
R154 B10.n511 B10.t8 1.02966
R155 B10.n573 B10.t71 1.02966
R156 B10.n636 B10.t134 1.02966
R157 B10.n699 B10.t197 1.02966
R158 B10.n762 B10.t260 1.02966
R159 B10.n825 B10.t323 1.02966
R160 B10.n888 B10.t386 1.02966
R161 B10.n951 B10.t449 1.02966
R162 B10.n8 B10.n7 0.7055
R163 B10.n9 B10.n8 0.7055
R164 B10.n10 B10.n9 0.7055
R165 B10.n11 B10.n10 0.7055
R166 B10.n12 B10.n11 0.7055
R167 B10.n13 B10.n12 0.7055
R168 B10.n14 B10.n13 0.7055
R169 B10.n15 B10.n14 0.7055
R170 B10.n16 B10.n15 0.7055
R171 B10.n17 B10.n16 0.7055
R172 B10.n18 B10.n17 0.7055
R173 B10.n19 B10.n18 0.7055
R174 B10.n20 B10.n19 0.7055
R175 B10.n21 B10.n20 0.7055
R176 B10.n22 B10.n21 0.7055
R177 B10.n23 B10.n22 0.7055
R178 B10.n24 B10.n23 0.7055
R179 B10.n25 B10.n24 0.7055
R180 B10.n26 B10.n25 0.7055
R181 B10.n27 B10.n26 0.7055
R182 B10.n28 B10.n27 0.7055
R183 B10.n29 B10.n28 0.7055
R184 B10.n30 B10.n29 0.7055
R185 B10.n31 B10.n30 0.7055
R186 B10.n32 B10.n31 0.7055
R187 B10.n33 B10.n32 0.7055
R188 B10.n34 B10.n33 0.7055
R189 B10.n35 B10.n34 0.7055
R190 B10.n36 B10.n35 0.7055
R191 B10.n37 B10.n36 0.7055
R192 B10.n38 B10.n37 0.7055
R193 B10.n39 B10.n38 0.7055
R194 B10.n40 B10.n39 0.7055
R195 B10.n41 B10.n40 0.7055
R196 B10.n42 B10.n41 0.7055
R197 B10.n43 B10.n42 0.7055
R198 B10.n44 B10.n43 0.7055
R199 B10.n45 B10.n44 0.7055
R200 B10.n46 B10.n45 0.7055
R201 B10.n47 B10.n46 0.7055
R202 B10.n48 B10.n47 0.7055
R203 B10.n49 B10.n48 0.7055
R204 B10.n50 B10.n49 0.7055
R205 B10.n51 B10.n50 0.7055
R206 B10.n52 B10.n51 0.7055
R207 B10.n53 B10.n52 0.7055
R208 B10.n54 B10.n53 0.7055
R209 B10.n55 B10.n54 0.7055
R210 B10.n56 B10.n55 0.7055
R211 B10.n57 B10.n56 0.7055
R212 B10.n58 B10.n57 0.7055
R213 B10.n59 B10.n58 0.7055
R214 B10.n60 B10.n59 0.7055
R215 B10.n61 B10.n60 0.7055
R216 B10.n62 B10.n61 0.7055
R217 B10.n63 B10.n62 0.7055
R218 B10.n64 B10.n63 0.7055
R219 B10.n65 B10.n64 0.7055
R220 B10.n66 B10.n65 0.7055
R221 B10.n67 B10.n66 0.7055
R222 B10.n68 B10.n67 0.7055
R223 B10.n71 B10.n70 0.7055
R224 B10.n72 B10.n71 0.7055
R225 B10.n73 B10.n72 0.7055
R226 B10.n74 B10.n73 0.7055
R227 B10.n75 B10.n74 0.7055
R228 B10.n76 B10.n75 0.7055
R229 B10.n77 B10.n76 0.7055
R230 B10.n78 B10.n77 0.7055
R231 B10.n79 B10.n78 0.7055
R232 B10.n80 B10.n79 0.7055
R233 B10.n81 B10.n80 0.7055
R234 B10.n82 B10.n81 0.7055
R235 B10.n83 B10.n82 0.7055
R236 B10.n84 B10.n83 0.7055
R237 B10.n85 B10.n84 0.7055
R238 B10.n86 B10.n85 0.7055
R239 B10.n87 B10.n86 0.7055
R240 B10.n88 B10.n87 0.7055
R241 B10.n89 B10.n88 0.7055
R242 B10.n90 B10.n89 0.7055
R243 B10.n91 B10.n90 0.7055
R244 B10.n92 B10.n91 0.7055
R245 B10.n93 B10.n92 0.7055
R246 B10.n94 B10.n93 0.7055
R247 B10.n95 B10.n94 0.7055
R248 B10.n96 B10.n95 0.7055
R249 B10.n97 B10.n96 0.7055
R250 B10.n98 B10.n97 0.7055
R251 B10.n99 B10.n98 0.7055
R252 B10.n100 B10.n99 0.7055
R253 B10.n101 B10.n100 0.7055
R254 B10.n102 B10.n101 0.7055
R255 B10.n103 B10.n102 0.7055
R256 B10.n104 B10.n103 0.7055
R257 B10.n105 B10.n104 0.7055
R258 B10.n106 B10.n105 0.7055
R259 B10.n107 B10.n106 0.7055
R260 B10.n108 B10.n107 0.7055
R261 B10.n109 B10.n108 0.7055
R262 B10.n110 B10.n109 0.7055
R263 B10.n111 B10.n110 0.7055
R264 B10.n112 B10.n111 0.7055
R265 B10.n113 B10.n112 0.7055
R266 B10.n114 B10.n113 0.7055
R267 B10.n115 B10.n114 0.7055
R268 B10.n116 B10.n115 0.7055
R269 B10.n117 B10.n116 0.7055
R270 B10.n118 B10.n117 0.7055
R271 B10.n119 B10.n118 0.7055
R272 B10.n120 B10.n119 0.7055
R273 B10.n121 B10.n120 0.7055
R274 B10.n122 B10.n121 0.7055
R275 B10.n123 B10.n122 0.7055
R276 B10.n124 B10.n123 0.7055
R277 B10.n125 B10.n124 0.7055
R278 B10.n126 B10.n125 0.7055
R279 B10.n127 B10.n126 0.7055
R280 B10.n128 B10.n127 0.7055
R281 B10.n129 B10.n128 0.7055
R282 B10.n130 B10.n129 0.7055
R283 B10.n131 B10.n130 0.7055
R284 B10.n134 B10.n133 0.7055
R285 B10.n135 B10.n134 0.7055
R286 B10.n136 B10.n135 0.7055
R287 B10.n137 B10.n136 0.7055
R288 B10.n138 B10.n137 0.7055
R289 B10.n139 B10.n138 0.7055
R290 B10.n140 B10.n139 0.7055
R291 B10.n141 B10.n140 0.7055
R292 B10.n142 B10.n141 0.7055
R293 B10.n143 B10.n142 0.7055
R294 B10.n144 B10.n143 0.7055
R295 B10.n145 B10.n144 0.7055
R296 B10.n146 B10.n145 0.7055
R297 B10.n147 B10.n146 0.7055
R298 B10.n148 B10.n147 0.7055
R299 B10.n149 B10.n148 0.7055
R300 B10.n150 B10.n149 0.7055
R301 B10.n151 B10.n150 0.7055
R302 B10.n152 B10.n151 0.7055
R303 B10.n153 B10.n152 0.7055
R304 B10.n154 B10.n153 0.7055
R305 B10.n155 B10.n154 0.7055
R306 B10.n156 B10.n155 0.7055
R307 B10.n157 B10.n156 0.7055
R308 B10.n158 B10.n157 0.7055
R309 B10.n159 B10.n158 0.7055
R310 B10.n160 B10.n159 0.7055
R311 B10.n161 B10.n160 0.7055
R312 B10.n162 B10.n161 0.7055
R313 B10.n163 B10.n162 0.7055
R314 B10.n164 B10.n163 0.7055
R315 B10.n165 B10.n164 0.7055
R316 B10.n166 B10.n165 0.7055
R317 B10.n167 B10.n166 0.7055
R318 B10.n168 B10.n167 0.7055
R319 B10.n169 B10.n168 0.7055
R320 B10.n170 B10.n169 0.7055
R321 B10.n171 B10.n170 0.7055
R322 B10.n172 B10.n171 0.7055
R323 B10.n173 B10.n172 0.7055
R324 B10.n174 B10.n173 0.7055
R325 B10.n175 B10.n174 0.7055
R326 B10.n176 B10.n175 0.7055
R327 B10.n177 B10.n176 0.7055
R328 B10.n178 B10.n177 0.7055
R329 B10.n179 B10.n178 0.7055
R330 B10.n180 B10.n179 0.7055
R331 B10.n181 B10.n180 0.7055
R332 B10.n182 B10.n181 0.7055
R333 B10.n183 B10.n182 0.7055
R334 B10.n184 B10.n183 0.7055
R335 B10.n185 B10.n184 0.7055
R336 B10.n186 B10.n185 0.7055
R337 B10.n187 B10.n186 0.7055
R338 B10.n188 B10.n187 0.7055
R339 B10.n189 B10.n188 0.7055
R340 B10.n190 B10.n189 0.7055
R341 B10.n191 B10.n190 0.7055
R342 B10.n192 B10.n191 0.7055
R343 B10.n193 B10.n192 0.7055
R344 B10.n194 B10.n193 0.7055
R345 B10.n197 B10.n196 0.7055
R346 B10.n198 B10.n197 0.7055
R347 B10.n199 B10.n198 0.7055
R348 B10.n200 B10.n199 0.7055
R349 B10.n201 B10.n200 0.7055
R350 B10.n202 B10.n201 0.7055
R351 B10.n203 B10.n202 0.7055
R352 B10.n204 B10.n203 0.7055
R353 B10.n205 B10.n204 0.7055
R354 B10.n206 B10.n205 0.7055
R355 B10.n207 B10.n206 0.7055
R356 B10.n208 B10.n207 0.7055
R357 B10.n209 B10.n208 0.7055
R358 B10.n210 B10.n209 0.7055
R359 B10.n211 B10.n210 0.7055
R360 B10.n212 B10.n211 0.7055
R361 B10.n213 B10.n212 0.7055
R362 B10.n214 B10.n213 0.7055
R363 B10.n215 B10.n214 0.7055
R364 B10.n216 B10.n215 0.7055
R365 B10.n217 B10.n216 0.7055
R366 B10.n218 B10.n217 0.7055
R367 B10.n219 B10.n218 0.7055
R368 B10.n220 B10.n219 0.7055
R369 B10.n221 B10.n220 0.7055
R370 B10.n222 B10.n221 0.7055
R371 B10.n223 B10.n222 0.7055
R372 B10.n224 B10.n223 0.7055
R373 B10.n225 B10.n224 0.7055
R374 B10.n226 B10.n225 0.7055
R375 B10.n227 B10.n226 0.7055
R376 B10.n228 B10.n227 0.7055
R377 B10.n229 B10.n228 0.7055
R378 B10.n230 B10.n229 0.7055
R379 B10.n231 B10.n230 0.7055
R380 B10.n232 B10.n231 0.7055
R381 B10.n233 B10.n232 0.7055
R382 B10.n234 B10.n233 0.7055
R383 B10.n235 B10.n234 0.7055
R384 B10.n236 B10.n235 0.7055
R385 B10.n237 B10.n236 0.7055
R386 B10.n238 B10.n237 0.7055
R387 B10.n239 B10.n238 0.7055
R388 B10.n240 B10.n239 0.7055
R389 B10.n241 B10.n240 0.7055
R390 B10.n242 B10.n241 0.7055
R391 B10.n243 B10.n242 0.7055
R392 B10.n244 B10.n243 0.7055
R393 B10.n245 B10.n244 0.7055
R394 B10.n246 B10.n245 0.7055
R395 B10.n247 B10.n246 0.7055
R396 B10.n248 B10.n247 0.7055
R397 B10.n249 B10.n248 0.7055
R398 B10.n250 B10.n249 0.7055
R399 B10.n251 B10.n250 0.7055
R400 B10.n252 B10.n251 0.7055
R401 B10.n253 B10.n252 0.7055
R402 B10.n254 B10.n253 0.7055
R403 B10.n255 B10.n254 0.7055
R404 B10.n256 B10.n255 0.7055
R405 B10.n257 B10.n256 0.7055
R406 B10.n260 B10.n259 0.7055
R407 B10.n261 B10.n260 0.7055
R408 B10.n262 B10.n261 0.7055
R409 B10.n263 B10.n262 0.7055
R410 B10.n264 B10.n263 0.7055
R411 B10.n265 B10.n264 0.7055
R412 B10.n266 B10.n265 0.7055
R413 B10.n267 B10.n266 0.7055
R414 B10.n268 B10.n267 0.7055
R415 B10.n269 B10.n268 0.7055
R416 B10.n270 B10.n269 0.7055
R417 B10.n271 B10.n270 0.7055
R418 B10.n272 B10.n271 0.7055
R419 B10.n273 B10.n272 0.7055
R420 B10.n274 B10.n273 0.7055
R421 B10.n275 B10.n274 0.7055
R422 B10.n276 B10.n275 0.7055
R423 B10.n277 B10.n276 0.7055
R424 B10.n278 B10.n277 0.7055
R425 B10.n279 B10.n278 0.7055
R426 B10.n280 B10.n279 0.7055
R427 B10.n281 B10.n280 0.7055
R428 B10.n282 B10.n281 0.7055
R429 B10.n283 B10.n282 0.7055
R430 B10.n284 B10.n283 0.7055
R431 B10.n285 B10.n284 0.7055
R432 B10.n286 B10.n285 0.7055
R433 B10.n287 B10.n286 0.7055
R434 B10.n288 B10.n287 0.7055
R435 B10.n289 B10.n288 0.7055
R436 B10.n290 B10.n289 0.7055
R437 B10.n291 B10.n290 0.7055
R438 B10.n292 B10.n291 0.7055
R439 B10.n293 B10.n292 0.7055
R440 B10.n294 B10.n293 0.7055
R441 B10.n295 B10.n294 0.7055
R442 B10.n296 B10.n295 0.7055
R443 B10.n297 B10.n296 0.7055
R444 B10.n298 B10.n297 0.7055
R445 B10.n299 B10.n298 0.7055
R446 B10.n300 B10.n299 0.7055
R447 B10.n301 B10.n300 0.7055
R448 B10.n302 B10.n301 0.7055
R449 B10.n303 B10.n302 0.7055
R450 B10.n304 B10.n303 0.7055
R451 B10.n305 B10.n304 0.7055
R452 B10.n306 B10.n305 0.7055
R453 B10.n307 B10.n306 0.7055
R454 B10.n308 B10.n307 0.7055
R455 B10.n309 B10.n308 0.7055
R456 B10.n310 B10.n309 0.7055
R457 B10.n311 B10.n310 0.7055
R458 B10.n312 B10.n311 0.7055
R459 B10.n313 B10.n312 0.7055
R460 B10.n314 B10.n313 0.7055
R461 B10.n315 B10.n314 0.7055
R462 B10.n316 B10.n315 0.7055
R463 B10.n317 B10.n316 0.7055
R464 B10.n318 B10.n317 0.7055
R465 B10.n319 B10.n318 0.7055
R466 B10.n320 B10.n319 0.7055
R467 B10.n323 B10.n322 0.7055
R468 B10.n324 B10.n323 0.7055
R469 B10.n325 B10.n324 0.7055
R470 B10.n326 B10.n325 0.7055
R471 B10.n327 B10.n326 0.7055
R472 B10.n328 B10.n327 0.7055
R473 B10.n329 B10.n328 0.7055
R474 B10.n330 B10.n329 0.7055
R475 B10.n331 B10.n330 0.7055
R476 B10.n332 B10.n331 0.7055
R477 B10.n333 B10.n332 0.7055
R478 B10.n334 B10.n333 0.7055
R479 B10.n335 B10.n334 0.7055
R480 B10.n336 B10.n335 0.7055
R481 B10.n337 B10.n336 0.7055
R482 B10.n338 B10.n337 0.7055
R483 B10.n339 B10.n338 0.7055
R484 B10.n340 B10.n339 0.7055
R485 B10.n341 B10.n340 0.7055
R486 B10.n342 B10.n341 0.7055
R487 B10.n343 B10.n342 0.7055
R488 B10.n344 B10.n343 0.7055
R489 B10.n345 B10.n344 0.7055
R490 B10.n346 B10.n345 0.7055
R491 B10.n347 B10.n346 0.7055
R492 B10.n348 B10.n347 0.7055
R493 B10.n349 B10.n348 0.7055
R494 B10.n350 B10.n349 0.7055
R495 B10.n351 B10.n350 0.7055
R496 B10.n352 B10.n351 0.7055
R497 B10.n353 B10.n352 0.7055
R498 B10.n354 B10.n353 0.7055
R499 B10.n355 B10.n354 0.7055
R500 B10.n356 B10.n355 0.7055
R501 B10.n357 B10.n356 0.7055
R502 B10.n358 B10.n357 0.7055
R503 B10.n359 B10.n358 0.7055
R504 B10.n360 B10.n359 0.7055
R505 B10.n361 B10.n360 0.7055
R506 B10.n362 B10.n361 0.7055
R507 B10.n363 B10.n362 0.7055
R508 B10.n364 B10.n363 0.7055
R509 B10.n365 B10.n364 0.7055
R510 B10.n366 B10.n365 0.7055
R511 B10.n367 B10.n366 0.7055
R512 B10.n368 B10.n367 0.7055
R513 B10.n369 B10.n368 0.7055
R514 B10.n370 B10.n369 0.7055
R515 B10.n371 B10.n370 0.7055
R516 B10.n372 B10.n371 0.7055
R517 B10.n373 B10.n372 0.7055
R518 B10.n374 B10.n373 0.7055
R519 B10.n375 B10.n374 0.7055
R520 B10.n376 B10.n375 0.7055
R521 B10.n377 B10.n376 0.7055
R522 B10.n378 B10.n377 0.7055
R523 B10.n379 B10.n378 0.7055
R524 B10.n380 B10.n379 0.7055
R525 B10.n381 B10.n380 0.7055
R526 B10.n382 B10.n381 0.7055
R527 B10.n383 B10.n382 0.7055
R528 B10.n386 B10.n385 0.7055
R529 B10.n387 B10.n386 0.7055
R530 B10.n388 B10.n387 0.7055
R531 B10.n389 B10.n388 0.7055
R532 B10.n390 B10.n389 0.7055
R533 B10.n391 B10.n390 0.7055
R534 B10.n392 B10.n391 0.7055
R535 B10.n393 B10.n392 0.7055
R536 B10.n394 B10.n393 0.7055
R537 B10.n395 B10.n394 0.7055
R538 B10.n396 B10.n395 0.7055
R539 B10.n397 B10.n396 0.7055
R540 B10.n398 B10.n397 0.7055
R541 B10.n399 B10.n398 0.7055
R542 B10.n400 B10.n399 0.7055
R543 B10.n401 B10.n400 0.7055
R544 B10.n402 B10.n401 0.7055
R545 B10.n403 B10.n402 0.7055
R546 B10.n404 B10.n403 0.7055
R547 B10.n405 B10.n404 0.7055
R548 B10.n406 B10.n405 0.7055
R549 B10.n407 B10.n406 0.7055
R550 B10.n408 B10.n407 0.7055
R551 B10.n409 B10.n408 0.7055
R552 B10.n410 B10.n409 0.7055
R553 B10.n411 B10.n410 0.7055
R554 B10.n412 B10.n411 0.7055
R555 B10.n413 B10.n412 0.7055
R556 B10.n414 B10.n413 0.7055
R557 B10.n415 B10.n414 0.7055
R558 B10.n416 B10.n415 0.7055
R559 B10.n417 B10.n416 0.7055
R560 B10.n418 B10.n417 0.7055
R561 B10.n419 B10.n418 0.7055
R562 B10.n420 B10.n419 0.7055
R563 B10.n421 B10.n420 0.7055
R564 B10.n422 B10.n421 0.7055
R565 B10.n423 B10.n422 0.7055
R566 B10.n424 B10.n423 0.7055
R567 B10.n425 B10.n424 0.7055
R568 B10.n426 B10.n425 0.7055
R569 B10.n427 B10.n426 0.7055
R570 B10.n428 B10.n427 0.7055
R571 B10.n429 B10.n428 0.7055
R572 B10.n430 B10.n429 0.7055
R573 B10.n431 B10.n430 0.7055
R574 B10.n432 B10.n431 0.7055
R575 B10.n433 B10.n432 0.7055
R576 B10.n434 B10.n433 0.7055
R577 B10.n435 B10.n434 0.7055
R578 B10.n436 B10.n435 0.7055
R579 B10.n437 B10.n436 0.7055
R580 B10.n438 B10.n437 0.7055
R581 B10.n439 B10.n438 0.7055
R582 B10.n440 B10.n439 0.7055
R583 B10.n441 B10.n440 0.7055
R584 B10.n442 B10.n441 0.7055
R585 B10.n443 B10.n442 0.7055
R586 B10.n444 B10.n443 0.7055
R587 B10.n445 B10.n444 0.7055
R588 B10.n446 B10.n445 0.7055
R589 B10.n449 B10.n448 0.7055
R590 B10.n450 B10.n449 0.7055
R591 B10.n451 B10.n450 0.7055
R592 B10.n452 B10.n451 0.7055
R593 B10.n453 B10.n452 0.7055
R594 B10.n454 B10.n453 0.7055
R595 B10.n455 B10.n454 0.7055
R596 B10.n456 B10.n455 0.7055
R597 B10.n457 B10.n456 0.7055
R598 B10.n458 B10.n457 0.7055
R599 B10.n459 B10.n458 0.7055
R600 B10.n460 B10.n459 0.7055
R601 B10.n461 B10.n460 0.7055
R602 B10.n462 B10.n461 0.7055
R603 B10.n463 B10.n462 0.7055
R604 B10.n464 B10.n463 0.7055
R605 B10.n465 B10.n464 0.7055
R606 B10.n466 B10.n465 0.7055
R607 B10.n467 B10.n466 0.7055
R608 B10.n468 B10.n467 0.7055
R609 B10.n469 B10.n468 0.7055
R610 B10.n470 B10.n469 0.7055
R611 B10.n471 B10.n470 0.7055
R612 B10.n472 B10.n471 0.7055
R613 B10.n473 B10.n472 0.7055
R614 B10.n474 B10.n473 0.7055
R615 B10.n475 B10.n474 0.7055
R616 B10.n476 B10.n475 0.7055
R617 B10.n477 B10.n476 0.7055
R618 B10.n478 B10.n477 0.7055
R619 B10.n479 B10.n478 0.7055
R620 B10.n480 B10.n479 0.7055
R621 B10.n481 B10.n480 0.7055
R622 B10.n482 B10.n481 0.7055
R623 B10.n483 B10.n482 0.7055
R624 B10.n484 B10.n483 0.7055
R625 B10.n485 B10.n484 0.7055
R626 B10.n486 B10.n485 0.7055
R627 B10.n487 B10.n486 0.7055
R628 B10.n488 B10.n487 0.7055
R629 B10.n489 B10.n488 0.7055
R630 B10.n490 B10.n489 0.7055
R631 B10.n491 B10.n490 0.7055
R632 B10.n492 B10.n491 0.7055
R633 B10.n493 B10.n492 0.7055
R634 B10.n494 B10.n493 0.7055
R635 B10.n495 B10.n494 0.7055
R636 B10.n496 B10.n495 0.7055
R637 B10.n497 B10.n496 0.7055
R638 B10.n498 B10.n497 0.7055
R639 B10.n499 B10.n498 0.7055
R640 B10.n500 B10.n499 0.7055
R641 B10.n501 B10.n500 0.7055
R642 B10.n502 B10.n501 0.7055
R643 B10.n503 B10.n502 0.7055
R644 B10.n504 B10.n503 0.7055
R645 B10.n505 B10.n504 0.7055
R646 B10.n506 B10.n505 0.7055
R647 B10.n507 B10.n506 0.7055
R648 B10.n508 B10.n507 0.7055
R649 B10.n509 B10.n508 0.7055
R650 B10.n572 B10.n571 0.7055
R651 B10.n571 B10.n570 0.7055
R652 B10.n570 B10.n569 0.7055
R653 B10.n569 B10.n568 0.7055
R654 B10.n568 B10.n567 0.7055
R655 B10.n567 B10.n566 0.7055
R656 B10.n566 B10.n565 0.7055
R657 B10.n565 B10.n564 0.7055
R658 B10.n564 B10.n563 0.7055
R659 B10.n563 B10.n562 0.7055
R660 B10.n562 B10.n561 0.7055
R661 B10.n561 B10.n560 0.7055
R662 B10.n560 B10.n559 0.7055
R663 B10.n559 B10.n558 0.7055
R664 B10.n558 B10.n557 0.7055
R665 B10.n557 B10.n556 0.7055
R666 B10.n556 B10.n555 0.7055
R667 B10.n555 B10.n554 0.7055
R668 B10.n554 B10.n553 0.7055
R669 B10.n553 B10.n552 0.7055
R670 B10.n552 B10.n551 0.7055
R671 B10.n551 B10.n550 0.7055
R672 B10.n550 B10.n549 0.7055
R673 B10.n549 B10.n548 0.7055
R674 B10.n548 B10.n547 0.7055
R675 B10.n547 B10.n546 0.7055
R676 B10.n546 B10.n545 0.7055
R677 B10.n545 B10.n544 0.7055
R678 B10.n544 B10.n543 0.7055
R679 B10.n543 B10.n542 0.7055
R680 B10.n542 B10.n541 0.7055
R681 B10.n541 B10.n540 0.7055
R682 B10.n540 B10.n539 0.7055
R683 B10.n539 B10.n538 0.7055
R684 B10.n538 B10.n537 0.7055
R685 B10.n537 B10.n536 0.7055
R686 B10.n536 B10.n535 0.7055
R687 B10.n535 B10.n534 0.7055
R688 B10.n534 B10.n533 0.7055
R689 B10.n533 B10.n532 0.7055
R690 B10.n532 B10.n531 0.7055
R691 B10.n531 B10.n530 0.7055
R692 B10.n530 B10.n529 0.7055
R693 B10.n529 B10.n528 0.7055
R694 B10.n528 B10.n527 0.7055
R695 B10.n527 B10.n526 0.7055
R696 B10.n526 B10.n525 0.7055
R697 B10.n525 B10.n524 0.7055
R698 B10.n524 B10.n523 0.7055
R699 B10.n523 B10.n522 0.7055
R700 B10.n522 B10.n521 0.7055
R701 B10.n521 B10.n520 0.7055
R702 B10.n520 B10.n519 0.7055
R703 B10.n519 B10.n518 0.7055
R704 B10.n518 B10.n517 0.7055
R705 B10.n517 B10.n516 0.7055
R706 B10.n516 B10.n515 0.7055
R707 B10.n515 B10.n514 0.7055
R708 B10.n514 B10.n513 0.7055
R709 B10.n513 B10.n512 0.7055
R710 B10.n512 B10.n511 0.7055
R711 B10.n634 B10.n633 0.7055
R712 B10.n633 B10.n632 0.7055
R713 B10.n632 B10.n631 0.7055
R714 B10.n631 B10.n630 0.7055
R715 B10.n630 B10.n629 0.7055
R716 B10.n629 B10.n628 0.7055
R717 B10.n628 B10.n627 0.7055
R718 B10.n627 B10.n626 0.7055
R719 B10.n626 B10.n625 0.7055
R720 B10.n625 B10.n624 0.7055
R721 B10.n624 B10.n623 0.7055
R722 B10.n623 B10.n622 0.7055
R723 B10.n622 B10.n621 0.7055
R724 B10.n621 B10.n620 0.7055
R725 B10.n620 B10.n619 0.7055
R726 B10.n619 B10.n618 0.7055
R727 B10.n618 B10.n617 0.7055
R728 B10.n617 B10.n616 0.7055
R729 B10.n616 B10.n615 0.7055
R730 B10.n615 B10.n614 0.7055
R731 B10.n614 B10.n613 0.7055
R732 B10.n613 B10.n612 0.7055
R733 B10.n612 B10.n611 0.7055
R734 B10.n611 B10.n610 0.7055
R735 B10.n610 B10.n609 0.7055
R736 B10.n609 B10.n608 0.7055
R737 B10.n608 B10.n607 0.7055
R738 B10.n607 B10.n606 0.7055
R739 B10.n606 B10.n605 0.7055
R740 B10.n605 B10.n604 0.7055
R741 B10.n604 B10.n603 0.7055
R742 B10.n603 B10.n602 0.7055
R743 B10.n602 B10.n601 0.7055
R744 B10.n601 B10.n600 0.7055
R745 B10.n600 B10.n599 0.7055
R746 B10.n599 B10.n598 0.7055
R747 B10.n598 B10.n597 0.7055
R748 B10.n597 B10.n596 0.7055
R749 B10.n596 B10.n595 0.7055
R750 B10.n595 B10.n594 0.7055
R751 B10.n594 B10.n593 0.7055
R752 B10.n593 B10.n592 0.7055
R753 B10.n592 B10.n591 0.7055
R754 B10.n591 B10.n590 0.7055
R755 B10.n590 B10.n589 0.7055
R756 B10.n589 B10.n588 0.7055
R757 B10.n588 B10.n587 0.7055
R758 B10.n587 B10.n586 0.7055
R759 B10.n586 B10.n585 0.7055
R760 B10.n585 B10.n584 0.7055
R761 B10.n584 B10.n583 0.7055
R762 B10.n583 B10.n582 0.7055
R763 B10.n582 B10.n581 0.7055
R764 B10.n581 B10.n580 0.7055
R765 B10.n580 B10.n579 0.7055
R766 B10.n579 B10.n578 0.7055
R767 B10.n578 B10.n577 0.7055
R768 B10.n577 B10.n576 0.7055
R769 B10.n576 B10.n575 0.7055
R770 B10.n575 B10.n574 0.7055
R771 B10.n574 B10.n573 0.7055
R772 B10.n697 B10.n696 0.7055
R773 B10.n696 B10.n695 0.7055
R774 B10.n695 B10.n694 0.7055
R775 B10.n694 B10.n693 0.7055
R776 B10.n693 B10.n692 0.7055
R777 B10.n692 B10.n691 0.7055
R778 B10.n691 B10.n690 0.7055
R779 B10.n690 B10.n689 0.7055
R780 B10.n689 B10.n688 0.7055
R781 B10.n688 B10.n687 0.7055
R782 B10.n687 B10.n686 0.7055
R783 B10.n686 B10.n685 0.7055
R784 B10.n685 B10.n684 0.7055
R785 B10.n684 B10.n683 0.7055
R786 B10.n683 B10.n682 0.7055
R787 B10.n682 B10.n681 0.7055
R788 B10.n681 B10.n680 0.7055
R789 B10.n680 B10.n679 0.7055
R790 B10.n679 B10.n678 0.7055
R791 B10.n678 B10.n677 0.7055
R792 B10.n677 B10.n676 0.7055
R793 B10.n676 B10.n675 0.7055
R794 B10.n675 B10.n674 0.7055
R795 B10.n674 B10.n673 0.7055
R796 B10.n673 B10.n672 0.7055
R797 B10.n672 B10.n671 0.7055
R798 B10.n671 B10.n670 0.7055
R799 B10.n670 B10.n669 0.7055
R800 B10.n669 B10.n668 0.7055
R801 B10.n668 B10.n667 0.7055
R802 B10.n667 B10.n666 0.7055
R803 B10.n666 B10.n665 0.7055
R804 B10.n665 B10.n664 0.7055
R805 B10.n664 B10.n663 0.7055
R806 B10.n663 B10.n662 0.7055
R807 B10.n662 B10.n661 0.7055
R808 B10.n661 B10.n660 0.7055
R809 B10.n660 B10.n659 0.7055
R810 B10.n659 B10.n658 0.7055
R811 B10.n658 B10.n657 0.7055
R812 B10.n657 B10.n656 0.7055
R813 B10.n656 B10.n655 0.7055
R814 B10.n655 B10.n654 0.7055
R815 B10.n654 B10.n653 0.7055
R816 B10.n653 B10.n652 0.7055
R817 B10.n652 B10.n651 0.7055
R818 B10.n651 B10.n650 0.7055
R819 B10.n650 B10.n649 0.7055
R820 B10.n649 B10.n648 0.7055
R821 B10.n648 B10.n647 0.7055
R822 B10.n647 B10.n646 0.7055
R823 B10.n646 B10.n645 0.7055
R824 B10.n645 B10.n644 0.7055
R825 B10.n644 B10.n643 0.7055
R826 B10.n643 B10.n642 0.7055
R827 B10.n642 B10.n641 0.7055
R828 B10.n641 B10.n640 0.7055
R829 B10.n640 B10.n639 0.7055
R830 B10.n639 B10.n638 0.7055
R831 B10.n638 B10.n637 0.7055
R832 B10.n637 B10.n636 0.7055
R833 B10.n760 B10.n759 0.7055
R834 B10.n759 B10.n758 0.7055
R835 B10.n758 B10.n757 0.7055
R836 B10.n757 B10.n756 0.7055
R837 B10.n756 B10.n755 0.7055
R838 B10.n755 B10.n754 0.7055
R839 B10.n754 B10.n753 0.7055
R840 B10.n753 B10.n752 0.7055
R841 B10.n752 B10.n751 0.7055
R842 B10.n751 B10.n750 0.7055
R843 B10.n750 B10.n749 0.7055
R844 B10.n749 B10.n748 0.7055
R845 B10.n748 B10.n747 0.7055
R846 B10.n747 B10.n746 0.7055
R847 B10.n746 B10.n745 0.7055
R848 B10.n745 B10.n744 0.7055
R849 B10.n744 B10.n743 0.7055
R850 B10.n743 B10.n742 0.7055
R851 B10.n742 B10.n741 0.7055
R852 B10.n741 B10.n740 0.7055
R853 B10.n740 B10.n739 0.7055
R854 B10.n739 B10.n738 0.7055
R855 B10.n738 B10.n737 0.7055
R856 B10.n737 B10.n736 0.7055
R857 B10.n736 B10.n735 0.7055
R858 B10.n735 B10.n734 0.7055
R859 B10.n734 B10.n733 0.7055
R860 B10.n733 B10.n732 0.7055
R861 B10.n732 B10.n731 0.7055
R862 B10.n731 B10.n730 0.7055
R863 B10.n730 B10.n729 0.7055
R864 B10.n729 B10.n728 0.7055
R865 B10.n728 B10.n727 0.7055
R866 B10.n727 B10.n726 0.7055
R867 B10.n726 B10.n725 0.7055
R868 B10.n725 B10.n724 0.7055
R869 B10.n724 B10.n723 0.7055
R870 B10.n723 B10.n722 0.7055
R871 B10.n722 B10.n721 0.7055
R872 B10.n721 B10.n720 0.7055
R873 B10.n720 B10.n719 0.7055
R874 B10.n719 B10.n718 0.7055
R875 B10.n718 B10.n717 0.7055
R876 B10.n717 B10.n716 0.7055
R877 B10.n716 B10.n715 0.7055
R878 B10.n715 B10.n714 0.7055
R879 B10.n714 B10.n713 0.7055
R880 B10.n713 B10.n712 0.7055
R881 B10.n712 B10.n711 0.7055
R882 B10.n711 B10.n710 0.7055
R883 B10.n710 B10.n709 0.7055
R884 B10.n709 B10.n708 0.7055
R885 B10.n708 B10.n707 0.7055
R886 B10.n707 B10.n706 0.7055
R887 B10.n706 B10.n705 0.7055
R888 B10.n705 B10.n704 0.7055
R889 B10.n704 B10.n703 0.7055
R890 B10.n703 B10.n702 0.7055
R891 B10.n702 B10.n701 0.7055
R892 B10.n701 B10.n700 0.7055
R893 B10.n700 B10.n699 0.7055
R894 B10.n823 B10.n822 0.7055
R895 B10.n822 B10.n821 0.7055
R896 B10.n821 B10.n820 0.7055
R897 B10.n820 B10.n819 0.7055
R898 B10.n819 B10.n818 0.7055
R899 B10.n818 B10.n817 0.7055
R900 B10.n817 B10.n816 0.7055
R901 B10.n816 B10.n815 0.7055
R902 B10.n815 B10.n814 0.7055
R903 B10.n814 B10.n813 0.7055
R904 B10.n813 B10.n812 0.7055
R905 B10.n812 B10.n811 0.7055
R906 B10.n811 B10.n810 0.7055
R907 B10.n810 B10.n809 0.7055
R908 B10.n809 B10.n808 0.7055
R909 B10.n808 B10.n807 0.7055
R910 B10.n807 B10.n806 0.7055
R911 B10.n806 B10.n805 0.7055
R912 B10.n805 B10.n804 0.7055
R913 B10.n804 B10.n803 0.7055
R914 B10.n803 B10.n802 0.7055
R915 B10.n802 B10.n801 0.7055
R916 B10.n801 B10.n800 0.7055
R917 B10.n800 B10.n799 0.7055
R918 B10.n799 B10.n798 0.7055
R919 B10.n798 B10.n797 0.7055
R920 B10.n797 B10.n796 0.7055
R921 B10.n796 B10.n795 0.7055
R922 B10.n795 B10.n794 0.7055
R923 B10.n794 B10.n793 0.7055
R924 B10.n793 B10.n792 0.7055
R925 B10.n792 B10.n791 0.7055
R926 B10.n791 B10.n790 0.7055
R927 B10.n790 B10.n789 0.7055
R928 B10.n789 B10.n788 0.7055
R929 B10.n788 B10.n787 0.7055
R930 B10.n787 B10.n786 0.7055
R931 B10.n786 B10.n785 0.7055
R932 B10.n785 B10.n784 0.7055
R933 B10.n784 B10.n783 0.7055
R934 B10.n783 B10.n782 0.7055
R935 B10.n782 B10.n781 0.7055
R936 B10.n781 B10.n780 0.7055
R937 B10.n780 B10.n779 0.7055
R938 B10.n779 B10.n778 0.7055
R939 B10.n778 B10.n777 0.7055
R940 B10.n777 B10.n776 0.7055
R941 B10.n776 B10.n775 0.7055
R942 B10.n775 B10.n774 0.7055
R943 B10.n774 B10.n773 0.7055
R944 B10.n773 B10.n772 0.7055
R945 B10.n772 B10.n771 0.7055
R946 B10.n771 B10.n770 0.7055
R947 B10.n770 B10.n769 0.7055
R948 B10.n769 B10.n768 0.7055
R949 B10.n768 B10.n767 0.7055
R950 B10.n767 B10.n766 0.7055
R951 B10.n766 B10.n765 0.7055
R952 B10.n765 B10.n764 0.7055
R953 B10.n764 B10.n763 0.7055
R954 B10.n763 B10.n762 0.7055
R955 B10.n886 B10.n885 0.7055
R956 B10.n885 B10.n884 0.7055
R957 B10.n884 B10.n883 0.7055
R958 B10.n883 B10.n882 0.7055
R959 B10.n882 B10.n881 0.7055
R960 B10.n881 B10.n880 0.7055
R961 B10.n880 B10.n879 0.7055
R962 B10.n879 B10.n878 0.7055
R963 B10.n878 B10.n877 0.7055
R964 B10.n877 B10.n876 0.7055
R965 B10.n876 B10.n875 0.7055
R966 B10.n875 B10.n874 0.7055
R967 B10.n874 B10.n873 0.7055
R968 B10.n873 B10.n872 0.7055
R969 B10.n872 B10.n871 0.7055
R970 B10.n871 B10.n870 0.7055
R971 B10.n870 B10.n869 0.7055
R972 B10.n869 B10.n868 0.7055
R973 B10.n868 B10.n867 0.7055
R974 B10.n867 B10.n866 0.7055
R975 B10.n866 B10.n865 0.7055
R976 B10.n865 B10.n864 0.7055
R977 B10.n864 B10.n863 0.7055
R978 B10.n863 B10.n862 0.7055
R979 B10.n862 B10.n861 0.7055
R980 B10.n861 B10.n860 0.7055
R981 B10.n860 B10.n859 0.7055
R982 B10.n859 B10.n858 0.7055
R983 B10.n858 B10.n857 0.7055
R984 B10.n857 B10.n856 0.7055
R985 B10.n856 B10.n855 0.7055
R986 B10.n855 B10.n854 0.7055
R987 B10.n854 B10.n853 0.7055
R988 B10.n853 B10.n852 0.7055
R989 B10.n852 B10.n851 0.7055
R990 B10.n851 B10.n850 0.7055
R991 B10.n850 B10.n849 0.7055
R992 B10.n849 B10.n848 0.7055
R993 B10.n848 B10.n847 0.7055
R994 B10.n847 B10.n846 0.7055
R995 B10.n846 B10.n845 0.7055
R996 B10.n845 B10.n844 0.7055
R997 B10.n844 B10.n843 0.7055
R998 B10.n843 B10.n842 0.7055
R999 B10.n842 B10.n841 0.7055
R1000 B10.n841 B10.n840 0.7055
R1001 B10.n840 B10.n839 0.7055
R1002 B10.n839 B10.n838 0.7055
R1003 B10.n838 B10.n837 0.7055
R1004 B10.n837 B10.n836 0.7055
R1005 B10.n836 B10.n835 0.7055
R1006 B10.n835 B10.n834 0.7055
R1007 B10.n834 B10.n833 0.7055
R1008 B10.n833 B10.n832 0.7055
R1009 B10.n832 B10.n831 0.7055
R1010 B10.n831 B10.n830 0.7055
R1011 B10.n830 B10.n829 0.7055
R1012 B10.n829 B10.n828 0.7055
R1013 B10.n828 B10.n827 0.7055
R1014 B10.n827 B10.n826 0.7055
R1015 B10.n826 B10.n825 0.7055
R1016 B10.n949 B10.n948 0.7055
R1017 B10.n948 B10.n947 0.7055
R1018 B10.n947 B10.n946 0.7055
R1019 B10.n946 B10.n945 0.7055
R1020 B10.n945 B10.n944 0.7055
R1021 B10.n944 B10.n943 0.7055
R1022 B10.n943 B10.n942 0.7055
R1023 B10.n942 B10.n941 0.7055
R1024 B10.n941 B10.n940 0.7055
R1025 B10.n940 B10.n939 0.7055
R1026 B10.n939 B10.n938 0.7055
R1027 B10.n938 B10.n937 0.7055
R1028 B10.n937 B10.n936 0.7055
R1029 B10.n936 B10.n935 0.7055
R1030 B10.n935 B10.n934 0.7055
R1031 B10.n934 B10.n933 0.7055
R1032 B10.n933 B10.n932 0.7055
R1033 B10.n932 B10.n931 0.7055
R1034 B10.n931 B10.n930 0.7055
R1035 B10.n930 B10.n929 0.7055
R1036 B10.n929 B10.n928 0.7055
R1037 B10.n928 B10.n927 0.7055
R1038 B10.n927 B10.n926 0.7055
R1039 B10.n926 B10.n925 0.7055
R1040 B10.n925 B10.n924 0.7055
R1041 B10.n924 B10.n923 0.7055
R1042 B10.n923 B10.n922 0.7055
R1043 B10.n922 B10.n921 0.7055
R1044 B10.n921 B10.n920 0.7055
R1045 B10.n920 B10.n919 0.7055
R1046 B10.n919 B10.n918 0.7055
R1047 B10.n918 B10.n917 0.7055
R1048 B10.n917 B10.n916 0.7055
R1049 B10.n916 B10.n915 0.7055
R1050 B10.n915 B10.n914 0.7055
R1051 B10.n914 B10.n913 0.7055
R1052 B10.n913 B10.n912 0.7055
R1053 B10.n912 B10.n911 0.7055
R1054 B10.n911 B10.n910 0.7055
R1055 B10.n910 B10.n909 0.7055
R1056 B10.n909 B10.n908 0.7055
R1057 B10.n908 B10.n907 0.7055
R1058 B10.n907 B10.n906 0.7055
R1059 B10.n906 B10.n905 0.7055
R1060 B10.n905 B10.n904 0.7055
R1061 B10.n904 B10.n903 0.7055
R1062 B10.n903 B10.n902 0.7055
R1063 B10.n902 B10.n901 0.7055
R1064 B10.n901 B10.n900 0.7055
R1065 B10.n900 B10.n899 0.7055
R1066 B10.n899 B10.n898 0.7055
R1067 B10.n898 B10.n897 0.7055
R1068 B10.n897 B10.n896 0.7055
R1069 B10.n896 B10.n895 0.7055
R1070 B10.n895 B10.n894 0.7055
R1071 B10.n894 B10.n893 0.7055
R1072 B10.n893 B10.n892 0.7055
R1073 B10.n892 B10.n891 0.7055
R1074 B10.n891 B10.n890 0.7055
R1075 B10.n890 B10.n889 0.7055
R1076 B10.n889 B10.n888 0.7055
R1077 B10.n1012 B10.n1011 0.7055
R1078 B10.n1011 B10.n1010 0.7055
R1079 B10.n1010 B10.n1009 0.7055
R1080 B10.n1009 B10.n1008 0.7055
R1081 B10.n1008 B10.n1007 0.7055
R1082 B10.n1007 B10.n1006 0.7055
R1083 B10.n1006 B10.n1005 0.7055
R1084 B10.n1005 B10.n1004 0.7055
R1085 B10.n1004 B10.n1003 0.7055
R1086 B10.n1003 B10.n1002 0.7055
R1087 B10.n1002 B10.n1001 0.7055
R1088 B10.n1001 B10.n1000 0.7055
R1089 B10.n1000 B10.n999 0.7055
R1090 B10.n999 B10.n998 0.7055
R1091 B10.n998 B10.n997 0.7055
R1092 B10.n997 B10.n996 0.7055
R1093 B10.n996 B10.n995 0.7055
R1094 B10.n995 B10.n994 0.7055
R1095 B10.n994 B10.n993 0.7055
R1096 B10.n993 B10.n992 0.7055
R1097 B10.n992 B10.n991 0.7055
R1098 B10.n991 B10.n990 0.7055
R1099 B10.n990 B10.n989 0.7055
R1100 B10.n989 B10.n988 0.7055
R1101 B10.n988 B10.n987 0.7055
R1102 B10.n987 B10.n986 0.7055
R1103 B10.n986 B10.n985 0.7055
R1104 B10.n985 B10.n984 0.7055
R1105 B10.n984 B10.n983 0.7055
R1106 B10.n983 B10.n982 0.7055
R1107 B10.n982 B10.n981 0.7055
R1108 B10.n981 B10.n980 0.7055
R1109 B10.n980 B10.n979 0.7055
R1110 B10.n979 B10.n978 0.7055
R1111 B10.n978 B10.n977 0.7055
R1112 B10.n977 B10.n976 0.7055
R1113 B10.n976 B10.n975 0.7055
R1114 B10.n975 B10.n974 0.7055
R1115 B10.n974 B10.n973 0.7055
R1116 B10.n973 B10.n972 0.7055
R1117 B10.n972 B10.n971 0.7055
R1118 B10.n971 B10.n970 0.7055
R1119 B10.n970 B10.n969 0.7055
R1120 B10.n969 B10.n968 0.7055
R1121 B10.n968 B10.n967 0.7055
R1122 B10.n967 B10.n966 0.7055
R1123 B10.n966 B10.n965 0.7055
R1124 B10.n965 B10.n964 0.7055
R1125 B10.n964 B10.n963 0.7055
R1126 B10.n963 B10.n962 0.7055
R1127 B10.n962 B10.n961 0.7055
R1128 B10.n961 B10.n960 0.7055
R1129 B10.n960 B10.n959 0.7055
R1130 B10.n959 B10.n958 0.7055
R1131 B10.n958 B10.n957 0.7055
R1132 B10.n957 B10.n956 0.7055
R1133 B10.n956 B10.n955 0.7055
R1134 B10.n955 B10.n954 0.7055
R1135 B10.n954 B10.n953 0.7055
R1136 B10.n953 B10.n952 0.7055
R1137 B10.n952 B10.n951 0.7055
R1138 B10.n68 B10.t512 0.324663
R1139 B10.n67 B10.t513 0.324663
R1140 B10.n66 B10.t514 0.324663
R1141 B10.n65 B10.t515 0.324663
R1142 B10.n64 B10.t516 0.324663
R1143 B10.n63 B10.t517 0.324663
R1144 B10.n62 B10.t518 0.324663
R1145 B10.n61 B10.t519 0.324663
R1146 B10.n60 B10.t520 0.324663
R1147 B10.n59 B10.t521 0.324663
R1148 B10.n58 B10.t522 0.324663
R1149 B10.n57 B10.t523 0.324663
R1150 B10.n56 B10.t524 0.324663
R1151 B10.n55 B10.t525 0.324663
R1152 B10.n54 B10.t526 0.324663
R1153 B10.n53 B10.t527 0.324663
R1154 B10.n52 B10.t528 0.324663
R1155 B10.n51 B10.t529 0.324663
R1156 B10.n50 B10.t530 0.324663
R1157 B10.n49 B10.t531 0.324663
R1158 B10.n48 B10.t532 0.324663
R1159 B10.n47 B10.t533 0.324663
R1160 B10.n46 B10.t534 0.324663
R1161 B10.n45 B10.t535 0.324663
R1162 B10.n44 B10.t536 0.324663
R1163 B10.n43 B10.t537 0.324663
R1164 B10.n42 B10.t538 0.324663
R1165 B10.n41 B10.t539 0.324663
R1166 B10.n40 B10.t540 0.324663
R1167 B10.n39 B10.t541 0.324663
R1168 B10.n38 B10.t542 0.324663
R1169 B10.n37 B10.t543 0.324663
R1170 B10.n36 B10.t544 0.324663
R1171 B10.n35 B10.t545 0.324663
R1172 B10.n34 B10.t546 0.324663
R1173 B10.n33 B10.t547 0.324663
R1174 B10.n32 B10.t548 0.324663
R1175 B10.n31 B10.t549 0.324663
R1176 B10.n30 B10.t550 0.324663
R1177 B10.n29 B10.t551 0.324663
R1178 B10.n28 B10.t552 0.324663
R1179 B10.n27 B10.t553 0.324663
R1180 B10.n26 B10.t554 0.324663
R1181 B10.n25 B10.t555 0.324663
R1182 B10.n24 B10.t556 0.324663
R1183 B10.n23 B10.t557 0.324663
R1184 B10.n22 B10.t558 0.324663
R1185 B10.n21 B10.t559 0.324663
R1186 B10.n20 B10.t560 0.324663
R1187 B10.n19 B10.t561 0.324663
R1188 B10.n18 B10.t562 0.324663
R1189 B10.n17 B10.t563 0.324663
R1190 B10.n16 B10.t564 0.324663
R1191 B10.n15 B10.t565 0.324663
R1192 B10.n14 B10.t566 0.324663
R1193 B10.n13 B10.t567 0.324663
R1194 B10.n12 B10.t568 0.324663
R1195 B10.n11 B10.t569 0.324663
R1196 B10.n10 B10.t570 0.324663
R1197 B10.n9 B10.t571 0.324663
R1198 B10.n8 B10.t572 0.324663
R1199 B10.n7 B10.t573 0.324663
R1200 B10.n131 B10.t575 0.324663
R1201 B10.n130 B10.t576 0.324663
R1202 B10.n129 B10.t577 0.324663
R1203 B10.n128 B10.t578 0.324663
R1204 B10.n127 B10.t579 0.324663
R1205 B10.n126 B10.t580 0.324663
R1206 B10.n125 B10.t581 0.324663
R1207 B10.n124 B10.t582 0.324663
R1208 B10.n123 B10.t583 0.324663
R1209 B10.n122 B10.t584 0.324663
R1210 B10.n121 B10.t585 0.324663
R1211 B10.n120 B10.t586 0.324663
R1212 B10.n119 B10.t587 0.324663
R1213 B10.n118 B10.t588 0.324663
R1214 B10.n117 B10.t589 0.324663
R1215 B10.n116 B10.t590 0.324663
R1216 B10.n115 B10.t591 0.324663
R1217 B10.n114 B10.t592 0.324663
R1218 B10.n113 B10.t593 0.324663
R1219 B10.n112 B10.t594 0.324663
R1220 B10.n111 B10.t595 0.324663
R1221 B10.n110 B10.t596 0.324663
R1222 B10.n109 B10.t597 0.324663
R1223 B10.n108 B10.t598 0.324663
R1224 B10.n107 B10.t599 0.324663
R1225 B10.n106 B10.t600 0.324663
R1226 B10.n105 B10.t601 0.324663
R1227 B10.n104 B10.t602 0.324663
R1228 B10.n103 B10.t603 0.324663
R1229 B10.n102 B10.t604 0.324663
R1230 B10.n101 B10.t605 0.324663
R1231 B10.n100 B10.t606 0.324663
R1232 B10.n99 B10.t607 0.324663
R1233 B10.n98 B10.t608 0.324663
R1234 B10.n97 B10.t609 0.324663
R1235 B10.n96 B10.t610 0.324663
R1236 B10.n95 B10.t611 0.324663
R1237 B10.n94 B10.t612 0.324663
R1238 B10.n93 B10.t613 0.324663
R1239 B10.n92 B10.t614 0.324663
R1240 B10.n91 B10.t615 0.324663
R1241 B10.n90 B10.t616 0.324663
R1242 B10.n89 B10.t617 0.324663
R1243 B10.n88 B10.t618 0.324663
R1244 B10.n87 B10.t619 0.324663
R1245 B10.n86 B10.t620 0.324663
R1246 B10.n85 B10.t621 0.324663
R1247 B10.n84 B10.t622 0.324663
R1248 B10.n83 B10.t623 0.324663
R1249 B10.n82 B10.t624 0.324663
R1250 B10.n81 B10.t625 0.324663
R1251 B10.n80 B10.t626 0.324663
R1252 B10.n79 B10.t627 0.324663
R1253 B10.n78 B10.t628 0.324663
R1254 B10.n77 B10.t629 0.324663
R1255 B10.n76 B10.t630 0.324663
R1256 B10.n75 B10.t631 0.324663
R1257 B10.n74 B10.t632 0.324663
R1258 B10.n73 B10.t633 0.324663
R1259 B10.n72 B10.t634 0.324663
R1260 B10.n71 B10.t635 0.324663
R1261 B10.n70 B10.t636 0.324663
R1262 B10.n194 B10.t638 0.324663
R1263 B10.n193 B10.t639 0.324663
R1264 B10.n192 B10.t640 0.324663
R1265 B10.n191 B10.t641 0.324663
R1266 B10.n190 B10.t642 0.324663
R1267 B10.n189 B10.t643 0.324663
R1268 B10.n188 B10.t644 0.324663
R1269 B10.n187 B10.t645 0.324663
R1270 B10.n186 B10.t646 0.324663
R1271 B10.n185 B10.t647 0.324663
R1272 B10.n184 B10.t648 0.324663
R1273 B10.n183 B10.t649 0.324663
R1274 B10.n182 B10.t650 0.324663
R1275 B10.n181 B10.t651 0.324663
R1276 B10.n180 B10.t652 0.324663
R1277 B10.n179 B10.t653 0.324663
R1278 B10.n178 B10.t654 0.324663
R1279 B10.n177 B10.t655 0.324663
R1280 B10.n176 B10.t656 0.324663
R1281 B10.n175 B10.t657 0.324663
R1282 B10.n174 B10.t658 0.324663
R1283 B10.n173 B10.t659 0.324663
R1284 B10.n172 B10.t660 0.324663
R1285 B10.n171 B10.t661 0.324663
R1286 B10.n170 B10.t662 0.324663
R1287 B10.n169 B10.t663 0.324663
R1288 B10.n168 B10.t664 0.324663
R1289 B10.n167 B10.t665 0.324663
R1290 B10.n166 B10.t666 0.324663
R1291 B10.n165 B10.t667 0.324663
R1292 B10.n164 B10.t668 0.324663
R1293 B10.n163 B10.t669 0.324663
R1294 B10.n162 B10.t670 0.324663
R1295 B10.n161 B10.t671 0.324663
R1296 B10.n160 B10.t672 0.324663
R1297 B10.n159 B10.t673 0.324663
R1298 B10.n158 B10.t674 0.324663
R1299 B10.n157 B10.t675 0.324663
R1300 B10.n156 B10.t676 0.324663
R1301 B10.n155 B10.t677 0.324663
R1302 B10.n154 B10.t678 0.324663
R1303 B10.n153 B10.t679 0.324663
R1304 B10.n152 B10.t680 0.324663
R1305 B10.n151 B10.t681 0.324663
R1306 B10.n150 B10.t682 0.324663
R1307 B10.n149 B10.t683 0.324663
R1308 B10.n148 B10.t684 0.324663
R1309 B10.n147 B10.t685 0.324663
R1310 B10.n146 B10.t686 0.324663
R1311 B10.n145 B10.t687 0.324663
R1312 B10.n144 B10.t688 0.324663
R1313 B10.n143 B10.t689 0.324663
R1314 B10.n142 B10.t690 0.324663
R1315 B10.n141 B10.t691 0.324663
R1316 B10.n140 B10.t692 0.324663
R1317 B10.n139 B10.t693 0.324663
R1318 B10.n138 B10.t694 0.324663
R1319 B10.n137 B10.t695 0.324663
R1320 B10.n136 B10.t696 0.324663
R1321 B10.n135 B10.t697 0.324663
R1322 B10.n134 B10.t698 0.324663
R1323 B10.n133 B10.t699 0.324663
R1324 B10.n257 B10.t701 0.324663
R1325 B10.n256 B10.t702 0.324663
R1326 B10.n255 B10.t703 0.324663
R1327 B10.n254 B10.t704 0.324663
R1328 B10.n253 B10.t705 0.324663
R1329 B10.n252 B10.t706 0.324663
R1330 B10.n251 B10.t707 0.324663
R1331 B10.n250 B10.t708 0.324663
R1332 B10.n249 B10.t709 0.324663
R1333 B10.n248 B10.t710 0.324663
R1334 B10.n247 B10.t711 0.324663
R1335 B10.n246 B10.t712 0.324663
R1336 B10.n245 B10.t713 0.324663
R1337 B10.n244 B10.t714 0.324663
R1338 B10.n243 B10.t715 0.324663
R1339 B10.n242 B10.t716 0.324663
R1340 B10.n241 B10.t717 0.324663
R1341 B10.n240 B10.t718 0.324663
R1342 B10.n239 B10.t719 0.324663
R1343 B10.n238 B10.t720 0.324663
R1344 B10.n237 B10.t721 0.324663
R1345 B10.n236 B10.t722 0.324663
R1346 B10.n235 B10.t723 0.324663
R1347 B10.n234 B10.t724 0.324663
R1348 B10.n233 B10.t725 0.324663
R1349 B10.n232 B10.t726 0.324663
R1350 B10.n231 B10.t727 0.324663
R1351 B10.n230 B10.t728 0.324663
R1352 B10.n229 B10.t729 0.324663
R1353 B10.n228 B10.t730 0.324663
R1354 B10.n227 B10.t731 0.324663
R1355 B10.n226 B10.t732 0.324663
R1356 B10.n225 B10.t733 0.324663
R1357 B10.n224 B10.t734 0.324663
R1358 B10.n223 B10.t735 0.324663
R1359 B10.n222 B10.t736 0.324663
R1360 B10.n221 B10.t737 0.324663
R1361 B10.n220 B10.t738 0.324663
R1362 B10.n219 B10.t739 0.324663
R1363 B10.n218 B10.t740 0.324663
R1364 B10.n217 B10.t741 0.324663
R1365 B10.n216 B10.t742 0.324663
R1366 B10.n215 B10.t743 0.324663
R1367 B10.n214 B10.t744 0.324663
R1368 B10.n213 B10.t745 0.324663
R1369 B10.n212 B10.t746 0.324663
R1370 B10.n211 B10.t747 0.324663
R1371 B10.n210 B10.t748 0.324663
R1372 B10.n209 B10.t749 0.324663
R1373 B10.n208 B10.t750 0.324663
R1374 B10.n207 B10.t751 0.324663
R1375 B10.n206 B10.t752 0.324663
R1376 B10.n205 B10.t753 0.324663
R1377 B10.n204 B10.t754 0.324663
R1378 B10.n203 B10.t755 0.324663
R1379 B10.n202 B10.t756 0.324663
R1380 B10.n201 B10.t757 0.324663
R1381 B10.n200 B10.t758 0.324663
R1382 B10.n199 B10.t759 0.324663
R1383 B10.n198 B10.t760 0.324663
R1384 B10.n197 B10.t761 0.324663
R1385 B10.n196 B10.t762 0.324663
R1386 B10.n320 B10.t764 0.324663
R1387 B10.n319 B10.t765 0.324663
R1388 B10.n318 B10.t766 0.324663
R1389 B10.n317 B10.t767 0.324663
R1390 B10.n316 B10.t768 0.324663
R1391 B10.n315 B10.t769 0.324663
R1392 B10.n314 B10.t770 0.324663
R1393 B10.n313 B10.t771 0.324663
R1394 B10.n312 B10.t772 0.324663
R1395 B10.n311 B10.t773 0.324663
R1396 B10.n310 B10.t774 0.324663
R1397 B10.n309 B10.t775 0.324663
R1398 B10.n308 B10.t776 0.324663
R1399 B10.n307 B10.t777 0.324663
R1400 B10.n306 B10.t778 0.324663
R1401 B10.n305 B10.t779 0.324663
R1402 B10.n304 B10.t780 0.324663
R1403 B10.n303 B10.t781 0.324663
R1404 B10.n302 B10.t782 0.324663
R1405 B10.n301 B10.t783 0.324663
R1406 B10.n300 B10.t784 0.324663
R1407 B10.n299 B10.t785 0.324663
R1408 B10.n298 B10.t786 0.324663
R1409 B10.n297 B10.t787 0.324663
R1410 B10.n296 B10.t788 0.324663
R1411 B10.n295 B10.t789 0.324663
R1412 B10.n294 B10.t790 0.324663
R1413 B10.n293 B10.t791 0.324663
R1414 B10.n292 B10.t792 0.324663
R1415 B10.n291 B10.t793 0.324663
R1416 B10.n290 B10.t794 0.324663
R1417 B10.n289 B10.t795 0.324663
R1418 B10.n288 B10.t796 0.324663
R1419 B10.n287 B10.t797 0.324663
R1420 B10.n286 B10.t798 0.324663
R1421 B10.n285 B10.t799 0.324663
R1422 B10.n284 B10.t800 0.324663
R1423 B10.n283 B10.t801 0.324663
R1424 B10.n282 B10.t802 0.324663
R1425 B10.n281 B10.t803 0.324663
R1426 B10.n280 B10.t804 0.324663
R1427 B10.n279 B10.t805 0.324663
R1428 B10.n278 B10.t806 0.324663
R1429 B10.n277 B10.t807 0.324663
R1430 B10.n276 B10.t808 0.324663
R1431 B10.n275 B10.t809 0.324663
R1432 B10.n274 B10.t810 0.324663
R1433 B10.n273 B10.t811 0.324663
R1434 B10.n272 B10.t812 0.324663
R1435 B10.n271 B10.t813 0.324663
R1436 B10.n270 B10.t814 0.324663
R1437 B10.n269 B10.t815 0.324663
R1438 B10.n268 B10.t816 0.324663
R1439 B10.n267 B10.t817 0.324663
R1440 B10.n266 B10.t818 0.324663
R1441 B10.n265 B10.t819 0.324663
R1442 B10.n264 B10.t820 0.324663
R1443 B10.n263 B10.t821 0.324663
R1444 B10.n262 B10.t822 0.324663
R1445 B10.n261 B10.t823 0.324663
R1446 B10.n260 B10.t824 0.324663
R1447 B10.n259 B10.t825 0.324663
R1448 B10.n383 B10.t827 0.324663
R1449 B10.n382 B10.t828 0.324663
R1450 B10.n381 B10.t829 0.324663
R1451 B10.n380 B10.t830 0.324663
R1452 B10.n379 B10.t831 0.324663
R1453 B10.n378 B10.t832 0.324663
R1454 B10.n377 B10.t833 0.324663
R1455 B10.n376 B10.t834 0.324663
R1456 B10.n375 B10.t835 0.324663
R1457 B10.n374 B10.t836 0.324663
R1458 B10.n373 B10.t837 0.324663
R1459 B10.n372 B10.t838 0.324663
R1460 B10.n371 B10.t839 0.324663
R1461 B10.n370 B10.t840 0.324663
R1462 B10.n369 B10.t841 0.324663
R1463 B10.n368 B10.t842 0.324663
R1464 B10.n367 B10.t843 0.324663
R1465 B10.n366 B10.t844 0.324663
R1466 B10.n365 B10.t845 0.324663
R1467 B10.n364 B10.t846 0.324663
R1468 B10.n363 B10.t847 0.324663
R1469 B10.n362 B10.t848 0.324663
R1470 B10.n361 B10.t849 0.324663
R1471 B10.n360 B10.t850 0.324663
R1472 B10.n359 B10.t851 0.324663
R1473 B10.n358 B10.t852 0.324663
R1474 B10.n357 B10.t853 0.324663
R1475 B10.n356 B10.t854 0.324663
R1476 B10.n355 B10.t855 0.324663
R1477 B10.n354 B10.t856 0.324663
R1478 B10.n353 B10.t857 0.324663
R1479 B10.n352 B10.t858 0.324663
R1480 B10.n351 B10.t859 0.324663
R1481 B10.n350 B10.t860 0.324663
R1482 B10.n349 B10.t861 0.324663
R1483 B10.n348 B10.t862 0.324663
R1484 B10.n347 B10.t863 0.324663
R1485 B10.n346 B10.t864 0.324663
R1486 B10.n345 B10.t865 0.324663
R1487 B10.n344 B10.t866 0.324663
R1488 B10.n343 B10.t867 0.324663
R1489 B10.n342 B10.t868 0.324663
R1490 B10.n341 B10.t869 0.324663
R1491 B10.n340 B10.t870 0.324663
R1492 B10.n339 B10.t871 0.324663
R1493 B10.n338 B10.t872 0.324663
R1494 B10.n337 B10.t873 0.324663
R1495 B10.n336 B10.t874 0.324663
R1496 B10.n335 B10.t875 0.324663
R1497 B10.n334 B10.t876 0.324663
R1498 B10.n333 B10.t877 0.324663
R1499 B10.n332 B10.t878 0.324663
R1500 B10.n331 B10.t879 0.324663
R1501 B10.n330 B10.t880 0.324663
R1502 B10.n329 B10.t881 0.324663
R1503 B10.n328 B10.t882 0.324663
R1504 B10.n327 B10.t883 0.324663
R1505 B10.n326 B10.t884 0.324663
R1506 B10.n325 B10.t885 0.324663
R1507 B10.n324 B10.t886 0.324663
R1508 B10.n323 B10.t887 0.324663
R1509 B10.n322 B10.t888 0.324663
R1510 B10.n446 B10.t890 0.324663
R1511 B10.n445 B10.t891 0.324663
R1512 B10.n444 B10.t892 0.324663
R1513 B10.n443 B10.t893 0.324663
R1514 B10.n442 B10.t894 0.324663
R1515 B10.n441 B10.t895 0.324663
R1516 B10.n440 B10.t896 0.324663
R1517 B10.n439 B10.t897 0.324663
R1518 B10.n438 B10.t898 0.324663
R1519 B10.n437 B10.t899 0.324663
R1520 B10.n436 B10.t900 0.324663
R1521 B10.n435 B10.t901 0.324663
R1522 B10.n434 B10.t902 0.324663
R1523 B10.n433 B10.t903 0.324663
R1524 B10.n432 B10.t904 0.324663
R1525 B10.n431 B10.t905 0.324663
R1526 B10.n430 B10.t906 0.324663
R1527 B10.n429 B10.t907 0.324663
R1528 B10.n428 B10.t908 0.324663
R1529 B10.n427 B10.t909 0.324663
R1530 B10.n426 B10.t910 0.324663
R1531 B10.n425 B10.t911 0.324663
R1532 B10.n424 B10.t912 0.324663
R1533 B10.n423 B10.t913 0.324663
R1534 B10.n422 B10.t914 0.324663
R1535 B10.n421 B10.t915 0.324663
R1536 B10.n420 B10.t916 0.324663
R1537 B10.n419 B10.t917 0.324663
R1538 B10.n418 B10.t918 0.324663
R1539 B10.n417 B10.t919 0.324663
R1540 B10.n416 B10.t920 0.324663
R1541 B10.n415 B10.t921 0.324663
R1542 B10.n414 B10.t922 0.324663
R1543 B10.n413 B10.t923 0.324663
R1544 B10.n412 B10.t924 0.324663
R1545 B10.n411 B10.t925 0.324663
R1546 B10.n410 B10.t926 0.324663
R1547 B10.n409 B10.t927 0.324663
R1548 B10.n408 B10.t928 0.324663
R1549 B10.n407 B10.t929 0.324663
R1550 B10.n406 B10.t930 0.324663
R1551 B10.n405 B10.t931 0.324663
R1552 B10.n404 B10.t932 0.324663
R1553 B10.n403 B10.t933 0.324663
R1554 B10.n402 B10.t934 0.324663
R1555 B10.n401 B10.t935 0.324663
R1556 B10.n400 B10.t936 0.324663
R1557 B10.n399 B10.t937 0.324663
R1558 B10.n398 B10.t938 0.324663
R1559 B10.n397 B10.t939 0.324663
R1560 B10.n396 B10.t940 0.324663
R1561 B10.n395 B10.t941 0.324663
R1562 B10.n394 B10.t942 0.324663
R1563 B10.n393 B10.t943 0.324663
R1564 B10.n392 B10.t944 0.324663
R1565 B10.n391 B10.t945 0.324663
R1566 B10.n390 B10.t946 0.324663
R1567 B10.n389 B10.t947 0.324663
R1568 B10.n388 B10.t948 0.324663
R1569 B10.n387 B10.t949 0.324663
R1570 B10.n386 B10.t950 0.324663
R1571 B10.n385 B10.t951 0.324663
R1572 B10.n509 B10.t953 0.324663
R1573 B10.n508 B10.t954 0.324663
R1574 B10.n507 B10.t955 0.324663
R1575 B10.n506 B10.t956 0.324663
R1576 B10.n505 B10.t957 0.324663
R1577 B10.n504 B10.t958 0.324663
R1578 B10.n503 B10.t959 0.324663
R1579 B10.n502 B10.t960 0.324663
R1580 B10.n501 B10.t961 0.324663
R1581 B10.n500 B10.t962 0.324663
R1582 B10.n499 B10.t963 0.324663
R1583 B10.n498 B10.t964 0.324663
R1584 B10.n497 B10.t965 0.324663
R1585 B10.n496 B10.t966 0.324663
R1586 B10.n495 B10.t967 0.324663
R1587 B10.n494 B10.t968 0.324663
R1588 B10.n493 B10.t969 0.324663
R1589 B10.n492 B10.t970 0.324663
R1590 B10.n491 B10.t971 0.324663
R1591 B10.n490 B10.t972 0.324663
R1592 B10.n489 B10.t973 0.324663
R1593 B10.n488 B10.t974 0.324663
R1594 B10.n487 B10.t975 0.324663
R1595 B10.n486 B10.t976 0.324663
R1596 B10.n485 B10.t977 0.324663
R1597 B10.n484 B10.t978 0.324663
R1598 B10.n483 B10.t979 0.324663
R1599 B10.n482 B10.t980 0.324663
R1600 B10.n481 B10.t981 0.324663
R1601 B10.n480 B10.t982 0.324663
R1602 B10.n479 B10.t983 0.324663
R1603 B10.n478 B10.t984 0.324663
R1604 B10.n477 B10.t985 0.324663
R1605 B10.n476 B10.t986 0.324663
R1606 B10.n475 B10.t987 0.324663
R1607 B10.n474 B10.t988 0.324663
R1608 B10.n473 B10.t989 0.324663
R1609 B10.n472 B10.t990 0.324663
R1610 B10.n471 B10.t991 0.324663
R1611 B10.n470 B10.t992 0.324663
R1612 B10.n469 B10.t993 0.324663
R1613 B10.n468 B10.t994 0.324663
R1614 B10.n467 B10.t995 0.324663
R1615 B10.n466 B10.t996 0.324663
R1616 B10.n465 B10.t997 0.324663
R1617 B10.n464 B10.t998 0.324663
R1618 B10.n463 B10.t999 0.324663
R1619 B10.n462 B10.t1000 0.324663
R1620 B10.n461 B10.t1001 0.324663
R1621 B10.n460 B10.t1002 0.324663
R1622 B10.n459 B10.t1003 0.324663
R1623 B10.n458 B10.t1004 0.324663
R1624 B10.n457 B10.t1005 0.324663
R1625 B10.n456 B10.t1006 0.324663
R1626 B10.n455 B10.t1007 0.324663
R1627 B10.n454 B10.t1008 0.324663
R1628 B10.n453 B10.t1009 0.324663
R1629 B10.n452 B10.t1010 0.324663
R1630 B10.n451 B10.t1011 0.324663
R1631 B10.n450 B10.t1012 0.324663
R1632 B10.n449 B10.t1013 0.324663
R1633 B10.n448 B10.t1014 0.324663
R1634 B10.n511 B10.t9 0.324663
R1635 B10.n512 B10.t10 0.324663
R1636 B10.n513 B10.t11 0.324663
R1637 B10.n514 B10.t12 0.324663
R1638 B10.n515 B10.t13 0.324663
R1639 B10.n516 B10.t14 0.324663
R1640 B10.n517 B10.t15 0.324663
R1641 B10.n518 B10.t16 0.324663
R1642 B10.n519 B10.t17 0.324663
R1643 B10.n520 B10.t18 0.324663
R1644 B10.n521 B10.t19 0.324663
R1645 B10.n522 B10.t20 0.324663
R1646 B10.n523 B10.t21 0.324663
R1647 B10.n524 B10.t22 0.324663
R1648 B10.n525 B10.t23 0.324663
R1649 B10.n526 B10.t24 0.324663
R1650 B10.n527 B10.t25 0.324663
R1651 B10.n528 B10.t26 0.324663
R1652 B10.n529 B10.t27 0.324663
R1653 B10.n530 B10.t28 0.324663
R1654 B10.n531 B10.t29 0.324663
R1655 B10.n532 B10.t30 0.324663
R1656 B10.n533 B10.t31 0.324663
R1657 B10.n534 B10.t32 0.324663
R1658 B10.n535 B10.t33 0.324663
R1659 B10.n536 B10.t34 0.324663
R1660 B10.n537 B10.t35 0.324663
R1661 B10.n538 B10.t36 0.324663
R1662 B10.n539 B10.t37 0.324663
R1663 B10.n540 B10.t38 0.324663
R1664 B10.n541 B10.t39 0.324663
R1665 B10.n542 B10.t40 0.324663
R1666 B10.n543 B10.t41 0.324663
R1667 B10.n544 B10.t42 0.324663
R1668 B10.n545 B10.t43 0.324663
R1669 B10.n546 B10.t44 0.324663
R1670 B10.n547 B10.t45 0.324663
R1671 B10.n548 B10.t46 0.324663
R1672 B10.n549 B10.t47 0.324663
R1673 B10.n550 B10.t48 0.324663
R1674 B10.n551 B10.t49 0.324663
R1675 B10.n552 B10.t50 0.324663
R1676 B10.n553 B10.t51 0.324663
R1677 B10.n554 B10.t52 0.324663
R1678 B10.n555 B10.t53 0.324663
R1679 B10.n556 B10.t54 0.324663
R1680 B10.n557 B10.t55 0.324663
R1681 B10.n558 B10.t56 0.324663
R1682 B10.n559 B10.t57 0.324663
R1683 B10.n560 B10.t58 0.324663
R1684 B10.n561 B10.t59 0.324663
R1685 B10.n562 B10.t60 0.324663
R1686 B10.n563 B10.t61 0.324663
R1687 B10.n564 B10.t62 0.324663
R1688 B10.n565 B10.t63 0.324663
R1689 B10.n566 B10.t64 0.324663
R1690 B10.n567 B10.t65 0.324663
R1691 B10.n568 B10.t66 0.324663
R1692 B10.n569 B10.t67 0.324663
R1693 B10.n570 B10.t68 0.324663
R1694 B10.n571 B10.t69 0.324663
R1695 B10.n572 B10.t70 0.324663
R1696 B10.n573 B10.t72 0.324663
R1697 B10.n574 B10.t73 0.324663
R1698 B10.n575 B10.t74 0.324663
R1699 B10.n576 B10.t75 0.324663
R1700 B10.n577 B10.t76 0.324663
R1701 B10.n578 B10.t77 0.324663
R1702 B10.n579 B10.t78 0.324663
R1703 B10.n580 B10.t79 0.324663
R1704 B10.n581 B10.t80 0.324663
R1705 B10.n582 B10.t81 0.324663
R1706 B10.n583 B10.t82 0.324663
R1707 B10.n584 B10.t83 0.324663
R1708 B10.n585 B10.t84 0.324663
R1709 B10.n586 B10.t85 0.324663
R1710 B10.n587 B10.t86 0.324663
R1711 B10.n588 B10.t87 0.324663
R1712 B10.n589 B10.t88 0.324663
R1713 B10.n590 B10.t89 0.324663
R1714 B10.n591 B10.t90 0.324663
R1715 B10.n592 B10.t91 0.324663
R1716 B10.n593 B10.t92 0.324663
R1717 B10.n594 B10.t93 0.324663
R1718 B10.n595 B10.t94 0.324663
R1719 B10.n596 B10.t95 0.324663
R1720 B10.n597 B10.t96 0.324663
R1721 B10.n598 B10.t97 0.324663
R1722 B10.n599 B10.t98 0.324663
R1723 B10.n600 B10.t99 0.324663
R1724 B10.n601 B10.t100 0.324663
R1725 B10.n602 B10.t101 0.324663
R1726 B10.n603 B10.t102 0.324663
R1727 B10.n604 B10.t103 0.324663
R1728 B10.n605 B10.t104 0.324663
R1729 B10.n606 B10.t105 0.324663
R1730 B10.n607 B10.t106 0.324663
R1731 B10.n608 B10.t107 0.324663
R1732 B10.n609 B10.t108 0.324663
R1733 B10.n610 B10.t109 0.324663
R1734 B10.n611 B10.t110 0.324663
R1735 B10.n612 B10.t111 0.324663
R1736 B10.n613 B10.t112 0.324663
R1737 B10.n614 B10.t113 0.324663
R1738 B10.n615 B10.t114 0.324663
R1739 B10.n616 B10.t115 0.324663
R1740 B10.n617 B10.t116 0.324663
R1741 B10.n618 B10.t117 0.324663
R1742 B10.n619 B10.t118 0.324663
R1743 B10.n620 B10.t119 0.324663
R1744 B10.n621 B10.t120 0.324663
R1745 B10.n622 B10.t121 0.324663
R1746 B10.n623 B10.t122 0.324663
R1747 B10.n624 B10.t123 0.324663
R1748 B10.n625 B10.t124 0.324663
R1749 B10.n626 B10.t125 0.324663
R1750 B10.n627 B10.t126 0.324663
R1751 B10.n628 B10.t127 0.324663
R1752 B10.n629 B10.t128 0.324663
R1753 B10.n630 B10.t129 0.324663
R1754 B10.n631 B10.t130 0.324663
R1755 B10.n632 B10.t131 0.324663
R1756 B10.n633 B10.t132 0.324663
R1757 B10.n634 B10.t133 0.324663
R1758 B10.n636 B10.t135 0.324663
R1759 B10.n637 B10.t136 0.324663
R1760 B10.n638 B10.t137 0.324663
R1761 B10.n639 B10.t138 0.324663
R1762 B10.n640 B10.t139 0.324663
R1763 B10.n641 B10.t140 0.324663
R1764 B10.n642 B10.t141 0.324663
R1765 B10.n643 B10.t142 0.324663
R1766 B10.n644 B10.t143 0.324663
R1767 B10.n645 B10.t144 0.324663
R1768 B10.n646 B10.t145 0.324663
R1769 B10.n647 B10.t146 0.324663
R1770 B10.n648 B10.t147 0.324663
R1771 B10.n649 B10.t148 0.324663
R1772 B10.n650 B10.t149 0.324663
R1773 B10.n651 B10.t150 0.324663
R1774 B10.n652 B10.t151 0.324663
R1775 B10.n653 B10.t152 0.324663
R1776 B10.n654 B10.t153 0.324663
R1777 B10.n655 B10.t154 0.324663
R1778 B10.n656 B10.t155 0.324663
R1779 B10.n657 B10.t156 0.324663
R1780 B10.n658 B10.t157 0.324663
R1781 B10.n659 B10.t158 0.324663
R1782 B10.n660 B10.t159 0.324663
R1783 B10.n661 B10.t160 0.324663
R1784 B10.n662 B10.t161 0.324663
R1785 B10.n663 B10.t162 0.324663
R1786 B10.n664 B10.t163 0.324663
R1787 B10.n665 B10.t164 0.324663
R1788 B10.n666 B10.t165 0.324663
R1789 B10.n667 B10.t166 0.324663
R1790 B10.n668 B10.t167 0.324663
R1791 B10.n669 B10.t168 0.324663
R1792 B10.n670 B10.t169 0.324663
R1793 B10.n671 B10.t170 0.324663
R1794 B10.n672 B10.t171 0.324663
R1795 B10.n673 B10.t172 0.324663
R1796 B10.n674 B10.t173 0.324663
R1797 B10.n675 B10.t174 0.324663
R1798 B10.n676 B10.t175 0.324663
R1799 B10.n677 B10.t176 0.324663
R1800 B10.n678 B10.t177 0.324663
R1801 B10.n679 B10.t178 0.324663
R1802 B10.n680 B10.t179 0.324663
R1803 B10.n681 B10.t180 0.324663
R1804 B10.n682 B10.t181 0.324663
R1805 B10.n683 B10.t182 0.324663
R1806 B10.n684 B10.t183 0.324663
R1807 B10.n685 B10.t184 0.324663
R1808 B10.n686 B10.t185 0.324663
R1809 B10.n687 B10.t186 0.324663
R1810 B10.n688 B10.t187 0.324663
R1811 B10.n689 B10.t188 0.324663
R1812 B10.n690 B10.t189 0.324663
R1813 B10.n691 B10.t190 0.324663
R1814 B10.n692 B10.t191 0.324663
R1815 B10.n693 B10.t192 0.324663
R1816 B10.n694 B10.t193 0.324663
R1817 B10.n695 B10.t194 0.324663
R1818 B10.n696 B10.t195 0.324663
R1819 B10.n697 B10.t196 0.324663
R1820 B10.n699 B10.t198 0.324663
R1821 B10.n700 B10.t199 0.324663
R1822 B10.n701 B10.t200 0.324663
R1823 B10.n702 B10.t201 0.324663
R1824 B10.n703 B10.t202 0.324663
R1825 B10.n704 B10.t203 0.324663
R1826 B10.n705 B10.t204 0.324663
R1827 B10.n706 B10.t205 0.324663
R1828 B10.n707 B10.t206 0.324663
R1829 B10.n708 B10.t207 0.324663
R1830 B10.n709 B10.t208 0.324663
R1831 B10.n710 B10.t209 0.324663
R1832 B10.n711 B10.t210 0.324663
R1833 B10.n712 B10.t211 0.324663
R1834 B10.n713 B10.t212 0.324663
R1835 B10.n714 B10.t213 0.324663
R1836 B10.n715 B10.t214 0.324663
R1837 B10.n716 B10.t215 0.324663
R1838 B10.n717 B10.t216 0.324663
R1839 B10.n718 B10.t217 0.324663
R1840 B10.n719 B10.t218 0.324663
R1841 B10.n720 B10.t219 0.324663
R1842 B10.n721 B10.t220 0.324663
R1843 B10.n722 B10.t221 0.324663
R1844 B10.n723 B10.t222 0.324663
R1845 B10.n724 B10.t223 0.324663
R1846 B10.n725 B10.t224 0.324663
R1847 B10.n726 B10.t225 0.324663
R1848 B10.n727 B10.t226 0.324663
R1849 B10.n728 B10.t227 0.324663
R1850 B10.n729 B10.t228 0.324663
R1851 B10.n730 B10.t229 0.324663
R1852 B10.n731 B10.t230 0.324663
R1853 B10.n732 B10.t231 0.324663
R1854 B10.n733 B10.t232 0.324663
R1855 B10.n734 B10.t233 0.324663
R1856 B10.n735 B10.t234 0.324663
R1857 B10.n736 B10.t235 0.324663
R1858 B10.n737 B10.t236 0.324663
R1859 B10.n738 B10.t237 0.324663
R1860 B10.n739 B10.t238 0.324663
R1861 B10.n740 B10.t239 0.324663
R1862 B10.n741 B10.t240 0.324663
R1863 B10.n742 B10.t241 0.324663
R1864 B10.n743 B10.t242 0.324663
R1865 B10.n744 B10.t243 0.324663
R1866 B10.n745 B10.t244 0.324663
R1867 B10.n746 B10.t245 0.324663
R1868 B10.n747 B10.t246 0.324663
R1869 B10.n748 B10.t247 0.324663
R1870 B10.n749 B10.t248 0.324663
R1871 B10.n750 B10.t249 0.324663
R1872 B10.n751 B10.t250 0.324663
R1873 B10.n752 B10.t251 0.324663
R1874 B10.n753 B10.t252 0.324663
R1875 B10.n754 B10.t253 0.324663
R1876 B10.n755 B10.t254 0.324663
R1877 B10.n756 B10.t255 0.324663
R1878 B10.n757 B10.t256 0.324663
R1879 B10.n758 B10.t257 0.324663
R1880 B10.n759 B10.t258 0.324663
R1881 B10.n760 B10.t259 0.324663
R1882 B10.n762 B10.t261 0.324663
R1883 B10.n763 B10.t262 0.324663
R1884 B10.n764 B10.t263 0.324663
R1885 B10.n765 B10.t264 0.324663
R1886 B10.n766 B10.t265 0.324663
R1887 B10.n767 B10.t266 0.324663
R1888 B10.n768 B10.t267 0.324663
R1889 B10.n769 B10.t268 0.324663
R1890 B10.n770 B10.t269 0.324663
R1891 B10.n771 B10.t270 0.324663
R1892 B10.n772 B10.t271 0.324663
R1893 B10.n773 B10.t272 0.324663
R1894 B10.n774 B10.t273 0.324663
R1895 B10.n775 B10.t274 0.324663
R1896 B10.n776 B10.t275 0.324663
R1897 B10.n777 B10.t276 0.324663
R1898 B10.n778 B10.t277 0.324663
R1899 B10.n779 B10.t278 0.324663
R1900 B10.n780 B10.t279 0.324663
R1901 B10.n781 B10.t280 0.324663
R1902 B10.n782 B10.t281 0.324663
R1903 B10.n783 B10.t282 0.324663
R1904 B10.n784 B10.t283 0.324663
R1905 B10.n785 B10.t284 0.324663
R1906 B10.n786 B10.t285 0.324663
R1907 B10.n787 B10.t286 0.324663
R1908 B10.n788 B10.t287 0.324663
R1909 B10.n789 B10.t288 0.324663
R1910 B10.n790 B10.t289 0.324663
R1911 B10.n791 B10.t290 0.324663
R1912 B10.n792 B10.t291 0.324663
R1913 B10.n793 B10.t292 0.324663
R1914 B10.n794 B10.t293 0.324663
R1915 B10.n795 B10.t294 0.324663
R1916 B10.n796 B10.t295 0.324663
R1917 B10.n797 B10.t296 0.324663
R1918 B10.n798 B10.t297 0.324663
R1919 B10.n799 B10.t298 0.324663
R1920 B10.n800 B10.t299 0.324663
R1921 B10.n801 B10.t300 0.324663
R1922 B10.n802 B10.t301 0.324663
R1923 B10.n803 B10.t302 0.324663
R1924 B10.n804 B10.t303 0.324663
R1925 B10.n805 B10.t304 0.324663
R1926 B10.n806 B10.t305 0.324663
R1927 B10.n807 B10.t306 0.324663
R1928 B10.n808 B10.t307 0.324663
R1929 B10.n809 B10.t308 0.324663
R1930 B10.n810 B10.t309 0.324663
R1931 B10.n811 B10.t310 0.324663
R1932 B10.n812 B10.t311 0.324663
R1933 B10.n813 B10.t312 0.324663
R1934 B10.n814 B10.t313 0.324663
R1935 B10.n815 B10.t314 0.324663
R1936 B10.n816 B10.t315 0.324663
R1937 B10.n817 B10.t316 0.324663
R1938 B10.n818 B10.t317 0.324663
R1939 B10.n819 B10.t318 0.324663
R1940 B10.n820 B10.t319 0.324663
R1941 B10.n821 B10.t320 0.324663
R1942 B10.n822 B10.t321 0.324663
R1943 B10.n823 B10.t322 0.324663
R1944 B10.n825 B10.t324 0.324663
R1945 B10.n826 B10.t325 0.324663
R1946 B10.n827 B10.t326 0.324663
R1947 B10.n828 B10.t327 0.324663
R1948 B10.n829 B10.t328 0.324663
R1949 B10.n830 B10.t329 0.324663
R1950 B10.n831 B10.t330 0.324663
R1951 B10.n832 B10.t331 0.324663
R1952 B10.n833 B10.t332 0.324663
R1953 B10.n834 B10.t333 0.324663
R1954 B10.n835 B10.t334 0.324663
R1955 B10.n836 B10.t335 0.324663
R1956 B10.n837 B10.t336 0.324663
R1957 B10.n838 B10.t337 0.324663
R1958 B10.n839 B10.t338 0.324663
R1959 B10.n840 B10.t339 0.324663
R1960 B10.n841 B10.t340 0.324663
R1961 B10.n842 B10.t341 0.324663
R1962 B10.n843 B10.t342 0.324663
R1963 B10.n844 B10.t343 0.324663
R1964 B10.n845 B10.t344 0.324663
R1965 B10.n846 B10.t345 0.324663
R1966 B10.n847 B10.t346 0.324663
R1967 B10.n848 B10.t347 0.324663
R1968 B10.n849 B10.t348 0.324663
R1969 B10.n850 B10.t349 0.324663
R1970 B10.n851 B10.t350 0.324663
R1971 B10.n852 B10.t351 0.324663
R1972 B10.n853 B10.t352 0.324663
R1973 B10.n854 B10.t353 0.324663
R1974 B10.n855 B10.t354 0.324663
R1975 B10.n856 B10.t355 0.324663
R1976 B10.n857 B10.t356 0.324663
R1977 B10.n858 B10.t357 0.324663
R1978 B10.n859 B10.t358 0.324663
R1979 B10.n860 B10.t359 0.324663
R1980 B10.n861 B10.t360 0.324663
R1981 B10.n862 B10.t361 0.324663
R1982 B10.n863 B10.t362 0.324663
R1983 B10.n864 B10.t363 0.324663
R1984 B10.n865 B10.t364 0.324663
R1985 B10.n866 B10.t365 0.324663
R1986 B10.n867 B10.t366 0.324663
R1987 B10.n868 B10.t367 0.324663
R1988 B10.n869 B10.t368 0.324663
R1989 B10.n870 B10.t369 0.324663
R1990 B10.n871 B10.t370 0.324663
R1991 B10.n872 B10.t371 0.324663
R1992 B10.n873 B10.t372 0.324663
R1993 B10.n874 B10.t373 0.324663
R1994 B10.n875 B10.t374 0.324663
R1995 B10.n876 B10.t375 0.324663
R1996 B10.n877 B10.t376 0.324663
R1997 B10.n878 B10.t377 0.324663
R1998 B10.n879 B10.t378 0.324663
R1999 B10.n880 B10.t379 0.324663
R2000 B10.n881 B10.t380 0.324663
R2001 B10.n882 B10.t381 0.324663
R2002 B10.n883 B10.t382 0.324663
R2003 B10.n884 B10.t383 0.324663
R2004 B10.n885 B10.t384 0.324663
R2005 B10.n886 B10.t385 0.324663
R2006 B10.n888 B10.t387 0.324663
R2007 B10.n889 B10.t388 0.324663
R2008 B10.n890 B10.t389 0.324663
R2009 B10.n891 B10.t390 0.324663
R2010 B10.n892 B10.t391 0.324663
R2011 B10.n893 B10.t392 0.324663
R2012 B10.n894 B10.t393 0.324663
R2013 B10.n895 B10.t394 0.324663
R2014 B10.n896 B10.t395 0.324663
R2015 B10.n897 B10.t396 0.324663
R2016 B10.n898 B10.t397 0.324663
R2017 B10.n899 B10.t398 0.324663
R2018 B10.n900 B10.t399 0.324663
R2019 B10.n901 B10.t400 0.324663
R2020 B10.n902 B10.t401 0.324663
R2021 B10.n903 B10.t402 0.324663
R2022 B10.n904 B10.t403 0.324663
R2023 B10.n905 B10.t404 0.324663
R2024 B10.n906 B10.t405 0.324663
R2025 B10.n907 B10.t406 0.324663
R2026 B10.n908 B10.t407 0.324663
R2027 B10.n909 B10.t408 0.324663
R2028 B10.n910 B10.t409 0.324663
R2029 B10.n911 B10.t410 0.324663
R2030 B10.n912 B10.t411 0.324663
R2031 B10.n913 B10.t412 0.324663
R2032 B10.n914 B10.t413 0.324663
R2033 B10.n915 B10.t414 0.324663
R2034 B10.n916 B10.t415 0.324663
R2035 B10.n917 B10.t416 0.324663
R2036 B10.n918 B10.t417 0.324663
R2037 B10.n919 B10.t418 0.324663
R2038 B10.n920 B10.t419 0.324663
R2039 B10.n921 B10.t420 0.324663
R2040 B10.n922 B10.t421 0.324663
R2041 B10.n923 B10.t422 0.324663
R2042 B10.n924 B10.t423 0.324663
R2043 B10.n925 B10.t424 0.324663
R2044 B10.n926 B10.t425 0.324663
R2045 B10.n927 B10.t426 0.324663
R2046 B10.n928 B10.t427 0.324663
R2047 B10.n929 B10.t428 0.324663
R2048 B10.n930 B10.t429 0.324663
R2049 B10.n931 B10.t430 0.324663
R2050 B10.n932 B10.t431 0.324663
R2051 B10.n933 B10.t432 0.324663
R2052 B10.n934 B10.t433 0.324663
R2053 B10.n935 B10.t434 0.324663
R2054 B10.n936 B10.t435 0.324663
R2055 B10.n937 B10.t436 0.324663
R2056 B10.n938 B10.t437 0.324663
R2057 B10.n939 B10.t438 0.324663
R2058 B10.n940 B10.t439 0.324663
R2059 B10.n941 B10.t440 0.324663
R2060 B10.n942 B10.t441 0.324663
R2061 B10.n943 B10.t442 0.324663
R2062 B10.n944 B10.t443 0.324663
R2063 B10.n945 B10.t444 0.324663
R2064 B10.n946 B10.t445 0.324663
R2065 B10.n947 B10.t446 0.324663
R2066 B10.n948 B10.t447 0.324663
R2067 B10.n949 B10.t448 0.324663
R2068 B10.n951 B10.t450 0.324663
R2069 B10.n952 B10.t451 0.324663
R2070 B10.n953 B10.t452 0.324663
R2071 B10.n954 B10.t453 0.324663
R2072 B10.n955 B10.t454 0.324663
R2073 B10.n956 B10.t455 0.324663
R2074 B10.n957 B10.t456 0.324663
R2075 B10.n958 B10.t457 0.324663
R2076 B10.n959 B10.t458 0.324663
R2077 B10.n960 B10.t459 0.324663
R2078 B10.n961 B10.t460 0.324663
R2079 B10.n962 B10.t461 0.324663
R2080 B10.n963 B10.t462 0.324663
R2081 B10.n964 B10.t463 0.324663
R2082 B10.n965 B10.t464 0.324663
R2083 B10.n966 B10.t465 0.324663
R2084 B10.n967 B10.t466 0.324663
R2085 B10.n968 B10.t467 0.324663
R2086 B10.n969 B10.t468 0.324663
R2087 B10.n970 B10.t469 0.324663
R2088 B10.n971 B10.t470 0.324663
R2089 B10.n972 B10.t471 0.324663
R2090 B10.n973 B10.t472 0.324663
R2091 B10.n974 B10.t473 0.324663
R2092 B10.n975 B10.t474 0.324663
R2093 B10.n976 B10.t475 0.324663
R2094 B10.n977 B10.t476 0.324663
R2095 B10.n978 B10.t477 0.324663
R2096 B10.n979 B10.t478 0.324663
R2097 B10.n980 B10.t479 0.324663
R2098 B10.n981 B10.t480 0.324663
R2099 B10.n982 B10.t481 0.324663
R2100 B10.n983 B10.t482 0.324663
R2101 B10.n984 B10.t483 0.324663
R2102 B10.n985 B10.t484 0.324663
R2103 B10.n986 B10.t485 0.324663
R2104 B10.n987 B10.t486 0.324663
R2105 B10.n988 B10.t487 0.324663
R2106 B10.n989 B10.t488 0.324663
R2107 B10.n990 B10.t489 0.324663
R2108 B10.n991 B10.t490 0.324663
R2109 B10.n992 B10.t491 0.324663
R2110 B10.n993 B10.t492 0.324663
R2111 B10.n994 B10.t493 0.324663
R2112 B10.n995 B10.t494 0.324663
R2113 B10.n996 B10.t495 0.324663
R2114 B10.n997 B10.t496 0.324663
R2115 B10.n998 B10.t497 0.324663
R2116 B10.n999 B10.t498 0.324663
R2117 B10.n1000 B10.t499 0.324663
R2118 B10.n1001 B10.t500 0.324663
R2119 B10.n1002 B10.t501 0.324663
R2120 B10.n1003 B10.t502 0.324663
R2121 B10.n1004 B10.t503 0.324663
R2122 B10.n1005 B10.t504 0.324663
R2123 B10.n1006 B10.t505 0.324663
R2124 B10.n1007 B10.t506 0.324663
R2125 B10.n1008 B10.t507 0.324663
R2126 B10.n1009 B10.t508 0.324663
R2127 B10.n1010 B10.t509 0.324663
R2128 B10.n1011 B10.t510 0.324663
R2129 B10.n1012 B10.t511 0.324663
R2130 B10.n1 B10.n0 0.10925
R2131 B10.n2 B10.n1 0.10925
R2132 B10.n3 B10.n2 0.10925
R2133 B10.n4 B10.n3 0.10925
R2134 B10.n5 B10.n4 0.10925
R2135 B10.n6 B10.n5 0.10925
R2136 B10.n132 B10.n69 0.10925
R2137 B10.n195 B10.n132 0.10925
R2138 B10.n258 B10.n195 0.10925
R2139 B10.n321 B10.n258 0.10925
R2140 B10.n384 B10.n321 0.10925
R2141 B10.n447 B10.n384 0.10925
R2142 B10.n510 B10.n447 0.10925
R2143 B10.n698 B10.n635 0.10925
R2144 B10.n761 B10.n698 0.10925
R2145 B10.n824 B10.n761 0.10925
R2146 B10.n887 B10.n824 0.10925
R2147 B10.n950 B10.n887 0.10925
R2148 B10.n1013 B10.n950 0.10925
R2149 B10.n1015 B10.n1014 0.10925
R2150 B10.n1016 B10.n1015 0.10925
R2151 B10.n1017 B10.n1016 0.10925
R2152 B10.n1018 B10.n1017 0.10925
R2153 B10.n1019 B10.n1018 0.10925
R2154 B10.n1020 B10.n1019 0.10925
R2155 B10.n1021 B10.n1020 0.10925
R2156 B9 B9.n509 28.4298
R2157 B9 B9.n254 24.7768
R2158 B9.n0 B9.t0 3.15636
R2159 B9.n65 B9.n2 3.15425
R2160 B9.n506 B9.n505 3.15425
R2161 B9.n0 B9.t1 3.04761
R2162 B9.n1 B9.t2 3.04761
R2163 B9.n2 B9.t3 3.04761
R2164 B9.n506 B9.t508 2.87606
R2165 B9.n507 B9.t509 2.87606
R2166 B9.n508 B9.t510 2.87606
R2167 B9.n509 B9.t511 2.87606
R2168 B9.n65 B9.n64 2.72345
R2169 B9.n128 B9.n127 2.72345
R2170 B9.n191 B9.n190 2.72345
R2171 B9.n254 B9.n253 2.72345
R2172 B9.n379 B9.n316 2.66065
R2173 B9.n379 B9.n378 2.5519
R2174 B9.n442 B9.n441 2.5519
R2175 B9.n505 B9.n504 2.5519
R2176 B9.n3 B9.t318 1.02966
R2177 B9.n66 B9.t381 1.02966
R2178 B9.n129 B9.t444 1.02966
R2179 B9.n192 B9.t507 1.02966
R2180 B9.n255 B9.t4 1.02966
R2181 B9.n317 B9.t67 1.02966
R2182 B9.n380 B9.t130 1.02966
R2183 B9.n443 B9.t193 1.02966
R2184 B9.n4 B9.n3 0.7055
R2185 B9.n5 B9.n4 0.7055
R2186 B9.n6 B9.n5 0.7055
R2187 B9.n7 B9.n6 0.7055
R2188 B9.n8 B9.n7 0.7055
R2189 B9.n9 B9.n8 0.7055
R2190 B9.n10 B9.n9 0.7055
R2191 B9.n11 B9.n10 0.7055
R2192 B9.n12 B9.n11 0.7055
R2193 B9.n13 B9.n12 0.7055
R2194 B9.n14 B9.n13 0.7055
R2195 B9.n15 B9.n14 0.7055
R2196 B9.n16 B9.n15 0.7055
R2197 B9.n17 B9.n16 0.7055
R2198 B9.n18 B9.n17 0.7055
R2199 B9.n19 B9.n18 0.7055
R2200 B9.n20 B9.n19 0.7055
R2201 B9.n21 B9.n20 0.7055
R2202 B9.n22 B9.n21 0.7055
R2203 B9.n23 B9.n22 0.7055
R2204 B9.n24 B9.n23 0.7055
R2205 B9.n25 B9.n24 0.7055
R2206 B9.n26 B9.n25 0.7055
R2207 B9.n27 B9.n26 0.7055
R2208 B9.n28 B9.n27 0.7055
R2209 B9.n29 B9.n28 0.7055
R2210 B9.n30 B9.n29 0.7055
R2211 B9.n31 B9.n30 0.7055
R2212 B9.n32 B9.n31 0.7055
R2213 B9.n33 B9.n32 0.7055
R2214 B9.n34 B9.n33 0.7055
R2215 B9.n35 B9.n34 0.7055
R2216 B9.n36 B9.n35 0.7055
R2217 B9.n37 B9.n36 0.7055
R2218 B9.n38 B9.n37 0.7055
R2219 B9.n39 B9.n38 0.7055
R2220 B9.n40 B9.n39 0.7055
R2221 B9.n41 B9.n40 0.7055
R2222 B9.n42 B9.n41 0.7055
R2223 B9.n43 B9.n42 0.7055
R2224 B9.n44 B9.n43 0.7055
R2225 B9.n45 B9.n44 0.7055
R2226 B9.n46 B9.n45 0.7055
R2227 B9.n47 B9.n46 0.7055
R2228 B9.n48 B9.n47 0.7055
R2229 B9.n49 B9.n48 0.7055
R2230 B9.n50 B9.n49 0.7055
R2231 B9.n51 B9.n50 0.7055
R2232 B9.n52 B9.n51 0.7055
R2233 B9.n53 B9.n52 0.7055
R2234 B9.n54 B9.n53 0.7055
R2235 B9.n55 B9.n54 0.7055
R2236 B9.n56 B9.n55 0.7055
R2237 B9.n57 B9.n56 0.7055
R2238 B9.n58 B9.n57 0.7055
R2239 B9.n59 B9.n58 0.7055
R2240 B9.n60 B9.n59 0.7055
R2241 B9.n61 B9.n60 0.7055
R2242 B9.n62 B9.n61 0.7055
R2243 B9.n63 B9.n62 0.7055
R2244 B9.n64 B9.n63 0.7055
R2245 B9.n67 B9.n66 0.7055
R2246 B9.n68 B9.n67 0.7055
R2247 B9.n69 B9.n68 0.7055
R2248 B9.n70 B9.n69 0.7055
R2249 B9.n71 B9.n70 0.7055
R2250 B9.n72 B9.n71 0.7055
R2251 B9.n73 B9.n72 0.7055
R2252 B9.n74 B9.n73 0.7055
R2253 B9.n75 B9.n74 0.7055
R2254 B9.n76 B9.n75 0.7055
R2255 B9.n77 B9.n76 0.7055
R2256 B9.n78 B9.n77 0.7055
R2257 B9.n79 B9.n78 0.7055
R2258 B9.n80 B9.n79 0.7055
R2259 B9.n81 B9.n80 0.7055
R2260 B9.n82 B9.n81 0.7055
R2261 B9.n83 B9.n82 0.7055
R2262 B9.n84 B9.n83 0.7055
R2263 B9.n85 B9.n84 0.7055
R2264 B9.n86 B9.n85 0.7055
R2265 B9.n87 B9.n86 0.7055
R2266 B9.n88 B9.n87 0.7055
R2267 B9.n89 B9.n88 0.7055
R2268 B9.n90 B9.n89 0.7055
R2269 B9.n91 B9.n90 0.7055
R2270 B9.n92 B9.n91 0.7055
R2271 B9.n93 B9.n92 0.7055
R2272 B9.n94 B9.n93 0.7055
R2273 B9.n95 B9.n94 0.7055
R2274 B9.n96 B9.n95 0.7055
R2275 B9.n97 B9.n96 0.7055
R2276 B9.n98 B9.n97 0.7055
R2277 B9.n99 B9.n98 0.7055
R2278 B9.n100 B9.n99 0.7055
R2279 B9.n101 B9.n100 0.7055
R2280 B9.n102 B9.n101 0.7055
R2281 B9.n103 B9.n102 0.7055
R2282 B9.n104 B9.n103 0.7055
R2283 B9.n105 B9.n104 0.7055
R2284 B9.n106 B9.n105 0.7055
R2285 B9.n107 B9.n106 0.7055
R2286 B9.n108 B9.n107 0.7055
R2287 B9.n109 B9.n108 0.7055
R2288 B9.n110 B9.n109 0.7055
R2289 B9.n111 B9.n110 0.7055
R2290 B9.n112 B9.n111 0.7055
R2291 B9.n113 B9.n112 0.7055
R2292 B9.n114 B9.n113 0.7055
R2293 B9.n115 B9.n114 0.7055
R2294 B9.n116 B9.n115 0.7055
R2295 B9.n117 B9.n116 0.7055
R2296 B9.n118 B9.n117 0.7055
R2297 B9.n119 B9.n118 0.7055
R2298 B9.n120 B9.n119 0.7055
R2299 B9.n121 B9.n120 0.7055
R2300 B9.n122 B9.n121 0.7055
R2301 B9.n123 B9.n122 0.7055
R2302 B9.n124 B9.n123 0.7055
R2303 B9.n125 B9.n124 0.7055
R2304 B9.n126 B9.n125 0.7055
R2305 B9.n127 B9.n126 0.7055
R2306 B9.n130 B9.n129 0.7055
R2307 B9.n131 B9.n130 0.7055
R2308 B9.n132 B9.n131 0.7055
R2309 B9.n133 B9.n132 0.7055
R2310 B9.n134 B9.n133 0.7055
R2311 B9.n135 B9.n134 0.7055
R2312 B9.n136 B9.n135 0.7055
R2313 B9.n137 B9.n136 0.7055
R2314 B9.n138 B9.n137 0.7055
R2315 B9.n139 B9.n138 0.7055
R2316 B9.n140 B9.n139 0.7055
R2317 B9.n141 B9.n140 0.7055
R2318 B9.n142 B9.n141 0.7055
R2319 B9.n143 B9.n142 0.7055
R2320 B9.n144 B9.n143 0.7055
R2321 B9.n145 B9.n144 0.7055
R2322 B9.n146 B9.n145 0.7055
R2323 B9.n147 B9.n146 0.7055
R2324 B9.n148 B9.n147 0.7055
R2325 B9.n149 B9.n148 0.7055
R2326 B9.n150 B9.n149 0.7055
R2327 B9.n151 B9.n150 0.7055
R2328 B9.n152 B9.n151 0.7055
R2329 B9.n153 B9.n152 0.7055
R2330 B9.n154 B9.n153 0.7055
R2331 B9.n155 B9.n154 0.7055
R2332 B9.n156 B9.n155 0.7055
R2333 B9.n157 B9.n156 0.7055
R2334 B9.n158 B9.n157 0.7055
R2335 B9.n159 B9.n158 0.7055
R2336 B9.n160 B9.n159 0.7055
R2337 B9.n161 B9.n160 0.7055
R2338 B9.n162 B9.n161 0.7055
R2339 B9.n163 B9.n162 0.7055
R2340 B9.n164 B9.n163 0.7055
R2341 B9.n165 B9.n164 0.7055
R2342 B9.n166 B9.n165 0.7055
R2343 B9.n167 B9.n166 0.7055
R2344 B9.n168 B9.n167 0.7055
R2345 B9.n169 B9.n168 0.7055
R2346 B9.n170 B9.n169 0.7055
R2347 B9.n171 B9.n170 0.7055
R2348 B9.n172 B9.n171 0.7055
R2349 B9.n173 B9.n172 0.7055
R2350 B9.n174 B9.n173 0.7055
R2351 B9.n175 B9.n174 0.7055
R2352 B9.n176 B9.n175 0.7055
R2353 B9.n177 B9.n176 0.7055
R2354 B9.n178 B9.n177 0.7055
R2355 B9.n179 B9.n178 0.7055
R2356 B9.n180 B9.n179 0.7055
R2357 B9.n181 B9.n180 0.7055
R2358 B9.n182 B9.n181 0.7055
R2359 B9.n183 B9.n182 0.7055
R2360 B9.n184 B9.n183 0.7055
R2361 B9.n185 B9.n184 0.7055
R2362 B9.n186 B9.n185 0.7055
R2363 B9.n187 B9.n186 0.7055
R2364 B9.n188 B9.n187 0.7055
R2365 B9.n189 B9.n188 0.7055
R2366 B9.n190 B9.n189 0.7055
R2367 B9.n193 B9.n192 0.7055
R2368 B9.n194 B9.n193 0.7055
R2369 B9.n195 B9.n194 0.7055
R2370 B9.n196 B9.n195 0.7055
R2371 B9.n197 B9.n196 0.7055
R2372 B9.n198 B9.n197 0.7055
R2373 B9.n199 B9.n198 0.7055
R2374 B9.n200 B9.n199 0.7055
R2375 B9.n201 B9.n200 0.7055
R2376 B9.n202 B9.n201 0.7055
R2377 B9.n203 B9.n202 0.7055
R2378 B9.n204 B9.n203 0.7055
R2379 B9.n205 B9.n204 0.7055
R2380 B9.n206 B9.n205 0.7055
R2381 B9.n207 B9.n206 0.7055
R2382 B9.n208 B9.n207 0.7055
R2383 B9.n209 B9.n208 0.7055
R2384 B9.n210 B9.n209 0.7055
R2385 B9.n211 B9.n210 0.7055
R2386 B9.n212 B9.n211 0.7055
R2387 B9.n213 B9.n212 0.7055
R2388 B9.n214 B9.n213 0.7055
R2389 B9.n215 B9.n214 0.7055
R2390 B9.n216 B9.n215 0.7055
R2391 B9.n217 B9.n216 0.7055
R2392 B9.n218 B9.n217 0.7055
R2393 B9.n219 B9.n218 0.7055
R2394 B9.n220 B9.n219 0.7055
R2395 B9.n221 B9.n220 0.7055
R2396 B9.n222 B9.n221 0.7055
R2397 B9.n223 B9.n222 0.7055
R2398 B9.n224 B9.n223 0.7055
R2399 B9.n225 B9.n224 0.7055
R2400 B9.n226 B9.n225 0.7055
R2401 B9.n227 B9.n226 0.7055
R2402 B9.n228 B9.n227 0.7055
R2403 B9.n229 B9.n228 0.7055
R2404 B9.n230 B9.n229 0.7055
R2405 B9.n231 B9.n230 0.7055
R2406 B9.n232 B9.n231 0.7055
R2407 B9.n233 B9.n232 0.7055
R2408 B9.n234 B9.n233 0.7055
R2409 B9.n235 B9.n234 0.7055
R2410 B9.n236 B9.n235 0.7055
R2411 B9.n237 B9.n236 0.7055
R2412 B9.n238 B9.n237 0.7055
R2413 B9.n239 B9.n238 0.7055
R2414 B9.n240 B9.n239 0.7055
R2415 B9.n241 B9.n240 0.7055
R2416 B9.n242 B9.n241 0.7055
R2417 B9.n243 B9.n242 0.7055
R2418 B9.n244 B9.n243 0.7055
R2419 B9.n245 B9.n244 0.7055
R2420 B9.n246 B9.n245 0.7055
R2421 B9.n247 B9.n246 0.7055
R2422 B9.n248 B9.n247 0.7055
R2423 B9.n249 B9.n248 0.7055
R2424 B9.n250 B9.n249 0.7055
R2425 B9.n251 B9.n250 0.7055
R2426 B9.n252 B9.n251 0.7055
R2427 B9.n253 B9.n252 0.7055
R2428 B9.n316 B9.n315 0.7055
R2429 B9.n315 B9.n314 0.7055
R2430 B9.n314 B9.n313 0.7055
R2431 B9.n313 B9.n312 0.7055
R2432 B9.n312 B9.n311 0.7055
R2433 B9.n311 B9.n310 0.7055
R2434 B9.n310 B9.n309 0.7055
R2435 B9.n309 B9.n308 0.7055
R2436 B9.n308 B9.n307 0.7055
R2437 B9.n307 B9.n306 0.7055
R2438 B9.n306 B9.n305 0.7055
R2439 B9.n305 B9.n304 0.7055
R2440 B9.n304 B9.n303 0.7055
R2441 B9.n303 B9.n302 0.7055
R2442 B9.n302 B9.n301 0.7055
R2443 B9.n301 B9.n300 0.7055
R2444 B9.n300 B9.n299 0.7055
R2445 B9.n299 B9.n298 0.7055
R2446 B9.n298 B9.n297 0.7055
R2447 B9.n297 B9.n296 0.7055
R2448 B9.n296 B9.n295 0.7055
R2449 B9.n295 B9.n294 0.7055
R2450 B9.n294 B9.n293 0.7055
R2451 B9.n293 B9.n292 0.7055
R2452 B9.n292 B9.n291 0.7055
R2453 B9.n291 B9.n290 0.7055
R2454 B9.n290 B9.n289 0.7055
R2455 B9.n289 B9.n288 0.7055
R2456 B9.n288 B9.n287 0.7055
R2457 B9.n287 B9.n286 0.7055
R2458 B9.n286 B9.n285 0.7055
R2459 B9.n285 B9.n284 0.7055
R2460 B9.n284 B9.n283 0.7055
R2461 B9.n283 B9.n282 0.7055
R2462 B9.n282 B9.n281 0.7055
R2463 B9.n281 B9.n280 0.7055
R2464 B9.n280 B9.n279 0.7055
R2465 B9.n279 B9.n278 0.7055
R2466 B9.n278 B9.n277 0.7055
R2467 B9.n277 B9.n276 0.7055
R2468 B9.n276 B9.n275 0.7055
R2469 B9.n275 B9.n274 0.7055
R2470 B9.n274 B9.n273 0.7055
R2471 B9.n273 B9.n272 0.7055
R2472 B9.n272 B9.n271 0.7055
R2473 B9.n271 B9.n270 0.7055
R2474 B9.n270 B9.n269 0.7055
R2475 B9.n269 B9.n268 0.7055
R2476 B9.n268 B9.n267 0.7055
R2477 B9.n267 B9.n266 0.7055
R2478 B9.n266 B9.n265 0.7055
R2479 B9.n265 B9.n264 0.7055
R2480 B9.n264 B9.n263 0.7055
R2481 B9.n263 B9.n262 0.7055
R2482 B9.n262 B9.n261 0.7055
R2483 B9.n261 B9.n260 0.7055
R2484 B9.n260 B9.n259 0.7055
R2485 B9.n259 B9.n258 0.7055
R2486 B9.n258 B9.n257 0.7055
R2487 B9.n257 B9.n256 0.7055
R2488 B9.n256 B9.n255 0.7055
R2489 B9.n378 B9.n377 0.7055
R2490 B9.n377 B9.n376 0.7055
R2491 B9.n376 B9.n375 0.7055
R2492 B9.n375 B9.n374 0.7055
R2493 B9.n374 B9.n373 0.7055
R2494 B9.n373 B9.n372 0.7055
R2495 B9.n372 B9.n371 0.7055
R2496 B9.n371 B9.n370 0.7055
R2497 B9.n370 B9.n369 0.7055
R2498 B9.n369 B9.n368 0.7055
R2499 B9.n368 B9.n367 0.7055
R2500 B9.n367 B9.n366 0.7055
R2501 B9.n366 B9.n365 0.7055
R2502 B9.n365 B9.n364 0.7055
R2503 B9.n364 B9.n363 0.7055
R2504 B9.n363 B9.n362 0.7055
R2505 B9.n362 B9.n361 0.7055
R2506 B9.n361 B9.n360 0.7055
R2507 B9.n360 B9.n359 0.7055
R2508 B9.n359 B9.n358 0.7055
R2509 B9.n358 B9.n357 0.7055
R2510 B9.n357 B9.n356 0.7055
R2511 B9.n356 B9.n355 0.7055
R2512 B9.n355 B9.n354 0.7055
R2513 B9.n354 B9.n353 0.7055
R2514 B9.n353 B9.n352 0.7055
R2515 B9.n352 B9.n351 0.7055
R2516 B9.n351 B9.n350 0.7055
R2517 B9.n350 B9.n349 0.7055
R2518 B9.n349 B9.n348 0.7055
R2519 B9.n348 B9.n347 0.7055
R2520 B9.n347 B9.n346 0.7055
R2521 B9.n346 B9.n345 0.7055
R2522 B9.n345 B9.n344 0.7055
R2523 B9.n344 B9.n343 0.7055
R2524 B9.n343 B9.n342 0.7055
R2525 B9.n342 B9.n341 0.7055
R2526 B9.n341 B9.n340 0.7055
R2527 B9.n340 B9.n339 0.7055
R2528 B9.n339 B9.n338 0.7055
R2529 B9.n338 B9.n337 0.7055
R2530 B9.n337 B9.n336 0.7055
R2531 B9.n336 B9.n335 0.7055
R2532 B9.n335 B9.n334 0.7055
R2533 B9.n334 B9.n333 0.7055
R2534 B9.n333 B9.n332 0.7055
R2535 B9.n332 B9.n331 0.7055
R2536 B9.n331 B9.n330 0.7055
R2537 B9.n330 B9.n329 0.7055
R2538 B9.n329 B9.n328 0.7055
R2539 B9.n328 B9.n327 0.7055
R2540 B9.n327 B9.n326 0.7055
R2541 B9.n326 B9.n325 0.7055
R2542 B9.n325 B9.n324 0.7055
R2543 B9.n324 B9.n323 0.7055
R2544 B9.n323 B9.n322 0.7055
R2545 B9.n322 B9.n321 0.7055
R2546 B9.n321 B9.n320 0.7055
R2547 B9.n320 B9.n319 0.7055
R2548 B9.n319 B9.n318 0.7055
R2549 B9.n318 B9.n317 0.7055
R2550 B9.n441 B9.n440 0.7055
R2551 B9.n440 B9.n439 0.7055
R2552 B9.n439 B9.n438 0.7055
R2553 B9.n438 B9.n437 0.7055
R2554 B9.n437 B9.n436 0.7055
R2555 B9.n436 B9.n435 0.7055
R2556 B9.n435 B9.n434 0.7055
R2557 B9.n434 B9.n433 0.7055
R2558 B9.n433 B9.n432 0.7055
R2559 B9.n432 B9.n431 0.7055
R2560 B9.n431 B9.n430 0.7055
R2561 B9.n430 B9.n429 0.7055
R2562 B9.n429 B9.n428 0.7055
R2563 B9.n428 B9.n427 0.7055
R2564 B9.n427 B9.n426 0.7055
R2565 B9.n426 B9.n425 0.7055
R2566 B9.n425 B9.n424 0.7055
R2567 B9.n424 B9.n423 0.7055
R2568 B9.n423 B9.n422 0.7055
R2569 B9.n422 B9.n421 0.7055
R2570 B9.n421 B9.n420 0.7055
R2571 B9.n420 B9.n419 0.7055
R2572 B9.n419 B9.n418 0.7055
R2573 B9.n418 B9.n417 0.7055
R2574 B9.n417 B9.n416 0.7055
R2575 B9.n416 B9.n415 0.7055
R2576 B9.n415 B9.n414 0.7055
R2577 B9.n414 B9.n413 0.7055
R2578 B9.n413 B9.n412 0.7055
R2579 B9.n412 B9.n411 0.7055
R2580 B9.n411 B9.n410 0.7055
R2581 B9.n410 B9.n409 0.7055
R2582 B9.n409 B9.n408 0.7055
R2583 B9.n408 B9.n407 0.7055
R2584 B9.n407 B9.n406 0.7055
R2585 B9.n406 B9.n405 0.7055
R2586 B9.n405 B9.n404 0.7055
R2587 B9.n404 B9.n403 0.7055
R2588 B9.n403 B9.n402 0.7055
R2589 B9.n402 B9.n401 0.7055
R2590 B9.n401 B9.n400 0.7055
R2591 B9.n400 B9.n399 0.7055
R2592 B9.n399 B9.n398 0.7055
R2593 B9.n398 B9.n397 0.7055
R2594 B9.n397 B9.n396 0.7055
R2595 B9.n396 B9.n395 0.7055
R2596 B9.n395 B9.n394 0.7055
R2597 B9.n394 B9.n393 0.7055
R2598 B9.n393 B9.n392 0.7055
R2599 B9.n392 B9.n391 0.7055
R2600 B9.n391 B9.n390 0.7055
R2601 B9.n390 B9.n389 0.7055
R2602 B9.n389 B9.n388 0.7055
R2603 B9.n388 B9.n387 0.7055
R2604 B9.n387 B9.n386 0.7055
R2605 B9.n386 B9.n385 0.7055
R2606 B9.n385 B9.n384 0.7055
R2607 B9.n384 B9.n383 0.7055
R2608 B9.n383 B9.n382 0.7055
R2609 B9.n382 B9.n381 0.7055
R2610 B9.n381 B9.n380 0.7055
R2611 B9.n504 B9.n503 0.7055
R2612 B9.n503 B9.n502 0.7055
R2613 B9.n502 B9.n501 0.7055
R2614 B9.n501 B9.n500 0.7055
R2615 B9.n500 B9.n499 0.7055
R2616 B9.n499 B9.n498 0.7055
R2617 B9.n498 B9.n497 0.7055
R2618 B9.n497 B9.n496 0.7055
R2619 B9.n496 B9.n495 0.7055
R2620 B9.n495 B9.n494 0.7055
R2621 B9.n494 B9.n493 0.7055
R2622 B9.n493 B9.n492 0.7055
R2623 B9.n492 B9.n491 0.7055
R2624 B9.n491 B9.n490 0.7055
R2625 B9.n490 B9.n489 0.7055
R2626 B9.n489 B9.n488 0.7055
R2627 B9.n488 B9.n487 0.7055
R2628 B9.n487 B9.n486 0.7055
R2629 B9.n486 B9.n485 0.7055
R2630 B9.n485 B9.n484 0.7055
R2631 B9.n484 B9.n483 0.7055
R2632 B9.n483 B9.n482 0.7055
R2633 B9.n482 B9.n481 0.7055
R2634 B9.n481 B9.n480 0.7055
R2635 B9.n480 B9.n479 0.7055
R2636 B9.n479 B9.n478 0.7055
R2637 B9.n478 B9.n477 0.7055
R2638 B9.n477 B9.n476 0.7055
R2639 B9.n476 B9.n475 0.7055
R2640 B9.n475 B9.n474 0.7055
R2641 B9.n474 B9.n473 0.7055
R2642 B9.n473 B9.n472 0.7055
R2643 B9.n472 B9.n471 0.7055
R2644 B9.n471 B9.n470 0.7055
R2645 B9.n470 B9.n469 0.7055
R2646 B9.n469 B9.n468 0.7055
R2647 B9.n468 B9.n467 0.7055
R2648 B9.n467 B9.n466 0.7055
R2649 B9.n466 B9.n465 0.7055
R2650 B9.n465 B9.n464 0.7055
R2651 B9.n464 B9.n463 0.7055
R2652 B9.n463 B9.n462 0.7055
R2653 B9.n462 B9.n461 0.7055
R2654 B9.n461 B9.n460 0.7055
R2655 B9.n460 B9.n459 0.7055
R2656 B9.n459 B9.n458 0.7055
R2657 B9.n458 B9.n457 0.7055
R2658 B9.n457 B9.n456 0.7055
R2659 B9.n456 B9.n455 0.7055
R2660 B9.n455 B9.n454 0.7055
R2661 B9.n454 B9.n453 0.7055
R2662 B9.n453 B9.n452 0.7055
R2663 B9.n452 B9.n451 0.7055
R2664 B9.n451 B9.n450 0.7055
R2665 B9.n450 B9.n449 0.7055
R2666 B9.n449 B9.n448 0.7055
R2667 B9.n448 B9.n447 0.7055
R2668 B9.n447 B9.n446 0.7055
R2669 B9.n446 B9.n445 0.7055
R2670 B9.n445 B9.n444 0.7055
R2671 B9.n444 B9.n443 0.7055
R2672 B9.n64 B9.t256 0.324663
R2673 B9.n63 B9.t257 0.324663
R2674 B9.n62 B9.t258 0.324663
R2675 B9.n61 B9.t259 0.324663
R2676 B9.n60 B9.t260 0.324663
R2677 B9.n59 B9.t261 0.324663
R2678 B9.n58 B9.t262 0.324663
R2679 B9.n57 B9.t263 0.324663
R2680 B9.n56 B9.t264 0.324663
R2681 B9.n55 B9.t265 0.324663
R2682 B9.n54 B9.t266 0.324663
R2683 B9.n53 B9.t267 0.324663
R2684 B9.n52 B9.t268 0.324663
R2685 B9.n51 B9.t269 0.324663
R2686 B9.n50 B9.t270 0.324663
R2687 B9.n49 B9.t271 0.324663
R2688 B9.n48 B9.t272 0.324663
R2689 B9.n47 B9.t273 0.324663
R2690 B9.n46 B9.t274 0.324663
R2691 B9.n45 B9.t275 0.324663
R2692 B9.n44 B9.t276 0.324663
R2693 B9.n43 B9.t277 0.324663
R2694 B9.n42 B9.t278 0.324663
R2695 B9.n41 B9.t279 0.324663
R2696 B9.n40 B9.t280 0.324663
R2697 B9.n39 B9.t281 0.324663
R2698 B9.n38 B9.t282 0.324663
R2699 B9.n37 B9.t283 0.324663
R2700 B9.n36 B9.t284 0.324663
R2701 B9.n35 B9.t285 0.324663
R2702 B9.n34 B9.t286 0.324663
R2703 B9.n33 B9.t287 0.324663
R2704 B9.n32 B9.t288 0.324663
R2705 B9.n31 B9.t289 0.324663
R2706 B9.n30 B9.t290 0.324663
R2707 B9.n29 B9.t291 0.324663
R2708 B9.n28 B9.t292 0.324663
R2709 B9.n27 B9.t293 0.324663
R2710 B9.n26 B9.t294 0.324663
R2711 B9.n25 B9.t295 0.324663
R2712 B9.n24 B9.t296 0.324663
R2713 B9.n23 B9.t297 0.324663
R2714 B9.n22 B9.t298 0.324663
R2715 B9.n21 B9.t299 0.324663
R2716 B9.n20 B9.t300 0.324663
R2717 B9.n19 B9.t301 0.324663
R2718 B9.n18 B9.t302 0.324663
R2719 B9.n17 B9.t303 0.324663
R2720 B9.n16 B9.t304 0.324663
R2721 B9.n15 B9.t305 0.324663
R2722 B9.n14 B9.t306 0.324663
R2723 B9.n13 B9.t307 0.324663
R2724 B9.n12 B9.t308 0.324663
R2725 B9.n11 B9.t309 0.324663
R2726 B9.n10 B9.t310 0.324663
R2727 B9.n9 B9.t311 0.324663
R2728 B9.n8 B9.t312 0.324663
R2729 B9.n7 B9.t313 0.324663
R2730 B9.n6 B9.t314 0.324663
R2731 B9.n5 B9.t315 0.324663
R2732 B9.n4 B9.t316 0.324663
R2733 B9.n3 B9.t317 0.324663
R2734 B9.n127 B9.t319 0.324663
R2735 B9.n126 B9.t320 0.324663
R2736 B9.n125 B9.t321 0.324663
R2737 B9.n124 B9.t322 0.324663
R2738 B9.n123 B9.t323 0.324663
R2739 B9.n122 B9.t324 0.324663
R2740 B9.n121 B9.t325 0.324663
R2741 B9.n120 B9.t326 0.324663
R2742 B9.n119 B9.t327 0.324663
R2743 B9.n118 B9.t328 0.324663
R2744 B9.n117 B9.t329 0.324663
R2745 B9.n116 B9.t330 0.324663
R2746 B9.n115 B9.t331 0.324663
R2747 B9.n114 B9.t332 0.324663
R2748 B9.n113 B9.t333 0.324663
R2749 B9.n112 B9.t334 0.324663
R2750 B9.n111 B9.t335 0.324663
R2751 B9.n110 B9.t336 0.324663
R2752 B9.n109 B9.t337 0.324663
R2753 B9.n108 B9.t338 0.324663
R2754 B9.n107 B9.t339 0.324663
R2755 B9.n106 B9.t340 0.324663
R2756 B9.n105 B9.t341 0.324663
R2757 B9.n104 B9.t342 0.324663
R2758 B9.n103 B9.t343 0.324663
R2759 B9.n102 B9.t344 0.324663
R2760 B9.n101 B9.t345 0.324663
R2761 B9.n100 B9.t346 0.324663
R2762 B9.n99 B9.t347 0.324663
R2763 B9.n98 B9.t348 0.324663
R2764 B9.n97 B9.t349 0.324663
R2765 B9.n96 B9.t350 0.324663
R2766 B9.n95 B9.t351 0.324663
R2767 B9.n94 B9.t352 0.324663
R2768 B9.n93 B9.t353 0.324663
R2769 B9.n92 B9.t354 0.324663
R2770 B9.n91 B9.t355 0.324663
R2771 B9.n90 B9.t356 0.324663
R2772 B9.n89 B9.t357 0.324663
R2773 B9.n88 B9.t358 0.324663
R2774 B9.n87 B9.t359 0.324663
R2775 B9.n86 B9.t360 0.324663
R2776 B9.n85 B9.t361 0.324663
R2777 B9.n84 B9.t362 0.324663
R2778 B9.n83 B9.t363 0.324663
R2779 B9.n82 B9.t364 0.324663
R2780 B9.n81 B9.t365 0.324663
R2781 B9.n80 B9.t366 0.324663
R2782 B9.n79 B9.t367 0.324663
R2783 B9.n78 B9.t368 0.324663
R2784 B9.n77 B9.t369 0.324663
R2785 B9.n76 B9.t370 0.324663
R2786 B9.n75 B9.t371 0.324663
R2787 B9.n74 B9.t372 0.324663
R2788 B9.n73 B9.t373 0.324663
R2789 B9.n72 B9.t374 0.324663
R2790 B9.n71 B9.t375 0.324663
R2791 B9.n70 B9.t376 0.324663
R2792 B9.n69 B9.t377 0.324663
R2793 B9.n68 B9.t378 0.324663
R2794 B9.n67 B9.t379 0.324663
R2795 B9.n66 B9.t380 0.324663
R2796 B9.n190 B9.t382 0.324663
R2797 B9.n189 B9.t383 0.324663
R2798 B9.n188 B9.t384 0.324663
R2799 B9.n187 B9.t385 0.324663
R2800 B9.n186 B9.t386 0.324663
R2801 B9.n185 B9.t387 0.324663
R2802 B9.n184 B9.t388 0.324663
R2803 B9.n183 B9.t389 0.324663
R2804 B9.n182 B9.t390 0.324663
R2805 B9.n181 B9.t391 0.324663
R2806 B9.n180 B9.t392 0.324663
R2807 B9.n179 B9.t393 0.324663
R2808 B9.n178 B9.t394 0.324663
R2809 B9.n177 B9.t395 0.324663
R2810 B9.n176 B9.t396 0.324663
R2811 B9.n175 B9.t397 0.324663
R2812 B9.n174 B9.t398 0.324663
R2813 B9.n173 B9.t399 0.324663
R2814 B9.n172 B9.t400 0.324663
R2815 B9.n171 B9.t401 0.324663
R2816 B9.n170 B9.t402 0.324663
R2817 B9.n169 B9.t403 0.324663
R2818 B9.n168 B9.t404 0.324663
R2819 B9.n167 B9.t405 0.324663
R2820 B9.n166 B9.t406 0.324663
R2821 B9.n165 B9.t407 0.324663
R2822 B9.n164 B9.t408 0.324663
R2823 B9.n163 B9.t409 0.324663
R2824 B9.n162 B9.t410 0.324663
R2825 B9.n161 B9.t411 0.324663
R2826 B9.n160 B9.t412 0.324663
R2827 B9.n159 B9.t413 0.324663
R2828 B9.n158 B9.t414 0.324663
R2829 B9.n157 B9.t415 0.324663
R2830 B9.n156 B9.t416 0.324663
R2831 B9.n155 B9.t417 0.324663
R2832 B9.n154 B9.t418 0.324663
R2833 B9.n153 B9.t419 0.324663
R2834 B9.n152 B9.t420 0.324663
R2835 B9.n151 B9.t421 0.324663
R2836 B9.n150 B9.t422 0.324663
R2837 B9.n149 B9.t423 0.324663
R2838 B9.n148 B9.t424 0.324663
R2839 B9.n147 B9.t425 0.324663
R2840 B9.n146 B9.t426 0.324663
R2841 B9.n145 B9.t427 0.324663
R2842 B9.n144 B9.t428 0.324663
R2843 B9.n143 B9.t429 0.324663
R2844 B9.n142 B9.t430 0.324663
R2845 B9.n141 B9.t431 0.324663
R2846 B9.n140 B9.t432 0.324663
R2847 B9.n139 B9.t433 0.324663
R2848 B9.n138 B9.t434 0.324663
R2849 B9.n137 B9.t435 0.324663
R2850 B9.n136 B9.t436 0.324663
R2851 B9.n135 B9.t437 0.324663
R2852 B9.n134 B9.t438 0.324663
R2853 B9.n133 B9.t439 0.324663
R2854 B9.n132 B9.t440 0.324663
R2855 B9.n131 B9.t441 0.324663
R2856 B9.n130 B9.t442 0.324663
R2857 B9.n129 B9.t443 0.324663
R2858 B9.n253 B9.t445 0.324663
R2859 B9.n252 B9.t446 0.324663
R2860 B9.n251 B9.t447 0.324663
R2861 B9.n250 B9.t448 0.324663
R2862 B9.n249 B9.t449 0.324663
R2863 B9.n248 B9.t450 0.324663
R2864 B9.n247 B9.t451 0.324663
R2865 B9.n246 B9.t452 0.324663
R2866 B9.n245 B9.t453 0.324663
R2867 B9.n244 B9.t454 0.324663
R2868 B9.n243 B9.t455 0.324663
R2869 B9.n242 B9.t456 0.324663
R2870 B9.n241 B9.t457 0.324663
R2871 B9.n240 B9.t458 0.324663
R2872 B9.n239 B9.t459 0.324663
R2873 B9.n238 B9.t460 0.324663
R2874 B9.n237 B9.t461 0.324663
R2875 B9.n236 B9.t462 0.324663
R2876 B9.n235 B9.t463 0.324663
R2877 B9.n234 B9.t464 0.324663
R2878 B9.n233 B9.t465 0.324663
R2879 B9.n232 B9.t466 0.324663
R2880 B9.n231 B9.t467 0.324663
R2881 B9.n230 B9.t468 0.324663
R2882 B9.n229 B9.t469 0.324663
R2883 B9.n228 B9.t470 0.324663
R2884 B9.n227 B9.t471 0.324663
R2885 B9.n226 B9.t472 0.324663
R2886 B9.n225 B9.t473 0.324663
R2887 B9.n224 B9.t474 0.324663
R2888 B9.n223 B9.t475 0.324663
R2889 B9.n222 B9.t476 0.324663
R2890 B9.n221 B9.t477 0.324663
R2891 B9.n220 B9.t478 0.324663
R2892 B9.n219 B9.t479 0.324663
R2893 B9.n218 B9.t480 0.324663
R2894 B9.n217 B9.t481 0.324663
R2895 B9.n216 B9.t482 0.324663
R2896 B9.n215 B9.t483 0.324663
R2897 B9.n214 B9.t484 0.324663
R2898 B9.n213 B9.t485 0.324663
R2899 B9.n212 B9.t486 0.324663
R2900 B9.n211 B9.t487 0.324663
R2901 B9.n210 B9.t488 0.324663
R2902 B9.n209 B9.t489 0.324663
R2903 B9.n208 B9.t490 0.324663
R2904 B9.n207 B9.t491 0.324663
R2905 B9.n206 B9.t492 0.324663
R2906 B9.n205 B9.t493 0.324663
R2907 B9.n204 B9.t494 0.324663
R2908 B9.n203 B9.t495 0.324663
R2909 B9.n202 B9.t496 0.324663
R2910 B9.n201 B9.t497 0.324663
R2911 B9.n200 B9.t498 0.324663
R2912 B9.n199 B9.t499 0.324663
R2913 B9.n198 B9.t500 0.324663
R2914 B9.n197 B9.t501 0.324663
R2915 B9.n196 B9.t502 0.324663
R2916 B9.n195 B9.t503 0.324663
R2917 B9.n194 B9.t504 0.324663
R2918 B9.n193 B9.t505 0.324663
R2919 B9.n192 B9.t506 0.324663
R2920 B9.n255 B9.t5 0.324663
R2921 B9.n256 B9.t6 0.324663
R2922 B9.n257 B9.t7 0.324663
R2923 B9.n258 B9.t8 0.324663
R2924 B9.n259 B9.t9 0.324663
R2925 B9.n260 B9.t10 0.324663
R2926 B9.n261 B9.t11 0.324663
R2927 B9.n262 B9.t12 0.324663
R2928 B9.n263 B9.t13 0.324663
R2929 B9.n264 B9.t14 0.324663
R2930 B9.n265 B9.t15 0.324663
R2931 B9.n266 B9.t16 0.324663
R2932 B9.n267 B9.t17 0.324663
R2933 B9.n268 B9.t18 0.324663
R2934 B9.n269 B9.t19 0.324663
R2935 B9.n270 B9.t20 0.324663
R2936 B9.n271 B9.t21 0.324663
R2937 B9.n272 B9.t22 0.324663
R2938 B9.n273 B9.t23 0.324663
R2939 B9.n274 B9.t24 0.324663
R2940 B9.n275 B9.t25 0.324663
R2941 B9.n276 B9.t26 0.324663
R2942 B9.n277 B9.t27 0.324663
R2943 B9.n278 B9.t28 0.324663
R2944 B9.n279 B9.t29 0.324663
R2945 B9.n280 B9.t30 0.324663
R2946 B9.n281 B9.t31 0.324663
R2947 B9.n282 B9.t32 0.324663
R2948 B9.n283 B9.t33 0.324663
R2949 B9.n284 B9.t34 0.324663
R2950 B9.n285 B9.t35 0.324663
R2951 B9.n286 B9.t36 0.324663
R2952 B9.n287 B9.t37 0.324663
R2953 B9.n288 B9.t38 0.324663
R2954 B9.n289 B9.t39 0.324663
R2955 B9.n290 B9.t40 0.324663
R2956 B9.n291 B9.t41 0.324663
R2957 B9.n292 B9.t42 0.324663
R2958 B9.n293 B9.t43 0.324663
R2959 B9.n294 B9.t44 0.324663
R2960 B9.n295 B9.t45 0.324663
R2961 B9.n296 B9.t46 0.324663
R2962 B9.n297 B9.t47 0.324663
R2963 B9.n298 B9.t48 0.324663
R2964 B9.n299 B9.t49 0.324663
R2965 B9.n300 B9.t50 0.324663
R2966 B9.n301 B9.t51 0.324663
R2967 B9.n302 B9.t52 0.324663
R2968 B9.n303 B9.t53 0.324663
R2969 B9.n304 B9.t54 0.324663
R2970 B9.n305 B9.t55 0.324663
R2971 B9.n306 B9.t56 0.324663
R2972 B9.n307 B9.t57 0.324663
R2973 B9.n308 B9.t58 0.324663
R2974 B9.n309 B9.t59 0.324663
R2975 B9.n310 B9.t60 0.324663
R2976 B9.n311 B9.t61 0.324663
R2977 B9.n312 B9.t62 0.324663
R2978 B9.n313 B9.t63 0.324663
R2979 B9.n314 B9.t64 0.324663
R2980 B9.n315 B9.t65 0.324663
R2981 B9.n316 B9.t66 0.324663
R2982 B9.n317 B9.t68 0.324663
R2983 B9.n318 B9.t69 0.324663
R2984 B9.n319 B9.t70 0.324663
R2985 B9.n320 B9.t71 0.324663
R2986 B9.n321 B9.t72 0.324663
R2987 B9.n322 B9.t73 0.324663
R2988 B9.n323 B9.t74 0.324663
R2989 B9.n324 B9.t75 0.324663
R2990 B9.n325 B9.t76 0.324663
R2991 B9.n326 B9.t77 0.324663
R2992 B9.n327 B9.t78 0.324663
R2993 B9.n328 B9.t79 0.324663
R2994 B9.n329 B9.t80 0.324663
R2995 B9.n330 B9.t81 0.324663
R2996 B9.n331 B9.t82 0.324663
R2997 B9.n332 B9.t83 0.324663
R2998 B9.n333 B9.t84 0.324663
R2999 B9.n334 B9.t85 0.324663
R3000 B9.n335 B9.t86 0.324663
R3001 B9.n336 B9.t87 0.324663
R3002 B9.n337 B9.t88 0.324663
R3003 B9.n338 B9.t89 0.324663
R3004 B9.n339 B9.t90 0.324663
R3005 B9.n340 B9.t91 0.324663
R3006 B9.n341 B9.t92 0.324663
R3007 B9.n342 B9.t93 0.324663
R3008 B9.n343 B9.t94 0.324663
R3009 B9.n344 B9.t95 0.324663
R3010 B9.n345 B9.t96 0.324663
R3011 B9.n346 B9.t97 0.324663
R3012 B9.n347 B9.t98 0.324663
R3013 B9.n348 B9.t99 0.324663
R3014 B9.n349 B9.t100 0.324663
R3015 B9.n350 B9.t101 0.324663
R3016 B9.n351 B9.t102 0.324663
R3017 B9.n352 B9.t103 0.324663
R3018 B9.n353 B9.t104 0.324663
R3019 B9.n354 B9.t105 0.324663
R3020 B9.n355 B9.t106 0.324663
R3021 B9.n356 B9.t107 0.324663
R3022 B9.n357 B9.t108 0.324663
R3023 B9.n358 B9.t109 0.324663
R3024 B9.n359 B9.t110 0.324663
R3025 B9.n360 B9.t111 0.324663
R3026 B9.n361 B9.t112 0.324663
R3027 B9.n362 B9.t113 0.324663
R3028 B9.n363 B9.t114 0.324663
R3029 B9.n364 B9.t115 0.324663
R3030 B9.n365 B9.t116 0.324663
R3031 B9.n366 B9.t117 0.324663
R3032 B9.n367 B9.t118 0.324663
R3033 B9.n368 B9.t119 0.324663
R3034 B9.n369 B9.t120 0.324663
R3035 B9.n370 B9.t121 0.324663
R3036 B9.n371 B9.t122 0.324663
R3037 B9.n372 B9.t123 0.324663
R3038 B9.n373 B9.t124 0.324663
R3039 B9.n374 B9.t125 0.324663
R3040 B9.n375 B9.t126 0.324663
R3041 B9.n376 B9.t127 0.324663
R3042 B9.n377 B9.t128 0.324663
R3043 B9.n378 B9.t129 0.324663
R3044 B9.n380 B9.t131 0.324663
R3045 B9.n381 B9.t132 0.324663
R3046 B9.n382 B9.t133 0.324663
R3047 B9.n383 B9.t134 0.324663
R3048 B9.n384 B9.t135 0.324663
R3049 B9.n385 B9.t136 0.324663
R3050 B9.n386 B9.t137 0.324663
R3051 B9.n387 B9.t138 0.324663
R3052 B9.n388 B9.t139 0.324663
R3053 B9.n389 B9.t140 0.324663
R3054 B9.n390 B9.t141 0.324663
R3055 B9.n391 B9.t142 0.324663
R3056 B9.n392 B9.t143 0.324663
R3057 B9.n393 B9.t144 0.324663
R3058 B9.n394 B9.t145 0.324663
R3059 B9.n395 B9.t146 0.324663
R3060 B9.n396 B9.t147 0.324663
R3061 B9.n397 B9.t148 0.324663
R3062 B9.n398 B9.t149 0.324663
R3063 B9.n399 B9.t150 0.324663
R3064 B9.n400 B9.t151 0.324663
R3065 B9.n401 B9.t152 0.324663
R3066 B9.n402 B9.t153 0.324663
R3067 B9.n403 B9.t154 0.324663
R3068 B9.n404 B9.t155 0.324663
R3069 B9.n405 B9.t156 0.324663
R3070 B9.n406 B9.t157 0.324663
R3071 B9.n407 B9.t158 0.324663
R3072 B9.n408 B9.t159 0.324663
R3073 B9.n409 B9.t160 0.324663
R3074 B9.n410 B9.t161 0.324663
R3075 B9.n411 B9.t162 0.324663
R3076 B9.n412 B9.t163 0.324663
R3077 B9.n413 B9.t164 0.324663
R3078 B9.n414 B9.t165 0.324663
R3079 B9.n415 B9.t166 0.324663
R3080 B9.n416 B9.t167 0.324663
R3081 B9.n417 B9.t168 0.324663
R3082 B9.n418 B9.t169 0.324663
R3083 B9.n419 B9.t170 0.324663
R3084 B9.n420 B9.t171 0.324663
R3085 B9.n421 B9.t172 0.324663
R3086 B9.n422 B9.t173 0.324663
R3087 B9.n423 B9.t174 0.324663
R3088 B9.n424 B9.t175 0.324663
R3089 B9.n425 B9.t176 0.324663
R3090 B9.n426 B9.t177 0.324663
R3091 B9.n427 B9.t178 0.324663
R3092 B9.n428 B9.t179 0.324663
R3093 B9.n429 B9.t180 0.324663
R3094 B9.n430 B9.t181 0.324663
R3095 B9.n431 B9.t182 0.324663
R3096 B9.n432 B9.t183 0.324663
R3097 B9.n433 B9.t184 0.324663
R3098 B9.n434 B9.t185 0.324663
R3099 B9.n435 B9.t186 0.324663
R3100 B9.n436 B9.t187 0.324663
R3101 B9.n437 B9.t188 0.324663
R3102 B9.n438 B9.t189 0.324663
R3103 B9.n439 B9.t190 0.324663
R3104 B9.n440 B9.t191 0.324663
R3105 B9.n441 B9.t192 0.324663
R3106 B9.n443 B9.t194 0.324663
R3107 B9.n444 B9.t195 0.324663
R3108 B9.n445 B9.t196 0.324663
R3109 B9.n446 B9.t197 0.324663
R3110 B9.n447 B9.t198 0.324663
R3111 B9.n448 B9.t199 0.324663
R3112 B9.n449 B9.t200 0.324663
R3113 B9.n450 B9.t201 0.324663
R3114 B9.n451 B9.t202 0.324663
R3115 B9.n452 B9.t203 0.324663
R3116 B9.n453 B9.t204 0.324663
R3117 B9.n454 B9.t205 0.324663
R3118 B9.n455 B9.t206 0.324663
R3119 B9.n456 B9.t207 0.324663
R3120 B9.n457 B9.t208 0.324663
R3121 B9.n458 B9.t209 0.324663
R3122 B9.n459 B9.t210 0.324663
R3123 B9.n460 B9.t211 0.324663
R3124 B9.n461 B9.t212 0.324663
R3125 B9.n462 B9.t213 0.324663
R3126 B9.n463 B9.t214 0.324663
R3127 B9.n464 B9.t215 0.324663
R3128 B9.n465 B9.t216 0.324663
R3129 B9.n466 B9.t217 0.324663
R3130 B9.n467 B9.t218 0.324663
R3131 B9.n468 B9.t219 0.324663
R3132 B9.n469 B9.t220 0.324663
R3133 B9.n470 B9.t221 0.324663
R3134 B9.n471 B9.t222 0.324663
R3135 B9.n472 B9.t223 0.324663
R3136 B9.n473 B9.t224 0.324663
R3137 B9.n474 B9.t225 0.324663
R3138 B9.n475 B9.t226 0.324663
R3139 B9.n476 B9.t227 0.324663
R3140 B9.n477 B9.t228 0.324663
R3141 B9.n478 B9.t229 0.324663
R3142 B9.n479 B9.t230 0.324663
R3143 B9.n480 B9.t231 0.324663
R3144 B9.n481 B9.t232 0.324663
R3145 B9.n482 B9.t233 0.324663
R3146 B9.n483 B9.t234 0.324663
R3147 B9.n484 B9.t235 0.324663
R3148 B9.n485 B9.t236 0.324663
R3149 B9.n486 B9.t237 0.324663
R3150 B9.n487 B9.t238 0.324663
R3151 B9.n488 B9.t239 0.324663
R3152 B9.n489 B9.t240 0.324663
R3153 B9.n490 B9.t241 0.324663
R3154 B9.n491 B9.t242 0.324663
R3155 B9.n492 B9.t243 0.324663
R3156 B9.n493 B9.t244 0.324663
R3157 B9.n494 B9.t245 0.324663
R3158 B9.n495 B9.t246 0.324663
R3159 B9.n496 B9.t247 0.324663
R3160 B9.n497 B9.t248 0.324663
R3161 B9.n498 B9.t249 0.324663
R3162 B9.n499 B9.t250 0.324663
R3163 B9.n500 B9.t251 0.324663
R3164 B9.n501 B9.t252 0.324663
R3165 B9.n502 B9.t253 0.324663
R3166 B9.n503 B9.t254 0.324663
R3167 B9.n504 B9.t255 0.324663
R3168 B9.n1 B9.n0 0.10925
R3169 B9.n2 B9.n1 0.10925
R3170 B9.n128 B9.n65 0.10925
R3171 B9.n191 B9.n128 0.10925
R3172 B9.n254 B9.n191 0.10925
R3173 B9.n442 B9.n379 0.10925
R3174 B9.n505 B9.n442 0.10925
R3175 B9.n507 B9.n506 0.10925
R3176 B9.n508 B9.n507 0.10925
R3177 B9.n509 B9.n508 0.10925
R3178 B8 B8.n253 27.8726
R3179 B8 B8.n126 24.8721
R3180 B8.n63 B8.n0 3.37175
R3181 B8.n252 B8.n251 3.37175
R3182 B8.n0 B8.t0 2.78036
R3183 B8.n0 B8.t1 2.67161
R3184 B8.n252 B8.t254 2.50006
R3185 B8.n253 B8.t255 2.50006
R3186 B8.n63 B8.n62 2.34745
R3187 B8.n126 B8.n125 2.34745
R3188 B8.n251 B8.n188 2.28465
R3189 B8.n251 B8.n250 2.1759
R3190 B8.n1 B8.t190 1.02966
R3191 B8.n64 B8.t253 1.02966
R3192 B8.n127 B8.t2 1.02966
R3193 B8.n189 B8.t65 1.02966
R3194 B8.n2 B8.n1 0.7055
R3195 B8.n3 B8.n2 0.7055
R3196 B8.n4 B8.n3 0.7055
R3197 B8.n5 B8.n4 0.7055
R3198 B8.n6 B8.n5 0.7055
R3199 B8.n7 B8.n6 0.7055
R3200 B8.n8 B8.n7 0.7055
R3201 B8.n9 B8.n8 0.7055
R3202 B8.n10 B8.n9 0.7055
R3203 B8.n11 B8.n10 0.7055
R3204 B8.n12 B8.n11 0.7055
R3205 B8.n13 B8.n12 0.7055
R3206 B8.n14 B8.n13 0.7055
R3207 B8.n15 B8.n14 0.7055
R3208 B8.n16 B8.n15 0.7055
R3209 B8.n17 B8.n16 0.7055
R3210 B8.n18 B8.n17 0.7055
R3211 B8.n19 B8.n18 0.7055
R3212 B8.n20 B8.n19 0.7055
R3213 B8.n21 B8.n20 0.7055
R3214 B8.n22 B8.n21 0.7055
R3215 B8.n23 B8.n22 0.7055
R3216 B8.n24 B8.n23 0.7055
R3217 B8.n25 B8.n24 0.7055
R3218 B8.n26 B8.n25 0.7055
R3219 B8.n27 B8.n26 0.7055
R3220 B8.n28 B8.n27 0.7055
R3221 B8.n29 B8.n28 0.7055
R3222 B8.n30 B8.n29 0.7055
R3223 B8.n31 B8.n30 0.7055
R3224 B8.n32 B8.n31 0.7055
R3225 B8.n33 B8.n32 0.7055
R3226 B8.n34 B8.n33 0.7055
R3227 B8.n35 B8.n34 0.7055
R3228 B8.n36 B8.n35 0.7055
R3229 B8.n37 B8.n36 0.7055
R3230 B8.n38 B8.n37 0.7055
R3231 B8.n39 B8.n38 0.7055
R3232 B8.n40 B8.n39 0.7055
R3233 B8.n41 B8.n40 0.7055
R3234 B8.n42 B8.n41 0.7055
R3235 B8.n43 B8.n42 0.7055
R3236 B8.n44 B8.n43 0.7055
R3237 B8.n45 B8.n44 0.7055
R3238 B8.n46 B8.n45 0.7055
R3239 B8.n47 B8.n46 0.7055
R3240 B8.n48 B8.n47 0.7055
R3241 B8.n49 B8.n48 0.7055
R3242 B8.n50 B8.n49 0.7055
R3243 B8.n51 B8.n50 0.7055
R3244 B8.n52 B8.n51 0.7055
R3245 B8.n53 B8.n52 0.7055
R3246 B8.n54 B8.n53 0.7055
R3247 B8.n55 B8.n54 0.7055
R3248 B8.n56 B8.n55 0.7055
R3249 B8.n57 B8.n56 0.7055
R3250 B8.n58 B8.n57 0.7055
R3251 B8.n59 B8.n58 0.7055
R3252 B8.n60 B8.n59 0.7055
R3253 B8.n61 B8.n60 0.7055
R3254 B8.n62 B8.n61 0.7055
R3255 B8.n65 B8.n64 0.7055
R3256 B8.n66 B8.n65 0.7055
R3257 B8.n67 B8.n66 0.7055
R3258 B8.n68 B8.n67 0.7055
R3259 B8.n69 B8.n68 0.7055
R3260 B8.n70 B8.n69 0.7055
R3261 B8.n71 B8.n70 0.7055
R3262 B8.n72 B8.n71 0.7055
R3263 B8.n73 B8.n72 0.7055
R3264 B8.n74 B8.n73 0.7055
R3265 B8.n75 B8.n74 0.7055
R3266 B8.n76 B8.n75 0.7055
R3267 B8.n77 B8.n76 0.7055
R3268 B8.n78 B8.n77 0.7055
R3269 B8.n79 B8.n78 0.7055
R3270 B8.n80 B8.n79 0.7055
R3271 B8.n81 B8.n80 0.7055
R3272 B8.n82 B8.n81 0.7055
R3273 B8.n83 B8.n82 0.7055
R3274 B8.n84 B8.n83 0.7055
R3275 B8.n85 B8.n84 0.7055
R3276 B8.n86 B8.n85 0.7055
R3277 B8.n87 B8.n86 0.7055
R3278 B8.n88 B8.n87 0.7055
R3279 B8.n89 B8.n88 0.7055
R3280 B8.n90 B8.n89 0.7055
R3281 B8.n91 B8.n90 0.7055
R3282 B8.n92 B8.n91 0.7055
R3283 B8.n93 B8.n92 0.7055
R3284 B8.n94 B8.n93 0.7055
R3285 B8.n95 B8.n94 0.7055
R3286 B8.n96 B8.n95 0.7055
R3287 B8.n97 B8.n96 0.7055
R3288 B8.n98 B8.n97 0.7055
R3289 B8.n99 B8.n98 0.7055
R3290 B8.n100 B8.n99 0.7055
R3291 B8.n101 B8.n100 0.7055
R3292 B8.n102 B8.n101 0.7055
R3293 B8.n103 B8.n102 0.7055
R3294 B8.n104 B8.n103 0.7055
R3295 B8.n105 B8.n104 0.7055
R3296 B8.n106 B8.n105 0.7055
R3297 B8.n107 B8.n106 0.7055
R3298 B8.n108 B8.n107 0.7055
R3299 B8.n109 B8.n108 0.7055
R3300 B8.n110 B8.n109 0.7055
R3301 B8.n111 B8.n110 0.7055
R3302 B8.n112 B8.n111 0.7055
R3303 B8.n113 B8.n112 0.7055
R3304 B8.n114 B8.n113 0.7055
R3305 B8.n115 B8.n114 0.7055
R3306 B8.n116 B8.n115 0.7055
R3307 B8.n117 B8.n116 0.7055
R3308 B8.n118 B8.n117 0.7055
R3309 B8.n119 B8.n118 0.7055
R3310 B8.n120 B8.n119 0.7055
R3311 B8.n121 B8.n120 0.7055
R3312 B8.n122 B8.n121 0.7055
R3313 B8.n123 B8.n122 0.7055
R3314 B8.n124 B8.n123 0.7055
R3315 B8.n125 B8.n124 0.7055
R3316 B8.n188 B8.n187 0.7055
R3317 B8.n187 B8.n186 0.7055
R3318 B8.n186 B8.n185 0.7055
R3319 B8.n185 B8.n184 0.7055
R3320 B8.n184 B8.n183 0.7055
R3321 B8.n183 B8.n182 0.7055
R3322 B8.n182 B8.n181 0.7055
R3323 B8.n181 B8.n180 0.7055
R3324 B8.n180 B8.n179 0.7055
R3325 B8.n179 B8.n178 0.7055
R3326 B8.n178 B8.n177 0.7055
R3327 B8.n177 B8.n176 0.7055
R3328 B8.n176 B8.n175 0.7055
R3329 B8.n175 B8.n174 0.7055
R3330 B8.n174 B8.n173 0.7055
R3331 B8.n173 B8.n172 0.7055
R3332 B8.n172 B8.n171 0.7055
R3333 B8.n171 B8.n170 0.7055
R3334 B8.n170 B8.n169 0.7055
R3335 B8.n169 B8.n168 0.7055
R3336 B8.n168 B8.n167 0.7055
R3337 B8.n167 B8.n166 0.7055
R3338 B8.n166 B8.n165 0.7055
R3339 B8.n165 B8.n164 0.7055
R3340 B8.n164 B8.n163 0.7055
R3341 B8.n163 B8.n162 0.7055
R3342 B8.n162 B8.n161 0.7055
R3343 B8.n161 B8.n160 0.7055
R3344 B8.n160 B8.n159 0.7055
R3345 B8.n159 B8.n158 0.7055
R3346 B8.n158 B8.n157 0.7055
R3347 B8.n157 B8.n156 0.7055
R3348 B8.n156 B8.n155 0.7055
R3349 B8.n155 B8.n154 0.7055
R3350 B8.n154 B8.n153 0.7055
R3351 B8.n153 B8.n152 0.7055
R3352 B8.n152 B8.n151 0.7055
R3353 B8.n151 B8.n150 0.7055
R3354 B8.n150 B8.n149 0.7055
R3355 B8.n149 B8.n148 0.7055
R3356 B8.n148 B8.n147 0.7055
R3357 B8.n147 B8.n146 0.7055
R3358 B8.n146 B8.n145 0.7055
R3359 B8.n145 B8.n144 0.7055
R3360 B8.n144 B8.n143 0.7055
R3361 B8.n143 B8.n142 0.7055
R3362 B8.n142 B8.n141 0.7055
R3363 B8.n141 B8.n140 0.7055
R3364 B8.n140 B8.n139 0.7055
R3365 B8.n139 B8.n138 0.7055
R3366 B8.n138 B8.n137 0.7055
R3367 B8.n137 B8.n136 0.7055
R3368 B8.n136 B8.n135 0.7055
R3369 B8.n135 B8.n134 0.7055
R3370 B8.n134 B8.n133 0.7055
R3371 B8.n133 B8.n132 0.7055
R3372 B8.n132 B8.n131 0.7055
R3373 B8.n131 B8.n130 0.7055
R3374 B8.n130 B8.n129 0.7055
R3375 B8.n129 B8.n128 0.7055
R3376 B8.n128 B8.n127 0.7055
R3377 B8.n250 B8.n249 0.7055
R3378 B8.n249 B8.n248 0.7055
R3379 B8.n248 B8.n247 0.7055
R3380 B8.n247 B8.n246 0.7055
R3381 B8.n246 B8.n245 0.7055
R3382 B8.n245 B8.n244 0.7055
R3383 B8.n244 B8.n243 0.7055
R3384 B8.n243 B8.n242 0.7055
R3385 B8.n242 B8.n241 0.7055
R3386 B8.n241 B8.n240 0.7055
R3387 B8.n240 B8.n239 0.7055
R3388 B8.n239 B8.n238 0.7055
R3389 B8.n238 B8.n237 0.7055
R3390 B8.n237 B8.n236 0.7055
R3391 B8.n236 B8.n235 0.7055
R3392 B8.n235 B8.n234 0.7055
R3393 B8.n234 B8.n233 0.7055
R3394 B8.n233 B8.n232 0.7055
R3395 B8.n232 B8.n231 0.7055
R3396 B8.n231 B8.n230 0.7055
R3397 B8.n230 B8.n229 0.7055
R3398 B8.n229 B8.n228 0.7055
R3399 B8.n228 B8.n227 0.7055
R3400 B8.n227 B8.n226 0.7055
R3401 B8.n226 B8.n225 0.7055
R3402 B8.n225 B8.n224 0.7055
R3403 B8.n224 B8.n223 0.7055
R3404 B8.n223 B8.n222 0.7055
R3405 B8.n222 B8.n221 0.7055
R3406 B8.n221 B8.n220 0.7055
R3407 B8.n220 B8.n219 0.7055
R3408 B8.n219 B8.n218 0.7055
R3409 B8.n218 B8.n217 0.7055
R3410 B8.n217 B8.n216 0.7055
R3411 B8.n216 B8.n215 0.7055
R3412 B8.n215 B8.n214 0.7055
R3413 B8.n214 B8.n213 0.7055
R3414 B8.n213 B8.n212 0.7055
R3415 B8.n212 B8.n211 0.7055
R3416 B8.n211 B8.n210 0.7055
R3417 B8.n210 B8.n209 0.7055
R3418 B8.n209 B8.n208 0.7055
R3419 B8.n208 B8.n207 0.7055
R3420 B8.n207 B8.n206 0.7055
R3421 B8.n206 B8.n205 0.7055
R3422 B8.n205 B8.n204 0.7055
R3423 B8.n204 B8.n203 0.7055
R3424 B8.n203 B8.n202 0.7055
R3425 B8.n202 B8.n201 0.7055
R3426 B8.n201 B8.n200 0.7055
R3427 B8.n200 B8.n199 0.7055
R3428 B8.n199 B8.n198 0.7055
R3429 B8.n198 B8.n197 0.7055
R3430 B8.n197 B8.n196 0.7055
R3431 B8.n196 B8.n195 0.7055
R3432 B8.n195 B8.n194 0.7055
R3433 B8.n194 B8.n193 0.7055
R3434 B8.n193 B8.n192 0.7055
R3435 B8.n192 B8.n191 0.7055
R3436 B8.n191 B8.n190 0.7055
R3437 B8.n190 B8.n189 0.7055
R3438 B8.n62 B8.t128 0.324663
R3439 B8.n61 B8.t129 0.324663
R3440 B8.n60 B8.t130 0.324663
R3441 B8.n59 B8.t131 0.324663
R3442 B8.n58 B8.t132 0.324663
R3443 B8.n57 B8.t133 0.324663
R3444 B8.n56 B8.t134 0.324663
R3445 B8.n55 B8.t135 0.324663
R3446 B8.n54 B8.t136 0.324663
R3447 B8.n53 B8.t137 0.324663
R3448 B8.n52 B8.t138 0.324663
R3449 B8.n51 B8.t139 0.324663
R3450 B8.n50 B8.t140 0.324663
R3451 B8.n49 B8.t141 0.324663
R3452 B8.n48 B8.t142 0.324663
R3453 B8.n47 B8.t143 0.324663
R3454 B8.n46 B8.t144 0.324663
R3455 B8.n45 B8.t145 0.324663
R3456 B8.n44 B8.t146 0.324663
R3457 B8.n43 B8.t147 0.324663
R3458 B8.n42 B8.t148 0.324663
R3459 B8.n41 B8.t149 0.324663
R3460 B8.n40 B8.t150 0.324663
R3461 B8.n39 B8.t151 0.324663
R3462 B8.n38 B8.t152 0.324663
R3463 B8.n37 B8.t153 0.324663
R3464 B8.n36 B8.t154 0.324663
R3465 B8.n35 B8.t155 0.324663
R3466 B8.n34 B8.t156 0.324663
R3467 B8.n33 B8.t157 0.324663
R3468 B8.n32 B8.t158 0.324663
R3469 B8.n31 B8.t159 0.324663
R3470 B8.n30 B8.t160 0.324663
R3471 B8.n29 B8.t161 0.324663
R3472 B8.n28 B8.t162 0.324663
R3473 B8.n27 B8.t163 0.324663
R3474 B8.n26 B8.t164 0.324663
R3475 B8.n25 B8.t165 0.324663
R3476 B8.n24 B8.t166 0.324663
R3477 B8.n23 B8.t167 0.324663
R3478 B8.n22 B8.t168 0.324663
R3479 B8.n21 B8.t169 0.324663
R3480 B8.n20 B8.t170 0.324663
R3481 B8.n19 B8.t171 0.324663
R3482 B8.n18 B8.t172 0.324663
R3483 B8.n17 B8.t173 0.324663
R3484 B8.n16 B8.t174 0.324663
R3485 B8.n15 B8.t175 0.324663
R3486 B8.n14 B8.t176 0.324663
R3487 B8.n13 B8.t177 0.324663
R3488 B8.n12 B8.t178 0.324663
R3489 B8.n11 B8.t179 0.324663
R3490 B8.n10 B8.t180 0.324663
R3491 B8.n9 B8.t181 0.324663
R3492 B8.n8 B8.t182 0.324663
R3493 B8.n7 B8.t183 0.324663
R3494 B8.n6 B8.t184 0.324663
R3495 B8.n5 B8.t185 0.324663
R3496 B8.n4 B8.t186 0.324663
R3497 B8.n3 B8.t187 0.324663
R3498 B8.n2 B8.t188 0.324663
R3499 B8.n1 B8.t189 0.324663
R3500 B8.n125 B8.t191 0.324663
R3501 B8.n124 B8.t192 0.324663
R3502 B8.n123 B8.t193 0.324663
R3503 B8.n122 B8.t194 0.324663
R3504 B8.n121 B8.t195 0.324663
R3505 B8.n120 B8.t196 0.324663
R3506 B8.n119 B8.t197 0.324663
R3507 B8.n118 B8.t198 0.324663
R3508 B8.n117 B8.t199 0.324663
R3509 B8.n116 B8.t200 0.324663
R3510 B8.n115 B8.t201 0.324663
R3511 B8.n114 B8.t202 0.324663
R3512 B8.n113 B8.t203 0.324663
R3513 B8.n112 B8.t204 0.324663
R3514 B8.n111 B8.t205 0.324663
R3515 B8.n110 B8.t206 0.324663
R3516 B8.n109 B8.t207 0.324663
R3517 B8.n108 B8.t208 0.324663
R3518 B8.n107 B8.t209 0.324663
R3519 B8.n106 B8.t210 0.324663
R3520 B8.n105 B8.t211 0.324663
R3521 B8.n104 B8.t212 0.324663
R3522 B8.n103 B8.t213 0.324663
R3523 B8.n102 B8.t214 0.324663
R3524 B8.n101 B8.t215 0.324663
R3525 B8.n100 B8.t216 0.324663
R3526 B8.n99 B8.t217 0.324663
R3527 B8.n98 B8.t218 0.324663
R3528 B8.n97 B8.t219 0.324663
R3529 B8.n96 B8.t220 0.324663
R3530 B8.n95 B8.t221 0.324663
R3531 B8.n94 B8.t222 0.324663
R3532 B8.n93 B8.t223 0.324663
R3533 B8.n92 B8.t224 0.324663
R3534 B8.n91 B8.t225 0.324663
R3535 B8.n90 B8.t226 0.324663
R3536 B8.n89 B8.t227 0.324663
R3537 B8.n88 B8.t228 0.324663
R3538 B8.n87 B8.t229 0.324663
R3539 B8.n86 B8.t230 0.324663
R3540 B8.n85 B8.t231 0.324663
R3541 B8.n84 B8.t232 0.324663
R3542 B8.n83 B8.t233 0.324663
R3543 B8.n82 B8.t234 0.324663
R3544 B8.n81 B8.t235 0.324663
R3545 B8.n80 B8.t236 0.324663
R3546 B8.n79 B8.t237 0.324663
R3547 B8.n78 B8.t238 0.324663
R3548 B8.n77 B8.t239 0.324663
R3549 B8.n76 B8.t240 0.324663
R3550 B8.n75 B8.t241 0.324663
R3551 B8.n74 B8.t242 0.324663
R3552 B8.n73 B8.t243 0.324663
R3553 B8.n72 B8.t244 0.324663
R3554 B8.n71 B8.t245 0.324663
R3555 B8.n70 B8.t246 0.324663
R3556 B8.n69 B8.t247 0.324663
R3557 B8.n68 B8.t248 0.324663
R3558 B8.n67 B8.t249 0.324663
R3559 B8.n66 B8.t250 0.324663
R3560 B8.n65 B8.t251 0.324663
R3561 B8.n64 B8.t252 0.324663
R3562 B8.n127 B8.t3 0.324663
R3563 B8.n128 B8.t4 0.324663
R3564 B8.n129 B8.t5 0.324663
R3565 B8.n130 B8.t6 0.324663
R3566 B8.n131 B8.t7 0.324663
R3567 B8.n132 B8.t8 0.324663
R3568 B8.n133 B8.t9 0.324663
R3569 B8.n134 B8.t10 0.324663
R3570 B8.n135 B8.t11 0.324663
R3571 B8.n136 B8.t12 0.324663
R3572 B8.n137 B8.t13 0.324663
R3573 B8.n138 B8.t14 0.324663
R3574 B8.n139 B8.t15 0.324663
R3575 B8.n140 B8.t16 0.324663
R3576 B8.n141 B8.t17 0.324663
R3577 B8.n142 B8.t18 0.324663
R3578 B8.n143 B8.t19 0.324663
R3579 B8.n144 B8.t20 0.324663
R3580 B8.n145 B8.t21 0.324663
R3581 B8.n146 B8.t22 0.324663
R3582 B8.n147 B8.t23 0.324663
R3583 B8.n148 B8.t24 0.324663
R3584 B8.n149 B8.t25 0.324663
R3585 B8.n150 B8.t26 0.324663
R3586 B8.n151 B8.t27 0.324663
R3587 B8.n152 B8.t28 0.324663
R3588 B8.n153 B8.t29 0.324663
R3589 B8.n154 B8.t30 0.324663
R3590 B8.n155 B8.t31 0.324663
R3591 B8.n156 B8.t32 0.324663
R3592 B8.n157 B8.t33 0.324663
R3593 B8.n158 B8.t34 0.324663
R3594 B8.n159 B8.t35 0.324663
R3595 B8.n160 B8.t36 0.324663
R3596 B8.n161 B8.t37 0.324663
R3597 B8.n162 B8.t38 0.324663
R3598 B8.n163 B8.t39 0.324663
R3599 B8.n164 B8.t40 0.324663
R3600 B8.n165 B8.t41 0.324663
R3601 B8.n166 B8.t42 0.324663
R3602 B8.n167 B8.t43 0.324663
R3603 B8.n168 B8.t44 0.324663
R3604 B8.n169 B8.t45 0.324663
R3605 B8.n170 B8.t46 0.324663
R3606 B8.n171 B8.t47 0.324663
R3607 B8.n172 B8.t48 0.324663
R3608 B8.n173 B8.t49 0.324663
R3609 B8.n174 B8.t50 0.324663
R3610 B8.n175 B8.t51 0.324663
R3611 B8.n176 B8.t52 0.324663
R3612 B8.n177 B8.t53 0.324663
R3613 B8.n178 B8.t54 0.324663
R3614 B8.n179 B8.t55 0.324663
R3615 B8.n180 B8.t56 0.324663
R3616 B8.n181 B8.t57 0.324663
R3617 B8.n182 B8.t58 0.324663
R3618 B8.n183 B8.t59 0.324663
R3619 B8.n184 B8.t60 0.324663
R3620 B8.n185 B8.t61 0.324663
R3621 B8.n186 B8.t62 0.324663
R3622 B8.n187 B8.t63 0.324663
R3623 B8.n188 B8.t64 0.324663
R3624 B8.n189 B8.t66 0.324663
R3625 B8.n190 B8.t67 0.324663
R3626 B8.n191 B8.t68 0.324663
R3627 B8.n192 B8.t69 0.324663
R3628 B8.n193 B8.t70 0.324663
R3629 B8.n194 B8.t71 0.324663
R3630 B8.n195 B8.t72 0.324663
R3631 B8.n196 B8.t73 0.324663
R3632 B8.n197 B8.t74 0.324663
R3633 B8.n198 B8.t75 0.324663
R3634 B8.n199 B8.t76 0.324663
R3635 B8.n200 B8.t77 0.324663
R3636 B8.n201 B8.t78 0.324663
R3637 B8.n202 B8.t79 0.324663
R3638 B8.n203 B8.t80 0.324663
R3639 B8.n204 B8.t81 0.324663
R3640 B8.n205 B8.t82 0.324663
R3641 B8.n206 B8.t83 0.324663
R3642 B8.n207 B8.t84 0.324663
R3643 B8.n208 B8.t85 0.324663
R3644 B8.n209 B8.t86 0.324663
R3645 B8.n210 B8.t87 0.324663
R3646 B8.n211 B8.t88 0.324663
R3647 B8.n212 B8.t89 0.324663
R3648 B8.n213 B8.t90 0.324663
R3649 B8.n214 B8.t91 0.324663
R3650 B8.n215 B8.t92 0.324663
R3651 B8.n216 B8.t93 0.324663
R3652 B8.n217 B8.t94 0.324663
R3653 B8.n218 B8.t95 0.324663
R3654 B8.n219 B8.t96 0.324663
R3655 B8.n220 B8.t97 0.324663
R3656 B8.n221 B8.t98 0.324663
R3657 B8.n222 B8.t99 0.324663
R3658 B8.n223 B8.t100 0.324663
R3659 B8.n224 B8.t101 0.324663
R3660 B8.n225 B8.t102 0.324663
R3661 B8.n226 B8.t103 0.324663
R3662 B8.n227 B8.t104 0.324663
R3663 B8.n228 B8.t105 0.324663
R3664 B8.n229 B8.t106 0.324663
R3665 B8.n230 B8.t107 0.324663
R3666 B8.n231 B8.t108 0.324663
R3667 B8.n232 B8.t109 0.324663
R3668 B8.n233 B8.t110 0.324663
R3669 B8.n234 B8.t111 0.324663
R3670 B8.n235 B8.t112 0.324663
R3671 B8.n236 B8.t113 0.324663
R3672 B8.n237 B8.t114 0.324663
R3673 B8.n238 B8.t115 0.324663
R3674 B8.n239 B8.t116 0.324663
R3675 B8.n240 B8.t117 0.324663
R3676 B8.n241 B8.t118 0.324663
R3677 B8.n242 B8.t119 0.324663
R3678 B8.n243 B8.t120 0.324663
R3679 B8.n244 B8.t121 0.324663
R3680 B8.n245 B8.t122 0.324663
R3681 B8.n246 B8.t123 0.324663
R3682 B8.n247 B8.t124 0.324663
R3683 B8.n248 B8.t125 0.324663
R3684 B8.n249 B8.t126 0.324663
R3685 B8.n250 B8.t127 0.324663
R3686 B8.n126 B8.n63 0.10925
R3687 B8.n253 B8.n252 0.10925
R3688 B7 B7.n125 27.4241
R3689 B7 B7.n62 24.7498
R3690 B7.n62 B7.t0 5.77561
R3691 B7.n125 B7.n124 5.2799
R3692 B7.n125 B7.t127 2.12406
R3693 B7.n62 B7.n61 1.97145
R3694 B7.n0 B7.t126 1.02966
R3695 B7.n63 B7.t1 1.02966
R3696 B7.n1 B7.n0 0.7055
R3697 B7.n2 B7.n1 0.7055
R3698 B7.n3 B7.n2 0.7055
R3699 B7.n4 B7.n3 0.7055
R3700 B7.n5 B7.n4 0.7055
R3701 B7.n6 B7.n5 0.7055
R3702 B7.n7 B7.n6 0.7055
R3703 B7.n8 B7.n7 0.7055
R3704 B7.n9 B7.n8 0.7055
R3705 B7.n10 B7.n9 0.7055
R3706 B7.n11 B7.n10 0.7055
R3707 B7.n12 B7.n11 0.7055
R3708 B7.n13 B7.n12 0.7055
R3709 B7.n14 B7.n13 0.7055
R3710 B7.n15 B7.n14 0.7055
R3711 B7.n16 B7.n15 0.7055
R3712 B7.n17 B7.n16 0.7055
R3713 B7.n18 B7.n17 0.7055
R3714 B7.n19 B7.n18 0.7055
R3715 B7.n20 B7.n19 0.7055
R3716 B7.n21 B7.n20 0.7055
R3717 B7.n22 B7.n21 0.7055
R3718 B7.n23 B7.n22 0.7055
R3719 B7.n24 B7.n23 0.7055
R3720 B7.n25 B7.n24 0.7055
R3721 B7.n26 B7.n25 0.7055
R3722 B7.n27 B7.n26 0.7055
R3723 B7.n28 B7.n27 0.7055
R3724 B7.n29 B7.n28 0.7055
R3725 B7.n30 B7.n29 0.7055
R3726 B7.n31 B7.n30 0.7055
R3727 B7.n32 B7.n31 0.7055
R3728 B7.n33 B7.n32 0.7055
R3729 B7.n34 B7.n33 0.7055
R3730 B7.n35 B7.n34 0.7055
R3731 B7.n36 B7.n35 0.7055
R3732 B7.n37 B7.n36 0.7055
R3733 B7.n38 B7.n37 0.7055
R3734 B7.n39 B7.n38 0.7055
R3735 B7.n40 B7.n39 0.7055
R3736 B7.n41 B7.n40 0.7055
R3737 B7.n42 B7.n41 0.7055
R3738 B7.n43 B7.n42 0.7055
R3739 B7.n44 B7.n43 0.7055
R3740 B7.n45 B7.n44 0.7055
R3741 B7.n46 B7.n45 0.7055
R3742 B7.n47 B7.n46 0.7055
R3743 B7.n48 B7.n47 0.7055
R3744 B7.n49 B7.n48 0.7055
R3745 B7.n50 B7.n49 0.7055
R3746 B7.n51 B7.n50 0.7055
R3747 B7.n52 B7.n51 0.7055
R3748 B7.n53 B7.n52 0.7055
R3749 B7.n54 B7.n53 0.7055
R3750 B7.n55 B7.n54 0.7055
R3751 B7.n56 B7.n55 0.7055
R3752 B7.n57 B7.n56 0.7055
R3753 B7.n58 B7.n57 0.7055
R3754 B7.n59 B7.n58 0.7055
R3755 B7.n60 B7.n59 0.7055
R3756 B7.n61 B7.n60 0.7055
R3757 B7.n124 B7.n123 0.7055
R3758 B7.n123 B7.n122 0.7055
R3759 B7.n122 B7.n121 0.7055
R3760 B7.n121 B7.n120 0.7055
R3761 B7.n120 B7.n119 0.7055
R3762 B7.n119 B7.n118 0.7055
R3763 B7.n118 B7.n117 0.7055
R3764 B7.n117 B7.n116 0.7055
R3765 B7.n116 B7.n115 0.7055
R3766 B7.n115 B7.n114 0.7055
R3767 B7.n114 B7.n113 0.7055
R3768 B7.n113 B7.n112 0.7055
R3769 B7.n112 B7.n111 0.7055
R3770 B7.n111 B7.n110 0.7055
R3771 B7.n110 B7.n109 0.7055
R3772 B7.n109 B7.n108 0.7055
R3773 B7.n108 B7.n107 0.7055
R3774 B7.n107 B7.n106 0.7055
R3775 B7.n106 B7.n105 0.7055
R3776 B7.n105 B7.n104 0.7055
R3777 B7.n104 B7.n103 0.7055
R3778 B7.n103 B7.n102 0.7055
R3779 B7.n102 B7.n101 0.7055
R3780 B7.n101 B7.n100 0.7055
R3781 B7.n100 B7.n99 0.7055
R3782 B7.n99 B7.n98 0.7055
R3783 B7.n98 B7.n97 0.7055
R3784 B7.n97 B7.n96 0.7055
R3785 B7.n96 B7.n95 0.7055
R3786 B7.n95 B7.n94 0.7055
R3787 B7.n94 B7.n93 0.7055
R3788 B7.n93 B7.n92 0.7055
R3789 B7.n92 B7.n91 0.7055
R3790 B7.n91 B7.n90 0.7055
R3791 B7.n90 B7.n89 0.7055
R3792 B7.n89 B7.n88 0.7055
R3793 B7.n88 B7.n87 0.7055
R3794 B7.n87 B7.n86 0.7055
R3795 B7.n86 B7.n85 0.7055
R3796 B7.n85 B7.n84 0.7055
R3797 B7.n84 B7.n83 0.7055
R3798 B7.n83 B7.n82 0.7055
R3799 B7.n82 B7.n81 0.7055
R3800 B7.n81 B7.n80 0.7055
R3801 B7.n80 B7.n79 0.7055
R3802 B7.n79 B7.n78 0.7055
R3803 B7.n78 B7.n77 0.7055
R3804 B7.n77 B7.n76 0.7055
R3805 B7.n76 B7.n75 0.7055
R3806 B7.n75 B7.n74 0.7055
R3807 B7.n74 B7.n73 0.7055
R3808 B7.n73 B7.n72 0.7055
R3809 B7.n72 B7.n71 0.7055
R3810 B7.n71 B7.n70 0.7055
R3811 B7.n70 B7.n69 0.7055
R3812 B7.n69 B7.n68 0.7055
R3813 B7.n68 B7.n67 0.7055
R3814 B7.n67 B7.n66 0.7055
R3815 B7.n66 B7.n65 0.7055
R3816 B7.n65 B7.n64 0.7055
R3817 B7.n64 B7.n63 0.7055
R3818 B7.n61 B7.t64 0.324663
R3819 B7.n60 B7.t65 0.324663
R3820 B7.n59 B7.t66 0.324663
R3821 B7.n58 B7.t67 0.324663
R3822 B7.n57 B7.t68 0.324663
R3823 B7.n56 B7.t69 0.324663
R3824 B7.n55 B7.t70 0.324663
R3825 B7.n54 B7.t71 0.324663
R3826 B7.n53 B7.t72 0.324663
R3827 B7.n52 B7.t73 0.324663
R3828 B7.n51 B7.t74 0.324663
R3829 B7.n50 B7.t75 0.324663
R3830 B7.n49 B7.t76 0.324663
R3831 B7.n48 B7.t77 0.324663
R3832 B7.n47 B7.t78 0.324663
R3833 B7.n46 B7.t79 0.324663
R3834 B7.n45 B7.t80 0.324663
R3835 B7.n44 B7.t81 0.324663
R3836 B7.n43 B7.t82 0.324663
R3837 B7.n42 B7.t83 0.324663
R3838 B7.n41 B7.t84 0.324663
R3839 B7.n40 B7.t85 0.324663
R3840 B7.n39 B7.t86 0.324663
R3841 B7.n38 B7.t87 0.324663
R3842 B7.n37 B7.t88 0.324663
R3843 B7.n36 B7.t89 0.324663
R3844 B7.n35 B7.t90 0.324663
R3845 B7.n34 B7.t91 0.324663
R3846 B7.n33 B7.t92 0.324663
R3847 B7.n32 B7.t93 0.324663
R3848 B7.n31 B7.t94 0.324663
R3849 B7.n30 B7.t95 0.324663
R3850 B7.n29 B7.t96 0.324663
R3851 B7.n28 B7.t97 0.324663
R3852 B7.n27 B7.t98 0.324663
R3853 B7.n26 B7.t99 0.324663
R3854 B7.n25 B7.t100 0.324663
R3855 B7.n24 B7.t101 0.324663
R3856 B7.n23 B7.t102 0.324663
R3857 B7.n22 B7.t103 0.324663
R3858 B7.n21 B7.t104 0.324663
R3859 B7.n20 B7.t105 0.324663
R3860 B7.n19 B7.t106 0.324663
R3861 B7.n18 B7.t107 0.324663
R3862 B7.n17 B7.t108 0.324663
R3863 B7.n16 B7.t109 0.324663
R3864 B7.n15 B7.t110 0.324663
R3865 B7.n14 B7.t111 0.324663
R3866 B7.n13 B7.t112 0.324663
R3867 B7.n12 B7.t113 0.324663
R3868 B7.n11 B7.t114 0.324663
R3869 B7.n10 B7.t115 0.324663
R3870 B7.n9 B7.t116 0.324663
R3871 B7.n8 B7.t117 0.324663
R3872 B7.n7 B7.t118 0.324663
R3873 B7.n6 B7.t119 0.324663
R3874 B7.n5 B7.t120 0.324663
R3875 B7.n4 B7.t121 0.324663
R3876 B7.n3 B7.t122 0.324663
R3877 B7.n2 B7.t123 0.324663
R3878 B7.n1 B7.t124 0.324663
R3879 B7.n0 B7.t125 0.324663
R3880 B7.n63 B7.t2 0.324663
R3881 B7.n64 B7.t3 0.324663
R3882 B7.n65 B7.t4 0.324663
R3883 B7.n66 B7.t5 0.324663
R3884 B7.n67 B7.t6 0.324663
R3885 B7.n68 B7.t7 0.324663
R3886 B7.n69 B7.t8 0.324663
R3887 B7.n70 B7.t9 0.324663
R3888 B7.n71 B7.t10 0.324663
R3889 B7.n72 B7.t11 0.324663
R3890 B7.n73 B7.t12 0.324663
R3891 B7.n74 B7.t13 0.324663
R3892 B7.n75 B7.t14 0.324663
R3893 B7.n76 B7.t15 0.324663
R3894 B7.n77 B7.t16 0.324663
R3895 B7.n78 B7.t17 0.324663
R3896 B7.n79 B7.t18 0.324663
R3897 B7.n80 B7.t19 0.324663
R3898 B7.n81 B7.t20 0.324663
R3899 B7.n82 B7.t21 0.324663
R3900 B7.n83 B7.t22 0.324663
R3901 B7.n84 B7.t23 0.324663
R3902 B7.n85 B7.t24 0.324663
R3903 B7.n86 B7.t25 0.324663
R3904 B7.n87 B7.t26 0.324663
R3905 B7.n88 B7.t27 0.324663
R3906 B7.n89 B7.t28 0.324663
R3907 B7.n90 B7.t29 0.324663
R3908 B7.n91 B7.t30 0.324663
R3909 B7.n92 B7.t31 0.324663
R3910 B7.n93 B7.t32 0.324663
R3911 B7.n94 B7.t33 0.324663
R3912 B7.n95 B7.t34 0.324663
R3913 B7.n96 B7.t35 0.324663
R3914 B7.n97 B7.t36 0.324663
R3915 B7.n98 B7.t37 0.324663
R3916 B7.n99 B7.t38 0.324663
R3917 B7.n100 B7.t39 0.324663
R3918 B7.n101 B7.t40 0.324663
R3919 B7.n102 B7.t41 0.324663
R3920 B7.n103 B7.t42 0.324663
R3921 B7.n104 B7.t43 0.324663
R3922 B7.n105 B7.t44 0.324663
R3923 B7.n106 B7.t45 0.324663
R3924 B7.n107 B7.t46 0.324663
R3925 B7.n108 B7.t47 0.324663
R3926 B7.n109 B7.t48 0.324663
R3927 B7.n110 B7.t49 0.324663
R3928 B7.n111 B7.t50 0.324663
R3929 B7.n112 B7.t51 0.324663
R3930 B7.n113 B7.t52 0.324663
R3931 B7.n114 B7.t53 0.324663
R3932 B7.n115 B7.t54 0.324663
R3933 B7.n116 B7.t55 0.324663
R3934 B7.n117 B7.t56 0.324663
R3935 B7.n118 B7.t57 0.324663
R3936 B7.n119 B7.t58 0.324663
R3937 B7.n120 B7.t59 0.324663
R3938 B7.n121 B7.t60 0.324663
R3939 B7.n122 B7.t61 0.324663
R3940 B7.n123 B7.t62 0.324663
R3941 B7.n124 B7.t63 0.324663
R3942 B11 B11.n2045 30.4143
R3943 B11 B11.n1022 22.8463
R3944 B11.n0 B11.t1008 3.90836
R3945 B11.n0 B11.t1009 3.79961
R3946 B11.n1 B11.t1010 3.79961
R3947 B11.n2 B11.t1011 3.79961
R3948 B11.n3 B11.t1012 3.79961
R3949 B11.n4 B11.t1013 3.79961
R3950 B11.n5 B11.t1014 3.79961
R3951 B11.n6 B11.t1015 3.79961
R3952 B11.n7 B11.t1016 3.79961
R3953 B11.n8 B11.t1017 3.79961
R3954 B11.n9 B11.t1018 3.79961
R3955 B11.n10 B11.t1019 3.79961
R3956 B11.n11 B11.t1020 3.79961
R3957 B11.n12 B11.t1021 3.79961
R3958 B11.n13 B11.t1022 3.79961
R3959 B11.n14 B11.t1023 3.79961
R3960 B11.n2030 B11.t1024 3.62806
R3961 B11.n2031 B11.t1025 3.62806
R3962 B11.n2032 B11.t1026 3.62806
R3963 B11.n2033 B11.t1027 3.62806
R3964 B11.n2034 B11.t1028 3.62806
R3965 B11.n2035 B11.t1029 3.62806
R3966 B11.n2036 B11.t1030 3.62806
R3967 B11.n2037 B11.t1031 3.62806
R3968 B11.n2038 B11.t1032 3.62806
R3969 B11.n2039 B11.t1033 3.62806
R3970 B11.n2040 B11.t1034 3.62806
R3971 B11.n2041 B11.t1035 3.62806
R3972 B11.n2042 B11.t1036 3.62806
R3973 B11.n2043 B11.t1037 3.62806
R3974 B11.n2044 B11.t1038 3.62806
R3975 B11.n2045 B11.t1039 3.62806
R3976 B11.n77 B11.n76 3.47545
R3977 B11.n140 B11.n139 3.47545
R3978 B11.n203 B11.n202 3.47545
R3979 B11.n266 B11.n265 3.47545
R3980 B11.n329 B11.n328 3.47545
R3981 B11.n392 B11.n391 3.47545
R3982 B11.n455 B11.n454 3.47545
R3983 B11.n518 B11.n517 3.47545
R3984 B11.n581 B11.n580 3.47545
R3985 B11.n644 B11.n643 3.47545
R3986 B11.n707 B11.n706 3.47545
R3987 B11.n770 B11.n769 3.47545
R3988 B11.n833 B11.n832 3.47545
R3989 B11.n896 B11.n895 3.47545
R3990 B11.n959 B11.n958 3.47545
R3991 B11.n1022 B11.n1021 3.47545
R3992 B11.n1147 B11.n1084 3.41265
R3993 B11.n1147 B11.n1146 3.3039
R3994 B11.n1210 B11.n1209 3.3039
R3995 B11.n1273 B11.n1272 3.3039
R3996 B11.n1336 B11.n1335 3.3039
R3997 B11.n1399 B11.n1398 3.3039
R3998 B11.n1462 B11.n1461 3.3039
R3999 B11.n1525 B11.n1524 3.3039
R4000 B11.n1588 B11.n1587 3.3039
R4001 B11.n1651 B11.n1650 3.3039
R4002 B11.n1714 B11.n1713 3.3039
R4003 B11.n1777 B11.n1776 3.3039
R4004 B11.n1840 B11.n1839 3.3039
R4005 B11.n1903 B11.n1902 3.3039
R4006 B11.n1966 B11.n1965 3.3039
R4007 B11.n2029 B11.n2028 3.3039
R4008 B11.n77 B11.n14 1.84925
R4009 B11.n2030 B11.n2029 1.84925
R4010 B11.n15 B11.t1102 1.02966
R4011 B11.n78 B11.t1165 1.02966
R4012 B11.n141 B11.t1228 1.02966
R4013 B11.n204 B11.t1291 1.02966
R4014 B11.n267 B11.t1354 1.02966
R4015 B11.n330 B11.t1417 1.02966
R4016 B11.n393 B11.t1480 1.02966
R4017 B11.n456 B11.t1543 1.02966
R4018 B11.n519 B11.t1606 1.02966
R4019 B11.n582 B11.t1669 1.02966
R4020 B11.n645 B11.t1732 1.02966
R4021 B11.n708 B11.t1795 1.02966
R4022 B11.n771 B11.t1858 1.02966
R4023 B11.n834 B11.t1921 1.02966
R4024 B11.n897 B11.t1984 1.02966
R4025 B11.n960 B11.t2047 1.02966
R4026 B11.n1023 B11.t0 1.02966
R4027 B11.n1085 B11.t63 1.02966
R4028 B11.n1148 B11.t126 1.02966
R4029 B11.n1211 B11.t189 1.02966
R4030 B11.n1274 B11.t252 1.02966
R4031 B11.n1337 B11.t315 1.02966
R4032 B11.n1400 B11.t378 1.02966
R4033 B11.n1463 B11.t441 1.02966
R4034 B11.n1526 B11.t504 1.02966
R4035 B11.n1589 B11.t567 1.02966
R4036 B11.n1652 B11.t630 1.02966
R4037 B11.n1715 B11.t693 1.02966
R4038 B11.n1778 B11.t756 1.02966
R4039 B11.n1841 B11.t819 1.02966
R4040 B11.n1904 B11.t882 1.02966
R4041 B11.n1967 B11.t945 1.02966
R4042 B11.n16 B11.n15 0.7055
R4043 B11.n17 B11.n16 0.7055
R4044 B11.n18 B11.n17 0.7055
R4045 B11.n19 B11.n18 0.7055
R4046 B11.n20 B11.n19 0.7055
R4047 B11.n21 B11.n20 0.7055
R4048 B11.n22 B11.n21 0.7055
R4049 B11.n23 B11.n22 0.7055
R4050 B11.n24 B11.n23 0.7055
R4051 B11.n25 B11.n24 0.7055
R4052 B11.n26 B11.n25 0.7055
R4053 B11.n27 B11.n26 0.7055
R4054 B11.n28 B11.n27 0.7055
R4055 B11.n29 B11.n28 0.7055
R4056 B11.n30 B11.n29 0.7055
R4057 B11.n31 B11.n30 0.7055
R4058 B11.n32 B11.n31 0.7055
R4059 B11.n33 B11.n32 0.7055
R4060 B11.n34 B11.n33 0.7055
R4061 B11.n35 B11.n34 0.7055
R4062 B11.n36 B11.n35 0.7055
R4063 B11.n37 B11.n36 0.7055
R4064 B11.n38 B11.n37 0.7055
R4065 B11.n39 B11.n38 0.7055
R4066 B11.n40 B11.n39 0.7055
R4067 B11.n41 B11.n40 0.7055
R4068 B11.n42 B11.n41 0.7055
R4069 B11.n43 B11.n42 0.7055
R4070 B11.n44 B11.n43 0.7055
R4071 B11.n45 B11.n44 0.7055
R4072 B11.n46 B11.n45 0.7055
R4073 B11.n47 B11.n46 0.7055
R4074 B11.n48 B11.n47 0.7055
R4075 B11.n49 B11.n48 0.7055
R4076 B11.n50 B11.n49 0.7055
R4077 B11.n51 B11.n50 0.7055
R4078 B11.n52 B11.n51 0.7055
R4079 B11.n53 B11.n52 0.7055
R4080 B11.n54 B11.n53 0.7055
R4081 B11.n55 B11.n54 0.7055
R4082 B11.n56 B11.n55 0.7055
R4083 B11.n57 B11.n56 0.7055
R4084 B11.n58 B11.n57 0.7055
R4085 B11.n59 B11.n58 0.7055
R4086 B11.n60 B11.n59 0.7055
R4087 B11.n61 B11.n60 0.7055
R4088 B11.n62 B11.n61 0.7055
R4089 B11.n63 B11.n62 0.7055
R4090 B11.n64 B11.n63 0.7055
R4091 B11.n65 B11.n64 0.7055
R4092 B11.n66 B11.n65 0.7055
R4093 B11.n67 B11.n66 0.7055
R4094 B11.n68 B11.n67 0.7055
R4095 B11.n69 B11.n68 0.7055
R4096 B11.n70 B11.n69 0.7055
R4097 B11.n71 B11.n70 0.7055
R4098 B11.n72 B11.n71 0.7055
R4099 B11.n73 B11.n72 0.7055
R4100 B11.n74 B11.n73 0.7055
R4101 B11.n75 B11.n74 0.7055
R4102 B11.n76 B11.n75 0.7055
R4103 B11.n79 B11.n78 0.7055
R4104 B11.n80 B11.n79 0.7055
R4105 B11.n81 B11.n80 0.7055
R4106 B11.n82 B11.n81 0.7055
R4107 B11.n83 B11.n82 0.7055
R4108 B11.n84 B11.n83 0.7055
R4109 B11.n85 B11.n84 0.7055
R4110 B11.n86 B11.n85 0.7055
R4111 B11.n87 B11.n86 0.7055
R4112 B11.n88 B11.n87 0.7055
R4113 B11.n89 B11.n88 0.7055
R4114 B11.n90 B11.n89 0.7055
R4115 B11.n91 B11.n90 0.7055
R4116 B11.n92 B11.n91 0.7055
R4117 B11.n93 B11.n92 0.7055
R4118 B11.n94 B11.n93 0.7055
R4119 B11.n95 B11.n94 0.7055
R4120 B11.n96 B11.n95 0.7055
R4121 B11.n97 B11.n96 0.7055
R4122 B11.n98 B11.n97 0.7055
R4123 B11.n99 B11.n98 0.7055
R4124 B11.n100 B11.n99 0.7055
R4125 B11.n101 B11.n100 0.7055
R4126 B11.n102 B11.n101 0.7055
R4127 B11.n103 B11.n102 0.7055
R4128 B11.n104 B11.n103 0.7055
R4129 B11.n105 B11.n104 0.7055
R4130 B11.n106 B11.n105 0.7055
R4131 B11.n107 B11.n106 0.7055
R4132 B11.n108 B11.n107 0.7055
R4133 B11.n109 B11.n108 0.7055
R4134 B11.n110 B11.n109 0.7055
R4135 B11.n111 B11.n110 0.7055
R4136 B11.n112 B11.n111 0.7055
R4137 B11.n113 B11.n112 0.7055
R4138 B11.n114 B11.n113 0.7055
R4139 B11.n115 B11.n114 0.7055
R4140 B11.n116 B11.n115 0.7055
R4141 B11.n117 B11.n116 0.7055
R4142 B11.n118 B11.n117 0.7055
R4143 B11.n119 B11.n118 0.7055
R4144 B11.n120 B11.n119 0.7055
R4145 B11.n121 B11.n120 0.7055
R4146 B11.n122 B11.n121 0.7055
R4147 B11.n123 B11.n122 0.7055
R4148 B11.n124 B11.n123 0.7055
R4149 B11.n125 B11.n124 0.7055
R4150 B11.n126 B11.n125 0.7055
R4151 B11.n127 B11.n126 0.7055
R4152 B11.n128 B11.n127 0.7055
R4153 B11.n129 B11.n128 0.7055
R4154 B11.n130 B11.n129 0.7055
R4155 B11.n131 B11.n130 0.7055
R4156 B11.n132 B11.n131 0.7055
R4157 B11.n133 B11.n132 0.7055
R4158 B11.n134 B11.n133 0.7055
R4159 B11.n135 B11.n134 0.7055
R4160 B11.n136 B11.n135 0.7055
R4161 B11.n137 B11.n136 0.7055
R4162 B11.n138 B11.n137 0.7055
R4163 B11.n139 B11.n138 0.7055
R4164 B11.n142 B11.n141 0.7055
R4165 B11.n143 B11.n142 0.7055
R4166 B11.n144 B11.n143 0.7055
R4167 B11.n145 B11.n144 0.7055
R4168 B11.n146 B11.n145 0.7055
R4169 B11.n147 B11.n146 0.7055
R4170 B11.n148 B11.n147 0.7055
R4171 B11.n149 B11.n148 0.7055
R4172 B11.n150 B11.n149 0.7055
R4173 B11.n151 B11.n150 0.7055
R4174 B11.n152 B11.n151 0.7055
R4175 B11.n153 B11.n152 0.7055
R4176 B11.n154 B11.n153 0.7055
R4177 B11.n155 B11.n154 0.7055
R4178 B11.n156 B11.n155 0.7055
R4179 B11.n157 B11.n156 0.7055
R4180 B11.n158 B11.n157 0.7055
R4181 B11.n159 B11.n158 0.7055
R4182 B11.n160 B11.n159 0.7055
R4183 B11.n161 B11.n160 0.7055
R4184 B11.n162 B11.n161 0.7055
R4185 B11.n163 B11.n162 0.7055
R4186 B11.n164 B11.n163 0.7055
R4187 B11.n165 B11.n164 0.7055
R4188 B11.n166 B11.n165 0.7055
R4189 B11.n167 B11.n166 0.7055
R4190 B11.n168 B11.n167 0.7055
R4191 B11.n169 B11.n168 0.7055
R4192 B11.n170 B11.n169 0.7055
R4193 B11.n171 B11.n170 0.7055
R4194 B11.n172 B11.n171 0.7055
R4195 B11.n173 B11.n172 0.7055
R4196 B11.n174 B11.n173 0.7055
R4197 B11.n175 B11.n174 0.7055
R4198 B11.n176 B11.n175 0.7055
R4199 B11.n177 B11.n176 0.7055
R4200 B11.n178 B11.n177 0.7055
R4201 B11.n179 B11.n178 0.7055
R4202 B11.n180 B11.n179 0.7055
R4203 B11.n181 B11.n180 0.7055
R4204 B11.n182 B11.n181 0.7055
R4205 B11.n183 B11.n182 0.7055
R4206 B11.n184 B11.n183 0.7055
R4207 B11.n185 B11.n184 0.7055
R4208 B11.n186 B11.n185 0.7055
R4209 B11.n187 B11.n186 0.7055
R4210 B11.n188 B11.n187 0.7055
R4211 B11.n189 B11.n188 0.7055
R4212 B11.n190 B11.n189 0.7055
R4213 B11.n191 B11.n190 0.7055
R4214 B11.n192 B11.n191 0.7055
R4215 B11.n193 B11.n192 0.7055
R4216 B11.n194 B11.n193 0.7055
R4217 B11.n195 B11.n194 0.7055
R4218 B11.n196 B11.n195 0.7055
R4219 B11.n197 B11.n196 0.7055
R4220 B11.n198 B11.n197 0.7055
R4221 B11.n199 B11.n198 0.7055
R4222 B11.n200 B11.n199 0.7055
R4223 B11.n201 B11.n200 0.7055
R4224 B11.n202 B11.n201 0.7055
R4225 B11.n205 B11.n204 0.7055
R4226 B11.n206 B11.n205 0.7055
R4227 B11.n207 B11.n206 0.7055
R4228 B11.n208 B11.n207 0.7055
R4229 B11.n209 B11.n208 0.7055
R4230 B11.n210 B11.n209 0.7055
R4231 B11.n211 B11.n210 0.7055
R4232 B11.n212 B11.n211 0.7055
R4233 B11.n213 B11.n212 0.7055
R4234 B11.n214 B11.n213 0.7055
R4235 B11.n215 B11.n214 0.7055
R4236 B11.n216 B11.n215 0.7055
R4237 B11.n217 B11.n216 0.7055
R4238 B11.n218 B11.n217 0.7055
R4239 B11.n219 B11.n218 0.7055
R4240 B11.n220 B11.n219 0.7055
R4241 B11.n221 B11.n220 0.7055
R4242 B11.n222 B11.n221 0.7055
R4243 B11.n223 B11.n222 0.7055
R4244 B11.n224 B11.n223 0.7055
R4245 B11.n225 B11.n224 0.7055
R4246 B11.n226 B11.n225 0.7055
R4247 B11.n227 B11.n226 0.7055
R4248 B11.n228 B11.n227 0.7055
R4249 B11.n229 B11.n228 0.7055
R4250 B11.n230 B11.n229 0.7055
R4251 B11.n231 B11.n230 0.7055
R4252 B11.n232 B11.n231 0.7055
R4253 B11.n233 B11.n232 0.7055
R4254 B11.n234 B11.n233 0.7055
R4255 B11.n235 B11.n234 0.7055
R4256 B11.n236 B11.n235 0.7055
R4257 B11.n237 B11.n236 0.7055
R4258 B11.n238 B11.n237 0.7055
R4259 B11.n239 B11.n238 0.7055
R4260 B11.n240 B11.n239 0.7055
R4261 B11.n241 B11.n240 0.7055
R4262 B11.n242 B11.n241 0.7055
R4263 B11.n243 B11.n242 0.7055
R4264 B11.n244 B11.n243 0.7055
R4265 B11.n245 B11.n244 0.7055
R4266 B11.n246 B11.n245 0.7055
R4267 B11.n247 B11.n246 0.7055
R4268 B11.n248 B11.n247 0.7055
R4269 B11.n249 B11.n248 0.7055
R4270 B11.n250 B11.n249 0.7055
R4271 B11.n251 B11.n250 0.7055
R4272 B11.n252 B11.n251 0.7055
R4273 B11.n253 B11.n252 0.7055
R4274 B11.n254 B11.n253 0.7055
R4275 B11.n255 B11.n254 0.7055
R4276 B11.n256 B11.n255 0.7055
R4277 B11.n257 B11.n256 0.7055
R4278 B11.n258 B11.n257 0.7055
R4279 B11.n259 B11.n258 0.7055
R4280 B11.n260 B11.n259 0.7055
R4281 B11.n261 B11.n260 0.7055
R4282 B11.n262 B11.n261 0.7055
R4283 B11.n263 B11.n262 0.7055
R4284 B11.n264 B11.n263 0.7055
R4285 B11.n265 B11.n264 0.7055
R4286 B11.n268 B11.n267 0.7055
R4287 B11.n269 B11.n268 0.7055
R4288 B11.n270 B11.n269 0.7055
R4289 B11.n271 B11.n270 0.7055
R4290 B11.n272 B11.n271 0.7055
R4291 B11.n273 B11.n272 0.7055
R4292 B11.n274 B11.n273 0.7055
R4293 B11.n275 B11.n274 0.7055
R4294 B11.n276 B11.n275 0.7055
R4295 B11.n277 B11.n276 0.7055
R4296 B11.n278 B11.n277 0.7055
R4297 B11.n279 B11.n278 0.7055
R4298 B11.n280 B11.n279 0.7055
R4299 B11.n281 B11.n280 0.7055
R4300 B11.n282 B11.n281 0.7055
R4301 B11.n283 B11.n282 0.7055
R4302 B11.n284 B11.n283 0.7055
R4303 B11.n285 B11.n284 0.7055
R4304 B11.n286 B11.n285 0.7055
R4305 B11.n287 B11.n286 0.7055
R4306 B11.n288 B11.n287 0.7055
R4307 B11.n289 B11.n288 0.7055
R4308 B11.n290 B11.n289 0.7055
R4309 B11.n291 B11.n290 0.7055
R4310 B11.n292 B11.n291 0.7055
R4311 B11.n293 B11.n292 0.7055
R4312 B11.n294 B11.n293 0.7055
R4313 B11.n295 B11.n294 0.7055
R4314 B11.n296 B11.n295 0.7055
R4315 B11.n297 B11.n296 0.7055
R4316 B11.n298 B11.n297 0.7055
R4317 B11.n299 B11.n298 0.7055
R4318 B11.n300 B11.n299 0.7055
R4319 B11.n301 B11.n300 0.7055
R4320 B11.n302 B11.n301 0.7055
R4321 B11.n303 B11.n302 0.7055
R4322 B11.n304 B11.n303 0.7055
R4323 B11.n305 B11.n304 0.7055
R4324 B11.n306 B11.n305 0.7055
R4325 B11.n307 B11.n306 0.7055
R4326 B11.n308 B11.n307 0.7055
R4327 B11.n309 B11.n308 0.7055
R4328 B11.n310 B11.n309 0.7055
R4329 B11.n311 B11.n310 0.7055
R4330 B11.n312 B11.n311 0.7055
R4331 B11.n313 B11.n312 0.7055
R4332 B11.n314 B11.n313 0.7055
R4333 B11.n315 B11.n314 0.7055
R4334 B11.n316 B11.n315 0.7055
R4335 B11.n317 B11.n316 0.7055
R4336 B11.n318 B11.n317 0.7055
R4337 B11.n319 B11.n318 0.7055
R4338 B11.n320 B11.n319 0.7055
R4339 B11.n321 B11.n320 0.7055
R4340 B11.n322 B11.n321 0.7055
R4341 B11.n323 B11.n322 0.7055
R4342 B11.n324 B11.n323 0.7055
R4343 B11.n325 B11.n324 0.7055
R4344 B11.n326 B11.n325 0.7055
R4345 B11.n327 B11.n326 0.7055
R4346 B11.n328 B11.n327 0.7055
R4347 B11.n331 B11.n330 0.7055
R4348 B11.n332 B11.n331 0.7055
R4349 B11.n333 B11.n332 0.7055
R4350 B11.n334 B11.n333 0.7055
R4351 B11.n335 B11.n334 0.7055
R4352 B11.n336 B11.n335 0.7055
R4353 B11.n337 B11.n336 0.7055
R4354 B11.n338 B11.n337 0.7055
R4355 B11.n339 B11.n338 0.7055
R4356 B11.n340 B11.n339 0.7055
R4357 B11.n341 B11.n340 0.7055
R4358 B11.n342 B11.n341 0.7055
R4359 B11.n343 B11.n342 0.7055
R4360 B11.n344 B11.n343 0.7055
R4361 B11.n345 B11.n344 0.7055
R4362 B11.n346 B11.n345 0.7055
R4363 B11.n347 B11.n346 0.7055
R4364 B11.n348 B11.n347 0.7055
R4365 B11.n349 B11.n348 0.7055
R4366 B11.n350 B11.n349 0.7055
R4367 B11.n351 B11.n350 0.7055
R4368 B11.n352 B11.n351 0.7055
R4369 B11.n353 B11.n352 0.7055
R4370 B11.n354 B11.n353 0.7055
R4371 B11.n355 B11.n354 0.7055
R4372 B11.n356 B11.n355 0.7055
R4373 B11.n357 B11.n356 0.7055
R4374 B11.n358 B11.n357 0.7055
R4375 B11.n359 B11.n358 0.7055
R4376 B11.n360 B11.n359 0.7055
R4377 B11.n361 B11.n360 0.7055
R4378 B11.n362 B11.n361 0.7055
R4379 B11.n363 B11.n362 0.7055
R4380 B11.n364 B11.n363 0.7055
R4381 B11.n365 B11.n364 0.7055
R4382 B11.n366 B11.n365 0.7055
R4383 B11.n367 B11.n366 0.7055
R4384 B11.n368 B11.n367 0.7055
R4385 B11.n369 B11.n368 0.7055
R4386 B11.n370 B11.n369 0.7055
R4387 B11.n371 B11.n370 0.7055
R4388 B11.n372 B11.n371 0.7055
R4389 B11.n373 B11.n372 0.7055
R4390 B11.n374 B11.n373 0.7055
R4391 B11.n375 B11.n374 0.7055
R4392 B11.n376 B11.n375 0.7055
R4393 B11.n377 B11.n376 0.7055
R4394 B11.n378 B11.n377 0.7055
R4395 B11.n379 B11.n378 0.7055
R4396 B11.n380 B11.n379 0.7055
R4397 B11.n381 B11.n380 0.7055
R4398 B11.n382 B11.n381 0.7055
R4399 B11.n383 B11.n382 0.7055
R4400 B11.n384 B11.n383 0.7055
R4401 B11.n385 B11.n384 0.7055
R4402 B11.n386 B11.n385 0.7055
R4403 B11.n387 B11.n386 0.7055
R4404 B11.n388 B11.n387 0.7055
R4405 B11.n389 B11.n388 0.7055
R4406 B11.n390 B11.n389 0.7055
R4407 B11.n391 B11.n390 0.7055
R4408 B11.n394 B11.n393 0.7055
R4409 B11.n395 B11.n394 0.7055
R4410 B11.n396 B11.n395 0.7055
R4411 B11.n397 B11.n396 0.7055
R4412 B11.n398 B11.n397 0.7055
R4413 B11.n399 B11.n398 0.7055
R4414 B11.n400 B11.n399 0.7055
R4415 B11.n401 B11.n400 0.7055
R4416 B11.n402 B11.n401 0.7055
R4417 B11.n403 B11.n402 0.7055
R4418 B11.n404 B11.n403 0.7055
R4419 B11.n405 B11.n404 0.7055
R4420 B11.n406 B11.n405 0.7055
R4421 B11.n407 B11.n406 0.7055
R4422 B11.n408 B11.n407 0.7055
R4423 B11.n409 B11.n408 0.7055
R4424 B11.n410 B11.n409 0.7055
R4425 B11.n411 B11.n410 0.7055
R4426 B11.n412 B11.n411 0.7055
R4427 B11.n413 B11.n412 0.7055
R4428 B11.n414 B11.n413 0.7055
R4429 B11.n415 B11.n414 0.7055
R4430 B11.n416 B11.n415 0.7055
R4431 B11.n417 B11.n416 0.7055
R4432 B11.n418 B11.n417 0.7055
R4433 B11.n419 B11.n418 0.7055
R4434 B11.n420 B11.n419 0.7055
R4435 B11.n421 B11.n420 0.7055
R4436 B11.n422 B11.n421 0.7055
R4437 B11.n423 B11.n422 0.7055
R4438 B11.n424 B11.n423 0.7055
R4439 B11.n425 B11.n424 0.7055
R4440 B11.n426 B11.n425 0.7055
R4441 B11.n427 B11.n426 0.7055
R4442 B11.n428 B11.n427 0.7055
R4443 B11.n429 B11.n428 0.7055
R4444 B11.n430 B11.n429 0.7055
R4445 B11.n431 B11.n430 0.7055
R4446 B11.n432 B11.n431 0.7055
R4447 B11.n433 B11.n432 0.7055
R4448 B11.n434 B11.n433 0.7055
R4449 B11.n435 B11.n434 0.7055
R4450 B11.n436 B11.n435 0.7055
R4451 B11.n437 B11.n436 0.7055
R4452 B11.n438 B11.n437 0.7055
R4453 B11.n439 B11.n438 0.7055
R4454 B11.n440 B11.n439 0.7055
R4455 B11.n441 B11.n440 0.7055
R4456 B11.n442 B11.n441 0.7055
R4457 B11.n443 B11.n442 0.7055
R4458 B11.n444 B11.n443 0.7055
R4459 B11.n445 B11.n444 0.7055
R4460 B11.n446 B11.n445 0.7055
R4461 B11.n447 B11.n446 0.7055
R4462 B11.n448 B11.n447 0.7055
R4463 B11.n449 B11.n448 0.7055
R4464 B11.n450 B11.n449 0.7055
R4465 B11.n451 B11.n450 0.7055
R4466 B11.n452 B11.n451 0.7055
R4467 B11.n453 B11.n452 0.7055
R4468 B11.n454 B11.n453 0.7055
R4469 B11.n457 B11.n456 0.7055
R4470 B11.n458 B11.n457 0.7055
R4471 B11.n459 B11.n458 0.7055
R4472 B11.n460 B11.n459 0.7055
R4473 B11.n461 B11.n460 0.7055
R4474 B11.n462 B11.n461 0.7055
R4475 B11.n463 B11.n462 0.7055
R4476 B11.n464 B11.n463 0.7055
R4477 B11.n465 B11.n464 0.7055
R4478 B11.n466 B11.n465 0.7055
R4479 B11.n467 B11.n466 0.7055
R4480 B11.n468 B11.n467 0.7055
R4481 B11.n469 B11.n468 0.7055
R4482 B11.n470 B11.n469 0.7055
R4483 B11.n471 B11.n470 0.7055
R4484 B11.n472 B11.n471 0.7055
R4485 B11.n473 B11.n472 0.7055
R4486 B11.n474 B11.n473 0.7055
R4487 B11.n475 B11.n474 0.7055
R4488 B11.n476 B11.n475 0.7055
R4489 B11.n477 B11.n476 0.7055
R4490 B11.n478 B11.n477 0.7055
R4491 B11.n479 B11.n478 0.7055
R4492 B11.n480 B11.n479 0.7055
R4493 B11.n481 B11.n480 0.7055
R4494 B11.n482 B11.n481 0.7055
R4495 B11.n483 B11.n482 0.7055
R4496 B11.n484 B11.n483 0.7055
R4497 B11.n485 B11.n484 0.7055
R4498 B11.n486 B11.n485 0.7055
R4499 B11.n487 B11.n486 0.7055
R4500 B11.n488 B11.n487 0.7055
R4501 B11.n489 B11.n488 0.7055
R4502 B11.n490 B11.n489 0.7055
R4503 B11.n491 B11.n490 0.7055
R4504 B11.n492 B11.n491 0.7055
R4505 B11.n493 B11.n492 0.7055
R4506 B11.n494 B11.n493 0.7055
R4507 B11.n495 B11.n494 0.7055
R4508 B11.n496 B11.n495 0.7055
R4509 B11.n497 B11.n496 0.7055
R4510 B11.n498 B11.n497 0.7055
R4511 B11.n499 B11.n498 0.7055
R4512 B11.n500 B11.n499 0.7055
R4513 B11.n501 B11.n500 0.7055
R4514 B11.n502 B11.n501 0.7055
R4515 B11.n503 B11.n502 0.7055
R4516 B11.n504 B11.n503 0.7055
R4517 B11.n505 B11.n504 0.7055
R4518 B11.n506 B11.n505 0.7055
R4519 B11.n507 B11.n506 0.7055
R4520 B11.n508 B11.n507 0.7055
R4521 B11.n509 B11.n508 0.7055
R4522 B11.n510 B11.n509 0.7055
R4523 B11.n511 B11.n510 0.7055
R4524 B11.n512 B11.n511 0.7055
R4525 B11.n513 B11.n512 0.7055
R4526 B11.n514 B11.n513 0.7055
R4527 B11.n515 B11.n514 0.7055
R4528 B11.n516 B11.n515 0.7055
R4529 B11.n517 B11.n516 0.7055
R4530 B11.n520 B11.n519 0.7055
R4531 B11.n521 B11.n520 0.7055
R4532 B11.n522 B11.n521 0.7055
R4533 B11.n523 B11.n522 0.7055
R4534 B11.n524 B11.n523 0.7055
R4535 B11.n525 B11.n524 0.7055
R4536 B11.n526 B11.n525 0.7055
R4537 B11.n527 B11.n526 0.7055
R4538 B11.n528 B11.n527 0.7055
R4539 B11.n529 B11.n528 0.7055
R4540 B11.n530 B11.n529 0.7055
R4541 B11.n531 B11.n530 0.7055
R4542 B11.n532 B11.n531 0.7055
R4543 B11.n533 B11.n532 0.7055
R4544 B11.n534 B11.n533 0.7055
R4545 B11.n535 B11.n534 0.7055
R4546 B11.n536 B11.n535 0.7055
R4547 B11.n537 B11.n536 0.7055
R4548 B11.n538 B11.n537 0.7055
R4549 B11.n539 B11.n538 0.7055
R4550 B11.n540 B11.n539 0.7055
R4551 B11.n541 B11.n540 0.7055
R4552 B11.n542 B11.n541 0.7055
R4553 B11.n543 B11.n542 0.7055
R4554 B11.n544 B11.n543 0.7055
R4555 B11.n545 B11.n544 0.7055
R4556 B11.n546 B11.n545 0.7055
R4557 B11.n547 B11.n546 0.7055
R4558 B11.n548 B11.n547 0.7055
R4559 B11.n549 B11.n548 0.7055
R4560 B11.n550 B11.n549 0.7055
R4561 B11.n551 B11.n550 0.7055
R4562 B11.n552 B11.n551 0.7055
R4563 B11.n553 B11.n552 0.7055
R4564 B11.n554 B11.n553 0.7055
R4565 B11.n555 B11.n554 0.7055
R4566 B11.n556 B11.n555 0.7055
R4567 B11.n557 B11.n556 0.7055
R4568 B11.n558 B11.n557 0.7055
R4569 B11.n559 B11.n558 0.7055
R4570 B11.n560 B11.n559 0.7055
R4571 B11.n561 B11.n560 0.7055
R4572 B11.n562 B11.n561 0.7055
R4573 B11.n563 B11.n562 0.7055
R4574 B11.n564 B11.n563 0.7055
R4575 B11.n565 B11.n564 0.7055
R4576 B11.n566 B11.n565 0.7055
R4577 B11.n567 B11.n566 0.7055
R4578 B11.n568 B11.n567 0.7055
R4579 B11.n569 B11.n568 0.7055
R4580 B11.n570 B11.n569 0.7055
R4581 B11.n571 B11.n570 0.7055
R4582 B11.n572 B11.n571 0.7055
R4583 B11.n573 B11.n572 0.7055
R4584 B11.n574 B11.n573 0.7055
R4585 B11.n575 B11.n574 0.7055
R4586 B11.n576 B11.n575 0.7055
R4587 B11.n577 B11.n576 0.7055
R4588 B11.n578 B11.n577 0.7055
R4589 B11.n579 B11.n578 0.7055
R4590 B11.n580 B11.n579 0.7055
R4591 B11.n583 B11.n582 0.7055
R4592 B11.n584 B11.n583 0.7055
R4593 B11.n585 B11.n584 0.7055
R4594 B11.n586 B11.n585 0.7055
R4595 B11.n587 B11.n586 0.7055
R4596 B11.n588 B11.n587 0.7055
R4597 B11.n589 B11.n588 0.7055
R4598 B11.n590 B11.n589 0.7055
R4599 B11.n591 B11.n590 0.7055
R4600 B11.n592 B11.n591 0.7055
R4601 B11.n593 B11.n592 0.7055
R4602 B11.n594 B11.n593 0.7055
R4603 B11.n595 B11.n594 0.7055
R4604 B11.n596 B11.n595 0.7055
R4605 B11.n597 B11.n596 0.7055
R4606 B11.n598 B11.n597 0.7055
R4607 B11.n599 B11.n598 0.7055
R4608 B11.n600 B11.n599 0.7055
R4609 B11.n601 B11.n600 0.7055
R4610 B11.n602 B11.n601 0.7055
R4611 B11.n603 B11.n602 0.7055
R4612 B11.n604 B11.n603 0.7055
R4613 B11.n605 B11.n604 0.7055
R4614 B11.n606 B11.n605 0.7055
R4615 B11.n607 B11.n606 0.7055
R4616 B11.n608 B11.n607 0.7055
R4617 B11.n609 B11.n608 0.7055
R4618 B11.n610 B11.n609 0.7055
R4619 B11.n611 B11.n610 0.7055
R4620 B11.n612 B11.n611 0.7055
R4621 B11.n613 B11.n612 0.7055
R4622 B11.n614 B11.n613 0.7055
R4623 B11.n615 B11.n614 0.7055
R4624 B11.n616 B11.n615 0.7055
R4625 B11.n617 B11.n616 0.7055
R4626 B11.n618 B11.n617 0.7055
R4627 B11.n619 B11.n618 0.7055
R4628 B11.n620 B11.n619 0.7055
R4629 B11.n621 B11.n620 0.7055
R4630 B11.n622 B11.n621 0.7055
R4631 B11.n623 B11.n622 0.7055
R4632 B11.n624 B11.n623 0.7055
R4633 B11.n625 B11.n624 0.7055
R4634 B11.n626 B11.n625 0.7055
R4635 B11.n627 B11.n626 0.7055
R4636 B11.n628 B11.n627 0.7055
R4637 B11.n629 B11.n628 0.7055
R4638 B11.n630 B11.n629 0.7055
R4639 B11.n631 B11.n630 0.7055
R4640 B11.n632 B11.n631 0.7055
R4641 B11.n633 B11.n632 0.7055
R4642 B11.n634 B11.n633 0.7055
R4643 B11.n635 B11.n634 0.7055
R4644 B11.n636 B11.n635 0.7055
R4645 B11.n637 B11.n636 0.7055
R4646 B11.n638 B11.n637 0.7055
R4647 B11.n639 B11.n638 0.7055
R4648 B11.n640 B11.n639 0.7055
R4649 B11.n641 B11.n640 0.7055
R4650 B11.n642 B11.n641 0.7055
R4651 B11.n643 B11.n642 0.7055
R4652 B11.n646 B11.n645 0.7055
R4653 B11.n647 B11.n646 0.7055
R4654 B11.n648 B11.n647 0.7055
R4655 B11.n649 B11.n648 0.7055
R4656 B11.n650 B11.n649 0.7055
R4657 B11.n651 B11.n650 0.7055
R4658 B11.n652 B11.n651 0.7055
R4659 B11.n653 B11.n652 0.7055
R4660 B11.n654 B11.n653 0.7055
R4661 B11.n655 B11.n654 0.7055
R4662 B11.n656 B11.n655 0.7055
R4663 B11.n657 B11.n656 0.7055
R4664 B11.n658 B11.n657 0.7055
R4665 B11.n659 B11.n658 0.7055
R4666 B11.n660 B11.n659 0.7055
R4667 B11.n661 B11.n660 0.7055
R4668 B11.n662 B11.n661 0.7055
R4669 B11.n663 B11.n662 0.7055
R4670 B11.n664 B11.n663 0.7055
R4671 B11.n665 B11.n664 0.7055
R4672 B11.n666 B11.n665 0.7055
R4673 B11.n667 B11.n666 0.7055
R4674 B11.n668 B11.n667 0.7055
R4675 B11.n669 B11.n668 0.7055
R4676 B11.n670 B11.n669 0.7055
R4677 B11.n671 B11.n670 0.7055
R4678 B11.n672 B11.n671 0.7055
R4679 B11.n673 B11.n672 0.7055
R4680 B11.n674 B11.n673 0.7055
R4681 B11.n675 B11.n674 0.7055
R4682 B11.n676 B11.n675 0.7055
R4683 B11.n677 B11.n676 0.7055
R4684 B11.n678 B11.n677 0.7055
R4685 B11.n679 B11.n678 0.7055
R4686 B11.n680 B11.n679 0.7055
R4687 B11.n681 B11.n680 0.7055
R4688 B11.n682 B11.n681 0.7055
R4689 B11.n683 B11.n682 0.7055
R4690 B11.n684 B11.n683 0.7055
R4691 B11.n685 B11.n684 0.7055
R4692 B11.n686 B11.n685 0.7055
R4693 B11.n687 B11.n686 0.7055
R4694 B11.n688 B11.n687 0.7055
R4695 B11.n689 B11.n688 0.7055
R4696 B11.n690 B11.n689 0.7055
R4697 B11.n691 B11.n690 0.7055
R4698 B11.n692 B11.n691 0.7055
R4699 B11.n693 B11.n692 0.7055
R4700 B11.n694 B11.n693 0.7055
R4701 B11.n695 B11.n694 0.7055
R4702 B11.n696 B11.n695 0.7055
R4703 B11.n697 B11.n696 0.7055
R4704 B11.n698 B11.n697 0.7055
R4705 B11.n699 B11.n698 0.7055
R4706 B11.n700 B11.n699 0.7055
R4707 B11.n701 B11.n700 0.7055
R4708 B11.n702 B11.n701 0.7055
R4709 B11.n703 B11.n702 0.7055
R4710 B11.n704 B11.n703 0.7055
R4711 B11.n705 B11.n704 0.7055
R4712 B11.n706 B11.n705 0.7055
R4713 B11.n709 B11.n708 0.7055
R4714 B11.n710 B11.n709 0.7055
R4715 B11.n711 B11.n710 0.7055
R4716 B11.n712 B11.n711 0.7055
R4717 B11.n713 B11.n712 0.7055
R4718 B11.n714 B11.n713 0.7055
R4719 B11.n715 B11.n714 0.7055
R4720 B11.n716 B11.n715 0.7055
R4721 B11.n717 B11.n716 0.7055
R4722 B11.n718 B11.n717 0.7055
R4723 B11.n719 B11.n718 0.7055
R4724 B11.n720 B11.n719 0.7055
R4725 B11.n721 B11.n720 0.7055
R4726 B11.n722 B11.n721 0.7055
R4727 B11.n723 B11.n722 0.7055
R4728 B11.n724 B11.n723 0.7055
R4729 B11.n725 B11.n724 0.7055
R4730 B11.n726 B11.n725 0.7055
R4731 B11.n727 B11.n726 0.7055
R4732 B11.n728 B11.n727 0.7055
R4733 B11.n729 B11.n728 0.7055
R4734 B11.n730 B11.n729 0.7055
R4735 B11.n731 B11.n730 0.7055
R4736 B11.n732 B11.n731 0.7055
R4737 B11.n733 B11.n732 0.7055
R4738 B11.n734 B11.n733 0.7055
R4739 B11.n735 B11.n734 0.7055
R4740 B11.n736 B11.n735 0.7055
R4741 B11.n737 B11.n736 0.7055
R4742 B11.n738 B11.n737 0.7055
R4743 B11.n739 B11.n738 0.7055
R4744 B11.n740 B11.n739 0.7055
R4745 B11.n741 B11.n740 0.7055
R4746 B11.n742 B11.n741 0.7055
R4747 B11.n743 B11.n742 0.7055
R4748 B11.n744 B11.n743 0.7055
R4749 B11.n745 B11.n744 0.7055
R4750 B11.n746 B11.n745 0.7055
R4751 B11.n747 B11.n746 0.7055
R4752 B11.n748 B11.n747 0.7055
R4753 B11.n749 B11.n748 0.7055
R4754 B11.n750 B11.n749 0.7055
R4755 B11.n751 B11.n750 0.7055
R4756 B11.n752 B11.n751 0.7055
R4757 B11.n753 B11.n752 0.7055
R4758 B11.n754 B11.n753 0.7055
R4759 B11.n755 B11.n754 0.7055
R4760 B11.n756 B11.n755 0.7055
R4761 B11.n757 B11.n756 0.7055
R4762 B11.n758 B11.n757 0.7055
R4763 B11.n759 B11.n758 0.7055
R4764 B11.n760 B11.n759 0.7055
R4765 B11.n761 B11.n760 0.7055
R4766 B11.n762 B11.n761 0.7055
R4767 B11.n763 B11.n762 0.7055
R4768 B11.n764 B11.n763 0.7055
R4769 B11.n765 B11.n764 0.7055
R4770 B11.n766 B11.n765 0.7055
R4771 B11.n767 B11.n766 0.7055
R4772 B11.n768 B11.n767 0.7055
R4773 B11.n769 B11.n768 0.7055
R4774 B11.n772 B11.n771 0.7055
R4775 B11.n773 B11.n772 0.7055
R4776 B11.n774 B11.n773 0.7055
R4777 B11.n775 B11.n774 0.7055
R4778 B11.n776 B11.n775 0.7055
R4779 B11.n777 B11.n776 0.7055
R4780 B11.n778 B11.n777 0.7055
R4781 B11.n779 B11.n778 0.7055
R4782 B11.n780 B11.n779 0.7055
R4783 B11.n781 B11.n780 0.7055
R4784 B11.n782 B11.n781 0.7055
R4785 B11.n783 B11.n782 0.7055
R4786 B11.n784 B11.n783 0.7055
R4787 B11.n785 B11.n784 0.7055
R4788 B11.n786 B11.n785 0.7055
R4789 B11.n787 B11.n786 0.7055
R4790 B11.n788 B11.n787 0.7055
R4791 B11.n789 B11.n788 0.7055
R4792 B11.n790 B11.n789 0.7055
R4793 B11.n791 B11.n790 0.7055
R4794 B11.n792 B11.n791 0.7055
R4795 B11.n793 B11.n792 0.7055
R4796 B11.n794 B11.n793 0.7055
R4797 B11.n795 B11.n794 0.7055
R4798 B11.n796 B11.n795 0.7055
R4799 B11.n797 B11.n796 0.7055
R4800 B11.n798 B11.n797 0.7055
R4801 B11.n799 B11.n798 0.7055
R4802 B11.n800 B11.n799 0.7055
R4803 B11.n801 B11.n800 0.7055
R4804 B11.n802 B11.n801 0.7055
R4805 B11.n803 B11.n802 0.7055
R4806 B11.n804 B11.n803 0.7055
R4807 B11.n805 B11.n804 0.7055
R4808 B11.n806 B11.n805 0.7055
R4809 B11.n807 B11.n806 0.7055
R4810 B11.n808 B11.n807 0.7055
R4811 B11.n809 B11.n808 0.7055
R4812 B11.n810 B11.n809 0.7055
R4813 B11.n811 B11.n810 0.7055
R4814 B11.n812 B11.n811 0.7055
R4815 B11.n813 B11.n812 0.7055
R4816 B11.n814 B11.n813 0.7055
R4817 B11.n815 B11.n814 0.7055
R4818 B11.n816 B11.n815 0.7055
R4819 B11.n817 B11.n816 0.7055
R4820 B11.n818 B11.n817 0.7055
R4821 B11.n819 B11.n818 0.7055
R4822 B11.n820 B11.n819 0.7055
R4823 B11.n821 B11.n820 0.7055
R4824 B11.n822 B11.n821 0.7055
R4825 B11.n823 B11.n822 0.7055
R4826 B11.n824 B11.n823 0.7055
R4827 B11.n825 B11.n824 0.7055
R4828 B11.n826 B11.n825 0.7055
R4829 B11.n827 B11.n826 0.7055
R4830 B11.n828 B11.n827 0.7055
R4831 B11.n829 B11.n828 0.7055
R4832 B11.n830 B11.n829 0.7055
R4833 B11.n831 B11.n830 0.7055
R4834 B11.n832 B11.n831 0.7055
R4835 B11.n835 B11.n834 0.7055
R4836 B11.n836 B11.n835 0.7055
R4837 B11.n837 B11.n836 0.7055
R4838 B11.n838 B11.n837 0.7055
R4839 B11.n839 B11.n838 0.7055
R4840 B11.n840 B11.n839 0.7055
R4841 B11.n841 B11.n840 0.7055
R4842 B11.n842 B11.n841 0.7055
R4843 B11.n843 B11.n842 0.7055
R4844 B11.n844 B11.n843 0.7055
R4845 B11.n845 B11.n844 0.7055
R4846 B11.n846 B11.n845 0.7055
R4847 B11.n847 B11.n846 0.7055
R4848 B11.n848 B11.n847 0.7055
R4849 B11.n849 B11.n848 0.7055
R4850 B11.n850 B11.n849 0.7055
R4851 B11.n851 B11.n850 0.7055
R4852 B11.n852 B11.n851 0.7055
R4853 B11.n853 B11.n852 0.7055
R4854 B11.n854 B11.n853 0.7055
R4855 B11.n855 B11.n854 0.7055
R4856 B11.n856 B11.n855 0.7055
R4857 B11.n857 B11.n856 0.7055
R4858 B11.n858 B11.n857 0.7055
R4859 B11.n859 B11.n858 0.7055
R4860 B11.n860 B11.n859 0.7055
R4861 B11.n861 B11.n860 0.7055
R4862 B11.n862 B11.n861 0.7055
R4863 B11.n863 B11.n862 0.7055
R4864 B11.n864 B11.n863 0.7055
R4865 B11.n865 B11.n864 0.7055
R4866 B11.n866 B11.n865 0.7055
R4867 B11.n867 B11.n866 0.7055
R4868 B11.n868 B11.n867 0.7055
R4869 B11.n869 B11.n868 0.7055
R4870 B11.n870 B11.n869 0.7055
R4871 B11.n871 B11.n870 0.7055
R4872 B11.n872 B11.n871 0.7055
R4873 B11.n873 B11.n872 0.7055
R4874 B11.n874 B11.n873 0.7055
R4875 B11.n875 B11.n874 0.7055
R4876 B11.n876 B11.n875 0.7055
R4877 B11.n877 B11.n876 0.7055
R4878 B11.n878 B11.n877 0.7055
R4879 B11.n879 B11.n878 0.7055
R4880 B11.n880 B11.n879 0.7055
R4881 B11.n881 B11.n880 0.7055
R4882 B11.n882 B11.n881 0.7055
R4883 B11.n883 B11.n882 0.7055
R4884 B11.n884 B11.n883 0.7055
R4885 B11.n885 B11.n884 0.7055
R4886 B11.n886 B11.n885 0.7055
R4887 B11.n887 B11.n886 0.7055
R4888 B11.n888 B11.n887 0.7055
R4889 B11.n889 B11.n888 0.7055
R4890 B11.n890 B11.n889 0.7055
R4891 B11.n891 B11.n890 0.7055
R4892 B11.n892 B11.n891 0.7055
R4893 B11.n893 B11.n892 0.7055
R4894 B11.n894 B11.n893 0.7055
R4895 B11.n895 B11.n894 0.7055
R4896 B11.n898 B11.n897 0.7055
R4897 B11.n899 B11.n898 0.7055
R4898 B11.n900 B11.n899 0.7055
R4899 B11.n901 B11.n900 0.7055
R4900 B11.n902 B11.n901 0.7055
R4901 B11.n903 B11.n902 0.7055
R4902 B11.n904 B11.n903 0.7055
R4903 B11.n905 B11.n904 0.7055
R4904 B11.n906 B11.n905 0.7055
R4905 B11.n907 B11.n906 0.7055
R4906 B11.n908 B11.n907 0.7055
R4907 B11.n909 B11.n908 0.7055
R4908 B11.n910 B11.n909 0.7055
R4909 B11.n911 B11.n910 0.7055
R4910 B11.n912 B11.n911 0.7055
R4911 B11.n913 B11.n912 0.7055
R4912 B11.n914 B11.n913 0.7055
R4913 B11.n915 B11.n914 0.7055
R4914 B11.n916 B11.n915 0.7055
R4915 B11.n917 B11.n916 0.7055
R4916 B11.n918 B11.n917 0.7055
R4917 B11.n919 B11.n918 0.7055
R4918 B11.n920 B11.n919 0.7055
R4919 B11.n921 B11.n920 0.7055
R4920 B11.n922 B11.n921 0.7055
R4921 B11.n923 B11.n922 0.7055
R4922 B11.n924 B11.n923 0.7055
R4923 B11.n925 B11.n924 0.7055
R4924 B11.n926 B11.n925 0.7055
R4925 B11.n927 B11.n926 0.7055
R4926 B11.n928 B11.n927 0.7055
R4927 B11.n929 B11.n928 0.7055
R4928 B11.n930 B11.n929 0.7055
R4929 B11.n931 B11.n930 0.7055
R4930 B11.n932 B11.n931 0.7055
R4931 B11.n933 B11.n932 0.7055
R4932 B11.n934 B11.n933 0.7055
R4933 B11.n935 B11.n934 0.7055
R4934 B11.n936 B11.n935 0.7055
R4935 B11.n937 B11.n936 0.7055
R4936 B11.n938 B11.n937 0.7055
R4937 B11.n939 B11.n938 0.7055
R4938 B11.n940 B11.n939 0.7055
R4939 B11.n941 B11.n940 0.7055
R4940 B11.n942 B11.n941 0.7055
R4941 B11.n943 B11.n942 0.7055
R4942 B11.n944 B11.n943 0.7055
R4943 B11.n945 B11.n944 0.7055
R4944 B11.n946 B11.n945 0.7055
R4945 B11.n947 B11.n946 0.7055
R4946 B11.n948 B11.n947 0.7055
R4947 B11.n949 B11.n948 0.7055
R4948 B11.n950 B11.n949 0.7055
R4949 B11.n951 B11.n950 0.7055
R4950 B11.n952 B11.n951 0.7055
R4951 B11.n953 B11.n952 0.7055
R4952 B11.n954 B11.n953 0.7055
R4953 B11.n955 B11.n954 0.7055
R4954 B11.n956 B11.n955 0.7055
R4955 B11.n957 B11.n956 0.7055
R4956 B11.n958 B11.n957 0.7055
R4957 B11.n961 B11.n960 0.7055
R4958 B11.n962 B11.n961 0.7055
R4959 B11.n963 B11.n962 0.7055
R4960 B11.n964 B11.n963 0.7055
R4961 B11.n965 B11.n964 0.7055
R4962 B11.n966 B11.n965 0.7055
R4963 B11.n967 B11.n966 0.7055
R4964 B11.n968 B11.n967 0.7055
R4965 B11.n969 B11.n968 0.7055
R4966 B11.n970 B11.n969 0.7055
R4967 B11.n971 B11.n970 0.7055
R4968 B11.n972 B11.n971 0.7055
R4969 B11.n973 B11.n972 0.7055
R4970 B11.n974 B11.n973 0.7055
R4971 B11.n975 B11.n974 0.7055
R4972 B11.n976 B11.n975 0.7055
R4973 B11.n977 B11.n976 0.7055
R4974 B11.n978 B11.n977 0.7055
R4975 B11.n979 B11.n978 0.7055
R4976 B11.n980 B11.n979 0.7055
R4977 B11.n981 B11.n980 0.7055
R4978 B11.n982 B11.n981 0.7055
R4979 B11.n983 B11.n982 0.7055
R4980 B11.n984 B11.n983 0.7055
R4981 B11.n985 B11.n984 0.7055
R4982 B11.n986 B11.n985 0.7055
R4983 B11.n987 B11.n986 0.7055
R4984 B11.n988 B11.n987 0.7055
R4985 B11.n989 B11.n988 0.7055
R4986 B11.n990 B11.n989 0.7055
R4987 B11.n991 B11.n990 0.7055
R4988 B11.n992 B11.n991 0.7055
R4989 B11.n993 B11.n992 0.7055
R4990 B11.n994 B11.n993 0.7055
R4991 B11.n995 B11.n994 0.7055
R4992 B11.n996 B11.n995 0.7055
R4993 B11.n997 B11.n996 0.7055
R4994 B11.n998 B11.n997 0.7055
R4995 B11.n999 B11.n998 0.7055
R4996 B11.n1000 B11.n999 0.7055
R4997 B11.n1001 B11.n1000 0.7055
R4998 B11.n1002 B11.n1001 0.7055
R4999 B11.n1003 B11.n1002 0.7055
R5000 B11.n1004 B11.n1003 0.7055
R5001 B11.n1005 B11.n1004 0.7055
R5002 B11.n1006 B11.n1005 0.7055
R5003 B11.n1007 B11.n1006 0.7055
R5004 B11.n1008 B11.n1007 0.7055
R5005 B11.n1009 B11.n1008 0.7055
R5006 B11.n1010 B11.n1009 0.7055
R5007 B11.n1011 B11.n1010 0.7055
R5008 B11.n1012 B11.n1011 0.7055
R5009 B11.n1013 B11.n1012 0.7055
R5010 B11.n1014 B11.n1013 0.7055
R5011 B11.n1015 B11.n1014 0.7055
R5012 B11.n1016 B11.n1015 0.7055
R5013 B11.n1017 B11.n1016 0.7055
R5014 B11.n1018 B11.n1017 0.7055
R5015 B11.n1019 B11.n1018 0.7055
R5016 B11.n1020 B11.n1019 0.7055
R5017 B11.n1021 B11.n1020 0.7055
R5018 B11.n1084 B11.n1083 0.7055
R5019 B11.n1083 B11.n1082 0.7055
R5020 B11.n1082 B11.n1081 0.7055
R5021 B11.n1081 B11.n1080 0.7055
R5022 B11.n1080 B11.n1079 0.7055
R5023 B11.n1079 B11.n1078 0.7055
R5024 B11.n1078 B11.n1077 0.7055
R5025 B11.n1077 B11.n1076 0.7055
R5026 B11.n1076 B11.n1075 0.7055
R5027 B11.n1075 B11.n1074 0.7055
R5028 B11.n1074 B11.n1073 0.7055
R5029 B11.n1073 B11.n1072 0.7055
R5030 B11.n1072 B11.n1071 0.7055
R5031 B11.n1071 B11.n1070 0.7055
R5032 B11.n1070 B11.n1069 0.7055
R5033 B11.n1069 B11.n1068 0.7055
R5034 B11.n1068 B11.n1067 0.7055
R5035 B11.n1067 B11.n1066 0.7055
R5036 B11.n1066 B11.n1065 0.7055
R5037 B11.n1065 B11.n1064 0.7055
R5038 B11.n1064 B11.n1063 0.7055
R5039 B11.n1063 B11.n1062 0.7055
R5040 B11.n1062 B11.n1061 0.7055
R5041 B11.n1061 B11.n1060 0.7055
R5042 B11.n1060 B11.n1059 0.7055
R5043 B11.n1059 B11.n1058 0.7055
R5044 B11.n1058 B11.n1057 0.7055
R5045 B11.n1057 B11.n1056 0.7055
R5046 B11.n1056 B11.n1055 0.7055
R5047 B11.n1055 B11.n1054 0.7055
R5048 B11.n1054 B11.n1053 0.7055
R5049 B11.n1053 B11.n1052 0.7055
R5050 B11.n1052 B11.n1051 0.7055
R5051 B11.n1051 B11.n1050 0.7055
R5052 B11.n1050 B11.n1049 0.7055
R5053 B11.n1049 B11.n1048 0.7055
R5054 B11.n1048 B11.n1047 0.7055
R5055 B11.n1047 B11.n1046 0.7055
R5056 B11.n1046 B11.n1045 0.7055
R5057 B11.n1045 B11.n1044 0.7055
R5058 B11.n1044 B11.n1043 0.7055
R5059 B11.n1043 B11.n1042 0.7055
R5060 B11.n1042 B11.n1041 0.7055
R5061 B11.n1041 B11.n1040 0.7055
R5062 B11.n1040 B11.n1039 0.7055
R5063 B11.n1039 B11.n1038 0.7055
R5064 B11.n1038 B11.n1037 0.7055
R5065 B11.n1037 B11.n1036 0.7055
R5066 B11.n1036 B11.n1035 0.7055
R5067 B11.n1035 B11.n1034 0.7055
R5068 B11.n1034 B11.n1033 0.7055
R5069 B11.n1033 B11.n1032 0.7055
R5070 B11.n1032 B11.n1031 0.7055
R5071 B11.n1031 B11.n1030 0.7055
R5072 B11.n1030 B11.n1029 0.7055
R5073 B11.n1029 B11.n1028 0.7055
R5074 B11.n1028 B11.n1027 0.7055
R5075 B11.n1027 B11.n1026 0.7055
R5076 B11.n1026 B11.n1025 0.7055
R5077 B11.n1025 B11.n1024 0.7055
R5078 B11.n1024 B11.n1023 0.7055
R5079 B11.n1146 B11.n1145 0.7055
R5080 B11.n1145 B11.n1144 0.7055
R5081 B11.n1144 B11.n1143 0.7055
R5082 B11.n1143 B11.n1142 0.7055
R5083 B11.n1142 B11.n1141 0.7055
R5084 B11.n1141 B11.n1140 0.7055
R5085 B11.n1140 B11.n1139 0.7055
R5086 B11.n1139 B11.n1138 0.7055
R5087 B11.n1138 B11.n1137 0.7055
R5088 B11.n1137 B11.n1136 0.7055
R5089 B11.n1136 B11.n1135 0.7055
R5090 B11.n1135 B11.n1134 0.7055
R5091 B11.n1134 B11.n1133 0.7055
R5092 B11.n1133 B11.n1132 0.7055
R5093 B11.n1132 B11.n1131 0.7055
R5094 B11.n1131 B11.n1130 0.7055
R5095 B11.n1130 B11.n1129 0.7055
R5096 B11.n1129 B11.n1128 0.7055
R5097 B11.n1128 B11.n1127 0.7055
R5098 B11.n1127 B11.n1126 0.7055
R5099 B11.n1126 B11.n1125 0.7055
R5100 B11.n1125 B11.n1124 0.7055
R5101 B11.n1124 B11.n1123 0.7055
R5102 B11.n1123 B11.n1122 0.7055
R5103 B11.n1122 B11.n1121 0.7055
R5104 B11.n1121 B11.n1120 0.7055
R5105 B11.n1120 B11.n1119 0.7055
R5106 B11.n1119 B11.n1118 0.7055
R5107 B11.n1118 B11.n1117 0.7055
R5108 B11.n1117 B11.n1116 0.7055
R5109 B11.n1116 B11.n1115 0.7055
R5110 B11.n1115 B11.n1114 0.7055
R5111 B11.n1114 B11.n1113 0.7055
R5112 B11.n1113 B11.n1112 0.7055
R5113 B11.n1112 B11.n1111 0.7055
R5114 B11.n1111 B11.n1110 0.7055
R5115 B11.n1110 B11.n1109 0.7055
R5116 B11.n1109 B11.n1108 0.7055
R5117 B11.n1108 B11.n1107 0.7055
R5118 B11.n1107 B11.n1106 0.7055
R5119 B11.n1106 B11.n1105 0.7055
R5120 B11.n1105 B11.n1104 0.7055
R5121 B11.n1104 B11.n1103 0.7055
R5122 B11.n1103 B11.n1102 0.7055
R5123 B11.n1102 B11.n1101 0.7055
R5124 B11.n1101 B11.n1100 0.7055
R5125 B11.n1100 B11.n1099 0.7055
R5126 B11.n1099 B11.n1098 0.7055
R5127 B11.n1098 B11.n1097 0.7055
R5128 B11.n1097 B11.n1096 0.7055
R5129 B11.n1096 B11.n1095 0.7055
R5130 B11.n1095 B11.n1094 0.7055
R5131 B11.n1094 B11.n1093 0.7055
R5132 B11.n1093 B11.n1092 0.7055
R5133 B11.n1092 B11.n1091 0.7055
R5134 B11.n1091 B11.n1090 0.7055
R5135 B11.n1090 B11.n1089 0.7055
R5136 B11.n1089 B11.n1088 0.7055
R5137 B11.n1088 B11.n1087 0.7055
R5138 B11.n1087 B11.n1086 0.7055
R5139 B11.n1086 B11.n1085 0.7055
R5140 B11.n1209 B11.n1208 0.7055
R5141 B11.n1208 B11.n1207 0.7055
R5142 B11.n1207 B11.n1206 0.7055
R5143 B11.n1206 B11.n1205 0.7055
R5144 B11.n1205 B11.n1204 0.7055
R5145 B11.n1204 B11.n1203 0.7055
R5146 B11.n1203 B11.n1202 0.7055
R5147 B11.n1202 B11.n1201 0.7055
R5148 B11.n1201 B11.n1200 0.7055
R5149 B11.n1200 B11.n1199 0.7055
R5150 B11.n1199 B11.n1198 0.7055
R5151 B11.n1198 B11.n1197 0.7055
R5152 B11.n1197 B11.n1196 0.7055
R5153 B11.n1196 B11.n1195 0.7055
R5154 B11.n1195 B11.n1194 0.7055
R5155 B11.n1194 B11.n1193 0.7055
R5156 B11.n1193 B11.n1192 0.7055
R5157 B11.n1192 B11.n1191 0.7055
R5158 B11.n1191 B11.n1190 0.7055
R5159 B11.n1190 B11.n1189 0.7055
R5160 B11.n1189 B11.n1188 0.7055
R5161 B11.n1188 B11.n1187 0.7055
R5162 B11.n1187 B11.n1186 0.7055
R5163 B11.n1186 B11.n1185 0.7055
R5164 B11.n1185 B11.n1184 0.7055
R5165 B11.n1184 B11.n1183 0.7055
R5166 B11.n1183 B11.n1182 0.7055
R5167 B11.n1182 B11.n1181 0.7055
R5168 B11.n1181 B11.n1180 0.7055
R5169 B11.n1180 B11.n1179 0.7055
R5170 B11.n1179 B11.n1178 0.7055
R5171 B11.n1178 B11.n1177 0.7055
R5172 B11.n1177 B11.n1176 0.7055
R5173 B11.n1176 B11.n1175 0.7055
R5174 B11.n1175 B11.n1174 0.7055
R5175 B11.n1174 B11.n1173 0.7055
R5176 B11.n1173 B11.n1172 0.7055
R5177 B11.n1172 B11.n1171 0.7055
R5178 B11.n1171 B11.n1170 0.7055
R5179 B11.n1170 B11.n1169 0.7055
R5180 B11.n1169 B11.n1168 0.7055
R5181 B11.n1168 B11.n1167 0.7055
R5182 B11.n1167 B11.n1166 0.7055
R5183 B11.n1166 B11.n1165 0.7055
R5184 B11.n1165 B11.n1164 0.7055
R5185 B11.n1164 B11.n1163 0.7055
R5186 B11.n1163 B11.n1162 0.7055
R5187 B11.n1162 B11.n1161 0.7055
R5188 B11.n1161 B11.n1160 0.7055
R5189 B11.n1160 B11.n1159 0.7055
R5190 B11.n1159 B11.n1158 0.7055
R5191 B11.n1158 B11.n1157 0.7055
R5192 B11.n1157 B11.n1156 0.7055
R5193 B11.n1156 B11.n1155 0.7055
R5194 B11.n1155 B11.n1154 0.7055
R5195 B11.n1154 B11.n1153 0.7055
R5196 B11.n1153 B11.n1152 0.7055
R5197 B11.n1152 B11.n1151 0.7055
R5198 B11.n1151 B11.n1150 0.7055
R5199 B11.n1150 B11.n1149 0.7055
R5200 B11.n1149 B11.n1148 0.7055
R5201 B11.n1272 B11.n1271 0.7055
R5202 B11.n1271 B11.n1270 0.7055
R5203 B11.n1270 B11.n1269 0.7055
R5204 B11.n1269 B11.n1268 0.7055
R5205 B11.n1268 B11.n1267 0.7055
R5206 B11.n1267 B11.n1266 0.7055
R5207 B11.n1266 B11.n1265 0.7055
R5208 B11.n1265 B11.n1264 0.7055
R5209 B11.n1264 B11.n1263 0.7055
R5210 B11.n1263 B11.n1262 0.7055
R5211 B11.n1262 B11.n1261 0.7055
R5212 B11.n1261 B11.n1260 0.7055
R5213 B11.n1260 B11.n1259 0.7055
R5214 B11.n1259 B11.n1258 0.7055
R5215 B11.n1258 B11.n1257 0.7055
R5216 B11.n1257 B11.n1256 0.7055
R5217 B11.n1256 B11.n1255 0.7055
R5218 B11.n1255 B11.n1254 0.7055
R5219 B11.n1254 B11.n1253 0.7055
R5220 B11.n1253 B11.n1252 0.7055
R5221 B11.n1252 B11.n1251 0.7055
R5222 B11.n1251 B11.n1250 0.7055
R5223 B11.n1250 B11.n1249 0.7055
R5224 B11.n1249 B11.n1248 0.7055
R5225 B11.n1248 B11.n1247 0.7055
R5226 B11.n1247 B11.n1246 0.7055
R5227 B11.n1246 B11.n1245 0.7055
R5228 B11.n1245 B11.n1244 0.7055
R5229 B11.n1244 B11.n1243 0.7055
R5230 B11.n1243 B11.n1242 0.7055
R5231 B11.n1242 B11.n1241 0.7055
R5232 B11.n1241 B11.n1240 0.7055
R5233 B11.n1240 B11.n1239 0.7055
R5234 B11.n1239 B11.n1238 0.7055
R5235 B11.n1238 B11.n1237 0.7055
R5236 B11.n1237 B11.n1236 0.7055
R5237 B11.n1236 B11.n1235 0.7055
R5238 B11.n1235 B11.n1234 0.7055
R5239 B11.n1234 B11.n1233 0.7055
R5240 B11.n1233 B11.n1232 0.7055
R5241 B11.n1232 B11.n1231 0.7055
R5242 B11.n1231 B11.n1230 0.7055
R5243 B11.n1230 B11.n1229 0.7055
R5244 B11.n1229 B11.n1228 0.7055
R5245 B11.n1228 B11.n1227 0.7055
R5246 B11.n1227 B11.n1226 0.7055
R5247 B11.n1226 B11.n1225 0.7055
R5248 B11.n1225 B11.n1224 0.7055
R5249 B11.n1224 B11.n1223 0.7055
R5250 B11.n1223 B11.n1222 0.7055
R5251 B11.n1222 B11.n1221 0.7055
R5252 B11.n1221 B11.n1220 0.7055
R5253 B11.n1220 B11.n1219 0.7055
R5254 B11.n1219 B11.n1218 0.7055
R5255 B11.n1218 B11.n1217 0.7055
R5256 B11.n1217 B11.n1216 0.7055
R5257 B11.n1216 B11.n1215 0.7055
R5258 B11.n1215 B11.n1214 0.7055
R5259 B11.n1214 B11.n1213 0.7055
R5260 B11.n1213 B11.n1212 0.7055
R5261 B11.n1212 B11.n1211 0.7055
R5262 B11.n1335 B11.n1334 0.7055
R5263 B11.n1334 B11.n1333 0.7055
R5264 B11.n1333 B11.n1332 0.7055
R5265 B11.n1332 B11.n1331 0.7055
R5266 B11.n1331 B11.n1330 0.7055
R5267 B11.n1330 B11.n1329 0.7055
R5268 B11.n1329 B11.n1328 0.7055
R5269 B11.n1328 B11.n1327 0.7055
R5270 B11.n1327 B11.n1326 0.7055
R5271 B11.n1326 B11.n1325 0.7055
R5272 B11.n1325 B11.n1324 0.7055
R5273 B11.n1324 B11.n1323 0.7055
R5274 B11.n1323 B11.n1322 0.7055
R5275 B11.n1322 B11.n1321 0.7055
R5276 B11.n1321 B11.n1320 0.7055
R5277 B11.n1320 B11.n1319 0.7055
R5278 B11.n1319 B11.n1318 0.7055
R5279 B11.n1318 B11.n1317 0.7055
R5280 B11.n1317 B11.n1316 0.7055
R5281 B11.n1316 B11.n1315 0.7055
R5282 B11.n1315 B11.n1314 0.7055
R5283 B11.n1314 B11.n1313 0.7055
R5284 B11.n1313 B11.n1312 0.7055
R5285 B11.n1312 B11.n1311 0.7055
R5286 B11.n1311 B11.n1310 0.7055
R5287 B11.n1310 B11.n1309 0.7055
R5288 B11.n1309 B11.n1308 0.7055
R5289 B11.n1308 B11.n1307 0.7055
R5290 B11.n1307 B11.n1306 0.7055
R5291 B11.n1306 B11.n1305 0.7055
R5292 B11.n1305 B11.n1304 0.7055
R5293 B11.n1304 B11.n1303 0.7055
R5294 B11.n1303 B11.n1302 0.7055
R5295 B11.n1302 B11.n1301 0.7055
R5296 B11.n1301 B11.n1300 0.7055
R5297 B11.n1300 B11.n1299 0.7055
R5298 B11.n1299 B11.n1298 0.7055
R5299 B11.n1298 B11.n1297 0.7055
R5300 B11.n1297 B11.n1296 0.7055
R5301 B11.n1296 B11.n1295 0.7055
R5302 B11.n1295 B11.n1294 0.7055
R5303 B11.n1294 B11.n1293 0.7055
R5304 B11.n1293 B11.n1292 0.7055
R5305 B11.n1292 B11.n1291 0.7055
R5306 B11.n1291 B11.n1290 0.7055
R5307 B11.n1290 B11.n1289 0.7055
R5308 B11.n1289 B11.n1288 0.7055
R5309 B11.n1288 B11.n1287 0.7055
R5310 B11.n1287 B11.n1286 0.7055
R5311 B11.n1286 B11.n1285 0.7055
R5312 B11.n1285 B11.n1284 0.7055
R5313 B11.n1284 B11.n1283 0.7055
R5314 B11.n1283 B11.n1282 0.7055
R5315 B11.n1282 B11.n1281 0.7055
R5316 B11.n1281 B11.n1280 0.7055
R5317 B11.n1280 B11.n1279 0.7055
R5318 B11.n1279 B11.n1278 0.7055
R5319 B11.n1278 B11.n1277 0.7055
R5320 B11.n1277 B11.n1276 0.7055
R5321 B11.n1276 B11.n1275 0.7055
R5322 B11.n1275 B11.n1274 0.7055
R5323 B11.n1398 B11.n1397 0.7055
R5324 B11.n1397 B11.n1396 0.7055
R5325 B11.n1396 B11.n1395 0.7055
R5326 B11.n1395 B11.n1394 0.7055
R5327 B11.n1394 B11.n1393 0.7055
R5328 B11.n1393 B11.n1392 0.7055
R5329 B11.n1392 B11.n1391 0.7055
R5330 B11.n1391 B11.n1390 0.7055
R5331 B11.n1390 B11.n1389 0.7055
R5332 B11.n1389 B11.n1388 0.7055
R5333 B11.n1388 B11.n1387 0.7055
R5334 B11.n1387 B11.n1386 0.7055
R5335 B11.n1386 B11.n1385 0.7055
R5336 B11.n1385 B11.n1384 0.7055
R5337 B11.n1384 B11.n1383 0.7055
R5338 B11.n1383 B11.n1382 0.7055
R5339 B11.n1382 B11.n1381 0.7055
R5340 B11.n1381 B11.n1380 0.7055
R5341 B11.n1380 B11.n1379 0.7055
R5342 B11.n1379 B11.n1378 0.7055
R5343 B11.n1378 B11.n1377 0.7055
R5344 B11.n1377 B11.n1376 0.7055
R5345 B11.n1376 B11.n1375 0.7055
R5346 B11.n1375 B11.n1374 0.7055
R5347 B11.n1374 B11.n1373 0.7055
R5348 B11.n1373 B11.n1372 0.7055
R5349 B11.n1372 B11.n1371 0.7055
R5350 B11.n1371 B11.n1370 0.7055
R5351 B11.n1370 B11.n1369 0.7055
R5352 B11.n1369 B11.n1368 0.7055
R5353 B11.n1368 B11.n1367 0.7055
R5354 B11.n1367 B11.n1366 0.7055
R5355 B11.n1366 B11.n1365 0.7055
R5356 B11.n1365 B11.n1364 0.7055
R5357 B11.n1364 B11.n1363 0.7055
R5358 B11.n1363 B11.n1362 0.7055
R5359 B11.n1362 B11.n1361 0.7055
R5360 B11.n1361 B11.n1360 0.7055
R5361 B11.n1360 B11.n1359 0.7055
R5362 B11.n1359 B11.n1358 0.7055
R5363 B11.n1358 B11.n1357 0.7055
R5364 B11.n1357 B11.n1356 0.7055
R5365 B11.n1356 B11.n1355 0.7055
R5366 B11.n1355 B11.n1354 0.7055
R5367 B11.n1354 B11.n1353 0.7055
R5368 B11.n1353 B11.n1352 0.7055
R5369 B11.n1352 B11.n1351 0.7055
R5370 B11.n1351 B11.n1350 0.7055
R5371 B11.n1350 B11.n1349 0.7055
R5372 B11.n1349 B11.n1348 0.7055
R5373 B11.n1348 B11.n1347 0.7055
R5374 B11.n1347 B11.n1346 0.7055
R5375 B11.n1346 B11.n1345 0.7055
R5376 B11.n1345 B11.n1344 0.7055
R5377 B11.n1344 B11.n1343 0.7055
R5378 B11.n1343 B11.n1342 0.7055
R5379 B11.n1342 B11.n1341 0.7055
R5380 B11.n1341 B11.n1340 0.7055
R5381 B11.n1340 B11.n1339 0.7055
R5382 B11.n1339 B11.n1338 0.7055
R5383 B11.n1338 B11.n1337 0.7055
R5384 B11.n1461 B11.n1460 0.7055
R5385 B11.n1460 B11.n1459 0.7055
R5386 B11.n1459 B11.n1458 0.7055
R5387 B11.n1458 B11.n1457 0.7055
R5388 B11.n1457 B11.n1456 0.7055
R5389 B11.n1456 B11.n1455 0.7055
R5390 B11.n1455 B11.n1454 0.7055
R5391 B11.n1454 B11.n1453 0.7055
R5392 B11.n1453 B11.n1452 0.7055
R5393 B11.n1452 B11.n1451 0.7055
R5394 B11.n1451 B11.n1450 0.7055
R5395 B11.n1450 B11.n1449 0.7055
R5396 B11.n1449 B11.n1448 0.7055
R5397 B11.n1448 B11.n1447 0.7055
R5398 B11.n1447 B11.n1446 0.7055
R5399 B11.n1446 B11.n1445 0.7055
R5400 B11.n1445 B11.n1444 0.7055
R5401 B11.n1444 B11.n1443 0.7055
R5402 B11.n1443 B11.n1442 0.7055
R5403 B11.n1442 B11.n1441 0.7055
R5404 B11.n1441 B11.n1440 0.7055
R5405 B11.n1440 B11.n1439 0.7055
R5406 B11.n1439 B11.n1438 0.7055
R5407 B11.n1438 B11.n1437 0.7055
R5408 B11.n1437 B11.n1436 0.7055
R5409 B11.n1436 B11.n1435 0.7055
R5410 B11.n1435 B11.n1434 0.7055
R5411 B11.n1434 B11.n1433 0.7055
R5412 B11.n1433 B11.n1432 0.7055
R5413 B11.n1432 B11.n1431 0.7055
R5414 B11.n1431 B11.n1430 0.7055
R5415 B11.n1430 B11.n1429 0.7055
R5416 B11.n1429 B11.n1428 0.7055
R5417 B11.n1428 B11.n1427 0.7055
R5418 B11.n1427 B11.n1426 0.7055
R5419 B11.n1426 B11.n1425 0.7055
R5420 B11.n1425 B11.n1424 0.7055
R5421 B11.n1424 B11.n1423 0.7055
R5422 B11.n1423 B11.n1422 0.7055
R5423 B11.n1422 B11.n1421 0.7055
R5424 B11.n1421 B11.n1420 0.7055
R5425 B11.n1420 B11.n1419 0.7055
R5426 B11.n1419 B11.n1418 0.7055
R5427 B11.n1418 B11.n1417 0.7055
R5428 B11.n1417 B11.n1416 0.7055
R5429 B11.n1416 B11.n1415 0.7055
R5430 B11.n1415 B11.n1414 0.7055
R5431 B11.n1414 B11.n1413 0.7055
R5432 B11.n1413 B11.n1412 0.7055
R5433 B11.n1412 B11.n1411 0.7055
R5434 B11.n1411 B11.n1410 0.7055
R5435 B11.n1410 B11.n1409 0.7055
R5436 B11.n1409 B11.n1408 0.7055
R5437 B11.n1408 B11.n1407 0.7055
R5438 B11.n1407 B11.n1406 0.7055
R5439 B11.n1406 B11.n1405 0.7055
R5440 B11.n1405 B11.n1404 0.7055
R5441 B11.n1404 B11.n1403 0.7055
R5442 B11.n1403 B11.n1402 0.7055
R5443 B11.n1402 B11.n1401 0.7055
R5444 B11.n1401 B11.n1400 0.7055
R5445 B11.n1524 B11.n1523 0.7055
R5446 B11.n1523 B11.n1522 0.7055
R5447 B11.n1522 B11.n1521 0.7055
R5448 B11.n1521 B11.n1520 0.7055
R5449 B11.n1520 B11.n1519 0.7055
R5450 B11.n1519 B11.n1518 0.7055
R5451 B11.n1518 B11.n1517 0.7055
R5452 B11.n1517 B11.n1516 0.7055
R5453 B11.n1516 B11.n1515 0.7055
R5454 B11.n1515 B11.n1514 0.7055
R5455 B11.n1514 B11.n1513 0.7055
R5456 B11.n1513 B11.n1512 0.7055
R5457 B11.n1512 B11.n1511 0.7055
R5458 B11.n1511 B11.n1510 0.7055
R5459 B11.n1510 B11.n1509 0.7055
R5460 B11.n1509 B11.n1508 0.7055
R5461 B11.n1508 B11.n1507 0.7055
R5462 B11.n1507 B11.n1506 0.7055
R5463 B11.n1506 B11.n1505 0.7055
R5464 B11.n1505 B11.n1504 0.7055
R5465 B11.n1504 B11.n1503 0.7055
R5466 B11.n1503 B11.n1502 0.7055
R5467 B11.n1502 B11.n1501 0.7055
R5468 B11.n1501 B11.n1500 0.7055
R5469 B11.n1500 B11.n1499 0.7055
R5470 B11.n1499 B11.n1498 0.7055
R5471 B11.n1498 B11.n1497 0.7055
R5472 B11.n1497 B11.n1496 0.7055
R5473 B11.n1496 B11.n1495 0.7055
R5474 B11.n1495 B11.n1494 0.7055
R5475 B11.n1494 B11.n1493 0.7055
R5476 B11.n1493 B11.n1492 0.7055
R5477 B11.n1492 B11.n1491 0.7055
R5478 B11.n1491 B11.n1490 0.7055
R5479 B11.n1490 B11.n1489 0.7055
R5480 B11.n1489 B11.n1488 0.7055
R5481 B11.n1488 B11.n1487 0.7055
R5482 B11.n1487 B11.n1486 0.7055
R5483 B11.n1486 B11.n1485 0.7055
R5484 B11.n1485 B11.n1484 0.7055
R5485 B11.n1484 B11.n1483 0.7055
R5486 B11.n1483 B11.n1482 0.7055
R5487 B11.n1482 B11.n1481 0.7055
R5488 B11.n1481 B11.n1480 0.7055
R5489 B11.n1480 B11.n1479 0.7055
R5490 B11.n1479 B11.n1478 0.7055
R5491 B11.n1478 B11.n1477 0.7055
R5492 B11.n1477 B11.n1476 0.7055
R5493 B11.n1476 B11.n1475 0.7055
R5494 B11.n1475 B11.n1474 0.7055
R5495 B11.n1474 B11.n1473 0.7055
R5496 B11.n1473 B11.n1472 0.7055
R5497 B11.n1472 B11.n1471 0.7055
R5498 B11.n1471 B11.n1470 0.7055
R5499 B11.n1470 B11.n1469 0.7055
R5500 B11.n1469 B11.n1468 0.7055
R5501 B11.n1468 B11.n1467 0.7055
R5502 B11.n1467 B11.n1466 0.7055
R5503 B11.n1466 B11.n1465 0.7055
R5504 B11.n1465 B11.n1464 0.7055
R5505 B11.n1464 B11.n1463 0.7055
R5506 B11.n1587 B11.n1586 0.7055
R5507 B11.n1586 B11.n1585 0.7055
R5508 B11.n1585 B11.n1584 0.7055
R5509 B11.n1584 B11.n1583 0.7055
R5510 B11.n1583 B11.n1582 0.7055
R5511 B11.n1582 B11.n1581 0.7055
R5512 B11.n1581 B11.n1580 0.7055
R5513 B11.n1580 B11.n1579 0.7055
R5514 B11.n1579 B11.n1578 0.7055
R5515 B11.n1578 B11.n1577 0.7055
R5516 B11.n1577 B11.n1576 0.7055
R5517 B11.n1576 B11.n1575 0.7055
R5518 B11.n1575 B11.n1574 0.7055
R5519 B11.n1574 B11.n1573 0.7055
R5520 B11.n1573 B11.n1572 0.7055
R5521 B11.n1572 B11.n1571 0.7055
R5522 B11.n1571 B11.n1570 0.7055
R5523 B11.n1570 B11.n1569 0.7055
R5524 B11.n1569 B11.n1568 0.7055
R5525 B11.n1568 B11.n1567 0.7055
R5526 B11.n1567 B11.n1566 0.7055
R5527 B11.n1566 B11.n1565 0.7055
R5528 B11.n1565 B11.n1564 0.7055
R5529 B11.n1564 B11.n1563 0.7055
R5530 B11.n1563 B11.n1562 0.7055
R5531 B11.n1562 B11.n1561 0.7055
R5532 B11.n1561 B11.n1560 0.7055
R5533 B11.n1560 B11.n1559 0.7055
R5534 B11.n1559 B11.n1558 0.7055
R5535 B11.n1558 B11.n1557 0.7055
R5536 B11.n1557 B11.n1556 0.7055
R5537 B11.n1556 B11.n1555 0.7055
R5538 B11.n1555 B11.n1554 0.7055
R5539 B11.n1554 B11.n1553 0.7055
R5540 B11.n1553 B11.n1552 0.7055
R5541 B11.n1552 B11.n1551 0.7055
R5542 B11.n1551 B11.n1550 0.7055
R5543 B11.n1550 B11.n1549 0.7055
R5544 B11.n1549 B11.n1548 0.7055
R5545 B11.n1548 B11.n1547 0.7055
R5546 B11.n1547 B11.n1546 0.7055
R5547 B11.n1546 B11.n1545 0.7055
R5548 B11.n1545 B11.n1544 0.7055
R5549 B11.n1544 B11.n1543 0.7055
R5550 B11.n1543 B11.n1542 0.7055
R5551 B11.n1542 B11.n1541 0.7055
R5552 B11.n1541 B11.n1540 0.7055
R5553 B11.n1540 B11.n1539 0.7055
R5554 B11.n1539 B11.n1538 0.7055
R5555 B11.n1538 B11.n1537 0.7055
R5556 B11.n1537 B11.n1536 0.7055
R5557 B11.n1536 B11.n1535 0.7055
R5558 B11.n1535 B11.n1534 0.7055
R5559 B11.n1534 B11.n1533 0.7055
R5560 B11.n1533 B11.n1532 0.7055
R5561 B11.n1532 B11.n1531 0.7055
R5562 B11.n1531 B11.n1530 0.7055
R5563 B11.n1530 B11.n1529 0.7055
R5564 B11.n1529 B11.n1528 0.7055
R5565 B11.n1528 B11.n1527 0.7055
R5566 B11.n1527 B11.n1526 0.7055
R5567 B11.n1650 B11.n1649 0.7055
R5568 B11.n1649 B11.n1648 0.7055
R5569 B11.n1648 B11.n1647 0.7055
R5570 B11.n1647 B11.n1646 0.7055
R5571 B11.n1646 B11.n1645 0.7055
R5572 B11.n1645 B11.n1644 0.7055
R5573 B11.n1644 B11.n1643 0.7055
R5574 B11.n1643 B11.n1642 0.7055
R5575 B11.n1642 B11.n1641 0.7055
R5576 B11.n1641 B11.n1640 0.7055
R5577 B11.n1640 B11.n1639 0.7055
R5578 B11.n1639 B11.n1638 0.7055
R5579 B11.n1638 B11.n1637 0.7055
R5580 B11.n1637 B11.n1636 0.7055
R5581 B11.n1636 B11.n1635 0.7055
R5582 B11.n1635 B11.n1634 0.7055
R5583 B11.n1634 B11.n1633 0.7055
R5584 B11.n1633 B11.n1632 0.7055
R5585 B11.n1632 B11.n1631 0.7055
R5586 B11.n1631 B11.n1630 0.7055
R5587 B11.n1630 B11.n1629 0.7055
R5588 B11.n1629 B11.n1628 0.7055
R5589 B11.n1628 B11.n1627 0.7055
R5590 B11.n1627 B11.n1626 0.7055
R5591 B11.n1626 B11.n1625 0.7055
R5592 B11.n1625 B11.n1624 0.7055
R5593 B11.n1624 B11.n1623 0.7055
R5594 B11.n1623 B11.n1622 0.7055
R5595 B11.n1622 B11.n1621 0.7055
R5596 B11.n1621 B11.n1620 0.7055
R5597 B11.n1620 B11.n1619 0.7055
R5598 B11.n1619 B11.n1618 0.7055
R5599 B11.n1618 B11.n1617 0.7055
R5600 B11.n1617 B11.n1616 0.7055
R5601 B11.n1616 B11.n1615 0.7055
R5602 B11.n1615 B11.n1614 0.7055
R5603 B11.n1614 B11.n1613 0.7055
R5604 B11.n1613 B11.n1612 0.7055
R5605 B11.n1612 B11.n1611 0.7055
R5606 B11.n1611 B11.n1610 0.7055
R5607 B11.n1610 B11.n1609 0.7055
R5608 B11.n1609 B11.n1608 0.7055
R5609 B11.n1608 B11.n1607 0.7055
R5610 B11.n1607 B11.n1606 0.7055
R5611 B11.n1606 B11.n1605 0.7055
R5612 B11.n1605 B11.n1604 0.7055
R5613 B11.n1604 B11.n1603 0.7055
R5614 B11.n1603 B11.n1602 0.7055
R5615 B11.n1602 B11.n1601 0.7055
R5616 B11.n1601 B11.n1600 0.7055
R5617 B11.n1600 B11.n1599 0.7055
R5618 B11.n1599 B11.n1598 0.7055
R5619 B11.n1598 B11.n1597 0.7055
R5620 B11.n1597 B11.n1596 0.7055
R5621 B11.n1596 B11.n1595 0.7055
R5622 B11.n1595 B11.n1594 0.7055
R5623 B11.n1594 B11.n1593 0.7055
R5624 B11.n1593 B11.n1592 0.7055
R5625 B11.n1592 B11.n1591 0.7055
R5626 B11.n1591 B11.n1590 0.7055
R5627 B11.n1590 B11.n1589 0.7055
R5628 B11.n1713 B11.n1712 0.7055
R5629 B11.n1712 B11.n1711 0.7055
R5630 B11.n1711 B11.n1710 0.7055
R5631 B11.n1710 B11.n1709 0.7055
R5632 B11.n1709 B11.n1708 0.7055
R5633 B11.n1708 B11.n1707 0.7055
R5634 B11.n1707 B11.n1706 0.7055
R5635 B11.n1706 B11.n1705 0.7055
R5636 B11.n1705 B11.n1704 0.7055
R5637 B11.n1704 B11.n1703 0.7055
R5638 B11.n1703 B11.n1702 0.7055
R5639 B11.n1702 B11.n1701 0.7055
R5640 B11.n1701 B11.n1700 0.7055
R5641 B11.n1700 B11.n1699 0.7055
R5642 B11.n1699 B11.n1698 0.7055
R5643 B11.n1698 B11.n1697 0.7055
R5644 B11.n1697 B11.n1696 0.7055
R5645 B11.n1696 B11.n1695 0.7055
R5646 B11.n1695 B11.n1694 0.7055
R5647 B11.n1694 B11.n1693 0.7055
R5648 B11.n1693 B11.n1692 0.7055
R5649 B11.n1692 B11.n1691 0.7055
R5650 B11.n1691 B11.n1690 0.7055
R5651 B11.n1690 B11.n1689 0.7055
R5652 B11.n1689 B11.n1688 0.7055
R5653 B11.n1688 B11.n1687 0.7055
R5654 B11.n1687 B11.n1686 0.7055
R5655 B11.n1686 B11.n1685 0.7055
R5656 B11.n1685 B11.n1684 0.7055
R5657 B11.n1684 B11.n1683 0.7055
R5658 B11.n1683 B11.n1682 0.7055
R5659 B11.n1682 B11.n1681 0.7055
R5660 B11.n1681 B11.n1680 0.7055
R5661 B11.n1680 B11.n1679 0.7055
R5662 B11.n1679 B11.n1678 0.7055
R5663 B11.n1678 B11.n1677 0.7055
R5664 B11.n1677 B11.n1676 0.7055
R5665 B11.n1676 B11.n1675 0.7055
R5666 B11.n1675 B11.n1674 0.7055
R5667 B11.n1674 B11.n1673 0.7055
R5668 B11.n1673 B11.n1672 0.7055
R5669 B11.n1672 B11.n1671 0.7055
R5670 B11.n1671 B11.n1670 0.7055
R5671 B11.n1670 B11.n1669 0.7055
R5672 B11.n1669 B11.n1668 0.7055
R5673 B11.n1668 B11.n1667 0.7055
R5674 B11.n1667 B11.n1666 0.7055
R5675 B11.n1666 B11.n1665 0.7055
R5676 B11.n1665 B11.n1664 0.7055
R5677 B11.n1664 B11.n1663 0.7055
R5678 B11.n1663 B11.n1662 0.7055
R5679 B11.n1662 B11.n1661 0.7055
R5680 B11.n1661 B11.n1660 0.7055
R5681 B11.n1660 B11.n1659 0.7055
R5682 B11.n1659 B11.n1658 0.7055
R5683 B11.n1658 B11.n1657 0.7055
R5684 B11.n1657 B11.n1656 0.7055
R5685 B11.n1656 B11.n1655 0.7055
R5686 B11.n1655 B11.n1654 0.7055
R5687 B11.n1654 B11.n1653 0.7055
R5688 B11.n1653 B11.n1652 0.7055
R5689 B11.n1776 B11.n1775 0.7055
R5690 B11.n1775 B11.n1774 0.7055
R5691 B11.n1774 B11.n1773 0.7055
R5692 B11.n1773 B11.n1772 0.7055
R5693 B11.n1772 B11.n1771 0.7055
R5694 B11.n1771 B11.n1770 0.7055
R5695 B11.n1770 B11.n1769 0.7055
R5696 B11.n1769 B11.n1768 0.7055
R5697 B11.n1768 B11.n1767 0.7055
R5698 B11.n1767 B11.n1766 0.7055
R5699 B11.n1766 B11.n1765 0.7055
R5700 B11.n1765 B11.n1764 0.7055
R5701 B11.n1764 B11.n1763 0.7055
R5702 B11.n1763 B11.n1762 0.7055
R5703 B11.n1762 B11.n1761 0.7055
R5704 B11.n1761 B11.n1760 0.7055
R5705 B11.n1760 B11.n1759 0.7055
R5706 B11.n1759 B11.n1758 0.7055
R5707 B11.n1758 B11.n1757 0.7055
R5708 B11.n1757 B11.n1756 0.7055
R5709 B11.n1756 B11.n1755 0.7055
R5710 B11.n1755 B11.n1754 0.7055
R5711 B11.n1754 B11.n1753 0.7055
R5712 B11.n1753 B11.n1752 0.7055
R5713 B11.n1752 B11.n1751 0.7055
R5714 B11.n1751 B11.n1750 0.7055
R5715 B11.n1750 B11.n1749 0.7055
R5716 B11.n1749 B11.n1748 0.7055
R5717 B11.n1748 B11.n1747 0.7055
R5718 B11.n1747 B11.n1746 0.7055
R5719 B11.n1746 B11.n1745 0.7055
R5720 B11.n1745 B11.n1744 0.7055
R5721 B11.n1744 B11.n1743 0.7055
R5722 B11.n1743 B11.n1742 0.7055
R5723 B11.n1742 B11.n1741 0.7055
R5724 B11.n1741 B11.n1740 0.7055
R5725 B11.n1740 B11.n1739 0.7055
R5726 B11.n1739 B11.n1738 0.7055
R5727 B11.n1738 B11.n1737 0.7055
R5728 B11.n1737 B11.n1736 0.7055
R5729 B11.n1736 B11.n1735 0.7055
R5730 B11.n1735 B11.n1734 0.7055
R5731 B11.n1734 B11.n1733 0.7055
R5732 B11.n1733 B11.n1732 0.7055
R5733 B11.n1732 B11.n1731 0.7055
R5734 B11.n1731 B11.n1730 0.7055
R5735 B11.n1730 B11.n1729 0.7055
R5736 B11.n1729 B11.n1728 0.7055
R5737 B11.n1728 B11.n1727 0.7055
R5738 B11.n1727 B11.n1726 0.7055
R5739 B11.n1726 B11.n1725 0.7055
R5740 B11.n1725 B11.n1724 0.7055
R5741 B11.n1724 B11.n1723 0.7055
R5742 B11.n1723 B11.n1722 0.7055
R5743 B11.n1722 B11.n1721 0.7055
R5744 B11.n1721 B11.n1720 0.7055
R5745 B11.n1720 B11.n1719 0.7055
R5746 B11.n1719 B11.n1718 0.7055
R5747 B11.n1718 B11.n1717 0.7055
R5748 B11.n1717 B11.n1716 0.7055
R5749 B11.n1716 B11.n1715 0.7055
R5750 B11.n1839 B11.n1838 0.7055
R5751 B11.n1838 B11.n1837 0.7055
R5752 B11.n1837 B11.n1836 0.7055
R5753 B11.n1836 B11.n1835 0.7055
R5754 B11.n1835 B11.n1834 0.7055
R5755 B11.n1834 B11.n1833 0.7055
R5756 B11.n1833 B11.n1832 0.7055
R5757 B11.n1832 B11.n1831 0.7055
R5758 B11.n1831 B11.n1830 0.7055
R5759 B11.n1830 B11.n1829 0.7055
R5760 B11.n1829 B11.n1828 0.7055
R5761 B11.n1828 B11.n1827 0.7055
R5762 B11.n1827 B11.n1826 0.7055
R5763 B11.n1826 B11.n1825 0.7055
R5764 B11.n1825 B11.n1824 0.7055
R5765 B11.n1824 B11.n1823 0.7055
R5766 B11.n1823 B11.n1822 0.7055
R5767 B11.n1822 B11.n1821 0.7055
R5768 B11.n1821 B11.n1820 0.7055
R5769 B11.n1820 B11.n1819 0.7055
R5770 B11.n1819 B11.n1818 0.7055
R5771 B11.n1818 B11.n1817 0.7055
R5772 B11.n1817 B11.n1816 0.7055
R5773 B11.n1816 B11.n1815 0.7055
R5774 B11.n1815 B11.n1814 0.7055
R5775 B11.n1814 B11.n1813 0.7055
R5776 B11.n1813 B11.n1812 0.7055
R5777 B11.n1812 B11.n1811 0.7055
R5778 B11.n1811 B11.n1810 0.7055
R5779 B11.n1810 B11.n1809 0.7055
R5780 B11.n1809 B11.n1808 0.7055
R5781 B11.n1808 B11.n1807 0.7055
R5782 B11.n1807 B11.n1806 0.7055
R5783 B11.n1806 B11.n1805 0.7055
R5784 B11.n1805 B11.n1804 0.7055
R5785 B11.n1804 B11.n1803 0.7055
R5786 B11.n1803 B11.n1802 0.7055
R5787 B11.n1802 B11.n1801 0.7055
R5788 B11.n1801 B11.n1800 0.7055
R5789 B11.n1800 B11.n1799 0.7055
R5790 B11.n1799 B11.n1798 0.7055
R5791 B11.n1798 B11.n1797 0.7055
R5792 B11.n1797 B11.n1796 0.7055
R5793 B11.n1796 B11.n1795 0.7055
R5794 B11.n1795 B11.n1794 0.7055
R5795 B11.n1794 B11.n1793 0.7055
R5796 B11.n1793 B11.n1792 0.7055
R5797 B11.n1792 B11.n1791 0.7055
R5798 B11.n1791 B11.n1790 0.7055
R5799 B11.n1790 B11.n1789 0.7055
R5800 B11.n1789 B11.n1788 0.7055
R5801 B11.n1788 B11.n1787 0.7055
R5802 B11.n1787 B11.n1786 0.7055
R5803 B11.n1786 B11.n1785 0.7055
R5804 B11.n1785 B11.n1784 0.7055
R5805 B11.n1784 B11.n1783 0.7055
R5806 B11.n1783 B11.n1782 0.7055
R5807 B11.n1782 B11.n1781 0.7055
R5808 B11.n1781 B11.n1780 0.7055
R5809 B11.n1780 B11.n1779 0.7055
R5810 B11.n1779 B11.n1778 0.7055
R5811 B11.n1902 B11.n1901 0.7055
R5812 B11.n1901 B11.n1900 0.7055
R5813 B11.n1900 B11.n1899 0.7055
R5814 B11.n1899 B11.n1898 0.7055
R5815 B11.n1898 B11.n1897 0.7055
R5816 B11.n1897 B11.n1896 0.7055
R5817 B11.n1896 B11.n1895 0.7055
R5818 B11.n1895 B11.n1894 0.7055
R5819 B11.n1894 B11.n1893 0.7055
R5820 B11.n1893 B11.n1892 0.7055
R5821 B11.n1892 B11.n1891 0.7055
R5822 B11.n1891 B11.n1890 0.7055
R5823 B11.n1890 B11.n1889 0.7055
R5824 B11.n1889 B11.n1888 0.7055
R5825 B11.n1888 B11.n1887 0.7055
R5826 B11.n1887 B11.n1886 0.7055
R5827 B11.n1886 B11.n1885 0.7055
R5828 B11.n1885 B11.n1884 0.7055
R5829 B11.n1884 B11.n1883 0.7055
R5830 B11.n1883 B11.n1882 0.7055
R5831 B11.n1882 B11.n1881 0.7055
R5832 B11.n1881 B11.n1880 0.7055
R5833 B11.n1880 B11.n1879 0.7055
R5834 B11.n1879 B11.n1878 0.7055
R5835 B11.n1878 B11.n1877 0.7055
R5836 B11.n1877 B11.n1876 0.7055
R5837 B11.n1876 B11.n1875 0.7055
R5838 B11.n1875 B11.n1874 0.7055
R5839 B11.n1874 B11.n1873 0.7055
R5840 B11.n1873 B11.n1872 0.7055
R5841 B11.n1872 B11.n1871 0.7055
R5842 B11.n1871 B11.n1870 0.7055
R5843 B11.n1870 B11.n1869 0.7055
R5844 B11.n1869 B11.n1868 0.7055
R5845 B11.n1868 B11.n1867 0.7055
R5846 B11.n1867 B11.n1866 0.7055
R5847 B11.n1866 B11.n1865 0.7055
R5848 B11.n1865 B11.n1864 0.7055
R5849 B11.n1864 B11.n1863 0.7055
R5850 B11.n1863 B11.n1862 0.7055
R5851 B11.n1862 B11.n1861 0.7055
R5852 B11.n1861 B11.n1860 0.7055
R5853 B11.n1860 B11.n1859 0.7055
R5854 B11.n1859 B11.n1858 0.7055
R5855 B11.n1858 B11.n1857 0.7055
R5856 B11.n1857 B11.n1856 0.7055
R5857 B11.n1856 B11.n1855 0.7055
R5858 B11.n1855 B11.n1854 0.7055
R5859 B11.n1854 B11.n1853 0.7055
R5860 B11.n1853 B11.n1852 0.7055
R5861 B11.n1852 B11.n1851 0.7055
R5862 B11.n1851 B11.n1850 0.7055
R5863 B11.n1850 B11.n1849 0.7055
R5864 B11.n1849 B11.n1848 0.7055
R5865 B11.n1848 B11.n1847 0.7055
R5866 B11.n1847 B11.n1846 0.7055
R5867 B11.n1846 B11.n1845 0.7055
R5868 B11.n1845 B11.n1844 0.7055
R5869 B11.n1844 B11.n1843 0.7055
R5870 B11.n1843 B11.n1842 0.7055
R5871 B11.n1842 B11.n1841 0.7055
R5872 B11.n1965 B11.n1964 0.7055
R5873 B11.n1964 B11.n1963 0.7055
R5874 B11.n1963 B11.n1962 0.7055
R5875 B11.n1962 B11.n1961 0.7055
R5876 B11.n1961 B11.n1960 0.7055
R5877 B11.n1960 B11.n1959 0.7055
R5878 B11.n1959 B11.n1958 0.7055
R5879 B11.n1958 B11.n1957 0.7055
R5880 B11.n1957 B11.n1956 0.7055
R5881 B11.n1956 B11.n1955 0.7055
R5882 B11.n1955 B11.n1954 0.7055
R5883 B11.n1954 B11.n1953 0.7055
R5884 B11.n1953 B11.n1952 0.7055
R5885 B11.n1952 B11.n1951 0.7055
R5886 B11.n1951 B11.n1950 0.7055
R5887 B11.n1950 B11.n1949 0.7055
R5888 B11.n1949 B11.n1948 0.7055
R5889 B11.n1948 B11.n1947 0.7055
R5890 B11.n1947 B11.n1946 0.7055
R5891 B11.n1946 B11.n1945 0.7055
R5892 B11.n1945 B11.n1944 0.7055
R5893 B11.n1944 B11.n1943 0.7055
R5894 B11.n1943 B11.n1942 0.7055
R5895 B11.n1942 B11.n1941 0.7055
R5896 B11.n1941 B11.n1940 0.7055
R5897 B11.n1940 B11.n1939 0.7055
R5898 B11.n1939 B11.n1938 0.7055
R5899 B11.n1938 B11.n1937 0.7055
R5900 B11.n1937 B11.n1936 0.7055
R5901 B11.n1936 B11.n1935 0.7055
R5902 B11.n1935 B11.n1934 0.7055
R5903 B11.n1934 B11.n1933 0.7055
R5904 B11.n1933 B11.n1932 0.7055
R5905 B11.n1932 B11.n1931 0.7055
R5906 B11.n1931 B11.n1930 0.7055
R5907 B11.n1930 B11.n1929 0.7055
R5908 B11.n1929 B11.n1928 0.7055
R5909 B11.n1928 B11.n1927 0.7055
R5910 B11.n1927 B11.n1926 0.7055
R5911 B11.n1926 B11.n1925 0.7055
R5912 B11.n1925 B11.n1924 0.7055
R5913 B11.n1924 B11.n1923 0.7055
R5914 B11.n1923 B11.n1922 0.7055
R5915 B11.n1922 B11.n1921 0.7055
R5916 B11.n1921 B11.n1920 0.7055
R5917 B11.n1920 B11.n1919 0.7055
R5918 B11.n1919 B11.n1918 0.7055
R5919 B11.n1918 B11.n1917 0.7055
R5920 B11.n1917 B11.n1916 0.7055
R5921 B11.n1916 B11.n1915 0.7055
R5922 B11.n1915 B11.n1914 0.7055
R5923 B11.n1914 B11.n1913 0.7055
R5924 B11.n1913 B11.n1912 0.7055
R5925 B11.n1912 B11.n1911 0.7055
R5926 B11.n1911 B11.n1910 0.7055
R5927 B11.n1910 B11.n1909 0.7055
R5928 B11.n1909 B11.n1908 0.7055
R5929 B11.n1908 B11.n1907 0.7055
R5930 B11.n1907 B11.n1906 0.7055
R5931 B11.n1906 B11.n1905 0.7055
R5932 B11.n1905 B11.n1904 0.7055
R5933 B11.n2028 B11.n2027 0.7055
R5934 B11.n2027 B11.n2026 0.7055
R5935 B11.n2026 B11.n2025 0.7055
R5936 B11.n2025 B11.n2024 0.7055
R5937 B11.n2024 B11.n2023 0.7055
R5938 B11.n2023 B11.n2022 0.7055
R5939 B11.n2022 B11.n2021 0.7055
R5940 B11.n2021 B11.n2020 0.7055
R5941 B11.n2020 B11.n2019 0.7055
R5942 B11.n2019 B11.n2018 0.7055
R5943 B11.n2018 B11.n2017 0.7055
R5944 B11.n2017 B11.n2016 0.7055
R5945 B11.n2016 B11.n2015 0.7055
R5946 B11.n2015 B11.n2014 0.7055
R5947 B11.n2014 B11.n2013 0.7055
R5948 B11.n2013 B11.n2012 0.7055
R5949 B11.n2012 B11.n2011 0.7055
R5950 B11.n2011 B11.n2010 0.7055
R5951 B11.n2010 B11.n2009 0.7055
R5952 B11.n2009 B11.n2008 0.7055
R5953 B11.n2008 B11.n2007 0.7055
R5954 B11.n2007 B11.n2006 0.7055
R5955 B11.n2006 B11.n2005 0.7055
R5956 B11.n2005 B11.n2004 0.7055
R5957 B11.n2004 B11.n2003 0.7055
R5958 B11.n2003 B11.n2002 0.7055
R5959 B11.n2002 B11.n2001 0.7055
R5960 B11.n2001 B11.n2000 0.7055
R5961 B11.n2000 B11.n1999 0.7055
R5962 B11.n1999 B11.n1998 0.7055
R5963 B11.n1998 B11.n1997 0.7055
R5964 B11.n1997 B11.n1996 0.7055
R5965 B11.n1996 B11.n1995 0.7055
R5966 B11.n1995 B11.n1994 0.7055
R5967 B11.n1994 B11.n1993 0.7055
R5968 B11.n1993 B11.n1992 0.7055
R5969 B11.n1992 B11.n1991 0.7055
R5970 B11.n1991 B11.n1990 0.7055
R5971 B11.n1990 B11.n1989 0.7055
R5972 B11.n1989 B11.n1988 0.7055
R5973 B11.n1988 B11.n1987 0.7055
R5974 B11.n1987 B11.n1986 0.7055
R5975 B11.n1986 B11.n1985 0.7055
R5976 B11.n1985 B11.n1984 0.7055
R5977 B11.n1984 B11.n1983 0.7055
R5978 B11.n1983 B11.n1982 0.7055
R5979 B11.n1982 B11.n1981 0.7055
R5980 B11.n1981 B11.n1980 0.7055
R5981 B11.n1980 B11.n1979 0.7055
R5982 B11.n1979 B11.n1978 0.7055
R5983 B11.n1978 B11.n1977 0.7055
R5984 B11.n1977 B11.n1976 0.7055
R5985 B11.n1976 B11.n1975 0.7055
R5986 B11.n1975 B11.n1974 0.7055
R5987 B11.n1974 B11.n1973 0.7055
R5988 B11.n1973 B11.n1972 0.7055
R5989 B11.n1972 B11.n1971 0.7055
R5990 B11.n1971 B11.n1970 0.7055
R5991 B11.n1970 B11.n1969 0.7055
R5992 B11.n1969 B11.n1968 0.7055
R5993 B11.n1968 B11.n1967 0.7055
R5994 B11.n76 B11.t1040 0.324663
R5995 B11.n75 B11.t1041 0.324663
R5996 B11.n74 B11.t1042 0.324663
R5997 B11.n73 B11.t1043 0.324663
R5998 B11.n72 B11.t1044 0.324663
R5999 B11.n71 B11.t1045 0.324663
R6000 B11.n70 B11.t1046 0.324663
R6001 B11.n69 B11.t1047 0.324663
R6002 B11.n68 B11.t1048 0.324663
R6003 B11.n67 B11.t1049 0.324663
R6004 B11.n66 B11.t1050 0.324663
R6005 B11.n65 B11.t1051 0.324663
R6006 B11.n64 B11.t1052 0.324663
R6007 B11.n63 B11.t1053 0.324663
R6008 B11.n62 B11.t1054 0.324663
R6009 B11.n61 B11.t1055 0.324663
R6010 B11.n60 B11.t1056 0.324663
R6011 B11.n59 B11.t1057 0.324663
R6012 B11.n58 B11.t1058 0.324663
R6013 B11.n57 B11.t1059 0.324663
R6014 B11.n56 B11.t1060 0.324663
R6015 B11.n55 B11.t1061 0.324663
R6016 B11.n54 B11.t1062 0.324663
R6017 B11.n53 B11.t1063 0.324663
R6018 B11.n52 B11.t1064 0.324663
R6019 B11.n51 B11.t1065 0.324663
R6020 B11.n50 B11.t1066 0.324663
R6021 B11.n49 B11.t1067 0.324663
R6022 B11.n48 B11.t1068 0.324663
R6023 B11.n47 B11.t1069 0.324663
R6024 B11.n46 B11.t1070 0.324663
R6025 B11.n45 B11.t1071 0.324663
R6026 B11.n44 B11.t1072 0.324663
R6027 B11.n43 B11.t1073 0.324663
R6028 B11.n42 B11.t1074 0.324663
R6029 B11.n41 B11.t1075 0.324663
R6030 B11.n40 B11.t1076 0.324663
R6031 B11.n39 B11.t1077 0.324663
R6032 B11.n38 B11.t1078 0.324663
R6033 B11.n37 B11.t1079 0.324663
R6034 B11.n36 B11.t1080 0.324663
R6035 B11.n35 B11.t1081 0.324663
R6036 B11.n34 B11.t1082 0.324663
R6037 B11.n33 B11.t1083 0.324663
R6038 B11.n32 B11.t1084 0.324663
R6039 B11.n31 B11.t1085 0.324663
R6040 B11.n30 B11.t1086 0.324663
R6041 B11.n29 B11.t1087 0.324663
R6042 B11.n28 B11.t1088 0.324663
R6043 B11.n27 B11.t1089 0.324663
R6044 B11.n26 B11.t1090 0.324663
R6045 B11.n25 B11.t1091 0.324663
R6046 B11.n24 B11.t1092 0.324663
R6047 B11.n23 B11.t1093 0.324663
R6048 B11.n22 B11.t1094 0.324663
R6049 B11.n21 B11.t1095 0.324663
R6050 B11.n20 B11.t1096 0.324663
R6051 B11.n19 B11.t1097 0.324663
R6052 B11.n18 B11.t1098 0.324663
R6053 B11.n17 B11.t1099 0.324663
R6054 B11.n16 B11.t1100 0.324663
R6055 B11.n15 B11.t1101 0.324663
R6056 B11.n139 B11.t1103 0.324663
R6057 B11.n138 B11.t1104 0.324663
R6058 B11.n137 B11.t1105 0.324663
R6059 B11.n136 B11.t1106 0.324663
R6060 B11.n135 B11.t1107 0.324663
R6061 B11.n134 B11.t1108 0.324663
R6062 B11.n133 B11.t1109 0.324663
R6063 B11.n132 B11.t1110 0.324663
R6064 B11.n131 B11.t1111 0.324663
R6065 B11.n130 B11.t1112 0.324663
R6066 B11.n129 B11.t1113 0.324663
R6067 B11.n128 B11.t1114 0.324663
R6068 B11.n127 B11.t1115 0.324663
R6069 B11.n126 B11.t1116 0.324663
R6070 B11.n125 B11.t1117 0.324663
R6071 B11.n124 B11.t1118 0.324663
R6072 B11.n123 B11.t1119 0.324663
R6073 B11.n122 B11.t1120 0.324663
R6074 B11.n121 B11.t1121 0.324663
R6075 B11.n120 B11.t1122 0.324663
R6076 B11.n119 B11.t1123 0.324663
R6077 B11.n118 B11.t1124 0.324663
R6078 B11.n117 B11.t1125 0.324663
R6079 B11.n116 B11.t1126 0.324663
R6080 B11.n115 B11.t1127 0.324663
R6081 B11.n114 B11.t1128 0.324663
R6082 B11.n113 B11.t1129 0.324663
R6083 B11.n112 B11.t1130 0.324663
R6084 B11.n111 B11.t1131 0.324663
R6085 B11.n110 B11.t1132 0.324663
R6086 B11.n109 B11.t1133 0.324663
R6087 B11.n108 B11.t1134 0.324663
R6088 B11.n107 B11.t1135 0.324663
R6089 B11.n106 B11.t1136 0.324663
R6090 B11.n105 B11.t1137 0.324663
R6091 B11.n104 B11.t1138 0.324663
R6092 B11.n103 B11.t1139 0.324663
R6093 B11.n102 B11.t1140 0.324663
R6094 B11.n101 B11.t1141 0.324663
R6095 B11.n100 B11.t1142 0.324663
R6096 B11.n99 B11.t1143 0.324663
R6097 B11.n98 B11.t1144 0.324663
R6098 B11.n97 B11.t1145 0.324663
R6099 B11.n96 B11.t1146 0.324663
R6100 B11.n95 B11.t1147 0.324663
R6101 B11.n94 B11.t1148 0.324663
R6102 B11.n93 B11.t1149 0.324663
R6103 B11.n92 B11.t1150 0.324663
R6104 B11.n91 B11.t1151 0.324663
R6105 B11.n90 B11.t1152 0.324663
R6106 B11.n89 B11.t1153 0.324663
R6107 B11.n88 B11.t1154 0.324663
R6108 B11.n87 B11.t1155 0.324663
R6109 B11.n86 B11.t1156 0.324663
R6110 B11.n85 B11.t1157 0.324663
R6111 B11.n84 B11.t1158 0.324663
R6112 B11.n83 B11.t1159 0.324663
R6113 B11.n82 B11.t1160 0.324663
R6114 B11.n81 B11.t1161 0.324663
R6115 B11.n80 B11.t1162 0.324663
R6116 B11.n79 B11.t1163 0.324663
R6117 B11.n78 B11.t1164 0.324663
R6118 B11.n202 B11.t1166 0.324663
R6119 B11.n201 B11.t1167 0.324663
R6120 B11.n200 B11.t1168 0.324663
R6121 B11.n199 B11.t1169 0.324663
R6122 B11.n198 B11.t1170 0.324663
R6123 B11.n197 B11.t1171 0.324663
R6124 B11.n196 B11.t1172 0.324663
R6125 B11.n195 B11.t1173 0.324663
R6126 B11.n194 B11.t1174 0.324663
R6127 B11.n193 B11.t1175 0.324663
R6128 B11.n192 B11.t1176 0.324663
R6129 B11.n191 B11.t1177 0.324663
R6130 B11.n190 B11.t1178 0.324663
R6131 B11.n189 B11.t1179 0.324663
R6132 B11.n188 B11.t1180 0.324663
R6133 B11.n187 B11.t1181 0.324663
R6134 B11.n186 B11.t1182 0.324663
R6135 B11.n185 B11.t1183 0.324663
R6136 B11.n184 B11.t1184 0.324663
R6137 B11.n183 B11.t1185 0.324663
R6138 B11.n182 B11.t1186 0.324663
R6139 B11.n181 B11.t1187 0.324663
R6140 B11.n180 B11.t1188 0.324663
R6141 B11.n179 B11.t1189 0.324663
R6142 B11.n178 B11.t1190 0.324663
R6143 B11.n177 B11.t1191 0.324663
R6144 B11.n176 B11.t1192 0.324663
R6145 B11.n175 B11.t1193 0.324663
R6146 B11.n174 B11.t1194 0.324663
R6147 B11.n173 B11.t1195 0.324663
R6148 B11.n172 B11.t1196 0.324663
R6149 B11.n171 B11.t1197 0.324663
R6150 B11.n170 B11.t1198 0.324663
R6151 B11.n169 B11.t1199 0.324663
R6152 B11.n168 B11.t1200 0.324663
R6153 B11.n167 B11.t1201 0.324663
R6154 B11.n166 B11.t1202 0.324663
R6155 B11.n165 B11.t1203 0.324663
R6156 B11.n164 B11.t1204 0.324663
R6157 B11.n163 B11.t1205 0.324663
R6158 B11.n162 B11.t1206 0.324663
R6159 B11.n161 B11.t1207 0.324663
R6160 B11.n160 B11.t1208 0.324663
R6161 B11.n159 B11.t1209 0.324663
R6162 B11.n158 B11.t1210 0.324663
R6163 B11.n157 B11.t1211 0.324663
R6164 B11.n156 B11.t1212 0.324663
R6165 B11.n155 B11.t1213 0.324663
R6166 B11.n154 B11.t1214 0.324663
R6167 B11.n153 B11.t1215 0.324663
R6168 B11.n152 B11.t1216 0.324663
R6169 B11.n151 B11.t1217 0.324663
R6170 B11.n150 B11.t1218 0.324663
R6171 B11.n149 B11.t1219 0.324663
R6172 B11.n148 B11.t1220 0.324663
R6173 B11.n147 B11.t1221 0.324663
R6174 B11.n146 B11.t1222 0.324663
R6175 B11.n145 B11.t1223 0.324663
R6176 B11.n144 B11.t1224 0.324663
R6177 B11.n143 B11.t1225 0.324663
R6178 B11.n142 B11.t1226 0.324663
R6179 B11.n141 B11.t1227 0.324663
R6180 B11.n265 B11.t1229 0.324663
R6181 B11.n264 B11.t1230 0.324663
R6182 B11.n263 B11.t1231 0.324663
R6183 B11.n262 B11.t1232 0.324663
R6184 B11.n261 B11.t1233 0.324663
R6185 B11.n260 B11.t1234 0.324663
R6186 B11.n259 B11.t1235 0.324663
R6187 B11.n258 B11.t1236 0.324663
R6188 B11.n257 B11.t1237 0.324663
R6189 B11.n256 B11.t1238 0.324663
R6190 B11.n255 B11.t1239 0.324663
R6191 B11.n254 B11.t1240 0.324663
R6192 B11.n253 B11.t1241 0.324663
R6193 B11.n252 B11.t1242 0.324663
R6194 B11.n251 B11.t1243 0.324663
R6195 B11.n250 B11.t1244 0.324663
R6196 B11.n249 B11.t1245 0.324663
R6197 B11.n248 B11.t1246 0.324663
R6198 B11.n247 B11.t1247 0.324663
R6199 B11.n246 B11.t1248 0.324663
R6200 B11.n245 B11.t1249 0.324663
R6201 B11.n244 B11.t1250 0.324663
R6202 B11.n243 B11.t1251 0.324663
R6203 B11.n242 B11.t1252 0.324663
R6204 B11.n241 B11.t1253 0.324663
R6205 B11.n240 B11.t1254 0.324663
R6206 B11.n239 B11.t1255 0.324663
R6207 B11.n238 B11.t1256 0.324663
R6208 B11.n237 B11.t1257 0.324663
R6209 B11.n236 B11.t1258 0.324663
R6210 B11.n235 B11.t1259 0.324663
R6211 B11.n234 B11.t1260 0.324663
R6212 B11.n233 B11.t1261 0.324663
R6213 B11.n232 B11.t1262 0.324663
R6214 B11.n231 B11.t1263 0.324663
R6215 B11.n230 B11.t1264 0.324663
R6216 B11.n229 B11.t1265 0.324663
R6217 B11.n228 B11.t1266 0.324663
R6218 B11.n227 B11.t1267 0.324663
R6219 B11.n226 B11.t1268 0.324663
R6220 B11.n225 B11.t1269 0.324663
R6221 B11.n224 B11.t1270 0.324663
R6222 B11.n223 B11.t1271 0.324663
R6223 B11.n222 B11.t1272 0.324663
R6224 B11.n221 B11.t1273 0.324663
R6225 B11.n220 B11.t1274 0.324663
R6226 B11.n219 B11.t1275 0.324663
R6227 B11.n218 B11.t1276 0.324663
R6228 B11.n217 B11.t1277 0.324663
R6229 B11.n216 B11.t1278 0.324663
R6230 B11.n215 B11.t1279 0.324663
R6231 B11.n214 B11.t1280 0.324663
R6232 B11.n213 B11.t1281 0.324663
R6233 B11.n212 B11.t1282 0.324663
R6234 B11.n211 B11.t1283 0.324663
R6235 B11.n210 B11.t1284 0.324663
R6236 B11.n209 B11.t1285 0.324663
R6237 B11.n208 B11.t1286 0.324663
R6238 B11.n207 B11.t1287 0.324663
R6239 B11.n206 B11.t1288 0.324663
R6240 B11.n205 B11.t1289 0.324663
R6241 B11.n204 B11.t1290 0.324663
R6242 B11.n328 B11.t1292 0.324663
R6243 B11.n327 B11.t1293 0.324663
R6244 B11.n326 B11.t1294 0.324663
R6245 B11.n325 B11.t1295 0.324663
R6246 B11.n324 B11.t1296 0.324663
R6247 B11.n323 B11.t1297 0.324663
R6248 B11.n322 B11.t1298 0.324663
R6249 B11.n321 B11.t1299 0.324663
R6250 B11.n320 B11.t1300 0.324663
R6251 B11.n319 B11.t1301 0.324663
R6252 B11.n318 B11.t1302 0.324663
R6253 B11.n317 B11.t1303 0.324663
R6254 B11.n316 B11.t1304 0.324663
R6255 B11.n315 B11.t1305 0.324663
R6256 B11.n314 B11.t1306 0.324663
R6257 B11.n313 B11.t1307 0.324663
R6258 B11.n312 B11.t1308 0.324663
R6259 B11.n311 B11.t1309 0.324663
R6260 B11.n310 B11.t1310 0.324663
R6261 B11.n309 B11.t1311 0.324663
R6262 B11.n308 B11.t1312 0.324663
R6263 B11.n307 B11.t1313 0.324663
R6264 B11.n306 B11.t1314 0.324663
R6265 B11.n305 B11.t1315 0.324663
R6266 B11.n304 B11.t1316 0.324663
R6267 B11.n303 B11.t1317 0.324663
R6268 B11.n302 B11.t1318 0.324663
R6269 B11.n301 B11.t1319 0.324663
R6270 B11.n300 B11.t1320 0.324663
R6271 B11.n299 B11.t1321 0.324663
R6272 B11.n298 B11.t1322 0.324663
R6273 B11.n297 B11.t1323 0.324663
R6274 B11.n296 B11.t1324 0.324663
R6275 B11.n295 B11.t1325 0.324663
R6276 B11.n294 B11.t1326 0.324663
R6277 B11.n293 B11.t1327 0.324663
R6278 B11.n292 B11.t1328 0.324663
R6279 B11.n291 B11.t1329 0.324663
R6280 B11.n290 B11.t1330 0.324663
R6281 B11.n289 B11.t1331 0.324663
R6282 B11.n288 B11.t1332 0.324663
R6283 B11.n287 B11.t1333 0.324663
R6284 B11.n286 B11.t1334 0.324663
R6285 B11.n285 B11.t1335 0.324663
R6286 B11.n284 B11.t1336 0.324663
R6287 B11.n283 B11.t1337 0.324663
R6288 B11.n282 B11.t1338 0.324663
R6289 B11.n281 B11.t1339 0.324663
R6290 B11.n280 B11.t1340 0.324663
R6291 B11.n279 B11.t1341 0.324663
R6292 B11.n278 B11.t1342 0.324663
R6293 B11.n277 B11.t1343 0.324663
R6294 B11.n276 B11.t1344 0.324663
R6295 B11.n275 B11.t1345 0.324663
R6296 B11.n274 B11.t1346 0.324663
R6297 B11.n273 B11.t1347 0.324663
R6298 B11.n272 B11.t1348 0.324663
R6299 B11.n271 B11.t1349 0.324663
R6300 B11.n270 B11.t1350 0.324663
R6301 B11.n269 B11.t1351 0.324663
R6302 B11.n268 B11.t1352 0.324663
R6303 B11.n267 B11.t1353 0.324663
R6304 B11.n391 B11.t1355 0.324663
R6305 B11.n390 B11.t1356 0.324663
R6306 B11.n389 B11.t1357 0.324663
R6307 B11.n388 B11.t1358 0.324663
R6308 B11.n387 B11.t1359 0.324663
R6309 B11.n386 B11.t1360 0.324663
R6310 B11.n385 B11.t1361 0.324663
R6311 B11.n384 B11.t1362 0.324663
R6312 B11.n383 B11.t1363 0.324663
R6313 B11.n382 B11.t1364 0.324663
R6314 B11.n381 B11.t1365 0.324663
R6315 B11.n380 B11.t1366 0.324663
R6316 B11.n379 B11.t1367 0.324663
R6317 B11.n378 B11.t1368 0.324663
R6318 B11.n377 B11.t1369 0.324663
R6319 B11.n376 B11.t1370 0.324663
R6320 B11.n375 B11.t1371 0.324663
R6321 B11.n374 B11.t1372 0.324663
R6322 B11.n373 B11.t1373 0.324663
R6323 B11.n372 B11.t1374 0.324663
R6324 B11.n371 B11.t1375 0.324663
R6325 B11.n370 B11.t1376 0.324663
R6326 B11.n369 B11.t1377 0.324663
R6327 B11.n368 B11.t1378 0.324663
R6328 B11.n367 B11.t1379 0.324663
R6329 B11.n366 B11.t1380 0.324663
R6330 B11.n365 B11.t1381 0.324663
R6331 B11.n364 B11.t1382 0.324663
R6332 B11.n363 B11.t1383 0.324663
R6333 B11.n362 B11.t1384 0.324663
R6334 B11.n361 B11.t1385 0.324663
R6335 B11.n360 B11.t1386 0.324663
R6336 B11.n359 B11.t1387 0.324663
R6337 B11.n358 B11.t1388 0.324663
R6338 B11.n357 B11.t1389 0.324663
R6339 B11.n356 B11.t1390 0.324663
R6340 B11.n355 B11.t1391 0.324663
R6341 B11.n354 B11.t1392 0.324663
R6342 B11.n353 B11.t1393 0.324663
R6343 B11.n352 B11.t1394 0.324663
R6344 B11.n351 B11.t1395 0.324663
R6345 B11.n350 B11.t1396 0.324663
R6346 B11.n349 B11.t1397 0.324663
R6347 B11.n348 B11.t1398 0.324663
R6348 B11.n347 B11.t1399 0.324663
R6349 B11.n346 B11.t1400 0.324663
R6350 B11.n345 B11.t1401 0.324663
R6351 B11.n344 B11.t1402 0.324663
R6352 B11.n343 B11.t1403 0.324663
R6353 B11.n342 B11.t1404 0.324663
R6354 B11.n341 B11.t1405 0.324663
R6355 B11.n340 B11.t1406 0.324663
R6356 B11.n339 B11.t1407 0.324663
R6357 B11.n338 B11.t1408 0.324663
R6358 B11.n337 B11.t1409 0.324663
R6359 B11.n336 B11.t1410 0.324663
R6360 B11.n335 B11.t1411 0.324663
R6361 B11.n334 B11.t1412 0.324663
R6362 B11.n333 B11.t1413 0.324663
R6363 B11.n332 B11.t1414 0.324663
R6364 B11.n331 B11.t1415 0.324663
R6365 B11.n330 B11.t1416 0.324663
R6366 B11.n454 B11.t1418 0.324663
R6367 B11.n453 B11.t1419 0.324663
R6368 B11.n452 B11.t1420 0.324663
R6369 B11.n451 B11.t1421 0.324663
R6370 B11.n450 B11.t1422 0.324663
R6371 B11.n449 B11.t1423 0.324663
R6372 B11.n448 B11.t1424 0.324663
R6373 B11.n447 B11.t1425 0.324663
R6374 B11.n446 B11.t1426 0.324663
R6375 B11.n445 B11.t1427 0.324663
R6376 B11.n444 B11.t1428 0.324663
R6377 B11.n443 B11.t1429 0.324663
R6378 B11.n442 B11.t1430 0.324663
R6379 B11.n441 B11.t1431 0.324663
R6380 B11.n440 B11.t1432 0.324663
R6381 B11.n439 B11.t1433 0.324663
R6382 B11.n438 B11.t1434 0.324663
R6383 B11.n437 B11.t1435 0.324663
R6384 B11.n436 B11.t1436 0.324663
R6385 B11.n435 B11.t1437 0.324663
R6386 B11.n434 B11.t1438 0.324663
R6387 B11.n433 B11.t1439 0.324663
R6388 B11.n432 B11.t1440 0.324663
R6389 B11.n431 B11.t1441 0.324663
R6390 B11.n430 B11.t1442 0.324663
R6391 B11.n429 B11.t1443 0.324663
R6392 B11.n428 B11.t1444 0.324663
R6393 B11.n427 B11.t1445 0.324663
R6394 B11.n426 B11.t1446 0.324663
R6395 B11.n425 B11.t1447 0.324663
R6396 B11.n424 B11.t1448 0.324663
R6397 B11.n423 B11.t1449 0.324663
R6398 B11.n422 B11.t1450 0.324663
R6399 B11.n421 B11.t1451 0.324663
R6400 B11.n420 B11.t1452 0.324663
R6401 B11.n419 B11.t1453 0.324663
R6402 B11.n418 B11.t1454 0.324663
R6403 B11.n417 B11.t1455 0.324663
R6404 B11.n416 B11.t1456 0.324663
R6405 B11.n415 B11.t1457 0.324663
R6406 B11.n414 B11.t1458 0.324663
R6407 B11.n413 B11.t1459 0.324663
R6408 B11.n412 B11.t1460 0.324663
R6409 B11.n411 B11.t1461 0.324663
R6410 B11.n410 B11.t1462 0.324663
R6411 B11.n409 B11.t1463 0.324663
R6412 B11.n408 B11.t1464 0.324663
R6413 B11.n407 B11.t1465 0.324663
R6414 B11.n406 B11.t1466 0.324663
R6415 B11.n405 B11.t1467 0.324663
R6416 B11.n404 B11.t1468 0.324663
R6417 B11.n403 B11.t1469 0.324663
R6418 B11.n402 B11.t1470 0.324663
R6419 B11.n401 B11.t1471 0.324663
R6420 B11.n400 B11.t1472 0.324663
R6421 B11.n399 B11.t1473 0.324663
R6422 B11.n398 B11.t1474 0.324663
R6423 B11.n397 B11.t1475 0.324663
R6424 B11.n396 B11.t1476 0.324663
R6425 B11.n395 B11.t1477 0.324663
R6426 B11.n394 B11.t1478 0.324663
R6427 B11.n393 B11.t1479 0.324663
R6428 B11.n517 B11.t1481 0.324663
R6429 B11.n516 B11.t1482 0.324663
R6430 B11.n515 B11.t1483 0.324663
R6431 B11.n514 B11.t1484 0.324663
R6432 B11.n513 B11.t1485 0.324663
R6433 B11.n512 B11.t1486 0.324663
R6434 B11.n511 B11.t1487 0.324663
R6435 B11.n510 B11.t1488 0.324663
R6436 B11.n509 B11.t1489 0.324663
R6437 B11.n508 B11.t1490 0.324663
R6438 B11.n507 B11.t1491 0.324663
R6439 B11.n506 B11.t1492 0.324663
R6440 B11.n505 B11.t1493 0.324663
R6441 B11.n504 B11.t1494 0.324663
R6442 B11.n503 B11.t1495 0.324663
R6443 B11.n502 B11.t1496 0.324663
R6444 B11.n501 B11.t1497 0.324663
R6445 B11.n500 B11.t1498 0.324663
R6446 B11.n499 B11.t1499 0.324663
R6447 B11.n498 B11.t1500 0.324663
R6448 B11.n497 B11.t1501 0.324663
R6449 B11.n496 B11.t1502 0.324663
R6450 B11.n495 B11.t1503 0.324663
R6451 B11.n494 B11.t1504 0.324663
R6452 B11.n493 B11.t1505 0.324663
R6453 B11.n492 B11.t1506 0.324663
R6454 B11.n491 B11.t1507 0.324663
R6455 B11.n490 B11.t1508 0.324663
R6456 B11.n489 B11.t1509 0.324663
R6457 B11.n488 B11.t1510 0.324663
R6458 B11.n487 B11.t1511 0.324663
R6459 B11.n486 B11.t1512 0.324663
R6460 B11.n485 B11.t1513 0.324663
R6461 B11.n484 B11.t1514 0.324663
R6462 B11.n483 B11.t1515 0.324663
R6463 B11.n482 B11.t1516 0.324663
R6464 B11.n481 B11.t1517 0.324663
R6465 B11.n480 B11.t1518 0.324663
R6466 B11.n479 B11.t1519 0.324663
R6467 B11.n478 B11.t1520 0.324663
R6468 B11.n477 B11.t1521 0.324663
R6469 B11.n476 B11.t1522 0.324663
R6470 B11.n475 B11.t1523 0.324663
R6471 B11.n474 B11.t1524 0.324663
R6472 B11.n473 B11.t1525 0.324663
R6473 B11.n472 B11.t1526 0.324663
R6474 B11.n471 B11.t1527 0.324663
R6475 B11.n470 B11.t1528 0.324663
R6476 B11.n469 B11.t1529 0.324663
R6477 B11.n468 B11.t1530 0.324663
R6478 B11.n467 B11.t1531 0.324663
R6479 B11.n466 B11.t1532 0.324663
R6480 B11.n465 B11.t1533 0.324663
R6481 B11.n464 B11.t1534 0.324663
R6482 B11.n463 B11.t1535 0.324663
R6483 B11.n462 B11.t1536 0.324663
R6484 B11.n461 B11.t1537 0.324663
R6485 B11.n460 B11.t1538 0.324663
R6486 B11.n459 B11.t1539 0.324663
R6487 B11.n458 B11.t1540 0.324663
R6488 B11.n457 B11.t1541 0.324663
R6489 B11.n456 B11.t1542 0.324663
R6490 B11.n580 B11.t1544 0.324663
R6491 B11.n579 B11.t1545 0.324663
R6492 B11.n578 B11.t1546 0.324663
R6493 B11.n577 B11.t1547 0.324663
R6494 B11.n576 B11.t1548 0.324663
R6495 B11.n575 B11.t1549 0.324663
R6496 B11.n574 B11.t1550 0.324663
R6497 B11.n573 B11.t1551 0.324663
R6498 B11.n572 B11.t1552 0.324663
R6499 B11.n571 B11.t1553 0.324663
R6500 B11.n570 B11.t1554 0.324663
R6501 B11.n569 B11.t1555 0.324663
R6502 B11.n568 B11.t1556 0.324663
R6503 B11.n567 B11.t1557 0.324663
R6504 B11.n566 B11.t1558 0.324663
R6505 B11.n565 B11.t1559 0.324663
R6506 B11.n564 B11.t1560 0.324663
R6507 B11.n563 B11.t1561 0.324663
R6508 B11.n562 B11.t1562 0.324663
R6509 B11.n561 B11.t1563 0.324663
R6510 B11.n560 B11.t1564 0.324663
R6511 B11.n559 B11.t1565 0.324663
R6512 B11.n558 B11.t1566 0.324663
R6513 B11.n557 B11.t1567 0.324663
R6514 B11.n556 B11.t1568 0.324663
R6515 B11.n555 B11.t1569 0.324663
R6516 B11.n554 B11.t1570 0.324663
R6517 B11.n553 B11.t1571 0.324663
R6518 B11.n552 B11.t1572 0.324663
R6519 B11.n551 B11.t1573 0.324663
R6520 B11.n550 B11.t1574 0.324663
R6521 B11.n549 B11.t1575 0.324663
R6522 B11.n548 B11.t1576 0.324663
R6523 B11.n547 B11.t1577 0.324663
R6524 B11.n546 B11.t1578 0.324663
R6525 B11.n545 B11.t1579 0.324663
R6526 B11.n544 B11.t1580 0.324663
R6527 B11.n543 B11.t1581 0.324663
R6528 B11.n542 B11.t1582 0.324663
R6529 B11.n541 B11.t1583 0.324663
R6530 B11.n540 B11.t1584 0.324663
R6531 B11.n539 B11.t1585 0.324663
R6532 B11.n538 B11.t1586 0.324663
R6533 B11.n537 B11.t1587 0.324663
R6534 B11.n536 B11.t1588 0.324663
R6535 B11.n535 B11.t1589 0.324663
R6536 B11.n534 B11.t1590 0.324663
R6537 B11.n533 B11.t1591 0.324663
R6538 B11.n532 B11.t1592 0.324663
R6539 B11.n531 B11.t1593 0.324663
R6540 B11.n530 B11.t1594 0.324663
R6541 B11.n529 B11.t1595 0.324663
R6542 B11.n528 B11.t1596 0.324663
R6543 B11.n527 B11.t1597 0.324663
R6544 B11.n526 B11.t1598 0.324663
R6545 B11.n525 B11.t1599 0.324663
R6546 B11.n524 B11.t1600 0.324663
R6547 B11.n523 B11.t1601 0.324663
R6548 B11.n522 B11.t1602 0.324663
R6549 B11.n521 B11.t1603 0.324663
R6550 B11.n520 B11.t1604 0.324663
R6551 B11.n519 B11.t1605 0.324663
R6552 B11.n643 B11.t1607 0.324663
R6553 B11.n642 B11.t1608 0.324663
R6554 B11.n641 B11.t1609 0.324663
R6555 B11.n640 B11.t1610 0.324663
R6556 B11.n639 B11.t1611 0.324663
R6557 B11.n638 B11.t1612 0.324663
R6558 B11.n637 B11.t1613 0.324663
R6559 B11.n636 B11.t1614 0.324663
R6560 B11.n635 B11.t1615 0.324663
R6561 B11.n634 B11.t1616 0.324663
R6562 B11.n633 B11.t1617 0.324663
R6563 B11.n632 B11.t1618 0.324663
R6564 B11.n631 B11.t1619 0.324663
R6565 B11.n630 B11.t1620 0.324663
R6566 B11.n629 B11.t1621 0.324663
R6567 B11.n628 B11.t1622 0.324663
R6568 B11.n627 B11.t1623 0.324663
R6569 B11.n626 B11.t1624 0.324663
R6570 B11.n625 B11.t1625 0.324663
R6571 B11.n624 B11.t1626 0.324663
R6572 B11.n623 B11.t1627 0.324663
R6573 B11.n622 B11.t1628 0.324663
R6574 B11.n621 B11.t1629 0.324663
R6575 B11.n620 B11.t1630 0.324663
R6576 B11.n619 B11.t1631 0.324663
R6577 B11.n618 B11.t1632 0.324663
R6578 B11.n617 B11.t1633 0.324663
R6579 B11.n616 B11.t1634 0.324663
R6580 B11.n615 B11.t1635 0.324663
R6581 B11.n614 B11.t1636 0.324663
R6582 B11.n613 B11.t1637 0.324663
R6583 B11.n612 B11.t1638 0.324663
R6584 B11.n611 B11.t1639 0.324663
R6585 B11.n610 B11.t1640 0.324663
R6586 B11.n609 B11.t1641 0.324663
R6587 B11.n608 B11.t1642 0.324663
R6588 B11.n607 B11.t1643 0.324663
R6589 B11.n606 B11.t1644 0.324663
R6590 B11.n605 B11.t1645 0.324663
R6591 B11.n604 B11.t1646 0.324663
R6592 B11.n603 B11.t1647 0.324663
R6593 B11.n602 B11.t1648 0.324663
R6594 B11.n601 B11.t1649 0.324663
R6595 B11.n600 B11.t1650 0.324663
R6596 B11.n599 B11.t1651 0.324663
R6597 B11.n598 B11.t1652 0.324663
R6598 B11.n597 B11.t1653 0.324663
R6599 B11.n596 B11.t1654 0.324663
R6600 B11.n595 B11.t1655 0.324663
R6601 B11.n594 B11.t1656 0.324663
R6602 B11.n593 B11.t1657 0.324663
R6603 B11.n592 B11.t1658 0.324663
R6604 B11.n591 B11.t1659 0.324663
R6605 B11.n590 B11.t1660 0.324663
R6606 B11.n589 B11.t1661 0.324663
R6607 B11.n588 B11.t1662 0.324663
R6608 B11.n587 B11.t1663 0.324663
R6609 B11.n586 B11.t1664 0.324663
R6610 B11.n585 B11.t1665 0.324663
R6611 B11.n584 B11.t1666 0.324663
R6612 B11.n583 B11.t1667 0.324663
R6613 B11.n582 B11.t1668 0.324663
R6614 B11.n706 B11.t1670 0.324663
R6615 B11.n705 B11.t1671 0.324663
R6616 B11.n704 B11.t1672 0.324663
R6617 B11.n703 B11.t1673 0.324663
R6618 B11.n702 B11.t1674 0.324663
R6619 B11.n701 B11.t1675 0.324663
R6620 B11.n700 B11.t1676 0.324663
R6621 B11.n699 B11.t1677 0.324663
R6622 B11.n698 B11.t1678 0.324663
R6623 B11.n697 B11.t1679 0.324663
R6624 B11.n696 B11.t1680 0.324663
R6625 B11.n695 B11.t1681 0.324663
R6626 B11.n694 B11.t1682 0.324663
R6627 B11.n693 B11.t1683 0.324663
R6628 B11.n692 B11.t1684 0.324663
R6629 B11.n691 B11.t1685 0.324663
R6630 B11.n690 B11.t1686 0.324663
R6631 B11.n689 B11.t1687 0.324663
R6632 B11.n688 B11.t1688 0.324663
R6633 B11.n687 B11.t1689 0.324663
R6634 B11.n686 B11.t1690 0.324663
R6635 B11.n685 B11.t1691 0.324663
R6636 B11.n684 B11.t1692 0.324663
R6637 B11.n683 B11.t1693 0.324663
R6638 B11.n682 B11.t1694 0.324663
R6639 B11.n681 B11.t1695 0.324663
R6640 B11.n680 B11.t1696 0.324663
R6641 B11.n679 B11.t1697 0.324663
R6642 B11.n678 B11.t1698 0.324663
R6643 B11.n677 B11.t1699 0.324663
R6644 B11.n676 B11.t1700 0.324663
R6645 B11.n675 B11.t1701 0.324663
R6646 B11.n674 B11.t1702 0.324663
R6647 B11.n673 B11.t1703 0.324663
R6648 B11.n672 B11.t1704 0.324663
R6649 B11.n671 B11.t1705 0.324663
R6650 B11.n670 B11.t1706 0.324663
R6651 B11.n669 B11.t1707 0.324663
R6652 B11.n668 B11.t1708 0.324663
R6653 B11.n667 B11.t1709 0.324663
R6654 B11.n666 B11.t1710 0.324663
R6655 B11.n665 B11.t1711 0.324663
R6656 B11.n664 B11.t1712 0.324663
R6657 B11.n663 B11.t1713 0.324663
R6658 B11.n662 B11.t1714 0.324663
R6659 B11.n661 B11.t1715 0.324663
R6660 B11.n660 B11.t1716 0.324663
R6661 B11.n659 B11.t1717 0.324663
R6662 B11.n658 B11.t1718 0.324663
R6663 B11.n657 B11.t1719 0.324663
R6664 B11.n656 B11.t1720 0.324663
R6665 B11.n655 B11.t1721 0.324663
R6666 B11.n654 B11.t1722 0.324663
R6667 B11.n653 B11.t1723 0.324663
R6668 B11.n652 B11.t1724 0.324663
R6669 B11.n651 B11.t1725 0.324663
R6670 B11.n650 B11.t1726 0.324663
R6671 B11.n649 B11.t1727 0.324663
R6672 B11.n648 B11.t1728 0.324663
R6673 B11.n647 B11.t1729 0.324663
R6674 B11.n646 B11.t1730 0.324663
R6675 B11.n645 B11.t1731 0.324663
R6676 B11.n769 B11.t1733 0.324663
R6677 B11.n768 B11.t1734 0.324663
R6678 B11.n767 B11.t1735 0.324663
R6679 B11.n766 B11.t1736 0.324663
R6680 B11.n765 B11.t1737 0.324663
R6681 B11.n764 B11.t1738 0.324663
R6682 B11.n763 B11.t1739 0.324663
R6683 B11.n762 B11.t1740 0.324663
R6684 B11.n761 B11.t1741 0.324663
R6685 B11.n760 B11.t1742 0.324663
R6686 B11.n759 B11.t1743 0.324663
R6687 B11.n758 B11.t1744 0.324663
R6688 B11.n757 B11.t1745 0.324663
R6689 B11.n756 B11.t1746 0.324663
R6690 B11.n755 B11.t1747 0.324663
R6691 B11.n754 B11.t1748 0.324663
R6692 B11.n753 B11.t1749 0.324663
R6693 B11.n752 B11.t1750 0.324663
R6694 B11.n751 B11.t1751 0.324663
R6695 B11.n750 B11.t1752 0.324663
R6696 B11.n749 B11.t1753 0.324663
R6697 B11.n748 B11.t1754 0.324663
R6698 B11.n747 B11.t1755 0.324663
R6699 B11.n746 B11.t1756 0.324663
R6700 B11.n745 B11.t1757 0.324663
R6701 B11.n744 B11.t1758 0.324663
R6702 B11.n743 B11.t1759 0.324663
R6703 B11.n742 B11.t1760 0.324663
R6704 B11.n741 B11.t1761 0.324663
R6705 B11.n740 B11.t1762 0.324663
R6706 B11.n739 B11.t1763 0.324663
R6707 B11.n738 B11.t1764 0.324663
R6708 B11.n737 B11.t1765 0.324663
R6709 B11.n736 B11.t1766 0.324663
R6710 B11.n735 B11.t1767 0.324663
R6711 B11.n734 B11.t1768 0.324663
R6712 B11.n733 B11.t1769 0.324663
R6713 B11.n732 B11.t1770 0.324663
R6714 B11.n731 B11.t1771 0.324663
R6715 B11.n730 B11.t1772 0.324663
R6716 B11.n729 B11.t1773 0.324663
R6717 B11.n728 B11.t1774 0.324663
R6718 B11.n727 B11.t1775 0.324663
R6719 B11.n726 B11.t1776 0.324663
R6720 B11.n725 B11.t1777 0.324663
R6721 B11.n724 B11.t1778 0.324663
R6722 B11.n723 B11.t1779 0.324663
R6723 B11.n722 B11.t1780 0.324663
R6724 B11.n721 B11.t1781 0.324663
R6725 B11.n720 B11.t1782 0.324663
R6726 B11.n719 B11.t1783 0.324663
R6727 B11.n718 B11.t1784 0.324663
R6728 B11.n717 B11.t1785 0.324663
R6729 B11.n716 B11.t1786 0.324663
R6730 B11.n715 B11.t1787 0.324663
R6731 B11.n714 B11.t1788 0.324663
R6732 B11.n713 B11.t1789 0.324663
R6733 B11.n712 B11.t1790 0.324663
R6734 B11.n711 B11.t1791 0.324663
R6735 B11.n710 B11.t1792 0.324663
R6736 B11.n709 B11.t1793 0.324663
R6737 B11.n708 B11.t1794 0.324663
R6738 B11.n832 B11.t1796 0.324663
R6739 B11.n831 B11.t1797 0.324663
R6740 B11.n830 B11.t1798 0.324663
R6741 B11.n829 B11.t1799 0.324663
R6742 B11.n828 B11.t1800 0.324663
R6743 B11.n827 B11.t1801 0.324663
R6744 B11.n826 B11.t1802 0.324663
R6745 B11.n825 B11.t1803 0.324663
R6746 B11.n824 B11.t1804 0.324663
R6747 B11.n823 B11.t1805 0.324663
R6748 B11.n822 B11.t1806 0.324663
R6749 B11.n821 B11.t1807 0.324663
R6750 B11.n820 B11.t1808 0.324663
R6751 B11.n819 B11.t1809 0.324663
R6752 B11.n818 B11.t1810 0.324663
R6753 B11.n817 B11.t1811 0.324663
R6754 B11.n816 B11.t1812 0.324663
R6755 B11.n815 B11.t1813 0.324663
R6756 B11.n814 B11.t1814 0.324663
R6757 B11.n813 B11.t1815 0.324663
R6758 B11.n812 B11.t1816 0.324663
R6759 B11.n811 B11.t1817 0.324663
R6760 B11.n810 B11.t1818 0.324663
R6761 B11.n809 B11.t1819 0.324663
R6762 B11.n808 B11.t1820 0.324663
R6763 B11.n807 B11.t1821 0.324663
R6764 B11.n806 B11.t1822 0.324663
R6765 B11.n805 B11.t1823 0.324663
R6766 B11.n804 B11.t1824 0.324663
R6767 B11.n803 B11.t1825 0.324663
R6768 B11.n802 B11.t1826 0.324663
R6769 B11.n801 B11.t1827 0.324663
R6770 B11.n800 B11.t1828 0.324663
R6771 B11.n799 B11.t1829 0.324663
R6772 B11.n798 B11.t1830 0.324663
R6773 B11.n797 B11.t1831 0.324663
R6774 B11.n796 B11.t1832 0.324663
R6775 B11.n795 B11.t1833 0.324663
R6776 B11.n794 B11.t1834 0.324663
R6777 B11.n793 B11.t1835 0.324663
R6778 B11.n792 B11.t1836 0.324663
R6779 B11.n791 B11.t1837 0.324663
R6780 B11.n790 B11.t1838 0.324663
R6781 B11.n789 B11.t1839 0.324663
R6782 B11.n788 B11.t1840 0.324663
R6783 B11.n787 B11.t1841 0.324663
R6784 B11.n786 B11.t1842 0.324663
R6785 B11.n785 B11.t1843 0.324663
R6786 B11.n784 B11.t1844 0.324663
R6787 B11.n783 B11.t1845 0.324663
R6788 B11.n782 B11.t1846 0.324663
R6789 B11.n781 B11.t1847 0.324663
R6790 B11.n780 B11.t1848 0.324663
R6791 B11.n779 B11.t1849 0.324663
R6792 B11.n778 B11.t1850 0.324663
R6793 B11.n777 B11.t1851 0.324663
R6794 B11.n776 B11.t1852 0.324663
R6795 B11.n775 B11.t1853 0.324663
R6796 B11.n774 B11.t1854 0.324663
R6797 B11.n773 B11.t1855 0.324663
R6798 B11.n772 B11.t1856 0.324663
R6799 B11.n771 B11.t1857 0.324663
R6800 B11.n895 B11.t1859 0.324663
R6801 B11.n894 B11.t1860 0.324663
R6802 B11.n893 B11.t1861 0.324663
R6803 B11.n892 B11.t1862 0.324663
R6804 B11.n891 B11.t1863 0.324663
R6805 B11.n890 B11.t1864 0.324663
R6806 B11.n889 B11.t1865 0.324663
R6807 B11.n888 B11.t1866 0.324663
R6808 B11.n887 B11.t1867 0.324663
R6809 B11.n886 B11.t1868 0.324663
R6810 B11.n885 B11.t1869 0.324663
R6811 B11.n884 B11.t1870 0.324663
R6812 B11.n883 B11.t1871 0.324663
R6813 B11.n882 B11.t1872 0.324663
R6814 B11.n881 B11.t1873 0.324663
R6815 B11.n880 B11.t1874 0.324663
R6816 B11.n879 B11.t1875 0.324663
R6817 B11.n878 B11.t1876 0.324663
R6818 B11.n877 B11.t1877 0.324663
R6819 B11.n876 B11.t1878 0.324663
R6820 B11.n875 B11.t1879 0.324663
R6821 B11.n874 B11.t1880 0.324663
R6822 B11.n873 B11.t1881 0.324663
R6823 B11.n872 B11.t1882 0.324663
R6824 B11.n871 B11.t1883 0.324663
R6825 B11.n870 B11.t1884 0.324663
R6826 B11.n869 B11.t1885 0.324663
R6827 B11.n868 B11.t1886 0.324663
R6828 B11.n867 B11.t1887 0.324663
R6829 B11.n866 B11.t1888 0.324663
R6830 B11.n865 B11.t1889 0.324663
R6831 B11.n864 B11.t1890 0.324663
R6832 B11.n863 B11.t1891 0.324663
R6833 B11.n862 B11.t1892 0.324663
R6834 B11.n861 B11.t1893 0.324663
R6835 B11.n860 B11.t1894 0.324663
R6836 B11.n859 B11.t1895 0.324663
R6837 B11.n858 B11.t1896 0.324663
R6838 B11.n857 B11.t1897 0.324663
R6839 B11.n856 B11.t1898 0.324663
R6840 B11.n855 B11.t1899 0.324663
R6841 B11.n854 B11.t1900 0.324663
R6842 B11.n853 B11.t1901 0.324663
R6843 B11.n852 B11.t1902 0.324663
R6844 B11.n851 B11.t1903 0.324663
R6845 B11.n850 B11.t1904 0.324663
R6846 B11.n849 B11.t1905 0.324663
R6847 B11.n848 B11.t1906 0.324663
R6848 B11.n847 B11.t1907 0.324663
R6849 B11.n846 B11.t1908 0.324663
R6850 B11.n845 B11.t1909 0.324663
R6851 B11.n844 B11.t1910 0.324663
R6852 B11.n843 B11.t1911 0.324663
R6853 B11.n842 B11.t1912 0.324663
R6854 B11.n841 B11.t1913 0.324663
R6855 B11.n840 B11.t1914 0.324663
R6856 B11.n839 B11.t1915 0.324663
R6857 B11.n838 B11.t1916 0.324663
R6858 B11.n837 B11.t1917 0.324663
R6859 B11.n836 B11.t1918 0.324663
R6860 B11.n835 B11.t1919 0.324663
R6861 B11.n834 B11.t1920 0.324663
R6862 B11.n958 B11.t1922 0.324663
R6863 B11.n957 B11.t1923 0.324663
R6864 B11.n956 B11.t1924 0.324663
R6865 B11.n955 B11.t1925 0.324663
R6866 B11.n954 B11.t1926 0.324663
R6867 B11.n953 B11.t1927 0.324663
R6868 B11.n952 B11.t1928 0.324663
R6869 B11.n951 B11.t1929 0.324663
R6870 B11.n950 B11.t1930 0.324663
R6871 B11.n949 B11.t1931 0.324663
R6872 B11.n948 B11.t1932 0.324663
R6873 B11.n947 B11.t1933 0.324663
R6874 B11.n946 B11.t1934 0.324663
R6875 B11.n945 B11.t1935 0.324663
R6876 B11.n944 B11.t1936 0.324663
R6877 B11.n943 B11.t1937 0.324663
R6878 B11.n942 B11.t1938 0.324663
R6879 B11.n941 B11.t1939 0.324663
R6880 B11.n940 B11.t1940 0.324663
R6881 B11.n939 B11.t1941 0.324663
R6882 B11.n938 B11.t1942 0.324663
R6883 B11.n937 B11.t1943 0.324663
R6884 B11.n936 B11.t1944 0.324663
R6885 B11.n935 B11.t1945 0.324663
R6886 B11.n934 B11.t1946 0.324663
R6887 B11.n933 B11.t1947 0.324663
R6888 B11.n932 B11.t1948 0.324663
R6889 B11.n931 B11.t1949 0.324663
R6890 B11.n930 B11.t1950 0.324663
R6891 B11.n929 B11.t1951 0.324663
R6892 B11.n928 B11.t1952 0.324663
R6893 B11.n927 B11.t1953 0.324663
R6894 B11.n926 B11.t1954 0.324663
R6895 B11.n925 B11.t1955 0.324663
R6896 B11.n924 B11.t1956 0.324663
R6897 B11.n923 B11.t1957 0.324663
R6898 B11.n922 B11.t1958 0.324663
R6899 B11.n921 B11.t1959 0.324663
R6900 B11.n920 B11.t1960 0.324663
R6901 B11.n919 B11.t1961 0.324663
R6902 B11.n918 B11.t1962 0.324663
R6903 B11.n917 B11.t1963 0.324663
R6904 B11.n916 B11.t1964 0.324663
R6905 B11.n915 B11.t1965 0.324663
R6906 B11.n914 B11.t1966 0.324663
R6907 B11.n913 B11.t1967 0.324663
R6908 B11.n912 B11.t1968 0.324663
R6909 B11.n911 B11.t1969 0.324663
R6910 B11.n910 B11.t1970 0.324663
R6911 B11.n909 B11.t1971 0.324663
R6912 B11.n908 B11.t1972 0.324663
R6913 B11.n907 B11.t1973 0.324663
R6914 B11.n906 B11.t1974 0.324663
R6915 B11.n905 B11.t1975 0.324663
R6916 B11.n904 B11.t1976 0.324663
R6917 B11.n903 B11.t1977 0.324663
R6918 B11.n902 B11.t1978 0.324663
R6919 B11.n901 B11.t1979 0.324663
R6920 B11.n900 B11.t1980 0.324663
R6921 B11.n899 B11.t1981 0.324663
R6922 B11.n898 B11.t1982 0.324663
R6923 B11.n897 B11.t1983 0.324663
R6924 B11.n1021 B11.t1985 0.324663
R6925 B11.n1020 B11.t1986 0.324663
R6926 B11.n1019 B11.t1987 0.324663
R6927 B11.n1018 B11.t1988 0.324663
R6928 B11.n1017 B11.t1989 0.324663
R6929 B11.n1016 B11.t1990 0.324663
R6930 B11.n1015 B11.t1991 0.324663
R6931 B11.n1014 B11.t1992 0.324663
R6932 B11.n1013 B11.t1993 0.324663
R6933 B11.n1012 B11.t1994 0.324663
R6934 B11.n1011 B11.t1995 0.324663
R6935 B11.n1010 B11.t1996 0.324663
R6936 B11.n1009 B11.t1997 0.324663
R6937 B11.n1008 B11.t1998 0.324663
R6938 B11.n1007 B11.t1999 0.324663
R6939 B11.n1006 B11.t2000 0.324663
R6940 B11.n1005 B11.t2001 0.324663
R6941 B11.n1004 B11.t2002 0.324663
R6942 B11.n1003 B11.t2003 0.324663
R6943 B11.n1002 B11.t2004 0.324663
R6944 B11.n1001 B11.t2005 0.324663
R6945 B11.n1000 B11.t2006 0.324663
R6946 B11.n999 B11.t2007 0.324663
R6947 B11.n998 B11.t2008 0.324663
R6948 B11.n997 B11.t2009 0.324663
R6949 B11.n996 B11.t2010 0.324663
R6950 B11.n995 B11.t2011 0.324663
R6951 B11.n994 B11.t2012 0.324663
R6952 B11.n993 B11.t2013 0.324663
R6953 B11.n992 B11.t2014 0.324663
R6954 B11.n991 B11.t2015 0.324663
R6955 B11.n990 B11.t2016 0.324663
R6956 B11.n989 B11.t2017 0.324663
R6957 B11.n988 B11.t2018 0.324663
R6958 B11.n987 B11.t2019 0.324663
R6959 B11.n986 B11.t2020 0.324663
R6960 B11.n985 B11.t2021 0.324663
R6961 B11.n984 B11.t2022 0.324663
R6962 B11.n983 B11.t2023 0.324663
R6963 B11.n982 B11.t2024 0.324663
R6964 B11.n981 B11.t2025 0.324663
R6965 B11.n980 B11.t2026 0.324663
R6966 B11.n979 B11.t2027 0.324663
R6967 B11.n978 B11.t2028 0.324663
R6968 B11.n977 B11.t2029 0.324663
R6969 B11.n976 B11.t2030 0.324663
R6970 B11.n975 B11.t2031 0.324663
R6971 B11.n974 B11.t2032 0.324663
R6972 B11.n973 B11.t2033 0.324663
R6973 B11.n972 B11.t2034 0.324663
R6974 B11.n971 B11.t2035 0.324663
R6975 B11.n970 B11.t2036 0.324663
R6976 B11.n969 B11.t2037 0.324663
R6977 B11.n968 B11.t2038 0.324663
R6978 B11.n967 B11.t2039 0.324663
R6979 B11.n966 B11.t2040 0.324663
R6980 B11.n965 B11.t2041 0.324663
R6981 B11.n964 B11.t2042 0.324663
R6982 B11.n963 B11.t2043 0.324663
R6983 B11.n962 B11.t2044 0.324663
R6984 B11.n961 B11.t2045 0.324663
R6985 B11.n960 B11.t2046 0.324663
R6986 B11.n1023 B11.t1 0.324663
R6987 B11.n1024 B11.t2 0.324663
R6988 B11.n1025 B11.t3 0.324663
R6989 B11.n1026 B11.t4 0.324663
R6990 B11.n1027 B11.t5 0.324663
R6991 B11.n1028 B11.t6 0.324663
R6992 B11.n1029 B11.t7 0.324663
R6993 B11.n1030 B11.t8 0.324663
R6994 B11.n1031 B11.t9 0.324663
R6995 B11.n1032 B11.t10 0.324663
R6996 B11.n1033 B11.t11 0.324663
R6997 B11.n1034 B11.t12 0.324663
R6998 B11.n1035 B11.t13 0.324663
R6999 B11.n1036 B11.t14 0.324663
R7000 B11.n1037 B11.t15 0.324663
R7001 B11.n1038 B11.t16 0.324663
R7002 B11.n1039 B11.t17 0.324663
R7003 B11.n1040 B11.t18 0.324663
R7004 B11.n1041 B11.t19 0.324663
R7005 B11.n1042 B11.t20 0.324663
R7006 B11.n1043 B11.t21 0.324663
R7007 B11.n1044 B11.t22 0.324663
R7008 B11.n1045 B11.t23 0.324663
R7009 B11.n1046 B11.t24 0.324663
R7010 B11.n1047 B11.t25 0.324663
R7011 B11.n1048 B11.t26 0.324663
R7012 B11.n1049 B11.t27 0.324663
R7013 B11.n1050 B11.t28 0.324663
R7014 B11.n1051 B11.t29 0.324663
R7015 B11.n1052 B11.t30 0.324663
R7016 B11.n1053 B11.t31 0.324663
R7017 B11.n1054 B11.t32 0.324663
R7018 B11.n1055 B11.t33 0.324663
R7019 B11.n1056 B11.t34 0.324663
R7020 B11.n1057 B11.t35 0.324663
R7021 B11.n1058 B11.t36 0.324663
R7022 B11.n1059 B11.t37 0.324663
R7023 B11.n1060 B11.t38 0.324663
R7024 B11.n1061 B11.t39 0.324663
R7025 B11.n1062 B11.t40 0.324663
R7026 B11.n1063 B11.t41 0.324663
R7027 B11.n1064 B11.t42 0.324663
R7028 B11.n1065 B11.t43 0.324663
R7029 B11.n1066 B11.t44 0.324663
R7030 B11.n1067 B11.t45 0.324663
R7031 B11.n1068 B11.t46 0.324663
R7032 B11.n1069 B11.t47 0.324663
R7033 B11.n1070 B11.t48 0.324663
R7034 B11.n1071 B11.t49 0.324663
R7035 B11.n1072 B11.t50 0.324663
R7036 B11.n1073 B11.t51 0.324663
R7037 B11.n1074 B11.t52 0.324663
R7038 B11.n1075 B11.t53 0.324663
R7039 B11.n1076 B11.t54 0.324663
R7040 B11.n1077 B11.t55 0.324663
R7041 B11.n1078 B11.t56 0.324663
R7042 B11.n1079 B11.t57 0.324663
R7043 B11.n1080 B11.t58 0.324663
R7044 B11.n1081 B11.t59 0.324663
R7045 B11.n1082 B11.t60 0.324663
R7046 B11.n1083 B11.t61 0.324663
R7047 B11.n1084 B11.t62 0.324663
R7048 B11.n1085 B11.t64 0.324663
R7049 B11.n1086 B11.t65 0.324663
R7050 B11.n1087 B11.t66 0.324663
R7051 B11.n1088 B11.t67 0.324663
R7052 B11.n1089 B11.t68 0.324663
R7053 B11.n1090 B11.t69 0.324663
R7054 B11.n1091 B11.t70 0.324663
R7055 B11.n1092 B11.t71 0.324663
R7056 B11.n1093 B11.t72 0.324663
R7057 B11.n1094 B11.t73 0.324663
R7058 B11.n1095 B11.t74 0.324663
R7059 B11.n1096 B11.t75 0.324663
R7060 B11.n1097 B11.t76 0.324663
R7061 B11.n1098 B11.t77 0.324663
R7062 B11.n1099 B11.t78 0.324663
R7063 B11.n1100 B11.t79 0.324663
R7064 B11.n1101 B11.t80 0.324663
R7065 B11.n1102 B11.t81 0.324663
R7066 B11.n1103 B11.t82 0.324663
R7067 B11.n1104 B11.t83 0.324663
R7068 B11.n1105 B11.t84 0.324663
R7069 B11.n1106 B11.t85 0.324663
R7070 B11.n1107 B11.t86 0.324663
R7071 B11.n1108 B11.t87 0.324663
R7072 B11.n1109 B11.t88 0.324663
R7073 B11.n1110 B11.t89 0.324663
R7074 B11.n1111 B11.t90 0.324663
R7075 B11.n1112 B11.t91 0.324663
R7076 B11.n1113 B11.t92 0.324663
R7077 B11.n1114 B11.t93 0.324663
R7078 B11.n1115 B11.t94 0.324663
R7079 B11.n1116 B11.t95 0.324663
R7080 B11.n1117 B11.t96 0.324663
R7081 B11.n1118 B11.t97 0.324663
R7082 B11.n1119 B11.t98 0.324663
R7083 B11.n1120 B11.t99 0.324663
R7084 B11.n1121 B11.t100 0.324663
R7085 B11.n1122 B11.t101 0.324663
R7086 B11.n1123 B11.t102 0.324663
R7087 B11.n1124 B11.t103 0.324663
R7088 B11.n1125 B11.t104 0.324663
R7089 B11.n1126 B11.t105 0.324663
R7090 B11.n1127 B11.t106 0.324663
R7091 B11.n1128 B11.t107 0.324663
R7092 B11.n1129 B11.t108 0.324663
R7093 B11.n1130 B11.t109 0.324663
R7094 B11.n1131 B11.t110 0.324663
R7095 B11.n1132 B11.t111 0.324663
R7096 B11.n1133 B11.t112 0.324663
R7097 B11.n1134 B11.t113 0.324663
R7098 B11.n1135 B11.t114 0.324663
R7099 B11.n1136 B11.t115 0.324663
R7100 B11.n1137 B11.t116 0.324663
R7101 B11.n1138 B11.t117 0.324663
R7102 B11.n1139 B11.t118 0.324663
R7103 B11.n1140 B11.t119 0.324663
R7104 B11.n1141 B11.t120 0.324663
R7105 B11.n1142 B11.t121 0.324663
R7106 B11.n1143 B11.t122 0.324663
R7107 B11.n1144 B11.t123 0.324663
R7108 B11.n1145 B11.t124 0.324663
R7109 B11.n1146 B11.t125 0.324663
R7110 B11.n1148 B11.t127 0.324663
R7111 B11.n1149 B11.t128 0.324663
R7112 B11.n1150 B11.t129 0.324663
R7113 B11.n1151 B11.t130 0.324663
R7114 B11.n1152 B11.t131 0.324663
R7115 B11.n1153 B11.t132 0.324663
R7116 B11.n1154 B11.t133 0.324663
R7117 B11.n1155 B11.t134 0.324663
R7118 B11.n1156 B11.t135 0.324663
R7119 B11.n1157 B11.t136 0.324663
R7120 B11.n1158 B11.t137 0.324663
R7121 B11.n1159 B11.t138 0.324663
R7122 B11.n1160 B11.t139 0.324663
R7123 B11.n1161 B11.t140 0.324663
R7124 B11.n1162 B11.t141 0.324663
R7125 B11.n1163 B11.t142 0.324663
R7126 B11.n1164 B11.t143 0.324663
R7127 B11.n1165 B11.t144 0.324663
R7128 B11.n1166 B11.t145 0.324663
R7129 B11.n1167 B11.t146 0.324663
R7130 B11.n1168 B11.t147 0.324663
R7131 B11.n1169 B11.t148 0.324663
R7132 B11.n1170 B11.t149 0.324663
R7133 B11.n1171 B11.t150 0.324663
R7134 B11.n1172 B11.t151 0.324663
R7135 B11.n1173 B11.t152 0.324663
R7136 B11.n1174 B11.t153 0.324663
R7137 B11.n1175 B11.t154 0.324663
R7138 B11.n1176 B11.t155 0.324663
R7139 B11.n1177 B11.t156 0.324663
R7140 B11.n1178 B11.t157 0.324663
R7141 B11.n1179 B11.t158 0.324663
R7142 B11.n1180 B11.t159 0.324663
R7143 B11.n1181 B11.t160 0.324663
R7144 B11.n1182 B11.t161 0.324663
R7145 B11.n1183 B11.t162 0.324663
R7146 B11.n1184 B11.t163 0.324663
R7147 B11.n1185 B11.t164 0.324663
R7148 B11.n1186 B11.t165 0.324663
R7149 B11.n1187 B11.t166 0.324663
R7150 B11.n1188 B11.t167 0.324663
R7151 B11.n1189 B11.t168 0.324663
R7152 B11.n1190 B11.t169 0.324663
R7153 B11.n1191 B11.t170 0.324663
R7154 B11.n1192 B11.t171 0.324663
R7155 B11.n1193 B11.t172 0.324663
R7156 B11.n1194 B11.t173 0.324663
R7157 B11.n1195 B11.t174 0.324663
R7158 B11.n1196 B11.t175 0.324663
R7159 B11.n1197 B11.t176 0.324663
R7160 B11.n1198 B11.t177 0.324663
R7161 B11.n1199 B11.t178 0.324663
R7162 B11.n1200 B11.t179 0.324663
R7163 B11.n1201 B11.t180 0.324663
R7164 B11.n1202 B11.t181 0.324663
R7165 B11.n1203 B11.t182 0.324663
R7166 B11.n1204 B11.t183 0.324663
R7167 B11.n1205 B11.t184 0.324663
R7168 B11.n1206 B11.t185 0.324663
R7169 B11.n1207 B11.t186 0.324663
R7170 B11.n1208 B11.t187 0.324663
R7171 B11.n1209 B11.t188 0.324663
R7172 B11.n1211 B11.t190 0.324663
R7173 B11.n1212 B11.t191 0.324663
R7174 B11.n1213 B11.t192 0.324663
R7175 B11.n1214 B11.t193 0.324663
R7176 B11.n1215 B11.t194 0.324663
R7177 B11.n1216 B11.t195 0.324663
R7178 B11.n1217 B11.t196 0.324663
R7179 B11.n1218 B11.t197 0.324663
R7180 B11.n1219 B11.t198 0.324663
R7181 B11.n1220 B11.t199 0.324663
R7182 B11.n1221 B11.t200 0.324663
R7183 B11.n1222 B11.t201 0.324663
R7184 B11.n1223 B11.t202 0.324663
R7185 B11.n1224 B11.t203 0.324663
R7186 B11.n1225 B11.t204 0.324663
R7187 B11.n1226 B11.t205 0.324663
R7188 B11.n1227 B11.t206 0.324663
R7189 B11.n1228 B11.t207 0.324663
R7190 B11.n1229 B11.t208 0.324663
R7191 B11.n1230 B11.t209 0.324663
R7192 B11.n1231 B11.t210 0.324663
R7193 B11.n1232 B11.t211 0.324663
R7194 B11.n1233 B11.t212 0.324663
R7195 B11.n1234 B11.t213 0.324663
R7196 B11.n1235 B11.t214 0.324663
R7197 B11.n1236 B11.t215 0.324663
R7198 B11.n1237 B11.t216 0.324663
R7199 B11.n1238 B11.t217 0.324663
R7200 B11.n1239 B11.t218 0.324663
R7201 B11.n1240 B11.t219 0.324663
R7202 B11.n1241 B11.t220 0.324663
R7203 B11.n1242 B11.t221 0.324663
R7204 B11.n1243 B11.t222 0.324663
R7205 B11.n1244 B11.t223 0.324663
R7206 B11.n1245 B11.t224 0.324663
R7207 B11.n1246 B11.t225 0.324663
R7208 B11.n1247 B11.t226 0.324663
R7209 B11.n1248 B11.t227 0.324663
R7210 B11.n1249 B11.t228 0.324663
R7211 B11.n1250 B11.t229 0.324663
R7212 B11.n1251 B11.t230 0.324663
R7213 B11.n1252 B11.t231 0.324663
R7214 B11.n1253 B11.t232 0.324663
R7215 B11.n1254 B11.t233 0.324663
R7216 B11.n1255 B11.t234 0.324663
R7217 B11.n1256 B11.t235 0.324663
R7218 B11.n1257 B11.t236 0.324663
R7219 B11.n1258 B11.t237 0.324663
R7220 B11.n1259 B11.t238 0.324663
R7221 B11.n1260 B11.t239 0.324663
R7222 B11.n1261 B11.t240 0.324663
R7223 B11.n1262 B11.t241 0.324663
R7224 B11.n1263 B11.t242 0.324663
R7225 B11.n1264 B11.t243 0.324663
R7226 B11.n1265 B11.t244 0.324663
R7227 B11.n1266 B11.t245 0.324663
R7228 B11.n1267 B11.t246 0.324663
R7229 B11.n1268 B11.t247 0.324663
R7230 B11.n1269 B11.t248 0.324663
R7231 B11.n1270 B11.t249 0.324663
R7232 B11.n1271 B11.t250 0.324663
R7233 B11.n1272 B11.t251 0.324663
R7234 B11.n1274 B11.t253 0.324663
R7235 B11.n1275 B11.t254 0.324663
R7236 B11.n1276 B11.t255 0.324663
R7237 B11.n1277 B11.t256 0.324663
R7238 B11.n1278 B11.t257 0.324663
R7239 B11.n1279 B11.t258 0.324663
R7240 B11.n1280 B11.t259 0.324663
R7241 B11.n1281 B11.t260 0.324663
R7242 B11.n1282 B11.t261 0.324663
R7243 B11.n1283 B11.t262 0.324663
R7244 B11.n1284 B11.t263 0.324663
R7245 B11.n1285 B11.t264 0.324663
R7246 B11.n1286 B11.t265 0.324663
R7247 B11.n1287 B11.t266 0.324663
R7248 B11.n1288 B11.t267 0.324663
R7249 B11.n1289 B11.t268 0.324663
R7250 B11.n1290 B11.t269 0.324663
R7251 B11.n1291 B11.t270 0.324663
R7252 B11.n1292 B11.t271 0.324663
R7253 B11.n1293 B11.t272 0.324663
R7254 B11.n1294 B11.t273 0.324663
R7255 B11.n1295 B11.t274 0.324663
R7256 B11.n1296 B11.t275 0.324663
R7257 B11.n1297 B11.t276 0.324663
R7258 B11.n1298 B11.t277 0.324663
R7259 B11.n1299 B11.t278 0.324663
R7260 B11.n1300 B11.t279 0.324663
R7261 B11.n1301 B11.t280 0.324663
R7262 B11.n1302 B11.t281 0.324663
R7263 B11.n1303 B11.t282 0.324663
R7264 B11.n1304 B11.t283 0.324663
R7265 B11.n1305 B11.t284 0.324663
R7266 B11.n1306 B11.t285 0.324663
R7267 B11.n1307 B11.t286 0.324663
R7268 B11.n1308 B11.t287 0.324663
R7269 B11.n1309 B11.t288 0.324663
R7270 B11.n1310 B11.t289 0.324663
R7271 B11.n1311 B11.t290 0.324663
R7272 B11.n1312 B11.t291 0.324663
R7273 B11.n1313 B11.t292 0.324663
R7274 B11.n1314 B11.t293 0.324663
R7275 B11.n1315 B11.t294 0.324663
R7276 B11.n1316 B11.t295 0.324663
R7277 B11.n1317 B11.t296 0.324663
R7278 B11.n1318 B11.t297 0.324663
R7279 B11.n1319 B11.t298 0.324663
R7280 B11.n1320 B11.t299 0.324663
R7281 B11.n1321 B11.t300 0.324663
R7282 B11.n1322 B11.t301 0.324663
R7283 B11.n1323 B11.t302 0.324663
R7284 B11.n1324 B11.t303 0.324663
R7285 B11.n1325 B11.t304 0.324663
R7286 B11.n1326 B11.t305 0.324663
R7287 B11.n1327 B11.t306 0.324663
R7288 B11.n1328 B11.t307 0.324663
R7289 B11.n1329 B11.t308 0.324663
R7290 B11.n1330 B11.t309 0.324663
R7291 B11.n1331 B11.t310 0.324663
R7292 B11.n1332 B11.t311 0.324663
R7293 B11.n1333 B11.t312 0.324663
R7294 B11.n1334 B11.t313 0.324663
R7295 B11.n1335 B11.t314 0.324663
R7296 B11.n1337 B11.t316 0.324663
R7297 B11.n1338 B11.t317 0.324663
R7298 B11.n1339 B11.t318 0.324663
R7299 B11.n1340 B11.t319 0.324663
R7300 B11.n1341 B11.t320 0.324663
R7301 B11.n1342 B11.t321 0.324663
R7302 B11.n1343 B11.t322 0.324663
R7303 B11.n1344 B11.t323 0.324663
R7304 B11.n1345 B11.t324 0.324663
R7305 B11.n1346 B11.t325 0.324663
R7306 B11.n1347 B11.t326 0.324663
R7307 B11.n1348 B11.t327 0.324663
R7308 B11.n1349 B11.t328 0.324663
R7309 B11.n1350 B11.t329 0.324663
R7310 B11.n1351 B11.t330 0.324663
R7311 B11.n1352 B11.t331 0.324663
R7312 B11.n1353 B11.t332 0.324663
R7313 B11.n1354 B11.t333 0.324663
R7314 B11.n1355 B11.t334 0.324663
R7315 B11.n1356 B11.t335 0.324663
R7316 B11.n1357 B11.t336 0.324663
R7317 B11.n1358 B11.t337 0.324663
R7318 B11.n1359 B11.t338 0.324663
R7319 B11.n1360 B11.t339 0.324663
R7320 B11.n1361 B11.t340 0.324663
R7321 B11.n1362 B11.t341 0.324663
R7322 B11.n1363 B11.t342 0.324663
R7323 B11.n1364 B11.t343 0.324663
R7324 B11.n1365 B11.t344 0.324663
R7325 B11.n1366 B11.t345 0.324663
R7326 B11.n1367 B11.t346 0.324663
R7327 B11.n1368 B11.t347 0.324663
R7328 B11.n1369 B11.t348 0.324663
R7329 B11.n1370 B11.t349 0.324663
R7330 B11.n1371 B11.t350 0.324663
R7331 B11.n1372 B11.t351 0.324663
R7332 B11.n1373 B11.t352 0.324663
R7333 B11.n1374 B11.t353 0.324663
R7334 B11.n1375 B11.t354 0.324663
R7335 B11.n1376 B11.t355 0.324663
R7336 B11.n1377 B11.t356 0.324663
R7337 B11.n1378 B11.t357 0.324663
R7338 B11.n1379 B11.t358 0.324663
R7339 B11.n1380 B11.t359 0.324663
R7340 B11.n1381 B11.t360 0.324663
R7341 B11.n1382 B11.t361 0.324663
R7342 B11.n1383 B11.t362 0.324663
R7343 B11.n1384 B11.t363 0.324663
R7344 B11.n1385 B11.t364 0.324663
R7345 B11.n1386 B11.t365 0.324663
R7346 B11.n1387 B11.t366 0.324663
R7347 B11.n1388 B11.t367 0.324663
R7348 B11.n1389 B11.t368 0.324663
R7349 B11.n1390 B11.t369 0.324663
R7350 B11.n1391 B11.t370 0.324663
R7351 B11.n1392 B11.t371 0.324663
R7352 B11.n1393 B11.t372 0.324663
R7353 B11.n1394 B11.t373 0.324663
R7354 B11.n1395 B11.t374 0.324663
R7355 B11.n1396 B11.t375 0.324663
R7356 B11.n1397 B11.t376 0.324663
R7357 B11.n1398 B11.t377 0.324663
R7358 B11.n1400 B11.t379 0.324663
R7359 B11.n1401 B11.t380 0.324663
R7360 B11.n1402 B11.t381 0.324663
R7361 B11.n1403 B11.t382 0.324663
R7362 B11.n1404 B11.t383 0.324663
R7363 B11.n1405 B11.t384 0.324663
R7364 B11.n1406 B11.t385 0.324663
R7365 B11.n1407 B11.t386 0.324663
R7366 B11.n1408 B11.t387 0.324663
R7367 B11.n1409 B11.t388 0.324663
R7368 B11.n1410 B11.t389 0.324663
R7369 B11.n1411 B11.t390 0.324663
R7370 B11.n1412 B11.t391 0.324663
R7371 B11.n1413 B11.t392 0.324663
R7372 B11.n1414 B11.t393 0.324663
R7373 B11.n1415 B11.t394 0.324663
R7374 B11.n1416 B11.t395 0.324663
R7375 B11.n1417 B11.t396 0.324663
R7376 B11.n1418 B11.t397 0.324663
R7377 B11.n1419 B11.t398 0.324663
R7378 B11.n1420 B11.t399 0.324663
R7379 B11.n1421 B11.t400 0.324663
R7380 B11.n1422 B11.t401 0.324663
R7381 B11.n1423 B11.t402 0.324663
R7382 B11.n1424 B11.t403 0.324663
R7383 B11.n1425 B11.t404 0.324663
R7384 B11.n1426 B11.t405 0.324663
R7385 B11.n1427 B11.t406 0.324663
R7386 B11.n1428 B11.t407 0.324663
R7387 B11.n1429 B11.t408 0.324663
R7388 B11.n1430 B11.t409 0.324663
R7389 B11.n1431 B11.t410 0.324663
R7390 B11.n1432 B11.t411 0.324663
R7391 B11.n1433 B11.t412 0.324663
R7392 B11.n1434 B11.t413 0.324663
R7393 B11.n1435 B11.t414 0.324663
R7394 B11.n1436 B11.t415 0.324663
R7395 B11.n1437 B11.t416 0.324663
R7396 B11.n1438 B11.t417 0.324663
R7397 B11.n1439 B11.t418 0.324663
R7398 B11.n1440 B11.t419 0.324663
R7399 B11.n1441 B11.t420 0.324663
R7400 B11.n1442 B11.t421 0.324663
R7401 B11.n1443 B11.t422 0.324663
R7402 B11.n1444 B11.t423 0.324663
R7403 B11.n1445 B11.t424 0.324663
R7404 B11.n1446 B11.t425 0.324663
R7405 B11.n1447 B11.t426 0.324663
R7406 B11.n1448 B11.t427 0.324663
R7407 B11.n1449 B11.t428 0.324663
R7408 B11.n1450 B11.t429 0.324663
R7409 B11.n1451 B11.t430 0.324663
R7410 B11.n1452 B11.t431 0.324663
R7411 B11.n1453 B11.t432 0.324663
R7412 B11.n1454 B11.t433 0.324663
R7413 B11.n1455 B11.t434 0.324663
R7414 B11.n1456 B11.t435 0.324663
R7415 B11.n1457 B11.t436 0.324663
R7416 B11.n1458 B11.t437 0.324663
R7417 B11.n1459 B11.t438 0.324663
R7418 B11.n1460 B11.t439 0.324663
R7419 B11.n1461 B11.t440 0.324663
R7420 B11.n1463 B11.t442 0.324663
R7421 B11.n1464 B11.t443 0.324663
R7422 B11.n1465 B11.t444 0.324663
R7423 B11.n1466 B11.t445 0.324663
R7424 B11.n1467 B11.t446 0.324663
R7425 B11.n1468 B11.t447 0.324663
R7426 B11.n1469 B11.t448 0.324663
R7427 B11.n1470 B11.t449 0.324663
R7428 B11.n1471 B11.t450 0.324663
R7429 B11.n1472 B11.t451 0.324663
R7430 B11.n1473 B11.t452 0.324663
R7431 B11.n1474 B11.t453 0.324663
R7432 B11.n1475 B11.t454 0.324663
R7433 B11.n1476 B11.t455 0.324663
R7434 B11.n1477 B11.t456 0.324663
R7435 B11.n1478 B11.t457 0.324663
R7436 B11.n1479 B11.t458 0.324663
R7437 B11.n1480 B11.t459 0.324663
R7438 B11.n1481 B11.t460 0.324663
R7439 B11.n1482 B11.t461 0.324663
R7440 B11.n1483 B11.t462 0.324663
R7441 B11.n1484 B11.t463 0.324663
R7442 B11.n1485 B11.t464 0.324663
R7443 B11.n1486 B11.t465 0.324663
R7444 B11.n1487 B11.t466 0.324663
R7445 B11.n1488 B11.t467 0.324663
R7446 B11.n1489 B11.t468 0.324663
R7447 B11.n1490 B11.t469 0.324663
R7448 B11.n1491 B11.t470 0.324663
R7449 B11.n1492 B11.t471 0.324663
R7450 B11.n1493 B11.t472 0.324663
R7451 B11.n1494 B11.t473 0.324663
R7452 B11.n1495 B11.t474 0.324663
R7453 B11.n1496 B11.t475 0.324663
R7454 B11.n1497 B11.t476 0.324663
R7455 B11.n1498 B11.t477 0.324663
R7456 B11.n1499 B11.t478 0.324663
R7457 B11.n1500 B11.t479 0.324663
R7458 B11.n1501 B11.t480 0.324663
R7459 B11.n1502 B11.t481 0.324663
R7460 B11.n1503 B11.t482 0.324663
R7461 B11.n1504 B11.t483 0.324663
R7462 B11.n1505 B11.t484 0.324663
R7463 B11.n1506 B11.t485 0.324663
R7464 B11.n1507 B11.t486 0.324663
R7465 B11.n1508 B11.t487 0.324663
R7466 B11.n1509 B11.t488 0.324663
R7467 B11.n1510 B11.t489 0.324663
R7468 B11.n1511 B11.t490 0.324663
R7469 B11.n1512 B11.t491 0.324663
R7470 B11.n1513 B11.t492 0.324663
R7471 B11.n1514 B11.t493 0.324663
R7472 B11.n1515 B11.t494 0.324663
R7473 B11.n1516 B11.t495 0.324663
R7474 B11.n1517 B11.t496 0.324663
R7475 B11.n1518 B11.t497 0.324663
R7476 B11.n1519 B11.t498 0.324663
R7477 B11.n1520 B11.t499 0.324663
R7478 B11.n1521 B11.t500 0.324663
R7479 B11.n1522 B11.t501 0.324663
R7480 B11.n1523 B11.t502 0.324663
R7481 B11.n1524 B11.t503 0.324663
R7482 B11.n1526 B11.t505 0.324663
R7483 B11.n1527 B11.t506 0.324663
R7484 B11.n1528 B11.t507 0.324663
R7485 B11.n1529 B11.t508 0.324663
R7486 B11.n1530 B11.t509 0.324663
R7487 B11.n1531 B11.t510 0.324663
R7488 B11.n1532 B11.t511 0.324663
R7489 B11.n1533 B11.t512 0.324663
R7490 B11.n1534 B11.t513 0.324663
R7491 B11.n1535 B11.t514 0.324663
R7492 B11.n1536 B11.t515 0.324663
R7493 B11.n1537 B11.t516 0.324663
R7494 B11.n1538 B11.t517 0.324663
R7495 B11.n1539 B11.t518 0.324663
R7496 B11.n1540 B11.t519 0.324663
R7497 B11.n1541 B11.t520 0.324663
R7498 B11.n1542 B11.t521 0.324663
R7499 B11.n1543 B11.t522 0.324663
R7500 B11.n1544 B11.t523 0.324663
R7501 B11.n1545 B11.t524 0.324663
R7502 B11.n1546 B11.t525 0.324663
R7503 B11.n1547 B11.t526 0.324663
R7504 B11.n1548 B11.t527 0.324663
R7505 B11.n1549 B11.t528 0.324663
R7506 B11.n1550 B11.t529 0.324663
R7507 B11.n1551 B11.t530 0.324663
R7508 B11.n1552 B11.t531 0.324663
R7509 B11.n1553 B11.t532 0.324663
R7510 B11.n1554 B11.t533 0.324663
R7511 B11.n1555 B11.t534 0.324663
R7512 B11.n1556 B11.t535 0.324663
R7513 B11.n1557 B11.t536 0.324663
R7514 B11.n1558 B11.t537 0.324663
R7515 B11.n1559 B11.t538 0.324663
R7516 B11.n1560 B11.t539 0.324663
R7517 B11.n1561 B11.t540 0.324663
R7518 B11.n1562 B11.t541 0.324663
R7519 B11.n1563 B11.t542 0.324663
R7520 B11.n1564 B11.t543 0.324663
R7521 B11.n1565 B11.t544 0.324663
R7522 B11.n1566 B11.t545 0.324663
R7523 B11.n1567 B11.t546 0.324663
R7524 B11.n1568 B11.t547 0.324663
R7525 B11.n1569 B11.t548 0.324663
R7526 B11.n1570 B11.t549 0.324663
R7527 B11.n1571 B11.t550 0.324663
R7528 B11.n1572 B11.t551 0.324663
R7529 B11.n1573 B11.t552 0.324663
R7530 B11.n1574 B11.t553 0.324663
R7531 B11.n1575 B11.t554 0.324663
R7532 B11.n1576 B11.t555 0.324663
R7533 B11.n1577 B11.t556 0.324663
R7534 B11.n1578 B11.t557 0.324663
R7535 B11.n1579 B11.t558 0.324663
R7536 B11.n1580 B11.t559 0.324663
R7537 B11.n1581 B11.t560 0.324663
R7538 B11.n1582 B11.t561 0.324663
R7539 B11.n1583 B11.t562 0.324663
R7540 B11.n1584 B11.t563 0.324663
R7541 B11.n1585 B11.t564 0.324663
R7542 B11.n1586 B11.t565 0.324663
R7543 B11.n1587 B11.t566 0.324663
R7544 B11.n1589 B11.t568 0.324663
R7545 B11.n1590 B11.t569 0.324663
R7546 B11.n1591 B11.t570 0.324663
R7547 B11.n1592 B11.t571 0.324663
R7548 B11.n1593 B11.t572 0.324663
R7549 B11.n1594 B11.t573 0.324663
R7550 B11.n1595 B11.t574 0.324663
R7551 B11.n1596 B11.t575 0.324663
R7552 B11.n1597 B11.t576 0.324663
R7553 B11.n1598 B11.t577 0.324663
R7554 B11.n1599 B11.t578 0.324663
R7555 B11.n1600 B11.t579 0.324663
R7556 B11.n1601 B11.t580 0.324663
R7557 B11.n1602 B11.t581 0.324663
R7558 B11.n1603 B11.t582 0.324663
R7559 B11.n1604 B11.t583 0.324663
R7560 B11.n1605 B11.t584 0.324663
R7561 B11.n1606 B11.t585 0.324663
R7562 B11.n1607 B11.t586 0.324663
R7563 B11.n1608 B11.t587 0.324663
R7564 B11.n1609 B11.t588 0.324663
R7565 B11.n1610 B11.t589 0.324663
R7566 B11.n1611 B11.t590 0.324663
R7567 B11.n1612 B11.t591 0.324663
R7568 B11.n1613 B11.t592 0.324663
R7569 B11.n1614 B11.t593 0.324663
R7570 B11.n1615 B11.t594 0.324663
R7571 B11.n1616 B11.t595 0.324663
R7572 B11.n1617 B11.t596 0.324663
R7573 B11.n1618 B11.t597 0.324663
R7574 B11.n1619 B11.t598 0.324663
R7575 B11.n1620 B11.t599 0.324663
R7576 B11.n1621 B11.t600 0.324663
R7577 B11.n1622 B11.t601 0.324663
R7578 B11.n1623 B11.t602 0.324663
R7579 B11.n1624 B11.t603 0.324663
R7580 B11.n1625 B11.t604 0.324663
R7581 B11.n1626 B11.t605 0.324663
R7582 B11.n1627 B11.t606 0.324663
R7583 B11.n1628 B11.t607 0.324663
R7584 B11.n1629 B11.t608 0.324663
R7585 B11.n1630 B11.t609 0.324663
R7586 B11.n1631 B11.t610 0.324663
R7587 B11.n1632 B11.t611 0.324663
R7588 B11.n1633 B11.t612 0.324663
R7589 B11.n1634 B11.t613 0.324663
R7590 B11.n1635 B11.t614 0.324663
R7591 B11.n1636 B11.t615 0.324663
R7592 B11.n1637 B11.t616 0.324663
R7593 B11.n1638 B11.t617 0.324663
R7594 B11.n1639 B11.t618 0.324663
R7595 B11.n1640 B11.t619 0.324663
R7596 B11.n1641 B11.t620 0.324663
R7597 B11.n1642 B11.t621 0.324663
R7598 B11.n1643 B11.t622 0.324663
R7599 B11.n1644 B11.t623 0.324663
R7600 B11.n1645 B11.t624 0.324663
R7601 B11.n1646 B11.t625 0.324663
R7602 B11.n1647 B11.t626 0.324663
R7603 B11.n1648 B11.t627 0.324663
R7604 B11.n1649 B11.t628 0.324663
R7605 B11.n1650 B11.t629 0.324663
R7606 B11.n1652 B11.t631 0.324663
R7607 B11.n1653 B11.t632 0.324663
R7608 B11.n1654 B11.t633 0.324663
R7609 B11.n1655 B11.t634 0.324663
R7610 B11.n1656 B11.t635 0.324663
R7611 B11.n1657 B11.t636 0.324663
R7612 B11.n1658 B11.t637 0.324663
R7613 B11.n1659 B11.t638 0.324663
R7614 B11.n1660 B11.t639 0.324663
R7615 B11.n1661 B11.t640 0.324663
R7616 B11.n1662 B11.t641 0.324663
R7617 B11.n1663 B11.t642 0.324663
R7618 B11.n1664 B11.t643 0.324663
R7619 B11.n1665 B11.t644 0.324663
R7620 B11.n1666 B11.t645 0.324663
R7621 B11.n1667 B11.t646 0.324663
R7622 B11.n1668 B11.t647 0.324663
R7623 B11.n1669 B11.t648 0.324663
R7624 B11.n1670 B11.t649 0.324663
R7625 B11.n1671 B11.t650 0.324663
R7626 B11.n1672 B11.t651 0.324663
R7627 B11.n1673 B11.t652 0.324663
R7628 B11.n1674 B11.t653 0.324663
R7629 B11.n1675 B11.t654 0.324663
R7630 B11.n1676 B11.t655 0.324663
R7631 B11.n1677 B11.t656 0.324663
R7632 B11.n1678 B11.t657 0.324663
R7633 B11.n1679 B11.t658 0.324663
R7634 B11.n1680 B11.t659 0.324663
R7635 B11.n1681 B11.t660 0.324663
R7636 B11.n1682 B11.t661 0.324663
R7637 B11.n1683 B11.t662 0.324663
R7638 B11.n1684 B11.t663 0.324663
R7639 B11.n1685 B11.t664 0.324663
R7640 B11.n1686 B11.t665 0.324663
R7641 B11.n1687 B11.t666 0.324663
R7642 B11.n1688 B11.t667 0.324663
R7643 B11.n1689 B11.t668 0.324663
R7644 B11.n1690 B11.t669 0.324663
R7645 B11.n1691 B11.t670 0.324663
R7646 B11.n1692 B11.t671 0.324663
R7647 B11.n1693 B11.t672 0.324663
R7648 B11.n1694 B11.t673 0.324663
R7649 B11.n1695 B11.t674 0.324663
R7650 B11.n1696 B11.t675 0.324663
R7651 B11.n1697 B11.t676 0.324663
R7652 B11.n1698 B11.t677 0.324663
R7653 B11.n1699 B11.t678 0.324663
R7654 B11.n1700 B11.t679 0.324663
R7655 B11.n1701 B11.t680 0.324663
R7656 B11.n1702 B11.t681 0.324663
R7657 B11.n1703 B11.t682 0.324663
R7658 B11.n1704 B11.t683 0.324663
R7659 B11.n1705 B11.t684 0.324663
R7660 B11.n1706 B11.t685 0.324663
R7661 B11.n1707 B11.t686 0.324663
R7662 B11.n1708 B11.t687 0.324663
R7663 B11.n1709 B11.t688 0.324663
R7664 B11.n1710 B11.t689 0.324663
R7665 B11.n1711 B11.t690 0.324663
R7666 B11.n1712 B11.t691 0.324663
R7667 B11.n1713 B11.t692 0.324663
R7668 B11.n1715 B11.t694 0.324663
R7669 B11.n1716 B11.t695 0.324663
R7670 B11.n1717 B11.t696 0.324663
R7671 B11.n1718 B11.t697 0.324663
R7672 B11.n1719 B11.t698 0.324663
R7673 B11.n1720 B11.t699 0.324663
R7674 B11.n1721 B11.t700 0.324663
R7675 B11.n1722 B11.t701 0.324663
R7676 B11.n1723 B11.t702 0.324663
R7677 B11.n1724 B11.t703 0.324663
R7678 B11.n1725 B11.t704 0.324663
R7679 B11.n1726 B11.t705 0.324663
R7680 B11.n1727 B11.t706 0.324663
R7681 B11.n1728 B11.t707 0.324663
R7682 B11.n1729 B11.t708 0.324663
R7683 B11.n1730 B11.t709 0.324663
R7684 B11.n1731 B11.t710 0.324663
R7685 B11.n1732 B11.t711 0.324663
R7686 B11.n1733 B11.t712 0.324663
R7687 B11.n1734 B11.t713 0.324663
R7688 B11.n1735 B11.t714 0.324663
R7689 B11.n1736 B11.t715 0.324663
R7690 B11.n1737 B11.t716 0.324663
R7691 B11.n1738 B11.t717 0.324663
R7692 B11.n1739 B11.t718 0.324663
R7693 B11.n1740 B11.t719 0.324663
R7694 B11.n1741 B11.t720 0.324663
R7695 B11.n1742 B11.t721 0.324663
R7696 B11.n1743 B11.t722 0.324663
R7697 B11.n1744 B11.t723 0.324663
R7698 B11.n1745 B11.t724 0.324663
R7699 B11.n1746 B11.t725 0.324663
R7700 B11.n1747 B11.t726 0.324663
R7701 B11.n1748 B11.t727 0.324663
R7702 B11.n1749 B11.t728 0.324663
R7703 B11.n1750 B11.t729 0.324663
R7704 B11.n1751 B11.t730 0.324663
R7705 B11.n1752 B11.t731 0.324663
R7706 B11.n1753 B11.t732 0.324663
R7707 B11.n1754 B11.t733 0.324663
R7708 B11.n1755 B11.t734 0.324663
R7709 B11.n1756 B11.t735 0.324663
R7710 B11.n1757 B11.t736 0.324663
R7711 B11.n1758 B11.t737 0.324663
R7712 B11.n1759 B11.t738 0.324663
R7713 B11.n1760 B11.t739 0.324663
R7714 B11.n1761 B11.t740 0.324663
R7715 B11.n1762 B11.t741 0.324663
R7716 B11.n1763 B11.t742 0.324663
R7717 B11.n1764 B11.t743 0.324663
R7718 B11.n1765 B11.t744 0.324663
R7719 B11.n1766 B11.t745 0.324663
R7720 B11.n1767 B11.t746 0.324663
R7721 B11.n1768 B11.t747 0.324663
R7722 B11.n1769 B11.t748 0.324663
R7723 B11.n1770 B11.t749 0.324663
R7724 B11.n1771 B11.t750 0.324663
R7725 B11.n1772 B11.t751 0.324663
R7726 B11.n1773 B11.t752 0.324663
R7727 B11.n1774 B11.t753 0.324663
R7728 B11.n1775 B11.t754 0.324663
R7729 B11.n1776 B11.t755 0.324663
R7730 B11.n1778 B11.t757 0.324663
R7731 B11.n1779 B11.t758 0.324663
R7732 B11.n1780 B11.t759 0.324663
R7733 B11.n1781 B11.t760 0.324663
R7734 B11.n1782 B11.t761 0.324663
R7735 B11.n1783 B11.t762 0.324663
R7736 B11.n1784 B11.t763 0.324663
R7737 B11.n1785 B11.t764 0.324663
R7738 B11.n1786 B11.t765 0.324663
R7739 B11.n1787 B11.t766 0.324663
R7740 B11.n1788 B11.t767 0.324663
R7741 B11.n1789 B11.t768 0.324663
R7742 B11.n1790 B11.t769 0.324663
R7743 B11.n1791 B11.t770 0.324663
R7744 B11.n1792 B11.t771 0.324663
R7745 B11.n1793 B11.t772 0.324663
R7746 B11.n1794 B11.t773 0.324663
R7747 B11.n1795 B11.t774 0.324663
R7748 B11.n1796 B11.t775 0.324663
R7749 B11.n1797 B11.t776 0.324663
R7750 B11.n1798 B11.t777 0.324663
R7751 B11.n1799 B11.t778 0.324663
R7752 B11.n1800 B11.t779 0.324663
R7753 B11.n1801 B11.t780 0.324663
R7754 B11.n1802 B11.t781 0.324663
R7755 B11.n1803 B11.t782 0.324663
R7756 B11.n1804 B11.t783 0.324663
R7757 B11.n1805 B11.t784 0.324663
R7758 B11.n1806 B11.t785 0.324663
R7759 B11.n1807 B11.t786 0.324663
R7760 B11.n1808 B11.t787 0.324663
R7761 B11.n1809 B11.t788 0.324663
R7762 B11.n1810 B11.t789 0.324663
R7763 B11.n1811 B11.t790 0.324663
R7764 B11.n1812 B11.t791 0.324663
R7765 B11.n1813 B11.t792 0.324663
R7766 B11.n1814 B11.t793 0.324663
R7767 B11.n1815 B11.t794 0.324663
R7768 B11.n1816 B11.t795 0.324663
R7769 B11.n1817 B11.t796 0.324663
R7770 B11.n1818 B11.t797 0.324663
R7771 B11.n1819 B11.t798 0.324663
R7772 B11.n1820 B11.t799 0.324663
R7773 B11.n1821 B11.t800 0.324663
R7774 B11.n1822 B11.t801 0.324663
R7775 B11.n1823 B11.t802 0.324663
R7776 B11.n1824 B11.t803 0.324663
R7777 B11.n1825 B11.t804 0.324663
R7778 B11.n1826 B11.t805 0.324663
R7779 B11.n1827 B11.t806 0.324663
R7780 B11.n1828 B11.t807 0.324663
R7781 B11.n1829 B11.t808 0.324663
R7782 B11.n1830 B11.t809 0.324663
R7783 B11.n1831 B11.t810 0.324663
R7784 B11.n1832 B11.t811 0.324663
R7785 B11.n1833 B11.t812 0.324663
R7786 B11.n1834 B11.t813 0.324663
R7787 B11.n1835 B11.t814 0.324663
R7788 B11.n1836 B11.t815 0.324663
R7789 B11.n1837 B11.t816 0.324663
R7790 B11.n1838 B11.t817 0.324663
R7791 B11.n1839 B11.t818 0.324663
R7792 B11.n1841 B11.t820 0.324663
R7793 B11.n1842 B11.t821 0.324663
R7794 B11.n1843 B11.t822 0.324663
R7795 B11.n1844 B11.t823 0.324663
R7796 B11.n1845 B11.t824 0.324663
R7797 B11.n1846 B11.t825 0.324663
R7798 B11.n1847 B11.t826 0.324663
R7799 B11.n1848 B11.t827 0.324663
R7800 B11.n1849 B11.t828 0.324663
R7801 B11.n1850 B11.t829 0.324663
R7802 B11.n1851 B11.t830 0.324663
R7803 B11.n1852 B11.t831 0.324663
R7804 B11.n1853 B11.t832 0.324663
R7805 B11.n1854 B11.t833 0.324663
R7806 B11.n1855 B11.t834 0.324663
R7807 B11.n1856 B11.t835 0.324663
R7808 B11.n1857 B11.t836 0.324663
R7809 B11.n1858 B11.t837 0.324663
R7810 B11.n1859 B11.t838 0.324663
R7811 B11.n1860 B11.t839 0.324663
R7812 B11.n1861 B11.t840 0.324663
R7813 B11.n1862 B11.t841 0.324663
R7814 B11.n1863 B11.t842 0.324663
R7815 B11.n1864 B11.t843 0.324663
R7816 B11.n1865 B11.t844 0.324663
R7817 B11.n1866 B11.t845 0.324663
R7818 B11.n1867 B11.t846 0.324663
R7819 B11.n1868 B11.t847 0.324663
R7820 B11.n1869 B11.t848 0.324663
R7821 B11.n1870 B11.t849 0.324663
R7822 B11.n1871 B11.t850 0.324663
R7823 B11.n1872 B11.t851 0.324663
R7824 B11.n1873 B11.t852 0.324663
R7825 B11.n1874 B11.t853 0.324663
R7826 B11.n1875 B11.t854 0.324663
R7827 B11.n1876 B11.t855 0.324663
R7828 B11.n1877 B11.t856 0.324663
R7829 B11.n1878 B11.t857 0.324663
R7830 B11.n1879 B11.t858 0.324663
R7831 B11.n1880 B11.t859 0.324663
R7832 B11.n1881 B11.t860 0.324663
R7833 B11.n1882 B11.t861 0.324663
R7834 B11.n1883 B11.t862 0.324663
R7835 B11.n1884 B11.t863 0.324663
R7836 B11.n1885 B11.t864 0.324663
R7837 B11.n1886 B11.t865 0.324663
R7838 B11.n1887 B11.t866 0.324663
R7839 B11.n1888 B11.t867 0.324663
R7840 B11.n1889 B11.t868 0.324663
R7841 B11.n1890 B11.t869 0.324663
R7842 B11.n1891 B11.t870 0.324663
R7843 B11.n1892 B11.t871 0.324663
R7844 B11.n1893 B11.t872 0.324663
R7845 B11.n1894 B11.t873 0.324663
R7846 B11.n1895 B11.t874 0.324663
R7847 B11.n1896 B11.t875 0.324663
R7848 B11.n1897 B11.t876 0.324663
R7849 B11.n1898 B11.t877 0.324663
R7850 B11.n1899 B11.t878 0.324663
R7851 B11.n1900 B11.t879 0.324663
R7852 B11.n1901 B11.t880 0.324663
R7853 B11.n1902 B11.t881 0.324663
R7854 B11.n1904 B11.t883 0.324663
R7855 B11.n1905 B11.t884 0.324663
R7856 B11.n1906 B11.t885 0.324663
R7857 B11.n1907 B11.t886 0.324663
R7858 B11.n1908 B11.t887 0.324663
R7859 B11.n1909 B11.t888 0.324663
R7860 B11.n1910 B11.t889 0.324663
R7861 B11.n1911 B11.t890 0.324663
R7862 B11.n1912 B11.t891 0.324663
R7863 B11.n1913 B11.t892 0.324663
R7864 B11.n1914 B11.t893 0.324663
R7865 B11.n1915 B11.t894 0.324663
R7866 B11.n1916 B11.t895 0.324663
R7867 B11.n1917 B11.t896 0.324663
R7868 B11.n1918 B11.t897 0.324663
R7869 B11.n1919 B11.t898 0.324663
R7870 B11.n1920 B11.t899 0.324663
R7871 B11.n1921 B11.t900 0.324663
R7872 B11.n1922 B11.t901 0.324663
R7873 B11.n1923 B11.t902 0.324663
R7874 B11.n1924 B11.t903 0.324663
R7875 B11.n1925 B11.t904 0.324663
R7876 B11.n1926 B11.t905 0.324663
R7877 B11.n1927 B11.t906 0.324663
R7878 B11.n1928 B11.t907 0.324663
R7879 B11.n1929 B11.t908 0.324663
R7880 B11.n1930 B11.t909 0.324663
R7881 B11.n1931 B11.t910 0.324663
R7882 B11.n1932 B11.t911 0.324663
R7883 B11.n1933 B11.t912 0.324663
R7884 B11.n1934 B11.t913 0.324663
R7885 B11.n1935 B11.t914 0.324663
R7886 B11.n1936 B11.t915 0.324663
R7887 B11.n1937 B11.t916 0.324663
R7888 B11.n1938 B11.t917 0.324663
R7889 B11.n1939 B11.t918 0.324663
R7890 B11.n1940 B11.t919 0.324663
R7891 B11.n1941 B11.t920 0.324663
R7892 B11.n1942 B11.t921 0.324663
R7893 B11.n1943 B11.t922 0.324663
R7894 B11.n1944 B11.t923 0.324663
R7895 B11.n1945 B11.t924 0.324663
R7896 B11.n1946 B11.t925 0.324663
R7897 B11.n1947 B11.t926 0.324663
R7898 B11.n1948 B11.t927 0.324663
R7899 B11.n1949 B11.t928 0.324663
R7900 B11.n1950 B11.t929 0.324663
R7901 B11.n1951 B11.t930 0.324663
R7902 B11.n1952 B11.t931 0.324663
R7903 B11.n1953 B11.t932 0.324663
R7904 B11.n1954 B11.t933 0.324663
R7905 B11.n1955 B11.t934 0.324663
R7906 B11.n1956 B11.t935 0.324663
R7907 B11.n1957 B11.t936 0.324663
R7908 B11.n1958 B11.t937 0.324663
R7909 B11.n1959 B11.t938 0.324663
R7910 B11.n1960 B11.t939 0.324663
R7911 B11.n1961 B11.t940 0.324663
R7912 B11.n1962 B11.t941 0.324663
R7913 B11.n1963 B11.t942 0.324663
R7914 B11.n1964 B11.t943 0.324663
R7915 B11.n1965 B11.t944 0.324663
R7916 B11.n1967 B11.t946 0.324663
R7917 B11.n1968 B11.t947 0.324663
R7918 B11.n1969 B11.t948 0.324663
R7919 B11.n1970 B11.t949 0.324663
R7920 B11.n1971 B11.t950 0.324663
R7921 B11.n1972 B11.t951 0.324663
R7922 B11.n1973 B11.t952 0.324663
R7923 B11.n1974 B11.t953 0.324663
R7924 B11.n1975 B11.t954 0.324663
R7925 B11.n1976 B11.t955 0.324663
R7926 B11.n1977 B11.t956 0.324663
R7927 B11.n1978 B11.t957 0.324663
R7928 B11.n1979 B11.t958 0.324663
R7929 B11.n1980 B11.t959 0.324663
R7930 B11.n1981 B11.t960 0.324663
R7931 B11.n1982 B11.t961 0.324663
R7932 B11.n1983 B11.t962 0.324663
R7933 B11.n1984 B11.t963 0.324663
R7934 B11.n1985 B11.t964 0.324663
R7935 B11.n1986 B11.t965 0.324663
R7936 B11.n1987 B11.t966 0.324663
R7937 B11.n1988 B11.t967 0.324663
R7938 B11.n1989 B11.t968 0.324663
R7939 B11.n1990 B11.t969 0.324663
R7940 B11.n1991 B11.t970 0.324663
R7941 B11.n1992 B11.t971 0.324663
R7942 B11.n1993 B11.t972 0.324663
R7943 B11.n1994 B11.t973 0.324663
R7944 B11.n1995 B11.t974 0.324663
R7945 B11.n1996 B11.t975 0.324663
R7946 B11.n1997 B11.t976 0.324663
R7947 B11.n1998 B11.t977 0.324663
R7948 B11.n1999 B11.t978 0.324663
R7949 B11.n2000 B11.t979 0.324663
R7950 B11.n2001 B11.t980 0.324663
R7951 B11.n2002 B11.t981 0.324663
R7952 B11.n2003 B11.t982 0.324663
R7953 B11.n2004 B11.t983 0.324663
R7954 B11.n2005 B11.t984 0.324663
R7955 B11.n2006 B11.t985 0.324663
R7956 B11.n2007 B11.t986 0.324663
R7957 B11.n2008 B11.t987 0.324663
R7958 B11.n2009 B11.t988 0.324663
R7959 B11.n2010 B11.t989 0.324663
R7960 B11.n2011 B11.t990 0.324663
R7961 B11.n2012 B11.t991 0.324663
R7962 B11.n2013 B11.t992 0.324663
R7963 B11.n2014 B11.t993 0.324663
R7964 B11.n2015 B11.t994 0.324663
R7965 B11.n2016 B11.t995 0.324663
R7966 B11.n2017 B11.t996 0.324663
R7967 B11.n2018 B11.t997 0.324663
R7968 B11.n2019 B11.t998 0.324663
R7969 B11.n2020 B11.t999 0.324663
R7970 B11.n2021 B11.t1000 0.324663
R7971 B11.n2022 B11.t1001 0.324663
R7972 B11.n2023 B11.t1002 0.324663
R7973 B11.n2024 B11.t1003 0.324663
R7974 B11.n2025 B11.t1004 0.324663
R7975 B11.n2026 B11.t1005 0.324663
R7976 B11.n2027 B11.t1006 0.324663
R7977 B11.n2028 B11.t1007 0.324663
R7978 B11.n1 B11.n0 0.10925
R7979 B11.n2 B11.n1 0.10925
R7980 B11.n3 B11.n2 0.10925
R7981 B11.n4 B11.n3 0.10925
R7982 B11.n5 B11.n4 0.10925
R7983 B11.n6 B11.n5 0.10925
R7984 B11.n7 B11.n6 0.10925
R7985 B11.n8 B11.n7 0.10925
R7986 B11.n9 B11.n8 0.10925
R7987 B11.n10 B11.n9 0.10925
R7988 B11.n11 B11.n10 0.10925
R7989 B11.n12 B11.n11 0.10925
R7990 B11.n13 B11.n12 0.10925
R7991 B11.n14 B11.n13 0.10925
R7992 B11.n140 B11.n77 0.10925
R7993 B11.n203 B11.n140 0.10925
R7994 B11.n266 B11.n203 0.10925
R7995 B11.n329 B11.n266 0.10925
R7996 B11.n392 B11.n329 0.10925
R7997 B11.n455 B11.n392 0.10925
R7998 B11.n518 B11.n455 0.10925
R7999 B11.n581 B11.n518 0.10925
R8000 B11.n644 B11.n581 0.10925
R8001 B11.n707 B11.n644 0.10925
R8002 B11.n770 B11.n707 0.10925
R8003 B11.n833 B11.n770 0.10925
R8004 B11.n896 B11.n833 0.10925
R8005 B11.n959 B11.n896 0.10925
R8006 B11.n1022 B11.n959 0.10925
R8007 B11.n1210 B11.n1147 0.10925
R8008 B11.n1273 B11.n1210 0.10925
R8009 B11.n1336 B11.n1273 0.10925
R8010 B11.n1399 B11.n1336 0.10925
R8011 B11.n1462 B11.n1399 0.10925
R8012 B11.n1525 B11.n1462 0.10925
R8013 B11.n1588 B11.n1525 0.10925
R8014 B11.n1651 B11.n1588 0.10925
R8015 B11.n1714 B11.n1651 0.10925
R8016 B11.n1777 B11.n1714 0.10925
R8017 B11.n1840 B11.n1777 0.10925
R8018 B11.n1903 B11.n1840 0.10925
R8019 B11.n1966 B11.n1903 0.10925
R8020 B11.n2029 B11.n1966 0.10925
R8021 B11.n2031 B11.n2030 0.10925
R8022 B11.n2032 B11.n2031 0.10925
R8023 B11.n2033 B11.n2032 0.10925
R8024 B11.n2034 B11.n2033 0.10925
R8025 B11.n2035 B11.n2034 0.10925
R8026 B11.n2036 B11.n2035 0.10925
R8027 B11.n2037 B11.n2036 0.10925
R8028 B11.n2038 B11.n2037 0.10925
R8029 B11.n2039 B11.n2038 0.10925
R8030 B11.n2040 B11.n2039 0.10925
R8031 B11.n2041 B11.n2040 0.10925
R8032 B11.n2042 B11.n2041 0.10925
R8033 B11.n2043 B11.n2042 0.10925
R8034 B11.n2044 B11.n2043 0.10925
R8035 B11.n2045 B11.n2044 0.10925
R8036 B6 B6.n61 26.9755
R8037 B6 B6.n30 24.5188
R8038 B6.n30 B6.t0 5.39961
R8039 B6.n61 B6.n60 4.9039
R8040 B6.n61 B6.t63 1.74806
R8041 B6.n30 B6.n29 1.59545
R8042 B6.n0 B6.t62 1.02966
R8043 B6.n31 B6.t1 1.02966
R8044 B6.n1 B6.n0 0.7055
R8045 B6.n2 B6.n1 0.7055
R8046 B6.n3 B6.n2 0.7055
R8047 B6.n4 B6.n3 0.7055
R8048 B6.n5 B6.n4 0.7055
R8049 B6.n6 B6.n5 0.7055
R8050 B6.n7 B6.n6 0.7055
R8051 B6.n8 B6.n7 0.7055
R8052 B6.n9 B6.n8 0.7055
R8053 B6.n10 B6.n9 0.7055
R8054 B6.n11 B6.n10 0.7055
R8055 B6.n12 B6.n11 0.7055
R8056 B6.n13 B6.n12 0.7055
R8057 B6.n14 B6.n13 0.7055
R8058 B6.n15 B6.n14 0.7055
R8059 B6.n16 B6.n15 0.7055
R8060 B6.n17 B6.n16 0.7055
R8061 B6.n18 B6.n17 0.7055
R8062 B6.n19 B6.n18 0.7055
R8063 B6.n20 B6.n19 0.7055
R8064 B6.n21 B6.n20 0.7055
R8065 B6.n22 B6.n21 0.7055
R8066 B6.n23 B6.n22 0.7055
R8067 B6.n24 B6.n23 0.7055
R8068 B6.n25 B6.n24 0.7055
R8069 B6.n26 B6.n25 0.7055
R8070 B6.n27 B6.n26 0.7055
R8071 B6.n28 B6.n27 0.7055
R8072 B6.n29 B6.n28 0.7055
R8073 B6.n60 B6.n59 0.7055
R8074 B6.n59 B6.n58 0.7055
R8075 B6.n58 B6.n57 0.7055
R8076 B6.n57 B6.n56 0.7055
R8077 B6.n56 B6.n55 0.7055
R8078 B6.n55 B6.n54 0.7055
R8079 B6.n54 B6.n53 0.7055
R8080 B6.n53 B6.n52 0.7055
R8081 B6.n52 B6.n51 0.7055
R8082 B6.n51 B6.n50 0.7055
R8083 B6.n50 B6.n49 0.7055
R8084 B6.n49 B6.n48 0.7055
R8085 B6.n48 B6.n47 0.7055
R8086 B6.n47 B6.n46 0.7055
R8087 B6.n46 B6.n45 0.7055
R8088 B6.n45 B6.n44 0.7055
R8089 B6.n44 B6.n43 0.7055
R8090 B6.n43 B6.n42 0.7055
R8091 B6.n42 B6.n41 0.7055
R8092 B6.n41 B6.n40 0.7055
R8093 B6.n40 B6.n39 0.7055
R8094 B6.n39 B6.n38 0.7055
R8095 B6.n38 B6.n37 0.7055
R8096 B6.n37 B6.n36 0.7055
R8097 B6.n36 B6.n35 0.7055
R8098 B6.n35 B6.n34 0.7055
R8099 B6.n34 B6.n33 0.7055
R8100 B6.n33 B6.n32 0.7055
R8101 B6.n32 B6.n31 0.7055
R8102 B6.n29 B6.t32 0.324663
R8103 B6.n28 B6.t33 0.324663
R8104 B6.n27 B6.t34 0.324663
R8105 B6.n26 B6.t35 0.324663
R8106 B6.n25 B6.t36 0.324663
R8107 B6.n24 B6.t37 0.324663
R8108 B6.n23 B6.t38 0.324663
R8109 B6.n22 B6.t39 0.324663
R8110 B6.n21 B6.t40 0.324663
R8111 B6.n20 B6.t41 0.324663
R8112 B6.n19 B6.t42 0.324663
R8113 B6.n18 B6.t43 0.324663
R8114 B6.n17 B6.t44 0.324663
R8115 B6.n16 B6.t45 0.324663
R8116 B6.n15 B6.t46 0.324663
R8117 B6.n14 B6.t47 0.324663
R8118 B6.n13 B6.t48 0.324663
R8119 B6.n12 B6.t49 0.324663
R8120 B6.n11 B6.t50 0.324663
R8121 B6.n10 B6.t51 0.324663
R8122 B6.n9 B6.t52 0.324663
R8123 B6.n8 B6.t53 0.324663
R8124 B6.n7 B6.t54 0.324663
R8125 B6.n6 B6.t55 0.324663
R8126 B6.n5 B6.t56 0.324663
R8127 B6.n4 B6.t57 0.324663
R8128 B6.n3 B6.t58 0.324663
R8129 B6.n2 B6.t59 0.324663
R8130 B6.n1 B6.t60 0.324663
R8131 B6.n0 B6.t61 0.324663
R8132 B6.n31 B6.t2 0.324663
R8133 B6.n32 B6.t3 0.324663
R8134 B6.n33 B6.t4 0.324663
R8135 B6.n34 B6.t5 0.324663
R8136 B6.n35 B6.t6 0.324663
R8137 B6.n36 B6.t7 0.324663
R8138 B6.n37 B6.t8 0.324663
R8139 B6.n38 B6.t9 0.324663
R8140 B6.n39 B6.t10 0.324663
R8141 B6.n40 B6.t11 0.324663
R8142 B6.n41 B6.t12 0.324663
R8143 B6.n42 B6.t13 0.324663
R8144 B6.n43 B6.t14 0.324663
R8145 B6.n44 B6.t15 0.324663
R8146 B6.n45 B6.t16 0.324663
R8147 B6.n46 B6.t17 0.324663
R8148 B6.n47 B6.t18 0.324663
R8149 B6.n48 B6.t19 0.324663
R8150 B6.n49 B6.t20 0.324663
R8151 B6.n50 B6.t21 0.324663
R8152 B6.n51 B6.t22 0.324663
R8153 B6.n52 B6.t23 0.324663
R8154 B6.n53 B6.t24 0.324663
R8155 B6.n54 B6.t25 0.324663
R8156 B6.n55 B6.t26 0.324663
R8157 B6.n56 B6.t27 0.324663
R8158 B6.n57 B6.t28 0.324663
R8159 B6.n58 B6.t29 0.324663
R8160 B6.n59 B6.t30 0.324663
R8161 B6.n60 B6.t31 0.324663
R8162 TOP.t5246 TOP.n61 0.449304
R8163 TOP.n0 TOP.t1148 0.449304
R8164 TOP.n61 TOP.n60 0.407833
R8165 TOP.n60 TOP.n59 0.407833
R8166 TOP.n59 TOP.n58 0.407833
R8167 TOP.n58 TOP.n57 0.407833
R8168 TOP.n57 TOP.n56 0.407833
R8169 TOP.n56 TOP.n55 0.407833
R8170 TOP.n55 TOP.n54 0.407833
R8171 TOP.n54 TOP.n53 0.407833
R8172 TOP.n53 TOP.n52 0.407833
R8173 TOP.n52 TOP.n51 0.407833
R8174 TOP.n51 TOP.n50 0.407833
R8175 TOP.n50 TOP.n49 0.407833
R8176 TOP.n49 TOP.n48 0.407833
R8177 TOP.n48 TOP.n47 0.407833
R8178 TOP.n47 TOP.n46 0.407833
R8179 TOP.n46 TOP.n45 0.407833
R8180 TOP.n45 TOP.n44 0.407833
R8181 TOP.n44 TOP.n43 0.407833
R8182 TOP.n43 TOP.n42 0.407833
R8183 TOP.n42 TOP.n41 0.407833
R8184 TOP.n41 TOP.n40 0.407833
R8185 TOP.n40 TOP.n39 0.407833
R8186 TOP.n39 TOP.n38 0.407833
R8187 TOP.n38 TOP.n37 0.407833
R8188 TOP.n37 TOP.n36 0.407833
R8189 TOP.n36 TOP.n35 0.407833
R8190 TOP.n35 TOP.n34 0.407833
R8191 TOP.n34 TOP.n33 0.407833
R8192 TOP.n33 TOP.n32 0.407833
R8193 TOP.n32 TOP.n31 0.407833
R8194 TOP.n31 TOP.n30 0.407833
R8195 TOP.n30 TOP.n29 0.407833
R8196 TOP.n29 TOP.n28 0.407833
R8197 TOP.n28 TOP.n27 0.407833
R8198 TOP.n27 TOP.n26 0.407833
R8199 TOP.n26 TOP.n25 0.407833
R8200 TOP.n25 TOP.n24 0.407833
R8201 TOP.n24 TOP.n23 0.407833
R8202 TOP.n23 TOP.n22 0.407833
R8203 TOP.n22 TOP.n21 0.407833
R8204 TOP.n21 TOP.n20 0.407833
R8205 TOP.n20 TOP.n19 0.407833
R8206 TOP.n19 TOP.n18 0.407833
R8207 TOP.n18 TOP.n17 0.407833
R8208 TOP.n17 TOP.n16 0.407833
R8209 TOP.n16 TOP.n15 0.407833
R8210 TOP.n15 TOP.n14 0.407833
R8211 TOP.n14 TOP.n13 0.407833
R8212 TOP.n13 TOP.n12 0.407833
R8213 TOP.n12 TOP.n11 0.407833
R8214 TOP.n11 TOP.n10 0.407833
R8215 TOP.n10 TOP.n9 0.407833
R8216 TOP.n9 TOP.n8 0.407833
R8217 TOP.n8 TOP.n7 0.407833
R8218 TOP.n7 TOP.n6 0.407833
R8219 TOP.n6 TOP.n5 0.407833
R8220 TOP.n5 TOP.n4 0.407833
R8221 TOP.n4 TOP.n3 0.407833
R8222 TOP.n3 TOP.n2 0.407833
R8223 TOP.n2 TOP.n1 0.407833
R8224 TOP.n1 TOP.n0 0.407833
R8225 TOP.t4996 TOP.t4998 0.156982
R8226 TOP.t4998 TOP.t5000 0.156982
R8227 TOP.t5000 TOP.t5002 0.156982
R8228 TOP.t5002 TOP.t5004 0.156982
R8229 TOP.t5004 TOP.t5006 0.156982
R8230 TOP.t5006 TOP.t5008 0.156982
R8231 TOP.t5008 TOP.t5010 0.156982
R8232 TOP.t5010 TOP.t5012 0.156982
R8233 TOP.t5012 TOP.t5014 0.156982
R8234 TOP.t5014 TOP.t5016 0.156982
R8235 TOP.t5016 TOP.t5018 0.156982
R8236 TOP.t5018 TOP.t5020 0.156982
R8237 TOP.t5020 TOP.t5022 0.156982
R8238 TOP.t5022 TOP.t5024 0.156982
R8239 TOP.t5024 TOP.t5026 0.156982
R8240 TOP.t5026 TOP.t5028 0.156982
R8241 TOP.t5028 TOP.t5030 0.156982
R8242 TOP.t5030 TOP.t5032 0.156982
R8243 TOP.t5032 TOP.t5034 0.156982
R8244 TOP.t5034 TOP.t5036 0.156982
R8245 TOP.t5036 TOP.t5038 0.156982
R8246 TOP.t5038 TOP.t5040 0.156982
R8247 TOP.t5040 TOP.t5042 0.156982
R8248 TOP.t5042 TOP.t5044 0.156982
R8249 TOP.t5044 TOP.t5046 0.156982
R8250 TOP.t5046 TOP.t5048 0.156982
R8251 TOP.t5048 TOP.t5050 0.156982
R8252 TOP.t5050 TOP.t5052 0.156982
R8253 TOP.t5052 TOP.t5054 0.156982
R8254 TOP.t5054 TOP.t5056 0.156982
R8255 TOP.t5056 TOP.t5058 0.156982
R8256 TOP.t5058 TOP.t5060 0.156982
R8257 TOP.t5060 TOP.t5062 0.156982
R8258 TOP.t5062 TOP.t5064 0.156982
R8259 TOP.t5064 TOP.t5066 0.156982
R8260 TOP.t5066 TOP.t5068 0.156982
R8261 TOP.t5068 TOP.t5070 0.156982
R8262 TOP.t5070 TOP.t5072 0.156982
R8263 TOP.t5072 TOP.t5074 0.156982
R8264 TOP.t5074 TOP.t5076 0.156982
R8265 TOP.t5076 TOP.t5078 0.156982
R8266 TOP.t5078 TOP.t5080 0.156982
R8267 TOP.t5080 TOP.t5082 0.156982
R8268 TOP.t5082 TOP.t5084 0.156982
R8269 TOP.t5084 TOP.t5086 0.156982
R8270 TOP.t5086 TOP.t5088 0.156982
R8271 TOP.t5088 TOP.t5090 0.156982
R8272 TOP.t5090 TOP.t5092 0.156982
R8273 TOP.t5092 TOP.t5094 0.156982
R8274 TOP.t5094 TOP.t5096 0.156982
R8275 TOP.t5096 TOP.t5098 0.156982
R8276 TOP.t5098 TOP.t5100 0.156982
R8277 TOP.t5100 TOP.t5102 0.156982
R8278 TOP.t5102 TOP.t5104 0.156982
R8279 TOP.t5104 TOP.t5106 0.156982
R8280 TOP.t5106 TOP.t5108 0.156982
R8281 TOP.t5108 TOP.t5110 0.156982
R8282 TOP.t5110 TOP.t5112 0.156982
R8283 TOP.t5112 TOP.t5114 0.156982
R8284 TOP.t5114 TOP.t5116 0.156982
R8285 TOP.t5116 TOP.t5118 0.156982
R8286 TOP.t5118 TOP.t5246 0.156982
R8287 TOP.t8062 TOP.t4992 0.156982
R8288 TOP.t4992 TOP.t4990 0.156982
R8289 TOP.t4990 TOP.t4988 0.156982
R8290 TOP.t4988 TOP.t4986 0.156982
R8291 TOP.t4986 TOP.t4984 0.156982
R8292 TOP.t4984 TOP.t4982 0.156982
R8293 TOP.t4982 TOP.t4980 0.156982
R8294 TOP.t4980 TOP.t4978 0.156982
R8295 TOP.t4978 TOP.t4976 0.156982
R8296 TOP.t4976 TOP.t4974 0.156982
R8297 TOP.t4974 TOP.t4972 0.156982
R8298 TOP.t4972 TOP.t4970 0.156982
R8299 TOP.t4970 TOP.t4968 0.156982
R8300 TOP.t4968 TOP.t4966 0.156982
R8301 TOP.t4966 TOP.t4964 0.156982
R8302 TOP.t4964 TOP.t4962 0.156982
R8303 TOP.t4962 TOP.t4960 0.156982
R8304 TOP.t4960 TOP.t4958 0.156982
R8305 TOP.t4958 TOP.t4956 0.156982
R8306 TOP.t4956 TOP.t4954 0.156982
R8307 TOP.t4954 TOP.t4952 0.156982
R8308 TOP.t4952 TOP.t4950 0.156982
R8309 TOP.t4950 TOP.t4948 0.156982
R8310 TOP.t4948 TOP.t4946 0.156982
R8311 TOP.t4946 TOP.t4944 0.156982
R8312 TOP.t4944 TOP.t4942 0.156982
R8313 TOP.t4942 TOP.t4940 0.156982
R8314 TOP.t4940 TOP.t4938 0.156982
R8315 TOP.t4938 TOP.t4936 0.156982
R8316 TOP.t4936 TOP.t4934 0.156982
R8317 TOP.t4934 TOP.t4932 0.156982
R8318 TOP.t4932 TOP.t4930 0.156982
R8319 TOP.t4930 TOP.t4928 0.156982
R8320 TOP.t4928 TOP.t4926 0.156982
R8321 TOP.t4926 TOP.t4924 0.156982
R8322 TOP.t4924 TOP.t4922 0.156982
R8323 TOP.t4922 TOP.t4920 0.156982
R8324 TOP.t4920 TOP.t4918 0.156982
R8325 TOP.t4918 TOP.t4916 0.156982
R8326 TOP.t4916 TOP.t4914 0.156982
R8327 TOP.t4914 TOP.t4912 0.156982
R8328 TOP.t4912 TOP.t4910 0.156982
R8329 TOP.t4910 TOP.t4908 0.156982
R8330 TOP.t4908 TOP.t4906 0.156982
R8331 TOP.t4906 TOP.t4904 0.156982
R8332 TOP.t4904 TOP.t4902 0.156982
R8333 TOP.t4902 TOP.t4900 0.156982
R8334 TOP.t4900 TOP.t4898 0.156982
R8335 TOP.t4898 TOP.t4896 0.156982
R8336 TOP.t4896 TOP.t4894 0.156982
R8337 TOP.t4894 TOP.t4892 0.156982
R8338 TOP.t4892 TOP.t4890 0.156982
R8339 TOP.t4890 TOP.t4888 0.156982
R8340 TOP.t4888 TOP.t4886 0.156982
R8341 TOP.t4886 TOP.t4884 0.156982
R8342 TOP.t4884 TOP.t4882 0.156982
R8343 TOP.t4882 TOP.t4880 0.156982
R8344 TOP.t4880 TOP.t4878 0.156982
R8345 TOP.t4878 TOP.t4876 0.156982
R8346 TOP.t4876 TOP.t4874 0.156982
R8347 TOP.t4874 TOP.t4872 0.156982
R8348 TOP.t4872 TOP.t4870 0.156982
R8349 TOP.t4870 TOP.t4868 0.156982
R8350 TOP.t7806 TOP.t4866 0.156982
R8351 TOP.t4866 TOP.t4864 0.156982
R8352 TOP.t4864 TOP.t4862 0.156982
R8353 TOP.t4862 TOP.t4860 0.156982
R8354 TOP.t4860 TOP.t4858 0.156982
R8355 TOP.t4858 TOP.t4856 0.156982
R8356 TOP.t4856 TOP.t4854 0.156982
R8357 TOP.t4854 TOP.t4852 0.156982
R8358 TOP.t4852 TOP.t4850 0.156982
R8359 TOP.t4850 TOP.t4848 0.156982
R8360 TOP.t4848 TOP.t4846 0.156982
R8361 TOP.t4846 TOP.t4844 0.156982
R8362 TOP.t4844 TOP.t4842 0.156982
R8363 TOP.t4842 TOP.t4840 0.156982
R8364 TOP.t4840 TOP.t4838 0.156982
R8365 TOP.t4838 TOP.t4836 0.156982
R8366 TOP.t4836 TOP.t4834 0.156982
R8367 TOP.t4834 TOP.t4832 0.156982
R8368 TOP.t4832 TOP.t4830 0.156982
R8369 TOP.t4830 TOP.t4828 0.156982
R8370 TOP.t4828 TOP.t4826 0.156982
R8371 TOP.t4826 TOP.t4824 0.156982
R8372 TOP.t4824 TOP.t4822 0.156982
R8373 TOP.t4822 TOP.t4820 0.156982
R8374 TOP.t4820 TOP.t4818 0.156982
R8375 TOP.t4818 TOP.t4816 0.156982
R8376 TOP.t4816 TOP.t4814 0.156982
R8377 TOP.t4814 TOP.t4812 0.156982
R8378 TOP.t4812 TOP.t4810 0.156982
R8379 TOP.t4810 TOP.t4808 0.156982
R8380 TOP.t4808 TOP.t4806 0.156982
R8381 TOP.t4806 TOP.t4804 0.156982
R8382 TOP.t4804 TOP.t4802 0.156982
R8383 TOP.t4802 TOP.t4800 0.156982
R8384 TOP.t4800 TOP.t4798 0.156982
R8385 TOP.t4798 TOP.t4796 0.156982
R8386 TOP.t4796 TOP.t4794 0.156982
R8387 TOP.t4794 TOP.t4792 0.156982
R8388 TOP.t4792 TOP.t4790 0.156982
R8389 TOP.t4790 TOP.t4788 0.156982
R8390 TOP.t4788 TOP.t4786 0.156982
R8391 TOP.t4786 TOP.t4784 0.156982
R8392 TOP.t4784 TOP.t4782 0.156982
R8393 TOP.t4782 TOP.t4780 0.156982
R8394 TOP.t4780 TOP.t4778 0.156982
R8395 TOP.t4778 TOP.t4776 0.156982
R8396 TOP.t4776 TOP.t4774 0.156982
R8397 TOP.t4774 TOP.t4772 0.156982
R8398 TOP.t4772 TOP.t4770 0.156982
R8399 TOP.t4770 TOP.t4768 0.156982
R8400 TOP.t4768 TOP.t4766 0.156982
R8401 TOP.t4766 TOP.t4764 0.156982
R8402 TOP.t4764 TOP.t4762 0.156982
R8403 TOP.t4762 TOP.t4760 0.156982
R8404 TOP.t4760 TOP.t4758 0.156982
R8405 TOP.t4758 TOP.t4756 0.156982
R8406 TOP.t4756 TOP.t4754 0.156982
R8407 TOP.t4754 TOP.t4752 0.156982
R8408 TOP.t4752 TOP.t4750 0.156982
R8409 TOP.t4750 TOP.t4748 0.156982
R8410 TOP.t4748 TOP.t4746 0.156982
R8411 TOP.t4746 TOP.t4744 0.156982
R8412 TOP.t4744 TOP.t4742 0.156982
R8413 TOP.t7804 TOP.t4740 0.156982
R8414 TOP.t4740 TOP.t4738 0.156982
R8415 TOP.t4738 TOP.t4736 0.156982
R8416 TOP.t4736 TOP.t4734 0.156982
R8417 TOP.t4734 TOP.t4732 0.156982
R8418 TOP.t4732 TOP.t4730 0.156982
R8419 TOP.t4730 TOP.t4728 0.156982
R8420 TOP.t4728 TOP.t4726 0.156982
R8421 TOP.t4726 TOP.t4724 0.156982
R8422 TOP.t4724 TOP.t4722 0.156982
R8423 TOP.t4722 TOP.t4720 0.156982
R8424 TOP.t4720 TOP.t4718 0.156982
R8425 TOP.t4718 TOP.t4716 0.156982
R8426 TOP.t4716 TOP.t4714 0.156982
R8427 TOP.t4714 TOP.t4712 0.156982
R8428 TOP.t4712 TOP.t4710 0.156982
R8429 TOP.t4710 TOP.t4708 0.156982
R8430 TOP.t4708 TOP.t4706 0.156982
R8431 TOP.t4706 TOP.t4704 0.156982
R8432 TOP.t4704 TOP.t4702 0.156982
R8433 TOP.t4702 TOP.t4700 0.156982
R8434 TOP.t4700 TOP.t4698 0.156982
R8435 TOP.t4698 TOP.t4696 0.156982
R8436 TOP.t4696 TOP.t4694 0.156982
R8437 TOP.t4694 TOP.t4692 0.156982
R8438 TOP.t4692 TOP.t4690 0.156982
R8439 TOP.t4690 TOP.t4688 0.156982
R8440 TOP.t4688 TOP.t4686 0.156982
R8441 TOP.t4686 TOP.t4684 0.156982
R8442 TOP.t4684 TOP.t4682 0.156982
R8443 TOP.t4682 TOP.t4680 0.156982
R8444 TOP.t4680 TOP.t4678 0.156982
R8445 TOP.t4678 TOP.t4676 0.156982
R8446 TOP.t4676 TOP.t4674 0.156982
R8447 TOP.t4674 TOP.t4672 0.156982
R8448 TOP.t4672 TOP.t4670 0.156982
R8449 TOP.t4670 TOP.t4668 0.156982
R8450 TOP.t4668 TOP.t4666 0.156982
R8451 TOP.t4666 TOP.t4664 0.156982
R8452 TOP.t4664 TOP.t4662 0.156982
R8453 TOP.t4662 TOP.t4660 0.156982
R8454 TOP.t4660 TOP.t4658 0.156982
R8455 TOP.t4658 TOP.t4656 0.156982
R8456 TOP.t4656 TOP.t4654 0.156982
R8457 TOP.t4654 TOP.t4652 0.156982
R8458 TOP.t4652 TOP.t4650 0.156982
R8459 TOP.t4650 TOP.t4648 0.156982
R8460 TOP.t4648 TOP.t4646 0.156982
R8461 TOP.t4646 TOP.t4644 0.156982
R8462 TOP.t4644 TOP.t4642 0.156982
R8463 TOP.t4642 TOP.t4640 0.156982
R8464 TOP.t4640 TOP.t4638 0.156982
R8465 TOP.t4638 TOP.t4636 0.156982
R8466 TOP.t4636 TOP.t4634 0.156982
R8467 TOP.t4634 TOP.t4632 0.156982
R8468 TOP.t4632 TOP.t4630 0.156982
R8469 TOP.t4630 TOP.t4628 0.156982
R8470 TOP.t4628 TOP.t4626 0.156982
R8471 TOP.t4626 TOP.t4624 0.156982
R8472 TOP.t4624 TOP.t4622 0.156982
R8473 TOP.t4622 TOP.t4620 0.156982
R8474 TOP.t4620 TOP.t4618 0.156982
R8475 TOP.t4618 TOP.t4616 0.156982
R8476 TOP.t1022 TOP.t4614 0.156982
R8477 TOP.t4614 TOP.t4612 0.156982
R8478 TOP.t4612 TOP.t4610 0.156982
R8479 TOP.t4610 TOP.t4608 0.156982
R8480 TOP.t4608 TOP.t4606 0.156982
R8481 TOP.t4606 TOP.t4604 0.156982
R8482 TOP.t4604 TOP.t4602 0.156982
R8483 TOP.t4602 TOP.t4600 0.156982
R8484 TOP.t4600 TOP.t4598 0.156982
R8485 TOP.t4598 TOP.t4596 0.156982
R8486 TOP.t4596 TOP.t4594 0.156982
R8487 TOP.t4594 TOP.t4592 0.156982
R8488 TOP.t4592 TOP.t4590 0.156982
R8489 TOP.t4590 TOP.t4588 0.156982
R8490 TOP.t4588 TOP.t4586 0.156982
R8491 TOP.t4586 TOP.t4584 0.156982
R8492 TOP.t4584 TOP.t4582 0.156982
R8493 TOP.t4582 TOP.t4580 0.156982
R8494 TOP.t4580 TOP.t4578 0.156982
R8495 TOP.t4578 TOP.t4576 0.156982
R8496 TOP.t4576 TOP.t4574 0.156982
R8497 TOP.t4574 TOP.t4572 0.156982
R8498 TOP.t4572 TOP.t4570 0.156982
R8499 TOP.t4570 TOP.t4568 0.156982
R8500 TOP.t4568 TOP.t4566 0.156982
R8501 TOP.t4566 TOP.t4564 0.156982
R8502 TOP.t4564 TOP.t4562 0.156982
R8503 TOP.t4562 TOP.t4560 0.156982
R8504 TOP.t4560 TOP.t4558 0.156982
R8505 TOP.t4558 TOP.t4556 0.156982
R8506 TOP.t4556 TOP.t4554 0.156982
R8507 TOP.t4554 TOP.t4552 0.156982
R8508 TOP.t4552 TOP.t4550 0.156982
R8509 TOP.t4550 TOP.t4548 0.156982
R8510 TOP.t4548 TOP.t4546 0.156982
R8511 TOP.t4546 TOP.t4544 0.156982
R8512 TOP.t4544 TOP.t4542 0.156982
R8513 TOP.t4542 TOP.t4540 0.156982
R8514 TOP.t4540 TOP.t4538 0.156982
R8515 TOP.t4538 TOP.t4536 0.156982
R8516 TOP.t4536 TOP.t4534 0.156982
R8517 TOP.t4534 TOP.t4532 0.156982
R8518 TOP.t4532 TOP.t4530 0.156982
R8519 TOP.t4530 TOP.t4528 0.156982
R8520 TOP.t4528 TOP.t4526 0.156982
R8521 TOP.t4526 TOP.t4524 0.156982
R8522 TOP.t4524 TOP.t4522 0.156982
R8523 TOP.t4522 TOP.t4520 0.156982
R8524 TOP.t4520 TOP.t4518 0.156982
R8525 TOP.t4518 TOP.t4516 0.156982
R8526 TOP.t4516 TOP.t4514 0.156982
R8527 TOP.t4514 TOP.t4512 0.156982
R8528 TOP.t4512 TOP.t4510 0.156982
R8529 TOP.t4510 TOP.t4508 0.156982
R8530 TOP.t4508 TOP.t4506 0.156982
R8531 TOP.t4506 TOP.t4504 0.156982
R8532 TOP.t4504 TOP.t4502 0.156982
R8533 TOP.t4502 TOP.t4500 0.156982
R8534 TOP.t4500 TOP.t4498 0.156982
R8535 TOP.t4498 TOP.t4496 0.156982
R8536 TOP.t4496 TOP.t4494 0.156982
R8537 TOP.t4494 TOP.t4492 0.156982
R8538 TOP.t4492 TOP.t4490 0.156982
R8539 TOP.t1020 TOP.t4488 0.156982
R8540 TOP.t4488 TOP.t4486 0.156982
R8541 TOP.t4486 TOP.t4484 0.156982
R8542 TOP.t4484 TOP.t4482 0.156982
R8543 TOP.t4482 TOP.t4480 0.156982
R8544 TOP.t4480 TOP.t4478 0.156982
R8545 TOP.t4478 TOP.t4476 0.156982
R8546 TOP.t4476 TOP.t4474 0.156982
R8547 TOP.t4474 TOP.t4472 0.156982
R8548 TOP.t4472 TOP.t4470 0.156982
R8549 TOP.t4470 TOP.t4468 0.156982
R8550 TOP.t4468 TOP.t4466 0.156982
R8551 TOP.t4466 TOP.t4464 0.156982
R8552 TOP.t4464 TOP.t4462 0.156982
R8553 TOP.t4462 TOP.t4460 0.156982
R8554 TOP.t4460 TOP.t4458 0.156982
R8555 TOP.t4458 TOP.t4456 0.156982
R8556 TOP.t4456 TOP.t4454 0.156982
R8557 TOP.t4454 TOP.t4452 0.156982
R8558 TOP.t4452 TOP.t4450 0.156982
R8559 TOP.t4450 TOP.t4448 0.156982
R8560 TOP.t4448 TOP.t4446 0.156982
R8561 TOP.t4446 TOP.t4444 0.156982
R8562 TOP.t4444 TOP.t4442 0.156982
R8563 TOP.t4442 TOP.t4440 0.156982
R8564 TOP.t4440 TOP.t4438 0.156982
R8565 TOP.t4438 TOP.t4436 0.156982
R8566 TOP.t4436 TOP.t4434 0.156982
R8567 TOP.t4434 TOP.t4432 0.156982
R8568 TOP.t4432 TOP.t4430 0.156982
R8569 TOP.t4430 TOP.t4428 0.156982
R8570 TOP.t4428 TOP.t4426 0.156982
R8571 TOP.t4426 TOP.t4424 0.156982
R8572 TOP.t4424 TOP.t4422 0.156982
R8573 TOP.t4422 TOP.t4420 0.156982
R8574 TOP.t4420 TOP.t4418 0.156982
R8575 TOP.t4418 TOP.t4416 0.156982
R8576 TOP.t4416 TOP.t4414 0.156982
R8577 TOP.t4414 TOP.t4412 0.156982
R8578 TOP.t4412 TOP.t4410 0.156982
R8579 TOP.t4410 TOP.t4408 0.156982
R8580 TOP.t4408 TOP.t4406 0.156982
R8581 TOP.t4406 TOP.t4404 0.156982
R8582 TOP.t4404 TOP.t4402 0.156982
R8583 TOP.t4402 TOP.t4400 0.156982
R8584 TOP.t4400 TOP.t4398 0.156982
R8585 TOP.t4398 TOP.t4396 0.156982
R8586 TOP.t4396 TOP.t4394 0.156982
R8587 TOP.t4394 TOP.t4392 0.156982
R8588 TOP.t4392 TOP.t4390 0.156982
R8589 TOP.t4390 TOP.t4388 0.156982
R8590 TOP.t4388 TOP.t4386 0.156982
R8591 TOP.t4386 TOP.t4384 0.156982
R8592 TOP.t4384 TOP.t4382 0.156982
R8593 TOP.t4382 TOP.t4380 0.156982
R8594 TOP.t4380 TOP.t4378 0.156982
R8595 TOP.t4378 TOP.t4376 0.156982
R8596 TOP.t4376 TOP.t4374 0.156982
R8597 TOP.t4374 TOP.t4372 0.156982
R8598 TOP.t4372 TOP.t4370 0.156982
R8599 TOP.t4370 TOP.t4368 0.156982
R8600 TOP.t4368 TOP.t4366 0.156982
R8601 TOP.t4366 TOP.t4364 0.156982
R8602 TOP.t1018 TOP.t4362 0.156982
R8603 TOP.t4362 TOP.t4360 0.156982
R8604 TOP.t4360 TOP.t4358 0.156982
R8605 TOP.t4358 TOP.t4356 0.156982
R8606 TOP.t4356 TOP.t4354 0.156982
R8607 TOP.t4354 TOP.t4352 0.156982
R8608 TOP.t4352 TOP.t4350 0.156982
R8609 TOP.t4350 TOP.t4348 0.156982
R8610 TOP.t4348 TOP.t4346 0.156982
R8611 TOP.t4346 TOP.t4344 0.156982
R8612 TOP.t4344 TOP.t4342 0.156982
R8613 TOP.t4342 TOP.t4340 0.156982
R8614 TOP.t4340 TOP.t4338 0.156982
R8615 TOP.t4338 TOP.t4336 0.156982
R8616 TOP.t4336 TOP.t4334 0.156982
R8617 TOP.t4334 TOP.t4332 0.156982
R8618 TOP.t4332 TOP.t4330 0.156982
R8619 TOP.t4330 TOP.t4328 0.156982
R8620 TOP.t4328 TOP.t4326 0.156982
R8621 TOP.t4326 TOP.t4324 0.156982
R8622 TOP.t4324 TOP.t4322 0.156982
R8623 TOP.t4322 TOP.t4320 0.156982
R8624 TOP.t4320 TOP.t4318 0.156982
R8625 TOP.t4318 TOP.t4316 0.156982
R8626 TOP.t4316 TOP.t4314 0.156982
R8627 TOP.t4314 TOP.t4312 0.156982
R8628 TOP.t4312 TOP.t4310 0.156982
R8629 TOP.t4310 TOP.t4308 0.156982
R8630 TOP.t4308 TOP.t4306 0.156982
R8631 TOP.t4306 TOP.t4304 0.156982
R8632 TOP.t4304 TOP.t4302 0.156982
R8633 TOP.t4302 TOP.t4300 0.156982
R8634 TOP.t4300 TOP.t4298 0.156982
R8635 TOP.t4298 TOP.t4296 0.156982
R8636 TOP.t4296 TOP.t4294 0.156982
R8637 TOP.t4294 TOP.t4292 0.156982
R8638 TOP.t4292 TOP.t4290 0.156982
R8639 TOP.t4290 TOP.t4288 0.156982
R8640 TOP.t4288 TOP.t4286 0.156982
R8641 TOP.t4286 TOP.t4284 0.156982
R8642 TOP.t4284 TOP.t4282 0.156982
R8643 TOP.t4282 TOP.t4280 0.156982
R8644 TOP.t4280 TOP.t4278 0.156982
R8645 TOP.t4278 TOP.t4276 0.156982
R8646 TOP.t4276 TOP.t4274 0.156982
R8647 TOP.t4274 TOP.t4272 0.156982
R8648 TOP.t4272 TOP.t4270 0.156982
R8649 TOP.t4270 TOP.t4268 0.156982
R8650 TOP.t4268 TOP.t4266 0.156982
R8651 TOP.t4266 TOP.t4264 0.156982
R8652 TOP.t4264 TOP.t4262 0.156982
R8653 TOP.t4262 TOP.t4260 0.156982
R8654 TOP.t4260 TOP.t4258 0.156982
R8655 TOP.t4258 TOP.t4256 0.156982
R8656 TOP.t4256 TOP.t4254 0.156982
R8657 TOP.t4254 TOP.t4252 0.156982
R8658 TOP.t4252 TOP.t4250 0.156982
R8659 TOP.t4250 TOP.t4248 0.156982
R8660 TOP.t4248 TOP.t4246 0.156982
R8661 TOP.t4246 TOP.t4244 0.156982
R8662 TOP.t4244 TOP.t4242 0.156982
R8663 TOP.t4242 TOP.t4240 0.156982
R8664 TOP.t4240 TOP.t4238 0.156982
R8665 TOP.t1016 TOP.t4236 0.156982
R8666 TOP.t4236 TOP.t4234 0.156982
R8667 TOP.t4234 TOP.t4232 0.156982
R8668 TOP.t4232 TOP.t4230 0.156982
R8669 TOP.t4230 TOP.t4228 0.156982
R8670 TOP.t4228 TOP.t4226 0.156982
R8671 TOP.t4226 TOP.t4224 0.156982
R8672 TOP.t4224 TOP.t4222 0.156982
R8673 TOP.t4222 TOP.t4220 0.156982
R8674 TOP.t4220 TOP.t4218 0.156982
R8675 TOP.t4218 TOP.t4216 0.156982
R8676 TOP.t4216 TOP.t4214 0.156982
R8677 TOP.t4214 TOP.t4212 0.156982
R8678 TOP.t4212 TOP.t4210 0.156982
R8679 TOP.t4210 TOP.t4208 0.156982
R8680 TOP.t4208 TOP.t4206 0.156982
R8681 TOP.t4206 TOP.t4204 0.156982
R8682 TOP.t4204 TOP.t4202 0.156982
R8683 TOP.t4202 TOP.t4200 0.156982
R8684 TOP.t4200 TOP.t4198 0.156982
R8685 TOP.t4198 TOP.t4196 0.156982
R8686 TOP.t4196 TOP.t4194 0.156982
R8687 TOP.t4194 TOP.t4192 0.156982
R8688 TOP.t4192 TOP.t4190 0.156982
R8689 TOP.t4190 TOP.t4188 0.156982
R8690 TOP.t4188 TOP.t4186 0.156982
R8691 TOP.t4186 TOP.t4184 0.156982
R8692 TOP.t4184 TOP.t4182 0.156982
R8693 TOP.t4182 TOP.t4180 0.156982
R8694 TOP.t4180 TOP.t4178 0.156982
R8695 TOP.t4178 TOP.t4176 0.156982
R8696 TOP.t4176 TOP.t4174 0.156982
R8697 TOP.t4174 TOP.t4172 0.156982
R8698 TOP.t4172 TOP.t4170 0.156982
R8699 TOP.t4170 TOP.t4168 0.156982
R8700 TOP.t4168 TOP.t4166 0.156982
R8701 TOP.t4166 TOP.t4164 0.156982
R8702 TOP.t4164 TOP.t4162 0.156982
R8703 TOP.t4162 TOP.t4160 0.156982
R8704 TOP.t4160 TOP.t4158 0.156982
R8705 TOP.t4158 TOP.t4156 0.156982
R8706 TOP.t4156 TOP.t4154 0.156982
R8707 TOP.t4154 TOP.t4152 0.156982
R8708 TOP.t4152 TOP.t4150 0.156982
R8709 TOP.t4150 TOP.t4148 0.156982
R8710 TOP.t4148 TOP.t4146 0.156982
R8711 TOP.t4146 TOP.t4144 0.156982
R8712 TOP.t4144 TOP.t4142 0.156982
R8713 TOP.t4142 TOP.t4140 0.156982
R8714 TOP.t4140 TOP.t4138 0.156982
R8715 TOP.t4138 TOP.t4136 0.156982
R8716 TOP.t4136 TOP.t4134 0.156982
R8717 TOP.t4134 TOP.t4132 0.156982
R8718 TOP.t4132 TOP.t4130 0.156982
R8719 TOP.t4130 TOP.t4128 0.156982
R8720 TOP.t4128 TOP.t4126 0.156982
R8721 TOP.t4126 TOP.t4124 0.156982
R8722 TOP.t4124 TOP.t4122 0.156982
R8723 TOP.t4122 TOP.t4120 0.156982
R8724 TOP.t4120 TOP.t4118 0.156982
R8725 TOP.t4118 TOP.t4116 0.156982
R8726 TOP.t4116 TOP.t4114 0.156982
R8727 TOP.t4114 TOP.t4112 0.156982
R8728 TOP.t7294 TOP.t4110 0.156982
R8729 TOP.t4110 TOP.t4108 0.156982
R8730 TOP.t4108 TOP.t4106 0.156982
R8731 TOP.t4106 TOP.t4104 0.156982
R8732 TOP.t4104 TOP.t4102 0.156982
R8733 TOP.t4102 TOP.t4100 0.156982
R8734 TOP.t4100 TOP.t4098 0.156982
R8735 TOP.t4098 TOP.t4096 0.156982
R8736 TOP.t4096 TOP.t4094 0.156982
R8737 TOP.t4094 TOP.t4092 0.156982
R8738 TOP.t4092 TOP.t4090 0.156982
R8739 TOP.t4090 TOP.t4088 0.156982
R8740 TOP.t4088 TOP.t4086 0.156982
R8741 TOP.t4086 TOP.t4084 0.156982
R8742 TOP.t4084 TOP.t4082 0.156982
R8743 TOP.t4082 TOP.t4080 0.156982
R8744 TOP.t4080 TOP.t4078 0.156982
R8745 TOP.t4078 TOP.t4076 0.156982
R8746 TOP.t4076 TOP.t4074 0.156982
R8747 TOP.t4074 TOP.t4072 0.156982
R8748 TOP.t4072 TOP.t4070 0.156982
R8749 TOP.t4070 TOP.t4068 0.156982
R8750 TOP.t4068 TOP.t4066 0.156982
R8751 TOP.t4066 TOP.t4064 0.156982
R8752 TOP.t4064 TOP.t4062 0.156982
R8753 TOP.t4062 TOP.t4060 0.156982
R8754 TOP.t4060 TOP.t4058 0.156982
R8755 TOP.t4058 TOP.t4056 0.156982
R8756 TOP.t4056 TOP.t4054 0.156982
R8757 TOP.t4054 TOP.t4052 0.156982
R8758 TOP.t4052 TOP.t4050 0.156982
R8759 TOP.t4050 TOP.t4048 0.156982
R8760 TOP.t4048 TOP.t4046 0.156982
R8761 TOP.t4046 TOP.t4044 0.156982
R8762 TOP.t4044 TOP.t4042 0.156982
R8763 TOP.t4042 TOP.t4040 0.156982
R8764 TOP.t4040 TOP.t4038 0.156982
R8765 TOP.t4038 TOP.t4036 0.156982
R8766 TOP.t4036 TOP.t4034 0.156982
R8767 TOP.t4034 TOP.t4032 0.156982
R8768 TOP.t4032 TOP.t4030 0.156982
R8769 TOP.t4030 TOP.t4028 0.156982
R8770 TOP.t4028 TOP.t4026 0.156982
R8771 TOP.t4026 TOP.t4024 0.156982
R8772 TOP.t4024 TOP.t4022 0.156982
R8773 TOP.t4022 TOP.t4020 0.156982
R8774 TOP.t4020 TOP.t4018 0.156982
R8775 TOP.t4018 TOP.t4016 0.156982
R8776 TOP.t4016 TOP.t4014 0.156982
R8777 TOP.t4014 TOP.t4012 0.156982
R8778 TOP.t4012 TOP.t4010 0.156982
R8779 TOP.t4010 TOP.t4008 0.156982
R8780 TOP.t4008 TOP.t4006 0.156982
R8781 TOP.t4006 TOP.t4004 0.156982
R8782 TOP.t4004 TOP.t4002 0.156982
R8783 TOP.t4002 TOP.t4000 0.156982
R8784 TOP.t4000 TOP.t3998 0.156982
R8785 TOP.t3998 TOP.t3996 0.156982
R8786 TOP.t3996 TOP.t3994 0.156982
R8787 TOP.t3994 TOP.t3992 0.156982
R8788 TOP.t3992 TOP.t3990 0.156982
R8789 TOP.t3990 TOP.t3988 0.156982
R8790 TOP.t3988 TOP.t3986 0.156982
R8791 TOP.t7292 TOP.t3984 0.156982
R8792 TOP.t3984 TOP.t3982 0.156982
R8793 TOP.t3982 TOP.t3980 0.156982
R8794 TOP.t3980 TOP.t3978 0.156982
R8795 TOP.t3978 TOP.t3976 0.156982
R8796 TOP.t3976 TOP.t3974 0.156982
R8797 TOP.t3974 TOP.t3972 0.156982
R8798 TOP.t3972 TOP.t3970 0.156982
R8799 TOP.t3970 TOP.t3968 0.156982
R8800 TOP.t3968 TOP.t3966 0.156982
R8801 TOP.t3966 TOP.t3964 0.156982
R8802 TOP.t3964 TOP.t3962 0.156982
R8803 TOP.t3962 TOP.t3960 0.156982
R8804 TOP.t3960 TOP.t3958 0.156982
R8805 TOP.t3958 TOP.t3956 0.156982
R8806 TOP.t3956 TOP.t3954 0.156982
R8807 TOP.t3954 TOP.t3952 0.156982
R8808 TOP.t3952 TOP.t3950 0.156982
R8809 TOP.t3950 TOP.t3948 0.156982
R8810 TOP.t3948 TOP.t3946 0.156982
R8811 TOP.t3946 TOP.t3944 0.156982
R8812 TOP.t3944 TOP.t3942 0.156982
R8813 TOP.t3942 TOP.t3940 0.156982
R8814 TOP.t3940 TOP.t3938 0.156982
R8815 TOP.t3938 TOP.t3936 0.156982
R8816 TOP.t3936 TOP.t3934 0.156982
R8817 TOP.t3934 TOP.t3932 0.156982
R8818 TOP.t3932 TOP.t3930 0.156982
R8819 TOP.t3930 TOP.t3928 0.156982
R8820 TOP.t3928 TOP.t3926 0.156982
R8821 TOP.t3926 TOP.t3924 0.156982
R8822 TOP.t3924 TOP.t3922 0.156982
R8823 TOP.t3922 TOP.t3920 0.156982
R8824 TOP.t3920 TOP.t3918 0.156982
R8825 TOP.t3918 TOP.t3916 0.156982
R8826 TOP.t3916 TOP.t3914 0.156982
R8827 TOP.t3914 TOP.t3912 0.156982
R8828 TOP.t3912 TOP.t3910 0.156982
R8829 TOP.t3910 TOP.t3908 0.156982
R8830 TOP.t3908 TOP.t3906 0.156982
R8831 TOP.t3906 TOP.t3904 0.156982
R8832 TOP.t3904 TOP.t3902 0.156982
R8833 TOP.t3902 TOP.t3900 0.156982
R8834 TOP.t3900 TOP.t3898 0.156982
R8835 TOP.t3898 TOP.t3896 0.156982
R8836 TOP.t3896 TOP.t3894 0.156982
R8837 TOP.t3894 TOP.t3892 0.156982
R8838 TOP.t3892 TOP.t3890 0.156982
R8839 TOP.t3890 TOP.t3888 0.156982
R8840 TOP.t3888 TOP.t3886 0.156982
R8841 TOP.t3886 TOP.t3884 0.156982
R8842 TOP.t3884 TOP.t3882 0.156982
R8843 TOP.t3882 TOP.t3880 0.156982
R8844 TOP.t3880 TOP.t3878 0.156982
R8845 TOP.t3878 TOP.t3876 0.156982
R8846 TOP.t3876 TOP.t3874 0.156982
R8847 TOP.t3874 TOP.t3872 0.156982
R8848 TOP.t3872 TOP.t3870 0.156982
R8849 TOP.t3870 TOP.t3868 0.156982
R8850 TOP.t3868 TOP.t3866 0.156982
R8851 TOP.t3866 TOP.t3864 0.156982
R8852 TOP.t3864 TOP.t3862 0.156982
R8853 TOP.t3862 TOP.t3860 0.156982
R8854 TOP.t7290 TOP.t3858 0.156982
R8855 TOP.t3858 TOP.t3856 0.156982
R8856 TOP.t3856 TOP.t3854 0.156982
R8857 TOP.t3854 TOP.t3852 0.156982
R8858 TOP.t3852 TOP.t3850 0.156982
R8859 TOP.t3850 TOP.t3848 0.156982
R8860 TOP.t3848 TOP.t3846 0.156982
R8861 TOP.t3846 TOP.t3844 0.156982
R8862 TOP.t3844 TOP.t3842 0.156982
R8863 TOP.t3842 TOP.t3840 0.156982
R8864 TOP.t3840 TOP.t3838 0.156982
R8865 TOP.t3838 TOP.t3836 0.156982
R8866 TOP.t3836 TOP.t3834 0.156982
R8867 TOP.t3834 TOP.t3832 0.156982
R8868 TOP.t3832 TOP.t3830 0.156982
R8869 TOP.t3830 TOP.t3828 0.156982
R8870 TOP.t3828 TOP.t3826 0.156982
R8871 TOP.t3826 TOP.t3824 0.156982
R8872 TOP.t3824 TOP.t3822 0.156982
R8873 TOP.t3822 TOP.t3820 0.156982
R8874 TOP.t3820 TOP.t3818 0.156982
R8875 TOP.t3818 TOP.t3816 0.156982
R8876 TOP.t3816 TOP.t3814 0.156982
R8877 TOP.t3814 TOP.t3812 0.156982
R8878 TOP.t3812 TOP.t3810 0.156982
R8879 TOP.t3810 TOP.t3808 0.156982
R8880 TOP.t3808 TOP.t3806 0.156982
R8881 TOP.t3806 TOP.t3804 0.156982
R8882 TOP.t3804 TOP.t3802 0.156982
R8883 TOP.t3802 TOP.t3800 0.156982
R8884 TOP.t3800 TOP.t3798 0.156982
R8885 TOP.t3798 TOP.t3796 0.156982
R8886 TOP.t3796 TOP.t3794 0.156982
R8887 TOP.t3794 TOP.t3792 0.156982
R8888 TOP.t3792 TOP.t3790 0.156982
R8889 TOP.t3790 TOP.t3788 0.156982
R8890 TOP.t3788 TOP.t3786 0.156982
R8891 TOP.t3786 TOP.t3784 0.156982
R8892 TOP.t3784 TOP.t3782 0.156982
R8893 TOP.t3782 TOP.t3780 0.156982
R8894 TOP.t3780 TOP.t3778 0.156982
R8895 TOP.t3778 TOP.t3776 0.156982
R8896 TOP.t3776 TOP.t3774 0.156982
R8897 TOP.t3774 TOP.t3772 0.156982
R8898 TOP.t3772 TOP.t3770 0.156982
R8899 TOP.t3770 TOP.t3768 0.156982
R8900 TOP.t3768 TOP.t3766 0.156982
R8901 TOP.t3766 TOP.t3764 0.156982
R8902 TOP.t3764 TOP.t3762 0.156982
R8903 TOP.t3762 TOP.t3760 0.156982
R8904 TOP.t3760 TOP.t3758 0.156982
R8905 TOP.t3758 TOP.t3756 0.156982
R8906 TOP.t3756 TOP.t3754 0.156982
R8907 TOP.t3754 TOP.t3752 0.156982
R8908 TOP.t3752 TOP.t3750 0.156982
R8909 TOP.t3750 TOP.t3748 0.156982
R8910 TOP.t3748 TOP.t3746 0.156982
R8911 TOP.t3746 TOP.t3744 0.156982
R8912 TOP.t3744 TOP.t3742 0.156982
R8913 TOP.t3742 TOP.t3740 0.156982
R8914 TOP.t3740 TOP.t3738 0.156982
R8915 TOP.t3738 TOP.t3736 0.156982
R8916 TOP.t3736 TOP.t3734 0.156982
R8917 TOP.t7288 TOP.t3732 0.156982
R8918 TOP.t3732 TOP.t3730 0.156982
R8919 TOP.t3730 TOP.t3728 0.156982
R8920 TOP.t3728 TOP.t3726 0.156982
R8921 TOP.t3726 TOP.t3724 0.156982
R8922 TOP.t3724 TOP.t3722 0.156982
R8923 TOP.t3722 TOP.t3720 0.156982
R8924 TOP.t3720 TOP.t3718 0.156982
R8925 TOP.t3718 TOP.t3716 0.156982
R8926 TOP.t3716 TOP.t3714 0.156982
R8927 TOP.t3714 TOP.t3712 0.156982
R8928 TOP.t3712 TOP.t3710 0.156982
R8929 TOP.t3710 TOP.t3708 0.156982
R8930 TOP.t3708 TOP.t3706 0.156982
R8931 TOP.t3706 TOP.t3704 0.156982
R8932 TOP.t3704 TOP.t3702 0.156982
R8933 TOP.t3702 TOP.t3700 0.156982
R8934 TOP.t3700 TOP.t3698 0.156982
R8935 TOP.t3698 TOP.t3696 0.156982
R8936 TOP.t3696 TOP.t3694 0.156982
R8937 TOP.t3694 TOP.t3692 0.156982
R8938 TOP.t3692 TOP.t3690 0.156982
R8939 TOP.t3690 TOP.t3688 0.156982
R8940 TOP.t3688 TOP.t3686 0.156982
R8941 TOP.t3686 TOP.t3684 0.156982
R8942 TOP.t3684 TOP.t3682 0.156982
R8943 TOP.t3682 TOP.t3680 0.156982
R8944 TOP.t3680 TOP.t3678 0.156982
R8945 TOP.t3678 TOP.t3676 0.156982
R8946 TOP.t3676 TOP.t3674 0.156982
R8947 TOP.t3674 TOP.t3672 0.156982
R8948 TOP.t3672 TOP.t3670 0.156982
R8949 TOP.t3670 TOP.t3668 0.156982
R8950 TOP.t3668 TOP.t3666 0.156982
R8951 TOP.t3666 TOP.t3664 0.156982
R8952 TOP.t3664 TOP.t3662 0.156982
R8953 TOP.t3662 TOP.t3660 0.156982
R8954 TOP.t3660 TOP.t3658 0.156982
R8955 TOP.t3658 TOP.t3656 0.156982
R8956 TOP.t3656 TOP.t3654 0.156982
R8957 TOP.t3654 TOP.t3652 0.156982
R8958 TOP.t3652 TOP.t3650 0.156982
R8959 TOP.t3650 TOP.t3648 0.156982
R8960 TOP.t3648 TOP.t3646 0.156982
R8961 TOP.t3646 TOP.t3644 0.156982
R8962 TOP.t3644 TOP.t3642 0.156982
R8963 TOP.t3642 TOP.t3640 0.156982
R8964 TOP.t3640 TOP.t3638 0.156982
R8965 TOP.t3638 TOP.t3636 0.156982
R8966 TOP.t3636 TOP.t3634 0.156982
R8967 TOP.t3634 TOP.t3632 0.156982
R8968 TOP.t3632 TOP.t3630 0.156982
R8969 TOP.t3630 TOP.t3628 0.156982
R8970 TOP.t3628 TOP.t3626 0.156982
R8971 TOP.t3626 TOP.t3624 0.156982
R8972 TOP.t3624 TOP.t3622 0.156982
R8973 TOP.t3622 TOP.t3620 0.156982
R8974 TOP.t3620 TOP.t3618 0.156982
R8975 TOP.t3618 TOP.t3616 0.156982
R8976 TOP.t3616 TOP.t3614 0.156982
R8977 TOP.t3614 TOP.t3612 0.156982
R8978 TOP.t3612 TOP.t3610 0.156982
R8979 TOP.t3610 TOP.t3608 0.156982
R8980 TOP.t7286 TOP.t3606 0.156982
R8981 TOP.t3606 TOP.t3604 0.156982
R8982 TOP.t3604 TOP.t3602 0.156982
R8983 TOP.t3602 TOP.t3600 0.156982
R8984 TOP.t3600 TOP.t3598 0.156982
R8985 TOP.t3598 TOP.t3596 0.156982
R8986 TOP.t3596 TOP.t3594 0.156982
R8987 TOP.t3594 TOP.t3592 0.156982
R8988 TOP.t3592 TOP.t3590 0.156982
R8989 TOP.t3590 TOP.t3588 0.156982
R8990 TOP.t3588 TOP.t3586 0.156982
R8991 TOP.t3586 TOP.t3584 0.156982
R8992 TOP.t3584 TOP.t3582 0.156982
R8993 TOP.t3582 TOP.t3580 0.156982
R8994 TOP.t3580 TOP.t3578 0.156982
R8995 TOP.t3578 TOP.t3576 0.156982
R8996 TOP.t3576 TOP.t3574 0.156982
R8997 TOP.t3574 TOP.t3572 0.156982
R8998 TOP.t3572 TOP.t3570 0.156982
R8999 TOP.t3570 TOP.t3568 0.156982
R9000 TOP.t3568 TOP.t3566 0.156982
R9001 TOP.t3566 TOP.t3564 0.156982
R9002 TOP.t3564 TOP.t3562 0.156982
R9003 TOP.t3562 TOP.t3560 0.156982
R9004 TOP.t3560 TOP.t3558 0.156982
R9005 TOP.t3558 TOP.t3556 0.156982
R9006 TOP.t3556 TOP.t3554 0.156982
R9007 TOP.t3554 TOP.t3552 0.156982
R9008 TOP.t3552 TOP.t3550 0.156982
R9009 TOP.t3550 TOP.t3548 0.156982
R9010 TOP.t3548 TOP.t3546 0.156982
R9011 TOP.t3546 TOP.t3544 0.156982
R9012 TOP.t3544 TOP.t3542 0.156982
R9013 TOP.t3542 TOP.t3540 0.156982
R9014 TOP.t3540 TOP.t3538 0.156982
R9015 TOP.t3538 TOP.t3536 0.156982
R9016 TOP.t3536 TOP.t3534 0.156982
R9017 TOP.t3534 TOP.t3532 0.156982
R9018 TOP.t3532 TOP.t3530 0.156982
R9019 TOP.t3530 TOP.t3528 0.156982
R9020 TOP.t3528 TOP.t3526 0.156982
R9021 TOP.t3526 TOP.t3524 0.156982
R9022 TOP.t3524 TOP.t3522 0.156982
R9023 TOP.t3522 TOP.t3520 0.156982
R9024 TOP.t3520 TOP.t3518 0.156982
R9025 TOP.t3518 TOP.t3516 0.156982
R9026 TOP.t3516 TOP.t3514 0.156982
R9027 TOP.t3514 TOP.t3512 0.156982
R9028 TOP.t3512 TOP.t3510 0.156982
R9029 TOP.t3510 TOP.t3508 0.156982
R9030 TOP.t3508 TOP.t3506 0.156982
R9031 TOP.t3506 TOP.t3504 0.156982
R9032 TOP.t3504 TOP.t3502 0.156982
R9033 TOP.t3502 TOP.t3500 0.156982
R9034 TOP.t3500 TOP.t3498 0.156982
R9035 TOP.t3498 TOP.t3496 0.156982
R9036 TOP.t3496 TOP.t3494 0.156982
R9037 TOP.t3494 TOP.t3492 0.156982
R9038 TOP.t3492 TOP.t3490 0.156982
R9039 TOP.t3490 TOP.t3488 0.156982
R9040 TOP.t3488 TOP.t3486 0.156982
R9041 TOP.t3486 TOP.t3484 0.156982
R9042 TOP.t3484 TOP.t3482 0.156982
R9043 TOP.t7284 TOP.t3480 0.156982
R9044 TOP.t3480 TOP.t3478 0.156982
R9045 TOP.t3478 TOP.t3476 0.156982
R9046 TOP.t3476 TOP.t3474 0.156982
R9047 TOP.t3474 TOP.t3472 0.156982
R9048 TOP.t3472 TOP.t3470 0.156982
R9049 TOP.t3470 TOP.t3468 0.156982
R9050 TOP.t3468 TOP.t3466 0.156982
R9051 TOP.t3466 TOP.t3464 0.156982
R9052 TOP.t3464 TOP.t3462 0.156982
R9053 TOP.t3462 TOP.t3460 0.156982
R9054 TOP.t3460 TOP.t3458 0.156982
R9055 TOP.t3458 TOP.t3456 0.156982
R9056 TOP.t3456 TOP.t3454 0.156982
R9057 TOP.t3454 TOP.t3452 0.156982
R9058 TOP.t3452 TOP.t3450 0.156982
R9059 TOP.t3450 TOP.t3448 0.156982
R9060 TOP.t3448 TOP.t3446 0.156982
R9061 TOP.t3446 TOP.t3444 0.156982
R9062 TOP.t3444 TOP.t3442 0.156982
R9063 TOP.t3442 TOP.t3440 0.156982
R9064 TOP.t3440 TOP.t3438 0.156982
R9065 TOP.t3438 TOP.t3436 0.156982
R9066 TOP.t3436 TOP.t3434 0.156982
R9067 TOP.t3434 TOP.t3432 0.156982
R9068 TOP.t3432 TOP.t3430 0.156982
R9069 TOP.t3430 TOP.t3428 0.156982
R9070 TOP.t3428 TOP.t3426 0.156982
R9071 TOP.t3426 TOP.t3424 0.156982
R9072 TOP.t3424 TOP.t3422 0.156982
R9073 TOP.t3422 TOP.t3420 0.156982
R9074 TOP.t3420 TOP.t3418 0.156982
R9075 TOP.t3418 TOP.t3416 0.156982
R9076 TOP.t3416 TOP.t3414 0.156982
R9077 TOP.t3414 TOP.t3412 0.156982
R9078 TOP.t3412 TOP.t3410 0.156982
R9079 TOP.t3410 TOP.t3408 0.156982
R9080 TOP.t3408 TOP.t3406 0.156982
R9081 TOP.t3406 TOP.t3404 0.156982
R9082 TOP.t3404 TOP.t3402 0.156982
R9083 TOP.t3402 TOP.t3400 0.156982
R9084 TOP.t3400 TOP.t3398 0.156982
R9085 TOP.t3398 TOP.t3396 0.156982
R9086 TOP.t3396 TOP.t3394 0.156982
R9087 TOP.t3394 TOP.t3392 0.156982
R9088 TOP.t3392 TOP.t3390 0.156982
R9089 TOP.t3390 TOP.t3388 0.156982
R9090 TOP.t3388 TOP.t3386 0.156982
R9091 TOP.t3386 TOP.t3384 0.156982
R9092 TOP.t3384 TOP.t3382 0.156982
R9093 TOP.t3382 TOP.t3380 0.156982
R9094 TOP.t3380 TOP.t3378 0.156982
R9095 TOP.t3378 TOP.t3376 0.156982
R9096 TOP.t3376 TOP.t3374 0.156982
R9097 TOP.t3374 TOP.t3372 0.156982
R9098 TOP.t3372 TOP.t3370 0.156982
R9099 TOP.t3370 TOP.t3368 0.156982
R9100 TOP.t3368 TOP.t3366 0.156982
R9101 TOP.t3366 TOP.t3364 0.156982
R9102 TOP.t3364 TOP.t3362 0.156982
R9103 TOP.t3362 TOP.t3360 0.156982
R9104 TOP.t3360 TOP.t3358 0.156982
R9105 TOP.t3358 TOP.t3356 0.156982
R9106 TOP.t7282 TOP.t3354 0.156982
R9107 TOP.t3354 TOP.t3352 0.156982
R9108 TOP.t3352 TOP.t3350 0.156982
R9109 TOP.t3350 TOP.t3348 0.156982
R9110 TOP.t3348 TOP.t3346 0.156982
R9111 TOP.t3346 TOP.t3344 0.156982
R9112 TOP.t3344 TOP.t3342 0.156982
R9113 TOP.t3342 TOP.t3340 0.156982
R9114 TOP.t3340 TOP.t3338 0.156982
R9115 TOP.t3338 TOP.t3336 0.156982
R9116 TOP.t3336 TOP.t3334 0.156982
R9117 TOP.t3334 TOP.t3332 0.156982
R9118 TOP.t3332 TOP.t3330 0.156982
R9119 TOP.t3330 TOP.t3328 0.156982
R9120 TOP.t3328 TOP.t3326 0.156982
R9121 TOP.t3326 TOP.t3324 0.156982
R9122 TOP.t3324 TOP.t3322 0.156982
R9123 TOP.t3322 TOP.t3320 0.156982
R9124 TOP.t3320 TOP.t3318 0.156982
R9125 TOP.t3318 TOP.t3316 0.156982
R9126 TOP.t3316 TOP.t3314 0.156982
R9127 TOP.t3314 TOP.t3312 0.156982
R9128 TOP.t3312 TOP.t3310 0.156982
R9129 TOP.t3310 TOP.t3308 0.156982
R9130 TOP.t3308 TOP.t3306 0.156982
R9131 TOP.t3306 TOP.t3304 0.156982
R9132 TOP.t3304 TOP.t3302 0.156982
R9133 TOP.t3302 TOP.t3300 0.156982
R9134 TOP.t3300 TOP.t3298 0.156982
R9135 TOP.t3298 TOP.t3296 0.156982
R9136 TOP.t3296 TOP.t3294 0.156982
R9137 TOP.t3294 TOP.t3292 0.156982
R9138 TOP.t3292 TOP.t3290 0.156982
R9139 TOP.t3290 TOP.t3288 0.156982
R9140 TOP.t3288 TOP.t3286 0.156982
R9141 TOP.t3286 TOP.t3284 0.156982
R9142 TOP.t3284 TOP.t3282 0.156982
R9143 TOP.t3282 TOP.t3280 0.156982
R9144 TOP.t3280 TOP.t3278 0.156982
R9145 TOP.t3278 TOP.t3276 0.156982
R9146 TOP.t3276 TOP.t3274 0.156982
R9147 TOP.t3274 TOP.t3272 0.156982
R9148 TOP.t3272 TOP.t3270 0.156982
R9149 TOP.t3270 TOP.t3268 0.156982
R9150 TOP.t3268 TOP.t3266 0.156982
R9151 TOP.t3266 TOP.t3264 0.156982
R9152 TOP.t3264 TOP.t3262 0.156982
R9153 TOP.t3262 TOP.t3260 0.156982
R9154 TOP.t3260 TOP.t3258 0.156982
R9155 TOP.t3258 TOP.t3256 0.156982
R9156 TOP.t3256 TOP.t3254 0.156982
R9157 TOP.t3254 TOP.t3252 0.156982
R9158 TOP.t3252 TOP.t3250 0.156982
R9159 TOP.t3250 TOP.t3248 0.156982
R9160 TOP.t3248 TOP.t3246 0.156982
R9161 TOP.t3246 TOP.t3244 0.156982
R9162 TOP.t3244 TOP.t3242 0.156982
R9163 TOP.t3242 TOP.t3240 0.156982
R9164 TOP.t3240 TOP.t3238 0.156982
R9165 TOP.t3238 TOP.t3236 0.156982
R9166 TOP.t3236 TOP.t3234 0.156982
R9167 TOP.t3234 TOP.t3232 0.156982
R9168 TOP.t3232 TOP.t3230 0.156982
R9169 TOP.t7280 TOP.t3228 0.156982
R9170 TOP.t3228 TOP.t3226 0.156982
R9171 TOP.t3226 TOP.t3224 0.156982
R9172 TOP.t3224 TOP.t3222 0.156982
R9173 TOP.t3222 TOP.t3220 0.156982
R9174 TOP.t3220 TOP.t3218 0.156982
R9175 TOP.t3218 TOP.t3216 0.156982
R9176 TOP.t3216 TOP.t3214 0.156982
R9177 TOP.t3214 TOP.t3212 0.156982
R9178 TOP.t3212 TOP.t3210 0.156982
R9179 TOP.t3210 TOP.t3208 0.156982
R9180 TOP.t3208 TOP.t3206 0.156982
R9181 TOP.t3206 TOP.t3204 0.156982
R9182 TOP.t3204 TOP.t3202 0.156982
R9183 TOP.t3202 TOP.t3200 0.156982
R9184 TOP.t3200 TOP.t3198 0.156982
R9185 TOP.t3198 TOP.t3196 0.156982
R9186 TOP.t3196 TOP.t3194 0.156982
R9187 TOP.t3194 TOP.t3192 0.156982
R9188 TOP.t3192 TOP.t3190 0.156982
R9189 TOP.t3190 TOP.t3188 0.156982
R9190 TOP.t3188 TOP.t3186 0.156982
R9191 TOP.t3186 TOP.t3184 0.156982
R9192 TOP.t3184 TOP.t3182 0.156982
R9193 TOP.t3182 TOP.t3180 0.156982
R9194 TOP.t3180 TOP.t3178 0.156982
R9195 TOP.t3178 TOP.t3176 0.156982
R9196 TOP.t3176 TOP.t3174 0.156982
R9197 TOP.t3174 TOP.t3172 0.156982
R9198 TOP.t3172 TOP.t3170 0.156982
R9199 TOP.t3170 TOP.t3168 0.156982
R9200 TOP.t3168 TOP.t3166 0.156982
R9201 TOP.t3166 TOP.t3164 0.156982
R9202 TOP.t3164 TOP.t3162 0.156982
R9203 TOP.t3162 TOP.t3160 0.156982
R9204 TOP.t3160 TOP.t3158 0.156982
R9205 TOP.t3158 TOP.t3156 0.156982
R9206 TOP.t3156 TOP.t3154 0.156982
R9207 TOP.t3154 TOP.t3152 0.156982
R9208 TOP.t3152 TOP.t3150 0.156982
R9209 TOP.t3150 TOP.t3148 0.156982
R9210 TOP.t3148 TOP.t3146 0.156982
R9211 TOP.t3146 TOP.t3144 0.156982
R9212 TOP.t3144 TOP.t3142 0.156982
R9213 TOP.t3142 TOP.t3140 0.156982
R9214 TOP.t3140 TOP.t3138 0.156982
R9215 TOP.t3138 TOP.t3136 0.156982
R9216 TOP.t3136 TOP.t3134 0.156982
R9217 TOP.t3134 TOP.t3132 0.156982
R9218 TOP.t3132 TOP.t3130 0.156982
R9219 TOP.t3130 TOP.t3128 0.156982
R9220 TOP.t3128 TOP.t3126 0.156982
R9221 TOP.t3126 TOP.t3124 0.156982
R9222 TOP.t3124 TOP.t3122 0.156982
R9223 TOP.t3122 TOP.t3120 0.156982
R9224 TOP.t3120 TOP.t3118 0.156982
R9225 TOP.t3118 TOP.t3116 0.156982
R9226 TOP.t3116 TOP.t3114 0.156982
R9227 TOP.t3114 TOP.t3112 0.156982
R9228 TOP.t3112 TOP.t3110 0.156982
R9229 TOP.t3110 TOP.t3108 0.156982
R9230 TOP.t3108 TOP.t3106 0.156982
R9231 TOP.t3106 TOP.t3104 0.156982
R9232 TOP.t3102 TOP.t7278 0.156982
R9233 TOP.t7278 TOP.t7276 0.156982
R9234 TOP.t7276 TOP.t7274 0.156982
R9235 TOP.t7274 TOP.t7272 0.156982
R9236 TOP.t7272 TOP.t7270 0.156982
R9237 TOP.t7270 TOP.t7268 0.156982
R9238 TOP.t7268 TOP.t7266 0.156982
R9239 TOP.t7266 TOP.t7264 0.156982
R9240 TOP.t7264 TOP.t7262 0.156982
R9241 TOP.t7262 TOP.t7260 0.156982
R9242 TOP.t7260 TOP.t7258 0.156982
R9243 TOP.t7258 TOP.t7256 0.156982
R9244 TOP.t7256 TOP.t7254 0.156982
R9245 TOP.t7254 TOP.t7252 0.156982
R9246 TOP.t7252 TOP.t7250 0.156982
R9247 TOP.t7250 TOP.t7248 0.156982
R9248 TOP.t7248 TOP.t7246 0.156982
R9249 TOP.t7246 TOP.t7244 0.156982
R9250 TOP.t7244 TOP.t7242 0.156982
R9251 TOP.t7242 TOP.t7240 0.156982
R9252 TOP.t7240 TOP.t7238 0.156982
R9253 TOP.t7238 TOP.t7236 0.156982
R9254 TOP.t7236 TOP.t7234 0.156982
R9255 TOP.t7234 TOP.t7232 0.156982
R9256 TOP.t7232 TOP.t7230 0.156982
R9257 TOP.t7230 TOP.t7228 0.156982
R9258 TOP.t7228 TOP.t7226 0.156982
R9259 TOP.t7226 TOP.t7224 0.156982
R9260 TOP.t7224 TOP.t7222 0.156982
R9261 TOP.t7222 TOP.t7220 0.156982
R9262 TOP.t7220 TOP.t7218 0.156982
R9263 TOP.t7218 TOP.t7216 0.156982
R9264 TOP.t7216 TOP.t7214 0.156982
R9265 TOP.t7214 TOP.t7212 0.156982
R9266 TOP.t7212 TOP.t7210 0.156982
R9267 TOP.t7210 TOP.t7208 0.156982
R9268 TOP.t7208 TOP.t7206 0.156982
R9269 TOP.t7206 TOP.t7204 0.156982
R9270 TOP.t7204 TOP.t7202 0.156982
R9271 TOP.t7202 TOP.t7200 0.156982
R9272 TOP.t7200 TOP.t7198 0.156982
R9273 TOP.t7198 TOP.t7196 0.156982
R9274 TOP.t7196 TOP.t7194 0.156982
R9275 TOP.t7194 TOP.t7192 0.156982
R9276 TOP.t7192 TOP.t7190 0.156982
R9277 TOP.t7190 TOP.t7188 0.156982
R9278 TOP.t7188 TOP.t7186 0.156982
R9279 TOP.t7186 TOP.t7184 0.156982
R9280 TOP.t7184 TOP.t7182 0.156982
R9281 TOP.t7182 TOP.t7180 0.156982
R9282 TOP.t7180 TOP.t7178 0.156982
R9283 TOP.t7178 TOP.t7176 0.156982
R9284 TOP.t7176 TOP.t7174 0.156982
R9285 TOP.t7174 TOP.t7172 0.156982
R9286 TOP.t7172 TOP.t7170 0.156982
R9287 TOP.t7170 TOP.t7168 0.156982
R9288 TOP.t7168 TOP.t7166 0.156982
R9289 TOP.t7166 TOP.t7164 0.156982
R9290 TOP.t7164 TOP.t7162 0.156982
R9291 TOP.t7162 TOP.t7160 0.156982
R9292 TOP.t7160 TOP.t7158 0.156982
R9293 TOP.t7158 TOP.t7156 0.156982
R9294 TOP.t7156 TOP.t7154 0.156982
R9295 TOP.t3100 TOP.t7152 0.156982
R9296 TOP.t7152 TOP.t7150 0.156982
R9297 TOP.t7150 TOP.t7148 0.156982
R9298 TOP.t7148 TOP.t7146 0.156982
R9299 TOP.t7146 TOP.t7144 0.156982
R9300 TOP.t7144 TOP.t7142 0.156982
R9301 TOP.t7142 TOP.t7140 0.156982
R9302 TOP.t7140 TOP.t7138 0.156982
R9303 TOP.t7138 TOP.t7136 0.156982
R9304 TOP.t7136 TOP.t7134 0.156982
R9305 TOP.t7134 TOP.t7132 0.156982
R9306 TOP.t7132 TOP.t7130 0.156982
R9307 TOP.t7130 TOP.t7128 0.156982
R9308 TOP.t7128 TOP.t7126 0.156982
R9309 TOP.t7126 TOP.t7124 0.156982
R9310 TOP.t7124 TOP.t7122 0.156982
R9311 TOP.t7122 TOP.t7120 0.156982
R9312 TOP.t7120 TOP.t7118 0.156982
R9313 TOP.t7118 TOP.t7116 0.156982
R9314 TOP.t7116 TOP.t7114 0.156982
R9315 TOP.t7114 TOP.t7112 0.156982
R9316 TOP.t7112 TOP.t7110 0.156982
R9317 TOP.t7110 TOP.t7108 0.156982
R9318 TOP.t7108 TOP.t7106 0.156982
R9319 TOP.t7106 TOP.t7104 0.156982
R9320 TOP.t7104 TOP.t7102 0.156982
R9321 TOP.t7102 TOP.t7100 0.156982
R9322 TOP.t7100 TOP.t7098 0.156982
R9323 TOP.t7098 TOP.t7096 0.156982
R9324 TOP.t7096 TOP.t7094 0.156982
R9325 TOP.t7094 TOP.t7092 0.156982
R9326 TOP.t7092 TOP.t7090 0.156982
R9327 TOP.t7090 TOP.t7088 0.156982
R9328 TOP.t7088 TOP.t7086 0.156982
R9329 TOP.t7086 TOP.t7084 0.156982
R9330 TOP.t7084 TOP.t7082 0.156982
R9331 TOP.t7082 TOP.t7080 0.156982
R9332 TOP.t7080 TOP.t7078 0.156982
R9333 TOP.t7078 TOP.t7076 0.156982
R9334 TOP.t7076 TOP.t7074 0.156982
R9335 TOP.t7074 TOP.t7072 0.156982
R9336 TOP.t7072 TOP.t7070 0.156982
R9337 TOP.t7070 TOP.t7068 0.156982
R9338 TOP.t7068 TOP.t7066 0.156982
R9339 TOP.t7066 TOP.t7064 0.156982
R9340 TOP.t7064 TOP.t7062 0.156982
R9341 TOP.t7062 TOP.t7060 0.156982
R9342 TOP.t7060 TOP.t7058 0.156982
R9343 TOP.t7058 TOP.t7056 0.156982
R9344 TOP.t7056 TOP.t7054 0.156982
R9345 TOP.t7054 TOP.t7052 0.156982
R9346 TOP.t7052 TOP.t7050 0.156982
R9347 TOP.t7050 TOP.t7048 0.156982
R9348 TOP.t7048 TOP.t7046 0.156982
R9349 TOP.t7046 TOP.t7044 0.156982
R9350 TOP.t7044 TOP.t7042 0.156982
R9351 TOP.t7042 TOP.t7040 0.156982
R9352 TOP.t7040 TOP.t7038 0.156982
R9353 TOP.t7038 TOP.t7036 0.156982
R9354 TOP.t7036 TOP.t7034 0.156982
R9355 TOP.t7034 TOP.t7032 0.156982
R9356 TOP.t7032 TOP.t7030 0.156982
R9357 TOP.t7030 TOP.t7028 0.156982
R9358 TOP.t3098 TOP.t7026 0.156982
R9359 TOP.t7026 TOP.t7024 0.156982
R9360 TOP.t7024 TOP.t7022 0.156982
R9361 TOP.t7022 TOP.t7020 0.156982
R9362 TOP.t7020 TOP.t7018 0.156982
R9363 TOP.t7018 TOP.t7016 0.156982
R9364 TOP.t7016 TOP.t7014 0.156982
R9365 TOP.t7014 TOP.t7012 0.156982
R9366 TOP.t7012 TOP.t7010 0.156982
R9367 TOP.t7010 TOP.t7008 0.156982
R9368 TOP.t7008 TOP.t7006 0.156982
R9369 TOP.t7006 TOP.t7004 0.156982
R9370 TOP.t7004 TOP.t7002 0.156982
R9371 TOP.t7002 TOP.t7000 0.156982
R9372 TOP.t7000 TOP.t6998 0.156982
R9373 TOP.t6998 TOP.t6996 0.156982
R9374 TOP.t6996 TOP.t6994 0.156982
R9375 TOP.t6994 TOP.t6992 0.156982
R9376 TOP.t6992 TOP.t6990 0.156982
R9377 TOP.t6990 TOP.t6988 0.156982
R9378 TOP.t6988 TOP.t6986 0.156982
R9379 TOP.t6986 TOP.t6984 0.156982
R9380 TOP.t6984 TOP.t6982 0.156982
R9381 TOP.t6982 TOP.t6980 0.156982
R9382 TOP.t6980 TOP.t6978 0.156982
R9383 TOP.t6978 TOP.t6976 0.156982
R9384 TOP.t6976 TOP.t6974 0.156982
R9385 TOP.t6974 TOP.t6972 0.156982
R9386 TOP.t6972 TOP.t6970 0.156982
R9387 TOP.t6970 TOP.t6968 0.156982
R9388 TOP.t6968 TOP.t6966 0.156982
R9389 TOP.t6966 TOP.t6964 0.156982
R9390 TOP.t6964 TOP.t6962 0.156982
R9391 TOP.t6962 TOP.t6960 0.156982
R9392 TOP.t6960 TOP.t6958 0.156982
R9393 TOP.t6958 TOP.t6956 0.156982
R9394 TOP.t6956 TOP.t6954 0.156982
R9395 TOP.t6954 TOP.t6952 0.156982
R9396 TOP.t6952 TOP.t6950 0.156982
R9397 TOP.t6950 TOP.t6948 0.156982
R9398 TOP.t6948 TOP.t6946 0.156982
R9399 TOP.t6946 TOP.t6944 0.156982
R9400 TOP.t6944 TOP.t6942 0.156982
R9401 TOP.t6942 TOP.t6940 0.156982
R9402 TOP.t6940 TOP.t6938 0.156982
R9403 TOP.t6938 TOP.t6936 0.156982
R9404 TOP.t6936 TOP.t6934 0.156982
R9405 TOP.t6934 TOP.t6932 0.156982
R9406 TOP.t6932 TOP.t6930 0.156982
R9407 TOP.t6930 TOP.t6928 0.156982
R9408 TOP.t6928 TOP.t6926 0.156982
R9409 TOP.t6926 TOP.t6924 0.156982
R9410 TOP.t6924 TOP.t6922 0.156982
R9411 TOP.t6922 TOP.t6920 0.156982
R9412 TOP.t6920 TOP.t6918 0.156982
R9413 TOP.t6918 TOP.t6916 0.156982
R9414 TOP.t6916 TOP.t6914 0.156982
R9415 TOP.t6914 TOP.t6912 0.156982
R9416 TOP.t6912 TOP.t6910 0.156982
R9417 TOP.t6910 TOP.t6908 0.156982
R9418 TOP.t6908 TOP.t6906 0.156982
R9419 TOP.t6906 TOP.t6904 0.156982
R9420 TOP.t6904 TOP.t6902 0.156982
R9421 TOP.t3096 TOP.t6900 0.156982
R9422 TOP.t6900 TOP.t6898 0.156982
R9423 TOP.t6898 TOP.t6896 0.156982
R9424 TOP.t6896 TOP.t6894 0.156982
R9425 TOP.t6894 TOP.t6892 0.156982
R9426 TOP.t6892 TOP.t6890 0.156982
R9427 TOP.t6890 TOP.t6888 0.156982
R9428 TOP.t6888 TOP.t6886 0.156982
R9429 TOP.t6886 TOP.t6884 0.156982
R9430 TOP.t6884 TOP.t6882 0.156982
R9431 TOP.t6882 TOP.t6880 0.156982
R9432 TOP.t6880 TOP.t6878 0.156982
R9433 TOP.t6878 TOP.t6876 0.156982
R9434 TOP.t6876 TOP.t6874 0.156982
R9435 TOP.t6874 TOP.t6872 0.156982
R9436 TOP.t6872 TOP.t6870 0.156982
R9437 TOP.t6870 TOP.t6868 0.156982
R9438 TOP.t6868 TOP.t6866 0.156982
R9439 TOP.t6866 TOP.t6864 0.156982
R9440 TOP.t6864 TOP.t6862 0.156982
R9441 TOP.t6862 TOP.t6860 0.156982
R9442 TOP.t6860 TOP.t6858 0.156982
R9443 TOP.t6858 TOP.t6856 0.156982
R9444 TOP.t6856 TOP.t6854 0.156982
R9445 TOP.t6854 TOP.t6852 0.156982
R9446 TOP.t6852 TOP.t6850 0.156982
R9447 TOP.t6850 TOP.t6848 0.156982
R9448 TOP.t6848 TOP.t6846 0.156982
R9449 TOP.t6846 TOP.t6844 0.156982
R9450 TOP.t6844 TOP.t6842 0.156982
R9451 TOP.t6842 TOP.t6840 0.156982
R9452 TOP.t6840 TOP.t6838 0.156982
R9453 TOP.t6838 TOP.t6836 0.156982
R9454 TOP.t6836 TOP.t6834 0.156982
R9455 TOP.t6834 TOP.t6832 0.156982
R9456 TOP.t6832 TOP.t6830 0.156982
R9457 TOP.t6830 TOP.t6828 0.156982
R9458 TOP.t6828 TOP.t6826 0.156982
R9459 TOP.t6826 TOP.t6824 0.156982
R9460 TOP.t6824 TOP.t6822 0.156982
R9461 TOP.t6822 TOP.t6820 0.156982
R9462 TOP.t6820 TOP.t6818 0.156982
R9463 TOP.t6818 TOP.t6816 0.156982
R9464 TOP.t6816 TOP.t6814 0.156982
R9465 TOP.t6814 TOP.t6812 0.156982
R9466 TOP.t6812 TOP.t6810 0.156982
R9467 TOP.t6810 TOP.t6808 0.156982
R9468 TOP.t6808 TOP.t6806 0.156982
R9469 TOP.t6806 TOP.t6804 0.156982
R9470 TOP.t6804 TOP.t6802 0.156982
R9471 TOP.t6802 TOP.t6800 0.156982
R9472 TOP.t6800 TOP.t6798 0.156982
R9473 TOP.t6798 TOP.t6796 0.156982
R9474 TOP.t6796 TOP.t6794 0.156982
R9475 TOP.t6794 TOP.t6792 0.156982
R9476 TOP.t6792 TOP.t6790 0.156982
R9477 TOP.t6790 TOP.t6788 0.156982
R9478 TOP.t6788 TOP.t6786 0.156982
R9479 TOP.t6786 TOP.t6784 0.156982
R9480 TOP.t6784 TOP.t6782 0.156982
R9481 TOP.t6782 TOP.t6780 0.156982
R9482 TOP.t6780 TOP.t6778 0.156982
R9483 TOP.t6778 TOP.t6776 0.156982
R9484 TOP.t3094 TOP.t6774 0.156982
R9485 TOP.t6774 TOP.t6772 0.156982
R9486 TOP.t6772 TOP.t6770 0.156982
R9487 TOP.t6770 TOP.t6768 0.156982
R9488 TOP.t6768 TOP.t6766 0.156982
R9489 TOP.t6766 TOP.t6764 0.156982
R9490 TOP.t6764 TOP.t6762 0.156982
R9491 TOP.t6762 TOP.t6760 0.156982
R9492 TOP.t6760 TOP.t6758 0.156982
R9493 TOP.t6758 TOP.t6756 0.156982
R9494 TOP.t6756 TOP.t6754 0.156982
R9495 TOP.t6754 TOP.t6752 0.156982
R9496 TOP.t6752 TOP.t6750 0.156982
R9497 TOP.t6750 TOP.t6748 0.156982
R9498 TOP.t6748 TOP.t6746 0.156982
R9499 TOP.t6746 TOP.t6744 0.156982
R9500 TOP.t6744 TOP.t6742 0.156982
R9501 TOP.t6742 TOP.t6740 0.156982
R9502 TOP.t6740 TOP.t6738 0.156982
R9503 TOP.t6738 TOP.t6736 0.156982
R9504 TOP.t6736 TOP.t6734 0.156982
R9505 TOP.t6734 TOP.t6732 0.156982
R9506 TOP.t6732 TOP.t6730 0.156982
R9507 TOP.t6730 TOP.t6728 0.156982
R9508 TOP.t6728 TOP.t6726 0.156982
R9509 TOP.t6726 TOP.t6724 0.156982
R9510 TOP.t6724 TOP.t6722 0.156982
R9511 TOP.t6722 TOP.t6720 0.156982
R9512 TOP.t6720 TOP.t6718 0.156982
R9513 TOP.t6718 TOP.t6716 0.156982
R9514 TOP.t6716 TOP.t6714 0.156982
R9515 TOP.t6714 TOP.t6712 0.156982
R9516 TOP.t6712 TOP.t6710 0.156982
R9517 TOP.t6710 TOP.t6708 0.156982
R9518 TOP.t6708 TOP.t6706 0.156982
R9519 TOP.t6706 TOP.t6704 0.156982
R9520 TOP.t6704 TOP.t6702 0.156982
R9521 TOP.t6702 TOP.t6700 0.156982
R9522 TOP.t6700 TOP.t6698 0.156982
R9523 TOP.t6698 TOP.t6696 0.156982
R9524 TOP.t6696 TOP.t6694 0.156982
R9525 TOP.t6694 TOP.t6692 0.156982
R9526 TOP.t6692 TOP.t6690 0.156982
R9527 TOP.t6690 TOP.t6688 0.156982
R9528 TOP.t6688 TOP.t6686 0.156982
R9529 TOP.t6686 TOP.t6684 0.156982
R9530 TOP.t6684 TOP.t6682 0.156982
R9531 TOP.t6682 TOP.t6680 0.156982
R9532 TOP.t6680 TOP.t6678 0.156982
R9533 TOP.t6678 TOP.t6676 0.156982
R9534 TOP.t6676 TOP.t6674 0.156982
R9535 TOP.t6674 TOP.t6672 0.156982
R9536 TOP.t6672 TOP.t6670 0.156982
R9537 TOP.t6670 TOP.t6668 0.156982
R9538 TOP.t6668 TOP.t6666 0.156982
R9539 TOP.t6666 TOP.t6664 0.156982
R9540 TOP.t6664 TOP.t6662 0.156982
R9541 TOP.t6662 TOP.t6660 0.156982
R9542 TOP.t6660 TOP.t6658 0.156982
R9543 TOP.t6658 TOP.t6656 0.156982
R9544 TOP.t6656 TOP.t6654 0.156982
R9545 TOP.t6654 TOP.t6652 0.156982
R9546 TOP.t6652 TOP.t6650 0.156982
R9547 TOP.t3092 TOP.t6648 0.156982
R9548 TOP.t6648 TOP.t6646 0.156982
R9549 TOP.t6646 TOP.t6644 0.156982
R9550 TOP.t6644 TOP.t6642 0.156982
R9551 TOP.t6642 TOP.t6640 0.156982
R9552 TOP.t6640 TOP.t6638 0.156982
R9553 TOP.t6638 TOP.t6636 0.156982
R9554 TOP.t6636 TOP.t6634 0.156982
R9555 TOP.t6634 TOP.t6632 0.156982
R9556 TOP.t6632 TOP.t6630 0.156982
R9557 TOP.t6630 TOP.t6628 0.156982
R9558 TOP.t6628 TOP.t6626 0.156982
R9559 TOP.t6626 TOP.t6624 0.156982
R9560 TOP.t6624 TOP.t6622 0.156982
R9561 TOP.t6622 TOP.t6620 0.156982
R9562 TOP.t6620 TOP.t6618 0.156982
R9563 TOP.t6618 TOP.t6616 0.156982
R9564 TOP.t6616 TOP.t6614 0.156982
R9565 TOP.t6614 TOP.t6612 0.156982
R9566 TOP.t6612 TOP.t6610 0.156982
R9567 TOP.t6610 TOP.t6608 0.156982
R9568 TOP.t6608 TOP.t6606 0.156982
R9569 TOP.t6606 TOP.t6604 0.156982
R9570 TOP.t6604 TOP.t6602 0.156982
R9571 TOP.t6602 TOP.t6600 0.156982
R9572 TOP.t6600 TOP.t6598 0.156982
R9573 TOP.t6598 TOP.t6596 0.156982
R9574 TOP.t6596 TOP.t6594 0.156982
R9575 TOP.t6594 TOP.t6592 0.156982
R9576 TOP.t6592 TOP.t6590 0.156982
R9577 TOP.t6590 TOP.t6588 0.156982
R9578 TOP.t6588 TOP.t6586 0.156982
R9579 TOP.t6586 TOP.t6584 0.156982
R9580 TOP.t6584 TOP.t6582 0.156982
R9581 TOP.t6582 TOP.t6580 0.156982
R9582 TOP.t6580 TOP.t6578 0.156982
R9583 TOP.t6578 TOP.t6576 0.156982
R9584 TOP.t6576 TOP.t6574 0.156982
R9585 TOP.t6574 TOP.t6572 0.156982
R9586 TOP.t6572 TOP.t6570 0.156982
R9587 TOP.t6570 TOP.t6568 0.156982
R9588 TOP.t6568 TOP.t6566 0.156982
R9589 TOP.t6566 TOP.t6564 0.156982
R9590 TOP.t6564 TOP.t6562 0.156982
R9591 TOP.t6562 TOP.t6560 0.156982
R9592 TOP.t6560 TOP.t6558 0.156982
R9593 TOP.t6558 TOP.t6556 0.156982
R9594 TOP.t6556 TOP.t6554 0.156982
R9595 TOP.t6554 TOP.t6552 0.156982
R9596 TOP.t6552 TOP.t6550 0.156982
R9597 TOP.t6550 TOP.t6548 0.156982
R9598 TOP.t6548 TOP.t6546 0.156982
R9599 TOP.t6546 TOP.t6544 0.156982
R9600 TOP.t6544 TOP.t6542 0.156982
R9601 TOP.t6542 TOP.t6540 0.156982
R9602 TOP.t6540 TOP.t6538 0.156982
R9603 TOP.t6538 TOP.t6536 0.156982
R9604 TOP.t6536 TOP.t6534 0.156982
R9605 TOP.t6534 TOP.t6532 0.156982
R9606 TOP.t6532 TOP.t6530 0.156982
R9607 TOP.t6530 TOP.t6528 0.156982
R9608 TOP.t6528 TOP.t6526 0.156982
R9609 TOP.t6526 TOP.t6524 0.156982
R9610 TOP.t3090 TOP.t6522 0.156982
R9611 TOP.t6522 TOP.t6520 0.156982
R9612 TOP.t6520 TOP.t6518 0.156982
R9613 TOP.t6518 TOP.t6516 0.156982
R9614 TOP.t6516 TOP.t6514 0.156982
R9615 TOP.t6514 TOP.t6512 0.156982
R9616 TOP.t6512 TOP.t6510 0.156982
R9617 TOP.t6510 TOP.t6508 0.156982
R9618 TOP.t6508 TOP.t6506 0.156982
R9619 TOP.t6506 TOP.t6504 0.156982
R9620 TOP.t6504 TOP.t6502 0.156982
R9621 TOP.t6502 TOP.t6500 0.156982
R9622 TOP.t6500 TOP.t6498 0.156982
R9623 TOP.t6498 TOP.t6496 0.156982
R9624 TOP.t6496 TOP.t6494 0.156982
R9625 TOP.t6494 TOP.t6492 0.156982
R9626 TOP.t6492 TOP.t6490 0.156982
R9627 TOP.t6490 TOP.t6488 0.156982
R9628 TOP.t6488 TOP.t6486 0.156982
R9629 TOP.t6486 TOP.t6484 0.156982
R9630 TOP.t6484 TOP.t6482 0.156982
R9631 TOP.t6482 TOP.t6480 0.156982
R9632 TOP.t6480 TOP.t6478 0.156982
R9633 TOP.t6478 TOP.t6476 0.156982
R9634 TOP.t6476 TOP.t6474 0.156982
R9635 TOP.t6474 TOP.t6472 0.156982
R9636 TOP.t6472 TOP.t6470 0.156982
R9637 TOP.t6470 TOP.t6468 0.156982
R9638 TOP.t6468 TOP.t6466 0.156982
R9639 TOP.t6466 TOP.t6464 0.156982
R9640 TOP.t6464 TOP.t6462 0.156982
R9641 TOP.t6462 TOP.t6460 0.156982
R9642 TOP.t6460 TOP.t6458 0.156982
R9643 TOP.t6458 TOP.t6456 0.156982
R9644 TOP.t6456 TOP.t6454 0.156982
R9645 TOP.t6454 TOP.t6452 0.156982
R9646 TOP.t6452 TOP.t6450 0.156982
R9647 TOP.t6450 TOP.t6448 0.156982
R9648 TOP.t6448 TOP.t6446 0.156982
R9649 TOP.t6446 TOP.t6444 0.156982
R9650 TOP.t6444 TOP.t6442 0.156982
R9651 TOP.t6442 TOP.t6440 0.156982
R9652 TOP.t6440 TOP.t6438 0.156982
R9653 TOP.t6438 TOP.t6436 0.156982
R9654 TOP.t6436 TOP.t6434 0.156982
R9655 TOP.t6434 TOP.t6432 0.156982
R9656 TOP.t6432 TOP.t6430 0.156982
R9657 TOP.t6430 TOP.t6428 0.156982
R9658 TOP.t6428 TOP.t6426 0.156982
R9659 TOP.t6426 TOP.t6424 0.156982
R9660 TOP.t6424 TOP.t6422 0.156982
R9661 TOP.t6422 TOP.t6420 0.156982
R9662 TOP.t6420 TOP.t6418 0.156982
R9663 TOP.t6418 TOP.t6416 0.156982
R9664 TOP.t6416 TOP.t6414 0.156982
R9665 TOP.t6414 TOP.t6412 0.156982
R9666 TOP.t6412 TOP.t6410 0.156982
R9667 TOP.t6410 TOP.t6408 0.156982
R9668 TOP.t6408 TOP.t6406 0.156982
R9669 TOP.t6406 TOP.t6404 0.156982
R9670 TOP.t6404 TOP.t6402 0.156982
R9671 TOP.t6402 TOP.t6400 0.156982
R9672 TOP.t6400 TOP.t6398 0.156982
R9673 TOP.t3088 TOP.t6396 0.156982
R9674 TOP.t6396 TOP.t6394 0.156982
R9675 TOP.t6394 TOP.t6392 0.156982
R9676 TOP.t6392 TOP.t6390 0.156982
R9677 TOP.t6390 TOP.t6388 0.156982
R9678 TOP.t6388 TOP.t6386 0.156982
R9679 TOP.t6386 TOP.t6384 0.156982
R9680 TOP.t6384 TOP.t6382 0.156982
R9681 TOP.t6382 TOP.t6380 0.156982
R9682 TOP.t6380 TOP.t6378 0.156982
R9683 TOP.t6378 TOP.t6376 0.156982
R9684 TOP.t6376 TOP.t6374 0.156982
R9685 TOP.t6374 TOP.t6372 0.156982
R9686 TOP.t6372 TOP.t6370 0.156982
R9687 TOP.t6370 TOP.t6368 0.156982
R9688 TOP.t6368 TOP.t6366 0.156982
R9689 TOP.t6366 TOP.t6364 0.156982
R9690 TOP.t6364 TOP.t6362 0.156982
R9691 TOP.t6362 TOP.t6360 0.156982
R9692 TOP.t6360 TOP.t6358 0.156982
R9693 TOP.t6358 TOP.t6356 0.156982
R9694 TOP.t6356 TOP.t6354 0.156982
R9695 TOP.t6354 TOP.t6352 0.156982
R9696 TOP.t6352 TOP.t6350 0.156982
R9697 TOP.t6350 TOP.t6348 0.156982
R9698 TOP.t6348 TOP.t6346 0.156982
R9699 TOP.t6346 TOP.t6344 0.156982
R9700 TOP.t6344 TOP.t6342 0.156982
R9701 TOP.t6342 TOP.t6340 0.156982
R9702 TOP.t6340 TOP.t6338 0.156982
R9703 TOP.t6338 TOP.t6336 0.156982
R9704 TOP.t6336 TOP.t6334 0.156982
R9705 TOP.t6334 TOP.t6332 0.156982
R9706 TOP.t6332 TOP.t6330 0.156982
R9707 TOP.t6330 TOP.t6328 0.156982
R9708 TOP.t6328 TOP.t6326 0.156982
R9709 TOP.t6326 TOP.t6324 0.156982
R9710 TOP.t6324 TOP.t6322 0.156982
R9711 TOP.t6322 TOP.t6320 0.156982
R9712 TOP.t6320 TOP.t6318 0.156982
R9713 TOP.t6318 TOP.t6316 0.156982
R9714 TOP.t6316 TOP.t6314 0.156982
R9715 TOP.t6314 TOP.t6312 0.156982
R9716 TOP.t6312 TOP.t6310 0.156982
R9717 TOP.t6310 TOP.t6308 0.156982
R9718 TOP.t6308 TOP.t6306 0.156982
R9719 TOP.t6306 TOP.t6304 0.156982
R9720 TOP.t6304 TOP.t6302 0.156982
R9721 TOP.t6302 TOP.t6300 0.156982
R9722 TOP.t6300 TOP.t6298 0.156982
R9723 TOP.t6298 TOP.t6296 0.156982
R9724 TOP.t6296 TOP.t6294 0.156982
R9725 TOP.t6294 TOP.t6292 0.156982
R9726 TOP.t6292 TOP.t6290 0.156982
R9727 TOP.t6290 TOP.t6288 0.156982
R9728 TOP.t6288 TOP.t6286 0.156982
R9729 TOP.t6286 TOP.t6284 0.156982
R9730 TOP.t6284 TOP.t6282 0.156982
R9731 TOP.t6282 TOP.t6280 0.156982
R9732 TOP.t6280 TOP.t6278 0.156982
R9733 TOP.t6278 TOP.t6276 0.156982
R9734 TOP.t6276 TOP.t6274 0.156982
R9735 TOP.t6274 TOP.t6272 0.156982
R9736 TOP.t3086 TOP.t1014 0.156982
R9737 TOP.t1014 TOP.t1012 0.156982
R9738 TOP.t1012 TOP.t1010 0.156982
R9739 TOP.t1010 TOP.t1008 0.156982
R9740 TOP.t1008 TOP.t1006 0.156982
R9741 TOP.t1006 TOP.t1004 0.156982
R9742 TOP.t1004 TOP.t1002 0.156982
R9743 TOP.t1002 TOP.t1000 0.156982
R9744 TOP.t1000 TOP.t998 0.156982
R9745 TOP.t998 TOP.t996 0.156982
R9746 TOP.t996 TOP.t994 0.156982
R9747 TOP.t994 TOP.t992 0.156982
R9748 TOP.t992 TOP.t990 0.156982
R9749 TOP.t990 TOP.t988 0.156982
R9750 TOP.t988 TOP.t986 0.156982
R9751 TOP.t986 TOP.t984 0.156982
R9752 TOP.t984 TOP.t982 0.156982
R9753 TOP.t982 TOP.t980 0.156982
R9754 TOP.t980 TOP.t978 0.156982
R9755 TOP.t978 TOP.t976 0.156982
R9756 TOP.t976 TOP.t974 0.156982
R9757 TOP.t974 TOP.t972 0.156982
R9758 TOP.t972 TOP.t970 0.156982
R9759 TOP.t970 TOP.t968 0.156982
R9760 TOP.t968 TOP.t966 0.156982
R9761 TOP.t966 TOP.t964 0.156982
R9762 TOP.t964 TOP.t962 0.156982
R9763 TOP.t962 TOP.t960 0.156982
R9764 TOP.t960 TOP.t958 0.156982
R9765 TOP.t958 TOP.t956 0.156982
R9766 TOP.t956 TOP.t954 0.156982
R9767 TOP.t954 TOP.t952 0.156982
R9768 TOP.t952 TOP.t950 0.156982
R9769 TOP.t950 TOP.t948 0.156982
R9770 TOP.t948 TOP.t946 0.156982
R9771 TOP.t946 TOP.t944 0.156982
R9772 TOP.t944 TOP.t942 0.156982
R9773 TOP.t942 TOP.t940 0.156982
R9774 TOP.t940 TOP.t938 0.156982
R9775 TOP.t938 TOP.t936 0.156982
R9776 TOP.t936 TOP.t934 0.156982
R9777 TOP.t934 TOP.t932 0.156982
R9778 TOP.t932 TOP.t930 0.156982
R9779 TOP.t930 TOP.t928 0.156982
R9780 TOP.t928 TOP.t926 0.156982
R9781 TOP.t926 TOP.t924 0.156982
R9782 TOP.t924 TOP.t922 0.156982
R9783 TOP.t922 TOP.t920 0.156982
R9784 TOP.t920 TOP.t918 0.156982
R9785 TOP.t918 TOP.t916 0.156982
R9786 TOP.t916 TOP.t914 0.156982
R9787 TOP.t914 TOP.t912 0.156982
R9788 TOP.t912 TOP.t910 0.156982
R9789 TOP.t910 TOP.t908 0.156982
R9790 TOP.t908 TOP.t906 0.156982
R9791 TOP.t906 TOP.t904 0.156982
R9792 TOP.t904 TOP.t902 0.156982
R9793 TOP.t902 TOP.t900 0.156982
R9794 TOP.t900 TOP.t898 0.156982
R9795 TOP.t898 TOP.t896 0.156982
R9796 TOP.t896 TOP.t894 0.156982
R9797 TOP.t894 TOP.t892 0.156982
R9798 TOP.t892 TOP.t890 0.156982
R9799 TOP.t3084 TOP.t888 0.156982
R9800 TOP.t888 TOP.t886 0.156982
R9801 TOP.t886 TOP.t884 0.156982
R9802 TOP.t884 TOP.t882 0.156982
R9803 TOP.t882 TOP.t880 0.156982
R9804 TOP.t880 TOP.t878 0.156982
R9805 TOP.t878 TOP.t876 0.156982
R9806 TOP.t876 TOP.t874 0.156982
R9807 TOP.t874 TOP.t872 0.156982
R9808 TOP.t872 TOP.t870 0.156982
R9809 TOP.t870 TOP.t868 0.156982
R9810 TOP.t868 TOP.t866 0.156982
R9811 TOP.t866 TOP.t864 0.156982
R9812 TOP.t864 TOP.t862 0.156982
R9813 TOP.t862 TOP.t860 0.156982
R9814 TOP.t860 TOP.t858 0.156982
R9815 TOP.t858 TOP.t856 0.156982
R9816 TOP.t856 TOP.t854 0.156982
R9817 TOP.t854 TOP.t852 0.156982
R9818 TOP.t852 TOP.t850 0.156982
R9819 TOP.t850 TOP.t848 0.156982
R9820 TOP.t848 TOP.t846 0.156982
R9821 TOP.t846 TOP.t844 0.156982
R9822 TOP.t844 TOP.t842 0.156982
R9823 TOP.t842 TOP.t840 0.156982
R9824 TOP.t840 TOP.t838 0.156982
R9825 TOP.t838 TOP.t836 0.156982
R9826 TOP.t836 TOP.t834 0.156982
R9827 TOP.t834 TOP.t832 0.156982
R9828 TOP.t832 TOP.t830 0.156982
R9829 TOP.t830 TOP.t828 0.156982
R9830 TOP.t828 TOP.t826 0.156982
R9831 TOP.t826 TOP.t824 0.156982
R9832 TOP.t824 TOP.t822 0.156982
R9833 TOP.t822 TOP.t820 0.156982
R9834 TOP.t820 TOP.t818 0.156982
R9835 TOP.t818 TOP.t816 0.156982
R9836 TOP.t816 TOP.t814 0.156982
R9837 TOP.t814 TOP.t812 0.156982
R9838 TOP.t812 TOP.t810 0.156982
R9839 TOP.t810 TOP.t808 0.156982
R9840 TOP.t808 TOP.t806 0.156982
R9841 TOP.t806 TOP.t804 0.156982
R9842 TOP.t804 TOP.t802 0.156982
R9843 TOP.t802 TOP.t800 0.156982
R9844 TOP.t800 TOP.t798 0.156982
R9845 TOP.t798 TOP.t796 0.156982
R9846 TOP.t796 TOP.t794 0.156982
R9847 TOP.t794 TOP.t792 0.156982
R9848 TOP.t792 TOP.t790 0.156982
R9849 TOP.t790 TOP.t788 0.156982
R9850 TOP.t788 TOP.t786 0.156982
R9851 TOP.t786 TOP.t784 0.156982
R9852 TOP.t784 TOP.t782 0.156982
R9853 TOP.t782 TOP.t780 0.156982
R9854 TOP.t780 TOP.t778 0.156982
R9855 TOP.t778 TOP.t776 0.156982
R9856 TOP.t776 TOP.t774 0.156982
R9857 TOP.t774 TOP.t772 0.156982
R9858 TOP.t772 TOP.t770 0.156982
R9859 TOP.t770 TOP.t768 0.156982
R9860 TOP.t768 TOP.t766 0.156982
R9861 TOP.t766 TOP.t764 0.156982
R9862 TOP.t3082 TOP.t762 0.156982
R9863 TOP.t762 TOP.t760 0.156982
R9864 TOP.t760 TOP.t758 0.156982
R9865 TOP.t758 TOP.t756 0.156982
R9866 TOP.t756 TOP.t754 0.156982
R9867 TOP.t754 TOP.t752 0.156982
R9868 TOP.t752 TOP.t750 0.156982
R9869 TOP.t750 TOP.t748 0.156982
R9870 TOP.t748 TOP.t746 0.156982
R9871 TOP.t746 TOP.t744 0.156982
R9872 TOP.t744 TOP.t742 0.156982
R9873 TOP.t742 TOP.t740 0.156982
R9874 TOP.t740 TOP.t738 0.156982
R9875 TOP.t738 TOP.t736 0.156982
R9876 TOP.t736 TOP.t734 0.156982
R9877 TOP.t734 TOP.t732 0.156982
R9878 TOP.t732 TOP.t730 0.156982
R9879 TOP.t730 TOP.t728 0.156982
R9880 TOP.t728 TOP.t726 0.156982
R9881 TOP.t726 TOP.t724 0.156982
R9882 TOP.t724 TOP.t722 0.156982
R9883 TOP.t722 TOP.t720 0.156982
R9884 TOP.t720 TOP.t718 0.156982
R9885 TOP.t718 TOP.t716 0.156982
R9886 TOP.t716 TOP.t714 0.156982
R9887 TOP.t714 TOP.t712 0.156982
R9888 TOP.t712 TOP.t710 0.156982
R9889 TOP.t710 TOP.t708 0.156982
R9890 TOP.t708 TOP.t706 0.156982
R9891 TOP.t706 TOP.t704 0.156982
R9892 TOP.t704 TOP.t702 0.156982
R9893 TOP.t702 TOP.t700 0.156982
R9894 TOP.t700 TOP.t698 0.156982
R9895 TOP.t698 TOP.t696 0.156982
R9896 TOP.t696 TOP.t694 0.156982
R9897 TOP.t694 TOP.t692 0.156982
R9898 TOP.t692 TOP.t690 0.156982
R9899 TOP.t690 TOP.t688 0.156982
R9900 TOP.t688 TOP.t686 0.156982
R9901 TOP.t686 TOP.t684 0.156982
R9902 TOP.t684 TOP.t682 0.156982
R9903 TOP.t682 TOP.t680 0.156982
R9904 TOP.t680 TOP.t678 0.156982
R9905 TOP.t678 TOP.t676 0.156982
R9906 TOP.t676 TOP.t674 0.156982
R9907 TOP.t674 TOP.t672 0.156982
R9908 TOP.t672 TOP.t670 0.156982
R9909 TOP.t670 TOP.t668 0.156982
R9910 TOP.t668 TOP.t666 0.156982
R9911 TOP.t666 TOP.t664 0.156982
R9912 TOP.t664 TOP.t662 0.156982
R9913 TOP.t662 TOP.t660 0.156982
R9914 TOP.t660 TOP.t658 0.156982
R9915 TOP.t658 TOP.t656 0.156982
R9916 TOP.t656 TOP.t654 0.156982
R9917 TOP.t654 TOP.t652 0.156982
R9918 TOP.t652 TOP.t650 0.156982
R9919 TOP.t650 TOP.t648 0.156982
R9920 TOP.t648 TOP.t646 0.156982
R9921 TOP.t646 TOP.t644 0.156982
R9922 TOP.t644 TOP.t642 0.156982
R9923 TOP.t642 TOP.t640 0.156982
R9924 TOP.t640 TOP.t638 0.156982
R9925 TOP.t3080 TOP.t636 0.156982
R9926 TOP.t636 TOP.t634 0.156982
R9927 TOP.t634 TOP.t632 0.156982
R9928 TOP.t632 TOP.t630 0.156982
R9929 TOP.t630 TOP.t628 0.156982
R9930 TOP.t628 TOP.t626 0.156982
R9931 TOP.t626 TOP.t624 0.156982
R9932 TOP.t624 TOP.t622 0.156982
R9933 TOP.t622 TOP.t620 0.156982
R9934 TOP.t620 TOP.t618 0.156982
R9935 TOP.t618 TOP.t616 0.156982
R9936 TOP.t616 TOP.t614 0.156982
R9937 TOP.t614 TOP.t612 0.156982
R9938 TOP.t612 TOP.t610 0.156982
R9939 TOP.t610 TOP.t608 0.156982
R9940 TOP.t608 TOP.t606 0.156982
R9941 TOP.t606 TOP.t604 0.156982
R9942 TOP.t604 TOP.t602 0.156982
R9943 TOP.t602 TOP.t600 0.156982
R9944 TOP.t600 TOP.t598 0.156982
R9945 TOP.t598 TOP.t596 0.156982
R9946 TOP.t596 TOP.t594 0.156982
R9947 TOP.t594 TOP.t592 0.156982
R9948 TOP.t592 TOP.t590 0.156982
R9949 TOP.t590 TOP.t588 0.156982
R9950 TOP.t588 TOP.t586 0.156982
R9951 TOP.t586 TOP.t584 0.156982
R9952 TOP.t584 TOP.t582 0.156982
R9953 TOP.t582 TOP.t580 0.156982
R9954 TOP.t580 TOP.t578 0.156982
R9955 TOP.t578 TOP.t576 0.156982
R9956 TOP.t576 TOP.t574 0.156982
R9957 TOP.t574 TOP.t572 0.156982
R9958 TOP.t572 TOP.t570 0.156982
R9959 TOP.t570 TOP.t568 0.156982
R9960 TOP.t568 TOP.t566 0.156982
R9961 TOP.t566 TOP.t564 0.156982
R9962 TOP.t564 TOP.t562 0.156982
R9963 TOP.t562 TOP.t560 0.156982
R9964 TOP.t560 TOP.t558 0.156982
R9965 TOP.t558 TOP.t556 0.156982
R9966 TOP.t556 TOP.t554 0.156982
R9967 TOP.t554 TOP.t552 0.156982
R9968 TOP.t552 TOP.t550 0.156982
R9969 TOP.t550 TOP.t548 0.156982
R9970 TOP.t548 TOP.t546 0.156982
R9971 TOP.t546 TOP.t544 0.156982
R9972 TOP.t544 TOP.t542 0.156982
R9973 TOP.t542 TOP.t540 0.156982
R9974 TOP.t540 TOP.t538 0.156982
R9975 TOP.t538 TOP.t536 0.156982
R9976 TOP.t536 TOP.t534 0.156982
R9977 TOP.t534 TOP.t532 0.156982
R9978 TOP.t532 TOP.t530 0.156982
R9979 TOP.t530 TOP.t528 0.156982
R9980 TOP.t528 TOP.t526 0.156982
R9981 TOP.t526 TOP.t524 0.156982
R9982 TOP.t524 TOP.t522 0.156982
R9983 TOP.t522 TOP.t520 0.156982
R9984 TOP.t520 TOP.t518 0.156982
R9985 TOP.t518 TOP.t516 0.156982
R9986 TOP.t516 TOP.t514 0.156982
R9987 TOP.t514 TOP.t512 0.156982
R9988 TOP.t3078 TOP.t7802 0.156982
R9989 TOP.t7802 TOP.t7800 0.156982
R9990 TOP.t7800 TOP.t7798 0.156982
R9991 TOP.t7798 TOP.t7796 0.156982
R9992 TOP.t7796 TOP.t7794 0.156982
R9993 TOP.t7794 TOP.t7792 0.156982
R9994 TOP.t7792 TOP.t7790 0.156982
R9995 TOP.t7790 TOP.t7788 0.156982
R9996 TOP.t7788 TOP.t7786 0.156982
R9997 TOP.t7786 TOP.t7784 0.156982
R9998 TOP.t7784 TOP.t7782 0.156982
R9999 TOP.t7782 TOP.t7780 0.156982
R10000 TOP.t7780 TOP.t7778 0.156982
R10001 TOP.t7778 TOP.t7776 0.156982
R10002 TOP.t7776 TOP.t7774 0.156982
R10003 TOP.t7774 TOP.t7772 0.156982
R10004 TOP.t7772 TOP.t7770 0.156982
R10005 TOP.t7770 TOP.t7768 0.156982
R10006 TOP.t7768 TOP.t7766 0.156982
R10007 TOP.t7766 TOP.t7764 0.156982
R10008 TOP.t7764 TOP.t7762 0.156982
R10009 TOP.t7762 TOP.t7760 0.156982
R10010 TOP.t7760 TOP.t7758 0.156982
R10011 TOP.t7758 TOP.t7756 0.156982
R10012 TOP.t7756 TOP.t7754 0.156982
R10013 TOP.t7754 TOP.t7752 0.156982
R10014 TOP.t7752 TOP.t7750 0.156982
R10015 TOP.t7750 TOP.t7748 0.156982
R10016 TOP.t7748 TOP.t7746 0.156982
R10017 TOP.t7746 TOP.t7744 0.156982
R10018 TOP.t7744 TOP.t7742 0.156982
R10019 TOP.t7742 TOP.t7740 0.156982
R10020 TOP.t7740 TOP.t7738 0.156982
R10021 TOP.t7738 TOP.t7736 0.156982
R10022 TOP.t7736 TOP.t7734 0.156982
R10023 TOP.t7734 TOP.t7732 0.156982
R10024 TOP.t7732 TOP.t7730 0.156982
R10025 TOP.t7730 TOP.t7728 0.156982
R10026 TOP.t7728 TOP.t7726 0.156982
R10027 TOP.t7726 TOP.t7724 0.156982
R10028 TOP.t7724 TOP.t7722 0.156982
R10029 TOP.t7722 TOP.t7720 0.156982
R10030 TOP.t7720 TOP.t7718 0.156982
R10031 TOP.t7718 TOP.t7716 0.156982
R10032 TOP.t7716 TOP.t7714 0.156982
R10033 TOP.t7714 TOP.t7712 0.156982
R10034 TOP.t7712 TOP.t7710 0.156982
R10035 TOP.t7710 TOP.t7708 0.156982
R10036 TOP.t7708 TOP.t7706 0.156982
R10037 TOP.t7706 TOP.t7704 0.156982
R10038 TOP.t7704 TOP.t7702 0.156982
R10039 TOP.t7702 TOP.t7700 0.156982
R10040 TOP.t7700 TOP.t7698 0.156982
R10041 TOP.t7698 TOP.t7696 0.156982
R10042 TOP.t7696 TOP.t7694 0.156982
R10043 TOP.t7694 TOP.t7692 0.156982
R10044 TOP.t7692 TOP.t7690 0.156982
R10045 TOP.t7690 TOP.t7688 0.156982
R10046 TOP.t7688 TOP.t7686 0.156982
R10047 TOP.t7686 TOP.t7684 0.156982
R10048 TOP.t7684 TOP.t7682 0.156982
R10049 TOP.t7682 TOP.t7680 0.156982
R10050 TOP.t7680 TOP.t7678 0.156982
R10051 TOP.t3076 TOP.t7676 0.156982
R10052 TOP.t7676 TOP.t7674 0.156982
R10053 TOP.t7674 TOP.t7672 0.156982
R10054 TOP.t7672 TOP.t7670 0.156982
R10055 TOP.t7670 TOP.t7668 0.156982
R10056 TOP.t7668 TOP.t7666 0.156982
R10057 TOP.t7666 TOP.t7664 0.156982
R10058 TOP.t7664 TOP.t7662 0.156982
R10059 TOP.t7662 TOP.t7660 0.156982
R10060 TOP.t7660 TOP.t7658 0.156982
R10061 TOP.t7658 TOP.t7656 0.156982
R10062 TOP.t7656 TOP.t7654 0.156982
R10063 TOP.t7654 TOP.t7652 0.156982
R10064 TOP.t7652 TOP.t7650 0.156982
R10065 TOP.t7650 TOP.t7648 0.156982
R10066 TOP.t7648 TOP.t7646 0.156982
R10067 TOP.t7646 TOP.t7644 0.156982
R10068 TOP.t7644 TOP.t7642 0.156982
R10069 TOP.t7642 TOP.t7640 0.156982
R10070 TOP.t7640 TOP.t7638 0.156982
R10071 TOP.t7638 TOP.t7636 0.156982
R10072 TOP.t7636 TOP.t7634 0.156982
R10073 TOP.t7634 TOP.t7632 0.156982
R10074 TOP.t7632 TOP.t7630 0.156982
R10075 TOP.t7630 TOP.t7628 0.156982
R10076 TOP.t7628 TOP.t7626 0.156982
R10077 TOP.t7626 TOP.t7624 0.156982
R10078 TOP.t7624 TOP.t7622 0.156982
R10079 TOP.t7622 TOP.t7620 0.156982
R10080 TOP.t7620 TOP.t7618 0.156982
R10081 TOP.t7618 TOP.t7616 0.156982
R10082 TOP.t7616 TOP.t7614 0.156982
R10083 TOP.t7614 TOP.t7612 0.156982
R10084 TOP.t7612 TOP.t7610 0.156982
R10085 TOP.t7610 TOP.t7608 0.156982
R10086 TOP.t7608 TOP.t7606 0.156982
R10087 TOP.t7606 TOP.t7604 0.156982
R10088 TOP.t7604 TOP.t7602 0.156982
R10089 TOP.t7602 TOP.t7600 0.156982
R10090 TOP.t7600 TOP.t7598 0.156982
R10091 TOP.t7598 TOP.t7596 0.156982
R10092 TOP.t7596 TOP.t7594 0.156982
R10093 TOP.t7594 TOP.t7592 0.156982
R10094 TOP.t7592 TOP.t7590 0.156982
R10095 TOP.t7590 TOP.t7588 0.156982
R10096 TOP.t7588 TOP.t7586 0.156982
R10097 TOP.t7586 TOP.t7584 0.156982
R10098 TOP.t7584 TOP.t7582 0.156982
R10099 TOP.t7582 TOP.t7580 0.156982
R10100 TOP.t7580 TOP.t7578 0.156982
R10101 TOP.t7578 TOP.t7576 0.156982
R10102 TOP.t7576 TOP.t7574 0.156982
R10103 TOP.t7574 TOP.t7572 0.156982
R10104 TOP.t7572 TOP.t7570 0.156982
R10105 TOP.t7570 TOP.t7568 0.156982
R10106 TOP.t7568 TOP.t7566 0.156982
R10107 TOP.t7566 TOP.t7564 0.156982
R10108 TOP.t7564 TOP.t7562 0.156982
R10109 TOP.t7562 TOP.t7560 0.156982
R10110 TOP.t7560 TOP.t7558 0.156982
R10111 TOP.t7558 TOP.t7556 0.156982
R10112 TOP.t7556 TOP.t7554 0.156982
R10113 TOP.t7554 TOP.t7552 0.156982
R10114 TOP.t3074 TOP.t8060 0.156982
R10115 TOP.t8060 TOP.t8058 0.156982
R10116 TOP.t8058 TOP.t8056 0.156982
R10117 TOP.t8056 TOP.t8054 0.156982
R10118 TOP.t8054 TOP.t8052 0.156982
R10119 TOP.t8052 TOP.t8050 0.156982
R10120 TOP.t8050 TOP.t8048 0.156982
R10121 TOP.t8048 TOP.t8046 0.156982
R10122 TOP.t8046 TOP.t8044 0.156982
R10123 TOP.t8044 TOP.t8042 0.156982
R10124 TOP.t8042 TOP.t8040 0.156982
R10125 TOP.t8040 TOP.t8038 0.156982
R10126 TOP.t8038 TOP.t8036 0.156982
R10127 TOP.t8036 TOP.t8034 0.156982
R10128 TOP.t8034 TOP.t8032 0.156982
R10129 TOP.t8032 TOP.t8030 0.156982
R10130 TOP.t8030 TOP.t8028 0.156982
R10131 TOP.t8028 TOP.t8026 0.156982
R10132 TOP.t8026 TOP.t8024 0.156982
R10133 TOP.t8024 TOP.t8022 0.156982
R10134 TOP.t8022 TOP.t8020 0.156982
R10135 TOP.t8020 TOP.t8018 0.156982
R10136 TOP.t8018 TOP.t8016 0.156982
R10137 TOP.t8016 TOP.t8014 0.156982
R10138 TOP.t8014 TOP.t8012 0.156982
R10139 TOP.t8012 TOP.t8010 0.156982
R10140 TOP.t8010 TOP.t8008 0.156982
R10141 TOP.t8008 TOP.t8006 0.156982
R10142 TOP.t8006 TOP.t8004 0.156982
R10143 TOP.t8004 TOP.t8002 0.156982
R10144 TOP.t8002 TOP.t8000 0.156982
R10145 TOP.t8000 TOP.t7998 0.156982
R10146 TOP.t7998 TOP.t7996 0.156982
R10147 TOP.t7996 TOP.t7994 0.156982
R10148 TOP.t7994 TOP.t7992 0.156982
R10149 TOP.t7992 TOP.t7990 0.156982
R10150 TOP.t7990 TOP.t7988 0.156982
R10151 TOP.t7988 TOP.t7986 0.156982
R10152 TOP.t7986 TOP.t7984 0.156982
R10153 TOP.t7984 TOP.t7982 0.156982
R10154 TOP.t7982 TOP.t7980 0.156982
R10155 TOP.t7980 TOP.t7978 0.156982
R10156 TOP.t7978 TOP.t7976 0.156982
R10157 TOP.t7976 TOP.t7974 0.156982
R10158 TOP.t7974 TOP.t7972 0.156982
R10159 TOP.t7972 TOP.t7970 0.156982
R10160 TOP.t7970 TOP.t7968 0.156982
R10161 TOP.t7968 TOP.t7966 0.156982
R10162 TOP.t7966 TOP.t7964 0.156982
R10163 TOP.t7964 TOP.t7962 0.156982
R10164 TOP.t7962 TOP.t7960 0.156982
R10165 TOP.t7960 TOP.t7958 0.156982
R10166 TOP.t7958 TOP.t7956 0.156982
R10167 TOP.t7956 TOP.t7954 0.156982
R10168 TOP.t7954 TOP.t7952 0.156982
R10169 TOP.t7952 TOP.t7950 0.156982
R10170 TOP.t7950 TOP.t7948 0.156982
R10171 TOP.t7948 TOP.t7946 0.156982
R10172 TOP.t7946 TOP.t7944 0.156982
R10173 TOP.t7944 TOP.t7942 0.156982
R10174 TOP.t7942 TOP.t7940 0.156982
R10175 TOP.t7940 TOP.t7938 0.156982
R10176 TOP.t7938 TOP.t7936 0.156982
R10177 TOP.t3072 TOP.t8148 0.156982
R10178 TOP.t8148 TOP.t8190 0.156982
R10179 TOP.t8190 TOP.t8188 0.156982
R10180 TOP.t8188 TOP.t8144 0.156982
R10181 TOP.t8144 TOP.t8142 0.156982
R10182 TOP.t8142 TOP.t8140 0.156982
R10183 TOP.t8140 TOP.t8138 0.156982
R10184 TOP.t8138 TOP.t8182 0.156982
R10185 TOP.t8182 TOP.t8180 0.156982
R10186 TOP.t8180 TOP.t8178 0.156982
R10187 TOP.t8178 TOP.t8176 0.156982
R10188 TOP.t8176 TOP.t8174 0.156982
R10189 TOP.t8174 TOP.t8172 0.156982
R10190 TOP.t8172 TOP.t8170 0.156982
R10191 TOP.t8170 TOP.t8168 0.156982
R10192 TOP.t8168 TOP.t8128 0.156982
R10193 TOP.t8128 TOP.t8126 0.156982
R10194 TOP.t8126 TOP.t8124 0.156982
R10195 TOP.t8124 TOP.t8122 0.156982
R10196 TOP.t8122 TOP.t8120 0.156982
R10197 TOP.t8120 TOP.t8118 0.156982
R10198 TOP.t8118 TOP.t8116 0.156982
R10199 TOP.t8116 TOP.t8114 0.156982
R10200 TOP.t8114 TOP.t8112 0.156982
R10201 TOP.t8112 TOP.t8110 0.156982
R10202 TOP.t8110 TOP.t8108 0.156982
R10203 TOP.t8108 TOP.t8106 0.156982
R10204 TOP.t8106 TOP.t8104 0.156982
R10205 TOP.t8104 TOP.t8102 0.156982
R10206 TOP.t8102 TOP.t8100 0.156982
R10207 TOP.t8100 TOP.t8098 0.156982
R10208 TOP.t8098 TOP.t8064 0.156982
R10209 TOP.t8064 TOP.t5244 0.156982
R10210 TOP.t5244 TOP.t5242 0.156982
R10211 TOP.t5242 TOP.t5240 0.156982
R10212 TOP.t5240 TOP.t5238 0.156982
R10213 TOP.t5238 TOP.t5236 0.156982
R10214 TOP.t5236 TOP.t5234 0.156982
R10215 TOP.t5234 TOP.t5232 0.156982
R10216 TOP.t5232 TOP.t5230 0.156982
R10217 TOP.t5230 TOP.t5228 0.156982
R10218 TOP.t5228 TOP.t5226 0.156982
R10219 TOP.t5226 TOP.t5224 0.156982
R10220 TOP.t5224 TOP.t5222 0.156982
R10221 TOP.t5222 TOP.t5220 0.156982
R10222 TOP.t5220 TOP.t5218 0.156982
R10223 TOP.t5218 TOP.t5216 0.156982
R10224 TOP.t5216 TOP.t5214 0.156982
R10225 TOP.t5214 TOP.t5212 0.156982
R10226 TOP.t5212 TOP.t5210 0.156982
R10227 TOP.t5210 TOP.t5208 0.156982
R10228 TOP.t5208 TOP.t5206 0.156982
R10229 TOP.t5206 TOP.t5204 0.156982
R10230 TOP.t5204 TOP.t5202 0.156982
R10231 TOP.t5202 TOP.t5200 0.156982
R10232 TOP.t5200 TOP.t5198 0.156982
R10233 TOP.t5198 TOP.t5196 0.156982
R10234 TOP.t5196 TOP.t5194 0.156982
R10235 TOP.t5194 TOP.t5192 0.156982
R10236 TOP.t5192 TOP.t5190 0.156982
R10237 TOP.t5190 TOP.t5188 0.156982
R10238 TOP.t5188 TOP.t5186 0.156982
R10239 TOP.t5186 TOP.t5184 0.156982
R10240 TOP.t5182 TOP.t5180 0.156982
R10241 TOP.t5180 TOP.t5178 0.156982
R10242 TOP.t5178 TOP.t5176 0.156982
R10243 TOP.t5176 TOP.t5174 0.156982
R10244 TOP.t5174 TOP.t5172 0.156982
R10245 TOP.t5172 TOP.t5170 0.156982
R10246 TOP.t5170 TOP.t5168 0.156982
R10247 TOP.t5168 TOP.t5166 0.156982
R10248 TOP.t5166 TOP.t5164 0.156982
R10249 TOP.t5164 TOP.t5162 0.156982
R10250 TOP.t5162 TOP.t5160 0.156982
R10251 TOP.t5160 TOP.t5158 0.156982
R10252 TOP.t5158 TOP.t5156 0.156982
R10253 TOP.t5156 TOP.t5154 0.156982
R10254 TOP.t5154 TOP.t5152 0.156982
R10255 TOP.t5152 TOP.t5150 0.156982
R10256 TOP.t5150 TOP.t5148 0.156982
R10257 TOP.t5148 TOP.t5146 0.156982
R10258 TOP.t5146 TOP.t5144 0.156982
R10259 TOP.t5144 TOP.t5142 0.156982
R10260 TOP.t5142 TOP.t5140 0.156982
R10261 TOP.t5140 TOP.t5138 0.156982
R10262 TOP.t5138 TOP.t5136 0.156982
R10263 TOP.t5136 TOP.t5134 0.156982
R10264 TOP.t5134 TOP.t5132 0.156982
R10265 TOP.t5132 TOP.t5130 0.156982
R10266 TOP.t5130 TOP.t5128 0.156982
R10267 TOP.t5128 TOP.t5126 0.156982
R10268 TOP.t5126 TOP.t5124 0.156982
R10269 TOP.t5124 TOP.t5122 0.156982
R10270 TOP.t5122 TOP.t8150 0.156982
R10271 TOP.t8150 TOP.t8096 0.156982
R10272 TOP.t8096 TOP.t8094 0.156982
R10273 TOP.t8094 TOP.t8092 0.156982
R10274 TOP.t8092 TOP.t8090 0.156982
R10275 TOP.t8090 TOP.t8088 0.156982
R10276 TOP.t8088 TOP.t8086 0.156982
R10277 TOP.t8086 TOP.t8084 0.156982
R10278 TOP.t8084 TOP.t8082 0.156982
R10279 TOP.t8082 TOP.t8080 0.156982
R10280 TOP.t8080 TOP.t8078 0.156982
R10281 TOP.t8078 TOP.t8076 0.156982
R10282 TOP.t8076 TOP.t8074 0.156982
R10283 TOP.t8074 TOP.t8072 0.156982
R10284 TOP.t8072 TOP.t8070 0.156982
R10285 TOP.t8070 TOP.t8068 0.156982
R10286 TOP.t8068 TOP.t8066 0.156982
R10287 TOP.t8066 TOP.t8166 0.156982
R10288 TOP.t8166 TOP.t8164 0.156982
R10289 TOP.t8164 TOP.t8162 0.156982
R10290 TOP.t8162 TOP.t8160 0.156982
R10291 TOP.t8160 TOP.t8158 0.156982
R10292 TOP.t8158 TOP.t8156 0.156982
R10293 TOP.t8156 TOP.t8154 0.156982
R10294 TOP.t8154 TOP.t8152 0.156982
R10295 TOP.t8152 TOP.t8136 0.156982
R10296 TOP.t8136 TOP.t8134 0.156982
R10297 TOP.t8134 TOP.t8132 0.156982
R10298 TOP.t8132 TOP.t8130 0.156982
R10299 TOP.t8130 TOP.t8186 0.156982
R10300 TOP.t8186 TOP.t8184 0.156982
R10301 TOP.t8184 TOP.t8146 0.156982
R10302 TOP.t8146 TOP.t3070 0.156982
R10303 TOP.t7934 TOP.t7932 0.156982
R10304 TOP.t7932 TOP.t7930 0.156982
R10305 TOP.t7930 TOP.t7928 0.156982
R10306 TOP.t7928 TOP.t7926 0.156982
R10307 TOP.t7926 TOP.t7924 0.156982
R10308 TOP.t7924 TOP.t7922 0.156982
R10309 TOP.t7922 TOP.t7920 0.156982
R10310 TOP.t7920 TOP.t7918 0.156982
R10311 TOP.t7918 TOP.t7916 0.156982
R10312 TOP.t7916 TOP.t7914 0.156982
R10313 TOP.t7914 TOP.t7912 0.156982
R10314 TOP.t7912 TOP.t7910 0.156982
R10315 TOP.t7910 TOP.t7908 0.156982
R10316 TOP.t7908 TOP.t7906 0.156982
R10317 TOP.t7906 TOP.t7904 0.156982
R10318 TOP.t7904 TOP.t7902 0.156982
R10319 TOP.t7902 TOP.t7900 0.156982
R10320 TOP.t7900 TOP.t7898 0.156982
R10321 TOP.t7898 TOP.t7896 0.156982
R10322 TOP.t7896 TOP.t7894 0.156982
R10323 TOP.t7894 TOP.t7892 0.156982
R10324 TOP.t7892 TOP.t7890 0.156982
R10325 TOP.t7890 TOP.t7888 0.156982
R10326 TOP.t7888 TOP.t7886 0.156982
R10327 TOP.t7886 TOP.t7884 0.156982
R10328 TOP.t7884 TOP.t7882 0.156982
R10329 TOP.t7882 TOP.t7880 0.156982
R10330 TOP.t7880 TOP.t7878 0.156982
R10331 TOP.t7878 TOP.t7876 0.156982
R10332 TOP.t7876 TOP.t7874 0.156982
R10333 TOP.t7874 TOP.t7872 0.156982
R10334 TOP.t7872 TOP.t7870 0.156982
R10335 TOP.t7870 TOP.t7868 0.156982
R10336 TOP.t7868 TOP.t7866 0.156982
R10337 TOP.t7866 TOP.t7864 0.156982
R10338 TOP.t7864 TOP.t7862 0.156982
R10339 TOP.t7862 TOP.t7860 0.156982
R10340 TOP.t7860 TOP.t7858 0.156982
R10341 TOP.t7858 TOP.t7856 0.156982
R10342 TOP.t7856 TOP.t7854 0.156982
R10343 TOP.t7854 TOP.t7852 0.156982
R10344 TOP.t7852 TOP.t7850 0.156982
R10345 TOP.t7850 TOP.t7848 0.156982
R10346 TOP.t7848 TOP.t7846 0.156982
R10347 TOP.t7846 TOP.t7844 0.156982
R10348 TOP.t7844 TOP.t7842 0.156982
R10349 TOP.t7842 TOP.t7840 0.156982
R10350 TOP.t7840 TOP.t7838 0.156982
R10351 TOP.t7838 TOP.t7836 0.156982
R10352 TOP.t7836 TOP.t7834 0.156982
R10353 TOP.t7834 TOP.t7832 0.156982
R10354 TOP.t7832 TOP.t7830 0.156982
R10355 TOP.t7830 TOP.t7828 0.156982
R10356 TOP.t7828 TOP.t7826 0.156982
R10357 TOP.t7826 TOP.t7824 0.156982
R10358 TOP.t7824 TOP.t7822 0.156982
R10359 TOP.t7822 TOP.t7820 0.156982
R10360 TOP.t7820 TOP.t7818 0.156982
R10361 TOP.t7818 TOP.t7816 0.156982
R10362 TOP.t7816 TOP.t7814 0.156982
R10363 TOP.t7814 TOP.t7812 0.156982
R10364 TOP.t7812 TOP.t7810 0.156982
R10365 TOP.t7810 TOP.t3068 0.156982
R10366 TOP.t7550 TOP.t7548 0.156982
R10367 TOP.t7548 TOP.t7546 0.156982
R10368 TOP.t7546 TOP.t7544 0.156982
R10369 TOP.t7544 TOP.t7542 0.156982
R10370 TOP.t7542 TOP.t7540 0.156982
R10371 TOP.t7540 TOP.t7538 0.156982
R10372 TOP.t7538 TOP.t7536 0.156982
R10373 TOP.t7536 TOP.t7534 0.156982
R10374 TOP.t7534 TOP.t7532 0.156982
R10375 TOP.t7532 TOP.t7530 0.156982
R10376 TOP.t7530 TOP.t7528 0.156982
R10377 TOP.t7528 TOP.t7526 0.156982
R10378 TOP.t7526 TOP.t7524 0.156982
R10379 TOP.t7524 TOP.t7522 0.156982
R10380 TOP.t7522 TOP.t7520 0.156982
R10381 TOP.t7520 TOP.t7518 0.156982
R10382 TOP.t7518 TOP.t7516 0.156982
R10383 TOP.t7516 TOP.t7514 0.156982
R10384 TOP.t7514 TOP.t7512 0.156982
R10385 TOP.t7512 TOP.t7510 0.156982
R10386 TOP.t7510 TOP.t7508 0.156982
R10387 TOP.t7508 TOP.t7506 0.156982
R10388 TOP.t7506 TOP.t7504 0.156982
R10389 TOP.t7504 TOP.t7502 0.156982
R10390 TOP.t7502 TOP.t7500 0.156982
R10391 TOP.t7500 TOP.t7498 0.156982
R10392 TOP.t7498 TOP.t7496 0.156982
R10393 TOP.t7496 TOP.t7494 0.156982
R10394 TOP.t7494 TOP.t7492 0.156982
R10395 TOP.t7492 TOP.t7490 0.156982
R10396 TOP.t7490 TOP.t7488 0.156982
R10397 TOP.t7488 TOP.t7486 0.156982
R10398 TOP.t7486 TOP.t7484 0.156982
R10399 TOP.t7484 TOP.t7482 0.156982
R10400 TOP.t7482 TOP.t7480 0.156982
R10401 TOP.t7480 TOP.t7478 0.156982
R10402 TOP.t7478 TOP.t7476 0.156982
R10403 TOP.t7476 TOP.t7474 0.156982
R10404 TOP.t7474 TOP.t7472 0.156982
R10405 TOP.t7472 TOP.t7470 0.156982
R10406 TOP.t7470 TOP.t7468 0.156982
R10407 TOP.t7468 TOP.t7466 0.156982
R10408 TOP.t7466 TOP.t7464 0.156982
R10409 TOP.t7464 TOP.t7462 0.156982
R10410 TOP.t7462 TOP.t7460 0.156982
R10411 TOP.t7460 TOP.t7458 0.156982
R10412 TOP.t7458 TOP.t7456 0.156982
R10413 TOP.t7456 TOP.t7454 0.156982
R10414 TOP.t7454 TOP.t7452 0.156982
R10415 TOP.t7452 TOP.t7450 0.156982
R10416 TOP.t7450 TOP.t7448 0.156982
R10417 TOP.t7448 TOP.t7446 0.156982
R10418 TOP.t7446 TOP.t7444 0.156982
R10419 TOP.t7444 TOP.t7442 0.156982
R10420 TOP.t7442 TOP.t7440 0.156982
R10421 TOP.t7440 TOP.t7438 0.156982
R10422 TOP.t7438 TOP.t7436 0.156982
R10423 TOP.t7436 TOP.t7434 0.156982
R10424 TOP.t7434 TOP.t7432 0.156982
R10425 TOP.t7432 TOP.t7430 0.156982
R10426 TOP.t7430 TOP.t7428 0.156982
R10427 TOP.t7428 TOP.t7426 0.156982
R10428 TOP.t7426 TOP.t3066 0.156982
R10429 TOP.t7424 TOP.t7422 0.156982
R10430 TOP.t7422 TOP.t7420 0.156982
R10431 TOP.t7420 TOP.t7418 0.156982
R10432 TOP.t7418 TOP.t7416 0.156982
R10433 TOP.t7416 TOP.t7414 0.156982
R10434 TOP.t7414 TOP.t7412 0.156982
R10435 TOP.t7412 TOP.t7410 0.156982
R10436 TOP.t7410 TOP.t7408 0.156982
R10437 TOP.t7408 TOP.t7406 0.156982
R10438 TOP.t7406 TOP.t7404 0.156982
R10439 TOP.t7404 TOP.t7402 0.156982
R10440 TOP.t7402 TOP.t7400 0.156982
R10441 TOP.t7400 TOP.t7398 0.156982
R10442 TOP.t7398 TOP.t7396 0.156982
R10443 TOP.t7396 TOP.t7394 0.156982
R10444 TOP.t7394 TOP.t7392 0.156982
R10445 TOP.t7392 TOP.t7390 0.156982
R10446 TOP.t7390 TOP.t7388 0.156982
R10447 TOP.t7388 TOP.t7386 0.156982
R10448 TOP.t7386 TOP.t7384 0.156982
R10449 TOP.t7384 TOP.t7382 0.156982
R10450 TOP.t7382 TOP.t7380 0.156982
R10451 TOP.t7380 TOP.t7378 0.156982
R10452 TOP.t7378 TOP.t7376 0.156982
R10453 TOP.t7376 TOP.t7374 0.156982
R10454 TOP.t7374 TOP.t7372 0.156982
R10455 TOP.t7372 TOP.t7370 0.156982
R10456 TOP.t7370 TOP.t7368 0.156982
R10457 TOP.t7368 TOP.t7366 0.156982
R10458 TOP.t7366 TOP.t7364 0.156982
R10459 TOP.t7364 TOP.t7362 0.156982
R10460 TOP.t7362 TOP.t7360 0.156982
R10461 TOP.t7360 TOP.t7358 0.156982
R10462 TOP.t7358 TOP.t7356 0.156982
R10463 TOP.t7356 TOP.t7354 0.156982
R10464 TOP.t7354 TOP.t7352 0.156982
R10465 TOP.t7352 TOP.t7350 0.156982
R10466 TOP.t7350 TOP.t7348 0.156982
R10467 TOP.t7348 TOP.t7346 0.156982
R10468 TOP.t7346 TOP.t7344 0.156982
R10469 TOP.t7344 TOP.t7342 0.156982
R10470 TOP.t7342 TOP.t7340 0.156982
R10471 TOP.t7340 TOP.t7338 0.156982
R10472 TOP.t7338 TOP.t7336 0.156982
R10473 TOP.t7336 TOP.t7334 0.156982
R10474 TOP.t7334 TOP.t7332 0.156982
R10475 TOP.t7332 TOP.t7330 0.156982
R10476 TOP.t7330 TOP.t7328 0.156982
R10477 TOP.t7328 TOP.t7326 0.156982
R10478 TOP.t7326 TOP.t7324 0.156982
R10479 TOP.t7324 TOP.t7322 0.156982
R10480 TOP.t7322 TOP.t7320 0.156982
R10481 TOP.t7320 TOP.t7318 0.156982
R10482 TOP.t7318 TOP.t7316 0.156982
R10483 TOP.t7316 TOP.t7314 0.156982
R10484 TOP.t7314 TOP.t7312 0.156982
R10485 TOP.t7312 TOP.t7310 0.156982
R10486 TOP.t7310 TOP.t7308 0.156982
R10487 TOP.t7308 TOP.t7306 0.156982
R10488 TOP.t7306 TOP.t7304 0.156982
R10489 TOP.t7304 TOP.t7302 0.156982
R10490 TOP.t7302 TOP.t7300 0.156982
R10491 TOP.t7300 TOP.t3064 0.156982
R10492 TOP.t510 TOP.t508 0.156982
R10493 TOP.t508 TOP.t506 0.156982
R10494 TOP.t506 TOP.t504 0.156982
R10495 TOP.t504 TOP.t502 0.156982
R10496 TOP.t502 TOP.t500 0.156982
R10497 TOP.t500 TOP.t498 0.156982
R10498 TOP.t498 TOP.t496 0.156982
R10499 TOP.t496 TOP.t494 0.156982
R10500 TOP.t494 TOP.t492 0.156982
R10501 TOP.t492 TOP.t490 0.156982
R10502 TOP.t490 TOP.t488 0.156982
R10503 TOP.t488 TOP.t486 0.156982
R10504 TOP.t486 TOP.t484 0.156982
R10505 TOP.t484 TOP.t482 0.156982
R10506 TOP.t482 TOP.t480 0.156982
R10507 TOP.t480 TOP.t478 0.156982
R10508 TOP.t478 TOP.t476 0.156982
R10509 TOP.t476 TOP.t474 0.156982
R10510 TOP.t474 TOP.t472 0.156982
R10511 TOP.t472 TOP.t470 0.156982
R10512 TOP.t470 TOP.t468 0.156982
R10513 TOP.t468 TOP.t466 0.156982
R10514 TOP.t466 TOP.t464 0.156982
R10515 TOP.t464 TOP.t462 0.156982
R10516 TOP.t462 TOP.t460 0.156982
R10517 TOP.t460 TOP.t458 0.156982
R10518 TOP.t458 TOP.t456 0.156982
R10519 TOP.t456 TOP.t454 0.156982
R10520 TOP.t454 TOP.t452 0.156982
R10521 TOP.t452 TOP.t450 0.156982
R10522 TOP.t450 TOP.t448 0.156982
R10523 TOP.t448 TOP.t446 0.156982
R10524 TOP.t446 TOP.t444 0.156982
R10525 TOP.t444 TOP.t442 0.156982
R10526 TOP.t442 TOP.t440 0.156982
R10527 TOP.t440 TOP.t438 0.156982
R10528 TOP.t438 TOP.t436 0.156982
R10529 TOP.t436 TOP.t434 0.156982
R10530 TOP.t434 TOP.t432 0.156982
R10531 TOP.t432 TOP.t430 0.156982
R10532 TOP.t430 TOP.t428 0.156982
R10533 TOP.t428 TOP.t426 0.156982
R10534 TOP.t426 TOP.t424 0.156982
R10535 TOP.t424 TOP.t422 0.156982
R10536 TOP.t422 TOP.t420 0.156982
R10537 TOP.t420 TOP.t418 0.156982
R10538 TOP.t418 TOP.t416 0.156982
R10539 TOP.t416 TOP.t414 0.156982
R10540 TOP.t414 TOP.t412 0.156982
R10541 TOP.t412 TOP.t410 0.156982
R10542 TOP.t410 TOP.t408 0.156982
R10543 TOP.t408 TOP.t406 0.156982
R10544 TOP.t406 TOP.t404 0.156982
R10545 TOP.t404 TOP.t402 0.156982
R10546 TOP.t402 TOP.t400 0.156982
R10547 TOP.t400 TOP.t398 0.156982
R10548 TOP.t398 TOP.t396 0.156982
R10549 TOP.t396 TOP.t394 0.156982
R10550 TOP.t394 TOP.t392 0.156982
R10551 TOP.t392 TOP.t390 0.156982
R10552 TOP.t390 TOP.t388 0.156982
R10553 TOP.t388 TOP.t386 0.156982
R10554 TOP.t386 TOP.t3062 0.156982
R10555 TOP.t384 TOP.t382 0.156982
R10556 TOP.t382 TOP.t380 0.156982
R10557 TOP.t380 TOP.t378 0.156982
R10558 TOP.t378 TOP.t376 0.156982
R10559 TOP.t376 TOP.t374 0.156982
R10560 TOP.t374 TOP.t372 0.156982
R10561 TOP.t372 TOP.t370 0.156982
R10562 TOP.t370 TOP.t368 0.156982
R10563 TOP.t368 TOP.t366 0.156982
R10564 TOP.t366 TOP.t364 0.156982
R10565 TOP.t364 TOP.t362 0.156982
R10566 TOP.t362 TOP.t360 0.156982
R10567 TOP.t360 TOP.t358 0.156982
R10568 TOP.t358 TOP.t356 0.156982
R10569 TOP.t356 TOP.t354 0.156982
R10570 TOP.t354 TOP.t352 0.156982
R10571 TOP.t352 TOP.t350 0.156982
R10572 TOP.t350 TOP.t348 0.156982
R10573 TOP.t348 TOP.t346 0.156982
R10574 TOP.t346 TOP.t344 0.156982
R10575 TOP.t344 TOP.t342 0.156982
R10576 TOP.t342 TOP.t340 0.156982
R10577 TOP.t340 TOP.t338 0.156982
R10578 TOP.t338 TOP.t336 0.156982
R10579 TOP.t336 TOP.t334 0.156982
R10580 TOP.t334 TOP.t332 0.156982
R10581 TOP.t332 TOP.t330 0.156982
R10582 TOP.t330 TOP.t328 0.156982
R10583 TOP.t328 TOP.t326 0.156982
R10584 TOP.t326 TOP.t324 0.156982
R10585 TOP.t324 TOP.t322 0.156982
R10586 TOP.t322 TOP.t320 0.156982
R10587 TOP.t320 TOP.t318 0.156982
R10588 TOP.t318 TOP.t316 0.156982
R10589 TOP.t316 TOP.t314 0.156982
R10590 TOP.t314 TOP.t312 0.156982
R10591 TOP.t312 TOP.t310 0.156982
R10592 TOP.t310 TOP.t308 0.156982
R10593 TOP.t308 TOP.t306 0.156982
R10594 TOP.t306 TOP.t304 0.156982
R10595 TOP.t304 TOP.t302 0.156982
R10596 TOP.t302 TOP.t300 0.156982
R10597 TOP.t300 TOP.t298 0.156982
R10598 TOP.t298 TOP.t296 0.156982
R10599 TOP.t296 TOP.t294 0.156982
R10600 TOP.t294 TOP.t292 0.156982
R10601 TOP.t292 TOP.t290 0.156982
R10602 TOP.t290 TOP.t288 0.156982
R10603 TOP.t288 TOP.t286 0.156982
R10604 TOP.t286 TOP.t284 0.156982
R10605 TOP.t284 TOP.t282 0.156982
R10606 TOP.t282 TOP.t280 0.156982
R10607 TOP.t280 TOP.t278 0.156982
R10608 TOP.t278 TOP.t276 0.156982
R10609 TOP.t276 TOP.t274 0.156982
R10610 TOP.t274 TOP.t272 0.156982
R10611 TOP.t272 TOP.t270 0.156982
R10612 TOP.t270 TOP.t268 0.156982
R10613 TOP.t268 TOP.t266 0.156982
R10614 TOP.t266 TOP.t264 0.156982
R10615 TOP.t264 TOP.t262 0.156982
R10616 TOP.t262 TOP.t260 0.156982
R10617 TOP.t260 TOP.t3060 0.156982
R10618 TOP.t258 TOP.t256 0.156982
R10619 TOP.t256 TOP.t254 0.156982
R10620 TOP.t254 TOP.t252 0.156982
R10621 TOP.t252 TOP.t250 0.156982
R10622 TOP.t250 TOP.t248 0.156982
R10623 TOP.t248 TOP.t246 0.156982
R10624 TOP.t246 TOP.t244 0.156982
R10625 TOP.t244 TOP.t242 0.156982
R10626 TOP.t242 TOP.t240 0.156982
R10627 TOP.t240 TOP.t238 0.156982
R10628 TOP.t238 TOP.t236 0.156982
R10629 TOP.t236 TOP.t234 0.156982
R10630 TOP.t234 TOP.t232 0.156982
R10631 TOP.t232 TOP.t230 0.156982
R10632 TOP.t230 TOP.t228 0.156982
R10633 TOP.t228 TOP.t226 0.156982
R10634 TOP.t226 TOP.t224 0.156982
R10635 TOP.t224 TOP.t222 0.156982
R10636 TOP.t222 TOP.t220 0.156982
R10637 TOP.t220 TOP.t218 0.156982
R10638 TOP.t218 TOP.t216 0.156982
R10639 TOP.t216 TOP.t214 0.156982
R10640 TOP.t214 TOP.t212 0.156982
R10641 TOP.t212 TOP.t210 0.156982
R10642 TOP.t210 TOP.t208 0.156982
R10643 TOP.t208 TOP.t206 0.156982
R10644 TOP.t206 TOP.t204 0.156982
R10645 TOP.t204 TOP.t202 0.156982
R10646 TOP.t202 TOP.t200 0.156982
R10647 TOP.t200 TOP.t198 0.156982
R10648 TOP.t198 TOP.t196 0.156982
R10649 TOP.t196 TOP.t194 0.156982
R10650 TOP.t194 TOP.t192 0.156982
R10651 TOP.t192 TOP.t190 0.156982
R10652 TOP.t190 TOP.t188 0.156982
R10653 TOP.t188 TOP.t186 0.156982
R10654 TOP.t186 TOP.t184 0.156982
R10655 TOP.t184 TOP.t182 0.156982
R10656 TOP.t182 TOP.t180 0.156982
R10657 TOP.t180 TOP.t178 0.156982
R10658 TOP.t178 TOP.t176 0.156982
R10659 TOP.t176 TOP.t174 0.156982
R10660 TOP.t174 TOP.t172 0.156982
R10661 TOP.t172 TOP.t170 0.156982
R10662 TOP.t170 TOP.t168 0.156982
R10663 TOP.t168 TOP.t166 0.156982
R10664 TOP.t166 TOP.t164 0.156982
R10665 TOP.t164 TOP.t162 0.156982
R10666 TOP.t162 TOP.t160 0.156982
R10667 TOP.t160 TOP.t158 0.156982
R10668 TOP.t158 TOP.t156 0.156982
R10669 TOP.t156 TOP.t154 0.156982
R10670 TOP.t154 TOP.t152 0.156982
R10671 TOP.t152 TOP.t150 0.156982
R10672 TOP.t150 TOP.t148 0.156982
R10673 TOP.t148 TOP.t146 0.156982
R10674 TOP.t146 TOP.t144 0.156982
R10675 TOP.t144 TOP.t142 0.156982
R10676 TOP.t142 TOP.t140 0.156982
R10677 TOP.t140 TOP.t138 0.156982
R10678 TOP.t138 TOP.t136 0.156982
R10679 TOP.t136 TOP.t134 0.156982
R10680 TOP.t134 TOP.t3058 0.156982
R10681 TOP.t132 TOP.t130 0.156982
R10682 TOP.t130 TOP.t128 0.156982
R10683 TOP.t128 TOP.t126 0.156982
R10684 TOP.t126 TOP.t124 0.156982
R10685 TOP.t124 TOP.t122 0.156982
R10686 TOP.t122 TOP.t120 0.156982
R10687 TOP.t120 TOP.t118 0.156982
R10688 TOP.t118 TOP.t116 0.156982
R10689 TOP.t116 TOP.t114 0.156982
R10690 TOP.t114 TOP.t112 0.156982
R10691 TOP.t112 TOP.t110 0.156982
R10692 TOP.t110 TOP.t108 0.156982
R10693 TOP.t108 TOP.t106 0.156982
R10694 TOP.t106 TOP.t104 0.156982
R10695 TOP.t104 TOP.t102 0.156982
R10696 TOP.t102 TOP.t100 0.156982
R10697 TOP.t100 TOP.t98 0.156982
R10698 TOP.t98 TOP.t96 0.156982
R10699 TOP.t96 TOP.t94 0.156982
R10700 TOP.t94 TOP.t92 0.156982
R10701 TOP.t92 TOP.t90 0.156982
R10702 TOP.t90 TOP.t88 0.156982
R10703 TOP.t88 TOP.t86 0.156982
R10704 TOP.t86 TOP.t84 0.156982
R10705 TOP.t84 TOP.t82 0.156982
R10706 TOP.t82 TOP.t80 0.156982
R10707 TOP.t80 TOP.t78 0.156982
R10708 TOP.t78 TOP.t76 0.156982
R10709 TOP.t76 TOP.t74 0.156982
R10710 TOP.t74 TOP.t72 0.156982
R10711 TOP.t72 TOP.t70 0.156982
R10712 TOP.t70 TOP.t68 0.156982
R10713 TOP.t68 TOP.t66 0.156982
R10714 TOP.t66 TOP.t64 0.156982
R10715 TOP.t64 TOP.t62 0.156982
R10716 TOP.t62 TOP.t60 0.156982
R10717 TOP.t60 TOP.t58 0.156982
R10718 TOP.t58 TOP.t56 0.156982
R10719 TOP.t56 TOP.t54 0.156982
R10720 TOP.t54 TOP.t52 0.156982
R10721 TOP.t52 TOP.t50 0.156982
R10722 TOP.t50 TOP.t48 0.156982
R10723 TOP.t48 TOP.t46 0.156982
R10724 TOP.t46 TOP.t44 0.156982
R10725 TOP.t44 TOP.t42 0.156982
R10726 TOP.t42 TOP.t40 0.156982
R10727 TOP.t40 TOP.t38 0.156982
R10728 TOP.t38 TOP.t36 0.156982
R10729 TOP.t36 TOP.t34 0.156982
R10730 TOP.t34 TOP.t32 0.156982
R10731 TOP.t32 TOP.t30 0.156982
R10732 TOP.t30 TOP.t28 0.156982
R10733 TOP.t28 TOP.t26 0.156982
R10734 TOP.t26 TOP.t24 0.156982
R10735 TOP.t24 TOP.t22 0.156982
R10736 TOP.t22 TOP.t20 0.156982
R10737 TOP.t20 TOP.t18 0.156982
R10738 TOP.t18 TOP.t16 0.156982
R10739 TOP.t16 TOP.t14 0.156982
R10740 TOP.t14 TOP.t12 0.156982
R10741 TOP.t12 TOP.t10 0.156982
R10742 TOP.t10 TOP.t8 0.156982
R10743 TOP.t8 TOP.t3056 0.156982
R10744 TOP.t6270 TOP.t6268 0.156982
R10745 TOP.t6268 TOP.t6266 0.156982
R10746 TOP.t6266 TOP.t6264 0.156982
R10747 TOP.t6264 TOP.t6262 0.156982
R10748 TOP.t6262 TOP.t6260 0.156982
R10749 TOP.t6260 TOP.t6258 0.156982
R10750 TOP.t6258 TOP.t6256 0.156982
R10751 TOP.t6256 TOP.t6254 0.156982
R10752 TOP.t6254 TOP.t6252 0.156982
R10753 TOP.t6252 TOP.t6250 0.156982
R10754 TOP.t6250 TOP.t6248 0.156982
R10755 TOP.t6248 TOP.t6246 0.156982
R10756 TOP.t6246 TOP.t6244 0.156982
R10757 TOP.t6244 TOP.t6242 0.156982
R10758 TOP.t6242 TOP.t6240 0.156982
R10759 TOP.t6240 TOP.t6238 0.156982
R10760 TOP.t6238 TOP.t6236 0.156982
R10761 TOP.t6236 TOP.t6234 0.156982
R10762 TOP.t6234 TOP.t6232 0.156982
R10763 TOP.t6232 TOP.t6230 0.156982
R10764 TOP.t6230 TOP.t6228 0.156982
R10765 TOP.t6228 TOP.t6226 0.156982
R10766 TOP.t6226 TOP.t6224 0.156982
R10767 TOP.t6224 TOP.t6222 0.156982
R10768 TOP.t6222 TOP.t6220 0.156982
R10769 TOP.t6220 TOP.t6218 0.156982
R10770 TOP.t6218 TOP.t6216 0.156982
R10771 TOP.t6216 TOP.t6214 0.156982
R10772 TOP.t6214 TOP.t6212 0.156982
R10773 TOP.t6212 TOP.t6210 0.156982
R10774 TOP.t6210 TOP.t6208 0.156982
R10775 TOP.t6208 TOP.t6206 0.156982
R10776 TOP.t6206 TOP.t6204 0.156982
R10777 TOP.t6204 TOP.t6202 0.156982
R10778 TOP.t6202 TOP.t6200 0.156982
R10779 TOP.t6200 TOP.t6198 0.156982
R10780 TOP.t6198 TOP.t6196 0.156982
R10781 TOP.t6196 TOP.t6194 0.156982
R10782 TOP.t6194 TOP.t6192 0.156982
R10783 TOP.t6192 TOP.t6190 0.156982
R10784 TOP.t6190 TOP.t6188 0.156982
R10785 TOP.t6188 TOP.t6186 0.156982
R10786 TOP.t6186 TOP.t6184 0.156982
R10787 TOP.t6184 TOP.t6182 0.156982
R10788 TOP.t6182 TOP.t6180 0.156982
R10789 TOP.t6180 TOP.t6178 0.156982
R10790 TOP.t6178 TOP.t6176 0.156982
R10791 TOP.t6176 TOP.t6174 0.156982
R10792 TOP.t6174 TOP.t6172 0.156982
R10793 TOP.t6172 TOP.t6170 0.156982
R10794 TOP.t6170 TOP.t6168 0.156982
R10795 TOP.t6168 TOP.t6166 0.156982
R10796 TOP.t6166 TOP.t6164 0.156982
R10797 TOP.t6164 TOP.t6162 0.156982
R10798 TOP.t6162 TOP.t6160 0.156982
R10799 TOP.t6160 TOP.t6158 0.156982
R10800 TOP.t6158 TOP.t6156 0.156982
R10801 TOP.t6156 TOP.t6154 0.156982
R10802 TOP.t6154 TOP.t6152 0.156982
R10803 TOP.t6152 TOP.t6150 0.156982
R10804 TOP.t6150 TOP.t6148 0.156982
R10805 TOP.t6148 TOP.t6146 0.156982
R10806 TOP.t6146 TOP.t3054 0.156982
R10807 TOP.t6144 TOP.t6142 0.156982
R10808 TOP.t6142 TOP.t6140 0.156982
R10809 TOP.t6140 TOP.t6138 0.156982
R10810 TOP.t6138 TOP.t6136 0.156982
R10811 TOP.t6136 TOP.t6134 0.156982
R10812 TOP.t6134 TOP.t6132 0.156982
R10813 TOP.t6132 TOP.t6130 0.156982
R10814 TOP.t6130 TOP.t6128 0.156982
R10815 TOP.t6128 TOP.t6126 0.156982
R10816 TOP.t6126 TOP.t6124 0.156982
R10817 TOP.t6124 TOP.t6122 0.156982
R10818 TOP.t6122 TOP.t6120 0.156982
R10819 TOP.t6120 TOP.t6118 0.156982
R10820 TOP.t6118 TOP.t6116 0.156982
R10821 TOP.t6116 TOP.t6114 0.156982
R10822 TOP.t6114 TOP.t6112 0.156982
R10823 TOP.t6112 TOP.t6110 0.156982
R10824 TOP.t6110 TOP.t6108 0.156982
R10825 TOP.t6108 TOP.t6106 0.156982
R10826 TOP.t6106 TOP.t6104 0.156982
R10827 TOP.t6104 TOP.t6102 0.156982
R10828 TOP.t6102 TOP.t6100 0.156982
R10829 TOP.t6100 TOP.t6098 0.156982
R10830 TOP.t6098 TOP.t6096 0.156982
R10831 TOP.t6096 TOP.t6094 0.156982
R10832 TOP.t6094 TOP.t6092 0.156982
R10833 TOP.t6092 TOP.t6090 0.156982
R10834 TOP.t6090 TOP.t6088 0.156982
R10835 TOP.t6088 TOP.t6086 0.156982
R10836 TOP.t6086 TOP.t6084 0.156982
R10837 TOP.t6084 TOP.t6082 0.156982
R10838 TOP.t6082 TOP.t6080 0.156982
R10839 TOP.t6080 TOP.t6078 0.156982
R10840 TOP.t6078 TOP.t6076 0.156982
R10841 TOP.t6076 TOP.t6074 0.156982
R10842 TOP.t6074 TOP.t6072 0.156982
R10843 TOP.t6072 TOP.t6070 0.156982
R10844 TOP.t6070 TOP.t6068 0.156982
R10845 TOP.t6068 TOP.t6066 0.156982
R10846 TOP.t6066 TOP.t6064 0.156982
R10847 TOP.t6064 TOP.t6062 0.156982
R10848 TOP.t6062 TOP.t6060 0.156982
R10849 TOP.t6060 TOP.t6058 0.156982
R10850 TOP.t6058 TOP.t6056 0.156982
R10851 TOP.t6056 TOP.t6054 0.156982
R10852 TOP.t6054 TOP.t6052 0.156982
R10853 TOP.t6052 TOP.t6050 0.156982
R10854 TOP.t6050 TOP.t6048 0.156982
R10855 TOP.t6048 TOP.t6046 0.156982
R10856 TOP.t6046 TOP.t6044 0.156982
R10857 TOP.t6044 TOP.t6042 0.156982
R10858 TOP.t6042 TOP.t6040 0.156982
R10859 TOP.t6040 TOP.t6038 0.156982
R10860 TOP.t6038 TOP.t6036 0.156982
R10861 TOP.t6036 TOP.t6034 0.156982
R10862 TOP.t6034 TOP.t6032 0.156982
R10863 TOP.t6032 TOP.t6030 0.156982
R10864 TOP.t6030 TOP.t6028 0.156982
R10865 TOP.t6028 TOP.t6026 0.156982
R10866 TOP.t6026 TOP.t6024 0.156982
R10867 TOP.t6024 TOP.t6022 0.156982
R10868 TOP.t6022 TOP.t6020 0.156982
R10869 TOP.t6020 TOP.t3052 0.156982
R10870 TOP.t6018 TOP.t6016 0.156982
R10871 TOP.t6016 TOP.t6014 0.156982
R10872 TOP.t6014 TOP.t6012 0.156982
R10873 TOP.t6012 TOP.t6010 0.156982
R10874 TOP.t6010 TOP.t6008 0.156982
R10875 TOP.t6008 TOP.t6006 0.156982
R10876 TOP.t6006 TOP.t6004 0.156982
R10877 TOP.t6004 TOP.t6002 0.156982
R10878 TOP.t6002 TOP.t6000 0.156982
R10879 TOP.t6000 TOP.t5998 0.156982
R10880 TOP.t5998 TOP.t5996 0.156982
R10881 TOP.t5996 TOP.t5994 0.156982
R10882 TOP.t5994 TOP.t5992 0.156982
R10883 TOP.t5992 TOP.t5990 0.156982
R10884 TOP.t5990 TOP.t5988 0.156982
R10885 TOP.t5988 TOP.t5986 0.156982
R10886 TOP.t5986 TOP.t5984 0.156982
R10887 TOP.t5984 TOP.t5982 0.156982
R10888 TOP.t5982 TOP.t5980 0.156982
R10889 TOP.t5980 TOP.t5978 0.156982
R10890 TOP.t5978 TOP.t5976 0.156982
R10891 TOP.t5976 TOP.t5974 0.156982
R10892 TOP.t5974 TOP.t5972 0.156982
R10893 TOP.t5972 TOP.t5970 0.156982
R10894 TOP.t5970 TOP.t5968 0.156982
R10895 TOP.t5968 TOP.t5966 0.156982
R10896 TOP.t5966 TOP.t5964 0.156982
R10897 TOP.t5964 TOP.t5962 0.156982
R10898 TOP.t5962 TOP.t5960 0.156982
R10899 TOP.t5960 TOP.t5958 0.156982
R10900 TOP.t5958 TOP.t5956 0.156982
R10901 TOP.t5956 TOP.t5954 0.156982
R10902 TOP.t5954 TOP.t5952 0.156982
R10903 TOP.t5952 TOP.t5950 0.156982
R10904 TOP.t5950 TOP.t5948 0.156982
R10905 TOP.t5948 TOP.t5946 0.156982
R10906 TOP.t5946 TOP.t5944 0.156982
R10907 TOP.t5944 TOP.t5942 0.156982
R10908 TOP.t5942 TOP.t5940 0.156982
R10909 TOP.t5940 TOP.t5938 0.156982
R10910 TOP.t5938 TOP.t5936 0.156982
R10911 TOP.t5936 TOP.t5934 0.156982
R10912 TOP.t5934 TOP.t5932 0.156982
R10913 TOP.t5932 TOP.t5930 0.156982
R10914 TOP.t5930 TOP.t5928 0.156982
R10915 TOP.t5928 TOP.t5926 0.156982
R10916 TOP.t5926 TOP.t5924 0.156982
R10917 TOP.t5924 TOP.t5922 0.156982
R10918 TOP.t5922 TOP.t5920 0.156982
R10919 TOP.t5920 TOP.t5918 0.156982
R10920 TOP.t5918 TOP.t5916 0.156982
R10921 TOP.t5916 TOP.t5914 0.156982
R10922 TOP.t5914 TOP.t5912 0.156982
R10923 TOP.t5912 TOP.t5910 0.156982
R10924 TOP.t5910 TOP.t5908 0.156982
R10925 TOP.t5908 TOP.t5906 0.156982
R10926 TOP.t5906 TOP.t5904 0.156982
R10927 TOP.t5904 TOP.t5902 0.156982
R10928 TOP.t5902 TOP.t5900 0.156982
R10929 TOP.t5900 TOP.t5898 0.156982
R10930 TOP.t5898 TOP.t5896 0.156982
R10931 TOP.t5896 TOP.t5894 0.156982
R10932 TOP.t5894 TOP.t3050 0.156982
R10933 TOP.t5892 TOP.t5890 0.156982
R10934 TOP.t5890 TOP.t5888 0.156982
R10935 TOP.t5888 TOP.t5886 0.156982
R10936 TOP.t5886 TOP.t5884 0.156982
R10937 TOP.t5884 TOP.t5882 0.156982
R10938 TOP.t5882 TOP.t5880 0.156982
R10939 TOP.t5880 TOP.t5878 0.156982
R10940 TOP.t5878 TOP.t5876 0.156982
R10941 TOP.t5876 TOP.t5874 0.156982
R10942 TOP.t5874 TOP.t5872 0.156982
R10943 TOP.t5872 TOP.t5870 0.156982
R10944 TOP.t5870 TOP.t5868 0.156982
R10945 TOP.t5868 TOP.t5866 0.156982
R10946 TOP.t5866 TOP.t5864 0.156982
R10947 TOP.t5864 TOP.t5862 0.156982
R10948 TOP.t5862 TOP.t5860 0.156982
R10949 TOP.t5860 TOP.t5858 0.156982
R10950 TOP.t5858 TOP.t5856 0.156982
R10951 TOP.t5856 TOP.t5854 0.156982
R10952 TOP.t5854 TOP.t5852 0.156982
R10953 TOP.t5852 TOP.t5850 0.156982
R10954 TOP.t5850 TOP.t5848 0.156982
R10955 TOP.t5848 TOP.t5846 0.156982
R10956 TOP.t5846 TOP.t5844 0.156982
R10957 TOP.t5844 TOP.t5842 0.156982
R10958 TOP.t5842 TOP.t5840 0.156982
R10959 TOP.t5840 TOP.t5838 0.156982
R10960 TOP.t5838 TOP.t5836 0.156982
R10961 TOP.t5836 TOP.t5834 0.156982
R10962 TOP.t5834 TOP.t5832 0.156982
R10963 TOP.t5832 TOP.t5830 0.156982
R10964 TOP.t5830 TOP.t5828 0.156982
R10965 TOP.t5828 TOP.t5826 0.156982
R10966 TOP.t5826 TOP.t5824 0.156982
R10967 TOP.t5824 TOP.t5822 0.156982
R10968 TOP.t5822 TOP.t5820 0.156982
R10969 TOP.t5820 TOP.t5818 0.156982
R10970 TOP.t5818 TOP.t5816 0.156982
R10971 TOP.t5816 TOP.t5814 0.156982
R10972 TOP.t5814 TOP.t5812 0.156982
R10973 TOP.t5812 TOP.t5810 0.156982
R10974 TOP.t5810 TOP.t5808 0.156982
R10975 TOP.t5808 TOP.t5806 0.156982
R10976 TOP.t5806 TOP.t5804 0.156982
R10977 TOP.t5804 TOP.t5802 0.156982
R10978 TOP.t5802 TOP.t5800 0.156982
R10979 TOP.t5800 TOP.t5798 0.156982
R10980 TOP.t5798 TOP.t5796 0.156982
R10981 TOP.t5796 TOP.t5794 0.156982
R10982 TOP.t5794 TOP.t5792 0.156982
R10983 TOP.t5792 TOP.t5790 0.156982
R10984 TOP.t5790 TOP.t5788 0.156982
R10985 TOP.t5788 TOP.t5786 0.156982
R10986 TOP.t5786 TOP.t5784 0.156982
R10987 TOP.t5784 TOP.t5782 0.156982
R10988 TOP.t5782 TOP.t5780 0.156982
R10989 TOP.t5780 TOP.t5778 0.156982
R10990 TOP.t5778 TOP.t5776 0.156982
R10991 TOP.t5776 TOP.t5774 0.156982
R10992 TOP.t5774 TOP.t5772 0.156982
R10993 TOP.t5772 TOP.t5770 0.156982
R10994 TOP.t5770 TOP.t5768 0.156982
R10995 TOP.t5768 TOP.t3048 0.156982
R10996 TOP.t5766 TOP.t5764 0.156982
R10997 TOP.t5764 TOP.t5762 0.156982
R10998 TOP.t5762 TOP.t5760 0.156982
R10999 TOP.t5760 TOP.t5758 0.156982
R11000 TOP.t5758 TOP.t5756 0.156982
R11001 TOP.t5756 TOP.t5754 0.156982
R11002 TOP.t5754 TOP.t5752 0.156982
R11003 TOP.t5752 TOP.t5750 0.156982
R11004 TOP.t5750 TOP.t5748 0.156982
R11005 TOP.t5748 TOP.t5746 0.156982
R11006 TOP.t5746 TOP.t5744 0.156982
R11007 TOP.t5744 TOP.t5742 0.156982
R11008 TOP.t5742 TOP.t5740 0.156982
R11009 TOP.t5740 TOP.t5738 0.156982
R11010 TOP.t5738 TOP.t5736 0.156982
R11011 TOP.t5736 TOP.t5734 0.156982
R11012 TOP.t5734 TOP.t5732 0.156982
R11013 TOP.t5732 TOP.t5730 0.156982
R11014 TOP.t5730 TOP.t5728 0.156982
R11015 TOP.t5728 TOP.t5726 0.156982
R11016 TOP.t5726 TOP.t5724 0.156982
R11017 TOP.t5724 TOP.t5722 0.156982
R11018 TOP.t5722 TOP.t5720 0.156982
R11019 TOP.t5720 TOP.t5718 0.156982
R11020 TOP.t5718 TOP.t5716 0.156982
R11021 TOP.t5716 TOP.t5714 0.156982
R11022 TOP.t5714 TOP.t5712 0.156982
R11023 TOP.t5712 TOP.t5710 0.156982
R11024 TOP.t5710 TOP.t5708 0.156982
R11025 TOP.t5708 TOP.t5706 0.156982
R11026 TOP.t5706 TOP.t5704 0.156982
R11027 TOP.t5704 TOP.t5702 0.156982
R11028 TOP.t5702 TOP.t5700 0.156982
R11029 TOP.t5700 TOP.t5698 0.156982
R11030 TOP.t5698 TOP.t5696 0.156982
R11031 TOP.t5696 TOP.t5694 0.156982
R11032 TOP.t5694 TOP.t5692 0.156982
R11033 TOP.t5692 TOP.t5690 0.156982
R11034 TOP.t5690 TOP.t5688 0.156982
R11035 TOP.t5688 TOP.t5686 0.156982
R11036 TOP.t5686 TOP.t5684 0.156982
R11037 TOP.t5684 TOP.t5682 0.156982
R11038 TOP.t5682 TOP.t5680 0.156982
R11039 TOP.t5680 TOP.t5678 0.156982
R11040 TOP.t5678 TOP.t5676 0.156982
R11041 TOP.t5676 TOP.t5674 0.156982
R11042 TOP.t5674 TOP.t5672 0.156982
R11043 TOP.t5672 TOP.t5670 0.156982
R11044 TOP.t5670 TOP.t5668 0.156982
R11045 TOP.t5668 TOP.t5666 0.156982
R11046 TOP.t5666 TOP.t5664 0.156982
R11047 TOP.t5664 TOP.t5662 0.156982
R11048 TOP.t5662 TOP.t5660 0.156982
R11049 TOP.t5660 TOP.t5658 0.156982
R11050 TOP.t5658 TOP.t5656 0.156982
R11051 TOP.t5656 TOP.t5654 0.156982
R11052 TOP.t5654 TOP.t5652 0.156982
R11053 TOP.t5652 TOP.t5650 0.156982
R11054 TOP.t5650 TOP.t5648 0.156982
R11055 TOP.t5648 TOP.t5646 0.156982
R11056 TOP.t5646 TOP.t5644 0.156982
R11057 TOP.t5644 TOP.t5642 0.156982
R11058 TOP.t5642 TOP.t3046 0.156982
R11059 TOP.t5640 TOP.t5638 0.156982
R11060 TOP.t5638 TOP.t5636 0.156982
R11061 TOP.t5636 TOP.t5634 0.156982
R11062 TOP.t5634 TOP.t5632 0.156982
R11063 TOP.t5632 TOP.t5630 0.156982
R11064 TOP.t5630 TOP.t5628 0.156982
R11065 TOP.t5628 TOP.t5626 0.156982
R11066 TOP.t5626 TOP.t5624 0.156982
R11067 TOP.t5624 TOP.t5622 0.156982
R11068 TOP.t5622 TOP.t5620 0.156982
R11069 TOP.t5620 TOP.t5618 0.156982
R11070 TOP.t5618 TOP.t5616 0.156982
R11071 TOP.t5616 TOP.t5614 0.156982
R11072 TOP.t5614 TOP.t5612 0.156982
R11073 TOP.t5612 TOP.t5610 0.156982
R11074 TOP.t5610 TOP.t5608 0.156982
R11075 TOP.t5608 TOP.t5606 0.156982
R11076 TOP.t5606 TOP.t5604 0.156982
R11077 TOP.t5604 TOP.t5602 0.156982
R11078 TOP.t5602 TOP.t5600 0.156982
R11079 TOP.t5600 TOP.t5598 0.156982
R11080 TOP.t5598 TOP.t5596 0.156982
R11081 TOP.t5596 TOP.t5594 0.156982
R11082 TOP.t5594 TOP.t5592 0.156982
R11083 TOP.t5592 TOP.t5590 0.156982
R11084 TOP.t5590 TOP.t5588 0.156982
R11085 TOP.t5588 TOP.t5586 0.156982
R11086 TOP.t5586 TOP.t5584 0.156982
R11087 TOP.t5584 TOP.t5582 0.156982
R11088 TOP.t5582 TOP.t5580 0.156982
R11089 TOP.t5580 TOP.t5578 0.156982
R11090 TOP.t5578 TOP.t5576 0.156982
R11091 TOP.t5576 TOP.t5574 0.156982
R11092 TOP.t5574 TOP.t5572 0.156982
R11093 TOP.t5572 TOP.t5570 0.156982
R11094 TOP.t5570 TOP.t5568 0.156982
R11095 TOP.t5568 TOP.t5566 0.156982
R11096 TOP.t5566 TOP.t5564 0.156982
R11097 TOP.t5564 TOP.t5562 0.156982
R11098 TOP.t5562 TOP.t5560 0.156982
R11099 TOP.t5560 TOP.t5558 0.156982
R11100 TOP.t5558 TOP.t5556 0.156982
R11101 TOP.t5556 TOP.t5554 0.156982
R11102 TOP.t5554 TOP.t5552 0.156982
R11103 TOP.t5552 TOP.t5550 0.156982
R11104 TOP.t5550 TOP.t5548 0.156982
R11105 TOP.t5548 TOP.t5546 0.156982
R11106 TOP.t5546 TOP.t5544 0.156982
R11107 TOP.t5544 TOP.t5542 0.156982
R11108 TOP.t5542 TOP.t5540 0.156982
R11109 TOP.t5540 TOP.t5538 0.156982
R11110 TOP.t5538 TOP.t5536 0.156982
R11111 TOP.t5536 TOP.t5534 0.156982
R11112 TOP.t5534 TOP.t5532 0.156982
R11113 TOP.t5532 TOP.t5530 0.156982
R11114 TOP.t5530 TOP.t5528 0.156982
R11115 TOP.t5528 TOP.t5526 0.156982
R11116 TOP.t5526 TOP.t5524 0.156982
R11117 TOP.t5524 TOP.t5522 0.156982
R11118 TOP.t5522 TOP.t5520 0.156982
R11119 TOP.t5520 TOP.t5518 0.156982
R11120 TOP.t5518 TOP.t5516 0.156982
R11121 TOP.t5516 TOP.t3044 0.156982
R11122 TOP.t5514 TOP.t5512 0.156982
R11123 TOP.t5512 TOP.t5510 0.156982
R11124 TOP.t5510 TOP.t5508 0.156982
R11125 TOP.t5508 TOP.t5506 0.156982
R11126 TOP.t5506 TOP.t5504 0.156982
R11127 TOP.t5504 TOP.t5502 0.156982
R11128 TOP.t5502 TOP.t5500 0.156982
R11129 TOP.t5500 TOP.t5498 0.156982
R11130 TOP.t5498 TOP.t5496 0.156982
R11131 TOP.t5496 TOP.t5494 0.156982
R11132 TOP.t5494 TOP.t5492 0.156982
R11133 TOP.t5492 TOP.t5490 0.156982
R11134 TOP.t5490 TOP.t5488 0.156982
R11135 TOP.t5488 TOP.t5486 0.156982
R11136 TOP.t5486 TOP.t5484 0.156982
R11137 TOP.t5484 TOP.t5482 0.156982
R11138 TOP.t5482 TOP.t5480 0.156982
R11139 TOP.t5480 TOP.t5478 0.156982
R11140 TOP.t5478 TOP.t5476 0.156982
R11141 TOP.t5476 TOP.t5474 0.156982
R11142 TOP.t5474 TOP.t5472 0.156982
R11143 TOP.t5472 TOP.t5470 0.156982
R11144 TOP.t5470 TOP.t5468 0.156982
R11145 TOP.t5468 TOP.t5466 0.156982
R11146 TOP.t5466 TOP.t5464 0.156982
R11147 TOP.t5464 TOP.t5462 0.156982
R11148 TOP.t5462 TOP.t5460 0.156982
R11149 TOP.t5460 TOP.t5458 0.156982
R11150 TOP.t5458 TOP.t5456 0.156982
R11151 TOP.t5456 TOP.t5454 0.156982
R11152 TOP.t5454 TOP.t5452 0.156982
R11153 TOP.t5452 TOP.t5450 0.156982
R11154 TOP.t5450 TOP.t5448 0.156982
R11155 TOP.t5448 TOP.t5446 0.156982
R11156 TOP.t5446 TOP.t5444 0.156982
R11157 TOP.t5444 TOP.t5442 0.156982
R11158 TOP.t5442 TOP.t5440 0.156982
R11159 TOP.t5440 TOP.t5438 0.156982
R11160 TOP.t5438 TOP.t5436 0.156982
R11161 TOP.t5436 TOP.t5434 0.156982
R11162 TOP.t5434 TOP.t5432 0.156982
R11163 TOP.t5432 TOP.t5430 0.156982
R11164 TOP.t5430 TOP.t5428 0.156982
R11165 TOP.t5428 TOP.t5426 0.156982
R11166 TOP.t5426 TOP.t5424 0.156982
R11167 TOP.t5424 TOP.t5422 0.156982
R11168 TOP.t5422 TOP.t5420 0.156982
R11169 TOP.t5420 TOP.t5418 0.156982
R11170 TOP.t5418 TOP.t5416 0.156982
R11171 TOP.t5416 TOP.t5414 0.156982
R11172 TOP.t5414 TOP.t5412 0.156982
R11173 TOP.t5412 TOP.t5410 0.156982
R11174 TOP.t5410 TOP.t5408 0.156982
R11175 TOP.t5408 TOP.t5406 0.156982
R11176 TOP.t5406 TOP.t5404 0.156982
R11177 TOP.t5404 TOP.t5402 0.156982
R11178 TOP.t5402 TOP.t5400 0.156982
R11179 TOP.t5400 TOP.t5398 0.156982
R11180 TOP.t5398 TOP.t5396 0.156982
R11181 TOP.t5396 TOP.t5394 0.156982
R11182 TOP.t5394 TOP.t5392 0.156982
R11183 TOP.t5392 TOP.t5390 0.156982
R11184 TOP.t5390 TOP.t3042 0.156982
R11185 TOP.t5388 TOP.t5386 0.156982
R11186 TOP.t5386 TOP.t5384 0.156982
R11187 TOP.t5384 TOP.t5382 0.156982
R11188 TOP.t5382 TOP.t5380 0.156982
R11189 TOP.t5380 TOP.t5378 0.156982
R11190 TOP.t5378 TOP.t5376 0.156982
R11191 TOP.t5376 TOP.t5374 0.156982
R11192 TOP.t5374 TOP.t5372 0.156982
R11193 TOP.t5372 TOP.t5370 0.156982
R11194 TOP.t5370 TOP.t5368 0.156982
R11195 TOP.t5368 TOP.t5366 0.156982
R11196 TOP.t5366 TOP.t5364 0.156982
R11197 TOP.t5364 TOP.t5362 0.156982
R11198 TOP.t5362 TOP.t5360 0.156982
R11199 TOP.t5360 TOP.t5358 0.156982
R11200 TOP.t5358 TOP.t5356 0.156982
R11201 TOP.t5356 TOP.t5354 0.156982
R11202 TOP.t5354 TOP.t5352 0.156982
R11203 TOP.t5352 TOP.t5350 0.156982
R11204 TOP.t5350 TOP.t5348 0.156982
R11205 TOP.t5348 TOP.t5346 0.156982
R11206 TOP.t5346 TOP.t5344 0.156982
R11207 TOP.t5344 TOP.t5342 0.156982
R11208 TOP.t5342 TOP.t5340 0.156982
R11209 TOP.t5340 TOP.t5338 0.156982
R11210 TOP.t5338 TOP.t5336 0.156982
R11211 TOP.t5336 TOP.t5334 0.156982
R11212 TOP.t5334 TOP.t5332 0.156982
R11213 TOP.t5332 TOP.t5330 0.156982
R11214 TOP.t5330 TOP.t5328 0.156982
R11215 TOP.t5328 TOP.t5326 0.156982
R11216 TOP.t5326 TOP.t5324 0.156982
R11217 TOP.t5324 TOP.t5322 0.156982
R11218 TOP.t5322 TOP.t5320 0.156982
R11219 TOP.t5320 TOP.t5318 0.156982
R11220 TOP.t5318 TOP.t5316 0.156982
R11221 TOP.t5316 TOP.t5314 0.156982
R11222 TOP.t5314 TOP.t5312 0.156982
R11223 TOP.t5312 TOP.t5310 0.156982
R11224 TOP.t5310 TOP.t5308 0.156982
R11225 TOP.t5308 TOP.t5306 0.156982
R11226 TOP.t5306 TOP.t5304 0.156982
R11227 TOP.t5304 TOP.t5302 0.156982
R11228 TOP.t5302 TOP.t5300 0.156982
R11229 TOP.t5300 TOP.t5298 0.156982
R11230 TOP.t5298 TOP.t5296 0.156982
R11231 TOP.t5296 TOP.t5294 0.156982
R11232 TOP.t5294 TOP.t5292 0.156982
R11233 TOP.t5292 TOP.t5290 0.156982
R11234 TOP.t5290 TOP.t5288 0.156982
R11235 TOP.t5288 TOP.t5286 0.156982
R11236 TOP.t5286 TOP.t5284 0.156982
R11237 TOP.t5284 TOP.t5282 0.156982
R11238 TOP.t5282 TOP.t5280 0.156982
R11239 TOP.t5280 TOP.t5278 0.156982
R11240 TOP.t5278 TOP.t5276 0.156982
R11241 TOP.t5276 TOP.t5274 0.156982
R11242 TOP.t5274 TOP.t5272 0.156982
R11243 TOP.t5272 TOP.t5270 0.156982
R11244 TOP.t5270 TOP.t5268 0.156982
R11245 TOP.t5268 TOP.t5266 0.156982
R11246 TOP.t5266 TOP.t5264 0.156982
R11247 TOP.t5264 TOP.t3040 0.156982
R11248 TOP.t3038 TOP.t3036 0.156982
R11249 TOP.t3036 TOP.t3034 0.156982
R11250 TOP.t3034 TOP.t3032 0.156982
R11251 TOP.t3032 TOP.t3030 0.156982
R11252 TOP.t3030 TOP.t3028 0.156982
R11253 TOP.t3028 TOP.t3026 0.156982
R11254 TOP.t3026 TOP.t3024 0.156982
R11255 TOP.t3024 TOP.t3022 0.156982
R11256 TOP.t3022 TOP.t3020 0.156982
R11257 TOP.t3020 TOP.t3018 0.156982
R11258 TOP.t3018 TOP.t3016 0.156982
R11259 TOP.t3016 TOP.t3014 0.156982
R11260 TOP.t3014 TOP.t3012 0.156982
R11261 TOP.t3012 TOP.t3010 0.156982
R11262 TOP.t3010 TOP.t3008 0.156982
R11263 TOP.t3008 TOP.t3006 0.156982
R11264 TOP.t3006 TOP.t3004 0.156982
R11265 TOP.t3004 TOP.t3002 0.156982
R11266 TOP.t3002 TOP.t3000 0.156982
R11267 TOP.t3000 TOP.t2998 0.156982
R11268 TOP.t2998 TOP.t2996 0.156982
R11269 TOP.t2996 TOP.t2994 0.156982
R11270 TOP.t2994 TOP.t2992 0.156982
R11271 TOP.t2992 TOP.t2990 0.156982
R11272 TOP.t2990 TOP.t2988 0.156982
R11273 TOP.t2988 TOP.t2986 0.156982
R11274 TOP.t2986 TOP.t2984 0.156982
R11275 TOP.t2984 TOP.t2982 0.156982
R11276 TOP.t2982 TOP.t2980 0.156982
R11277 TOP.t2980 TOP.t2978 0.156982
R11278 TOP.t2978 TOP.t2976 0.156982
R11279 TOP.t2976 TOP.t2974 0.156982
R11280 TOP.t2974 TOP.t2972 0.156982
R11281 TOP.t2972 TOP.t2970 0.156982
R11282 TOP.t2970 TOP.t2968 0.156982
R11283 TOP.t2968 TOP.t2966 0.156982
R11284 TOP.t2966 TOP.t2964 0.156982
R11285 TOP.t2964 TOP.t2962 0.156982
R11286 TOP.t2962 TOP.t2960 0.156982
R11287 TOP.t2960 TOP.t2958 0.156982
R11288 TOP.t2958 TOP.t2956 0.156982
R11289 TOP.t2956 TOP.t2954 0.156982
R11290 TOP.t2954 TOP.t2952 0.156982
R11291 TOP.t2952 TOP.t2950 0.156982
R11292 TOP.t2950 TOP.t2948 0.156982
R11293 TOP.t2948 TOP.t2946 0.156982
R11294 TOP.t2946 TOP.t2944 0.156982
R11295 TOP.t2944 TOP.t2942 0.156982
R11296 TOP.t2942 TOP.t2940 0.156982
R11297 TOP.t2940 TOP.t2938 0.156982
R11298 TOP.t2938 TOP.t2936 0.156982
R11299 TOP.t2936 TOP.t2934 0.156982
R11300 TOP.t2934 TOP.t2932 0.156982
R11301 TOP.t2932 TOP.t2930 0.156982
R11302 TOP.t2930 TOP.t2928 0.156982
R11303 TOP.t2928 TOP.t2926 0.156982
R11304 TOP.t2926 TOP.t2924 0.156982
R11305 TOP.t2924 TOP.t2922 0.156982
R11306 TOP.t2922 TOP.t2920 0.156982
R11307 TOP.t2920 TOP.t2918 0.156982
R11308 TOP.t2918 TOP.t2916 0.156982
R11309 TOP.t2916 TOP.t2914 0.156982
R11310 TOP.t2914 TOP.t5262 0.156982
R11311 TOP.t2912 TOP.t2910 0.156982
R11312 TOP.t2910 TOP.t2908 0.156982
R11313 TOP.t2908 TOP.t2906 0.156982
R11314 TOP.t2906 TOP.t2904 0.156982
R11315 TOP.t2904 TOP.t2902 0.156982
R11316 TOP.t2902 TOP.t2900 0.156982
R11317 TOP.t2900 TOP.t2898 0.156982
R11318 TOP.t2898 TOP.t2896 0.156982
R11319 TOP.t2896 TOP.t2894 0.156982
R11320 TOP.t2894 TOP.t2892 0.156982
R11321 TOP.t2892 TOP.t2890 0.156982
R11322 TOP.t2890 TOP.t2888 0.156982
R11323 TOP.t2888 TOP.t2886 0.156982
R11324 TOP.t2886 TOP.t2884 0.156982
R11325 TOP.t2884 TOP.t2882 0.156982
R11326 TOP.t2882 TOP.t2880 0.156982
R11327 TOP.t2880 TOP.t2878 0.156982
R11328 TOP.t2878 TOP.t2876 0.156982
R11329 TOP.t2876 TOP.t2874 0.156982
R11330 TOP.t2874 TOP.t2872 0.156982
R11331 TOP.t2872 TOP.t2870 0.156982
R11332 TOP.t2870 TOP.t2868 0.156982
R11333 TOP.t2868 TOP.t2866 0.156982
R11334 TOP.t2866 TOP.t2864 0.156982
R11335 TOP.t2864 TOP.t2862 0.156982
R11336 TOP.t2862 TOP.t2860 0.156982
R11337 TOP.t2860 TOP.t2858 0.156982
R11338 TOP.t2858 TOP.t2856 0.156982
R11339 TOP.t2856 TOP.t2854 0.156982
R11340 TOP.t2854 TOP.t2852 0.156982
R11341 TOP.t2852 TOP.t2850 0.156982
R11342 TOP.t2850 TOP.t2848 0.156982
R11343 TOP.t2848 TOP.t2846 0.156982
R11344 TOP.t2846 TOP.t2844 0.156982
R11345 TOP.t2844 TOP.t2842 0.156982
R11346 TOP.t2842 TOP.t2840 0.156982
R11347 TOP.t2840 TOP.t2838 0.156982
R11348 TOP.t2838 TOP.t2836 0.156982
R11349 TOP.t2836 TOP.t2834 0.156982
R11350 TOP.t2834 TOP.t2832 0.156982
R11351 TOP.t2832 TOP.t2830 0.156982
R11352 TOP.t2830 TOP.t2828 0.156982
R11353 TOP.t2828 TOP.t2826 0.156982
R11354 TOP.t2826 TOP.t2824 0.156982
R11355 TOP.t2824 TOP.t2822 0.156982
R11356 TOP.t2822 TOP.t2820 0.156982
R11357 TOP.t2820 TOP.t2818 0.156982
R11358 TOP.t2818 TOP.t2816 0.156982
R11359 TOP.t2816 TOP.t2814 0.156982
R11360 TOP.t2814 TOP.t2812 0.156982
R11361 TOP.t2812 TOP.t2810 0.156982
R11362 TOP.t2810 TOP.t2808 0.156982
R11363 TOP.t2808 TOP.t2806 0.156982
R11364 TOP.t2806 TOP.t2804 0.156982
R11365 TOP.t2804 TOP.t2802 0.156982
R11366 TOP.t2802 TOP.t2800 0.156982
R11367 TOP.t2800 TOP.t2798 0.156982
R11368 TOP.t2798 TOP.t2796 0.156982
R11369 TOP.t2796 TOP.t2794 0.156982
R11370 TOP.t2794 TOP.t2792 0.156982
R11371 TOP.t2792 TOP.t2790 0.156982
R11372 TOP.t2790 TOP.t2788 0.156982
R11373 TOP.t2788 TOP.t5260 0.156982
R11374 TOP.t2786 TOP.t2784 0.156982
R11375 TOP.t2784 TOP.t2782 0.156982
R11376 TOP.t2782 TOP.t2780 0.156982
R11377 TOP.t2780 TOP.t2778 0.156982
R11378 TOP.t2778 TOP.t2776 0.156982
R11379 TOP.t2776 TOP.t2774 0.156982
R11380 TOP.t2774 TOP.t2772 0.156982
R11381 TOP.t2772 TOP.t2770 0.156982
R11382 TOP.t2770 TOP.t2768 0.156982
R11383 TOP.t2768 TOP.t2766 0.156982
R11384 TOP.t2766 TOP.t2764 0.156982
R11385 TOP.t2764 TOP.t2762 0.156982
R11386 TOP.t2762 TOP.t2760 0.156982
R11387 TOP.t2760 TOP.t2758 0.156982
R11388 TOP.t2758 TOP.t2756 0.156982
R11389 TOP.t2756 TOP.t2754 0.156982
R11390 TOP.t2754 TOP.t2752 0.156982
R11391 TOP.t2752 TOP.t2750 0.156982
R11392 TOP.t2750 TOP.t2748 0.156982
R11393 TOP.t2748 TOP.t2746 0.156982
R11394 TOP.t2746 TOP.t2744 0.156982
R11395 TOP.t2744 TOP.t2742 0.156982
R11396 TOP.t2742 TOP.t2740 0.156982
R11397 TOP.t2740 TOP.t2738 0.156982
R11398 TOP.t2738 TOP.t2736 0.156982
R11399 TOP.t2736 TOP.t2734 0.156982
R11400 TOP.t2734 TOP.t2732 0.156982
R11401 TOP.t2732 TOP.t2730 0.156982
R11402 TOP.t2730 TOP.t2728 0.156982
R11403 TOP.t2728 TOP.t2726 0.156982
R11404 TOP.t2726 TOP.t2724 0.156982
R11405 TOP.t2724 TOP.t2722 0.156982
R11406 TOP.t2722 TOP.t2720 0.156982
R11407 TOP.t2720 TOP.t2718 0.156982
R11408 TOP.t2718 TOP.t2716 0.156982
R11409 TOP.t2716 TOP.t2714 0.156982
R11410 TOP.t2714 TOP.t2712 0.156982
R11411 TOP.t2712 TOP.t2710 0.156982
R11412 TOP.t2710 TOP.t2708 0.156982
R11413 TOP.t2708 TOP.t2706 0.156982
R11414 TOP.t2706 TOP.t2704 0.156982
R11415 TOP.t2704 TOP.t2702 0.156982
R11416 TOP.t2702 TOP.t2700 0.156982
R11417 TOP.t2700 TOP.t2698 0.156982
R11418 TOP.t2698 TOP.t2696 0.156982
R11419 TOP.t2696 TOP.t2694 0.156982
R11420 TOP.t2694 TOP.t2692 0.156982
R11421 TOP.t2692 TOP.t2690 0.156982
R11422 TOP.t2690 TOP.t2688 0.156982
R11423 TOP.t2688 TOP.t2686 0.156982
R11424 TOP.t2686 TOP.t2684 0.156982
R11425 TOP.t2684 TOP.t2682 0.156982
R11426 TOP.t2682 TOP.t2680 0.156982
R11427 TOP.t2680 TOP.t2678 0.156982
R11428 TOP.t2678 TOP.t2676 0.156982
R11429 TOP.t2676 TOP.t2674 0.156982
R11430 TOP.t2674 TOP.t2672 0.156982
R11431 TOP.t2672 TOP.t2670 0.156982
R11432 TOP.t2670 TOP.t2668 0.156982
R11433 TOP.t2668 TOP.t2666 0.156982
R11434 TOP.t2666 TOP.t2664 0.156982
R11435 TOP.t2664 TOP.t2662 0.156982
R11436 TOP.t2662 TOP.t5258 0.156982
R11437 TOP.t2660 TOP.t2658 0.156982
R11438 TOP.t2658 TOP.t2656 0.156982
R11439 TOP.t2656 TOP.t2654 0.156982
R11440 TOP.t2654 TOP.t2652 0.156982
R11441 TOP.t2652 TOP.t2650 0.156982
R11442 TOP.t2650 TOP.t2648 0.156982
R11443 TOP.t2648 TOP.t2646 0.156982
R11444 TOP.t2646 TOP.t2644 0.156982
R11445 TOP.t2644 TOP.t2642 0.156982
R11446 TOP.t2642 TOP.t2640 0.156982
R11447 TOP.t2640 TOP.t2638 0.156982
R11448 TOP.t2638 TOP.t2636 0.156982
R11449 TOP.t2636 TOP.t2634 0.156982
R11450 TOP.t2634 TOP.t2632 0.156982
R11451 TOP.t2632 TOP.t2630 0.156982
R11452 TOP.t2630 TOP.t2628 0.156982
R11453 TOP.t2628 TOP.t2626 0.156982
R11454 TOP.t2626 TOP.t2624 0.156982
R11455 TOP.t2624 TOP.t2622 0.156982
R11456 TOP.t2622 TOP.t2620 0.156982
R11457 TOP.t2620 TOP.t2618 0.156982
R11458 TOP.t2618 TOP.t2616 0.156982
R11459 TOP.t2616 TOP.t2614 0.156982
R11460 TOP.t2614 TOP.t2612 0.156982
R11461 TOP.t2612 TOP.t2610 0.156982
R11462 TOP.t2610 TOP.t2608 0.156982
R11463 TOP.t2608 TOP.t2606 0.156982
R11464 TOP.t2606 TOP.t2604 0.156982
R11465 TOP.t2604 TOP.t2602 0.156982
R11466 TOP.t2602 TOP.t2600 0.156982
R11467 TOP.t2600 TOP.t2598 0.156982
R11468 TOP.t2598 TOP.t2596 0.156982
R11469 TOP.t2596 TOP.t2594 0.156982
R11470 TOP.t2594 TOP.t2592 0.156982
R11471 TOP.t2592 TOP.t2590 0.156982
R11472 TOP.t2590 TOP.t2588 0.156982
R11473 TOP.t2588 TOP.t2586 0.156982
R11474 TOP.t2586 TOP.t2584 0.156982
R11475 TOP.t2584 TOP.t2582 0.156982
R11476 TOP.t2582 TOP.t2580 0.156982
R11477 TOP.t2580 TOP.t2578 0.156982
R11478 TOP.t2578 TOP.t2576 0.156982
R11479 TOP.t2576 TOP.t2574 0.156982
R11480 TOP.t2574 TOP.t2572 0.156982
R11481 TOP.t2572 TOP.t2570 0.156982
R11482 TOP.t2570 TOP.t2568 0.156982
R11483 TOP.t2568 TOP.t2566 0.156982
R11484 TOP.t2566 TOP.t2564 0.156982
R11485 TOP.t2564 TOP.t2562 0.156982
R11486 TOP.t2562 TOP.t2560 0.156982
R11487 TOP.t2560 TOP.t2558 0.156982
R11488 TOP.t2558 TOP.t2556 0.156982
R11489 TOP.t2556 TOP.t2554 0.156982
R11490 TOP.t2554 TOP.t2552 0.156982
R11491 TOP.t2552 TOP.t2550 0.156982
R11492 TOP.t2550 TOP.t2548 0.156982
R11493 TOP.t2548 TOP.t2546 0.156982
R11494 TOP.t2546 TOP.t2544 0.156982
R11495 TOP.t2544 TOP.t2542 0.156982
R11496 TOP.t2542 TOP.t2540 0.156982
R11497 TOP.t2540 TOP.t2538 0.156982
R11498 TOP.t2538 TOP.t2536 0.156982
R11499 TOP.t2536 TOP.t5256 0.156982
R11500 TOP.t2534 TOP.t2532 0.156982
R11501 TOP.t2532 TOP.t2530 0.156982
R11502 TOP.t2530 TOP.t2528 0.156982
R11503 TOP.t2528 TOP.t2526 0.156982
R11504 TOP.t2526 TOP.t2524 0.156982
R11505 TOP.t2524 TOP.t2522 0.156982
R11506 TOP.t2522 TOP.t2520 0.156982
R11507 TOP.t2520 TOP.t2518 0.156982
R11508 TOP.t2518 TOP.t2516 0.156982
R11509 TOP.t2516 TOP.t2514 0.156982
R11510 TOP.t2514 TOP.t2512 0.156982
R11511 TOP.t2512 TOP.t2510 0.156982
R11512 TOP.t2510 TOP.t2508 0.156982
R11513 TOP.t2508 TOP.t2506 0.156982
R11514 TOP.t2506 TOP.t2504 0.156982
R11515 TOP.t2504 TOP.t2502 0.156982
R11516 TOP.t2502 TOP.t2500 0.156982
R11517 TOP.t2500 TOP.t2498 0.156982
R11518 TOP.t2498 TOP.t2496 0.156982
R11519 TOP.t2496 TOP.t2494 0.156982
R11520 TOP.t2494 TOP.t2492 0.156982
R11521 TOP.t2492 TOP.t2490 0.156982
R11522 TOP.t2490 TOP.t2488 0.156982
R11523 TOP.t2488 TOP.t2486 0.156982
R11524 TOP.t2486 TOP.t2484 0.156982
R11525 TOP.t2484 TOP.t2482 0.156982
R11526 TOP.t2482 TOP.t2480 0.156982
R11527 TOP.t2480 TOP.t2478 0.156982
R11528 TOP.t2478 TOP.t2476 0.156982
R11529 TOP.t2476 TOP.t2474 0.156982
R11530 TOP.t2474 TOP.t2472 0.156982
R11531 TOP.t2472 TOP.t2470 0.156982
R11532 TOP.t2470 TOP.t2468 0.156982
R11533 TOP.t2468 TOP.t2466 0.156982
R11534 TOP.t2466 TOP.t2464 0.156982
R11535 TOP.t2464 TOP.t2462 0.156982
R11536 TOP.t2462 TOP.t2460 0.156982
R11537 TOP.t2460 TOP.t2458 0.156982
R11538 TOP.t2458 TOP.t2456 0.156982
R11539 TOP.t2456 TOP.t2454 0.156982
R11540 TOP.t2454 TOP.t2452 0.156982
R11541 TOP.t2452 TOP.t2450 0.156982
R11542 TOP.t2450 TOP.t2448 0.156982
R11543 TOP.t2448 TOP.t2446 0.156982
R11544 TOP.t2446 TOP.t2444 0.156982
R11545 TOP.t2444 TOP.t2442 0.156982
R11546 TOP.t2442 TOP.t2440 0.156982
R11547 TOP.t2440 TOP.t2438 0.156982
R11548 TOP.t2438 TOP.t2436 0.156982
R11549 TOP.t2436 TOP.t2434 0.156982
R11550 TOP.t2434 TOP.t2432 0.156982
R11551 TOP.t2432 TOP.t2430 0.156982
R11552 TOP.t2430 TOP.t2428 0.156982
R11553 TOP.t2428 TOP.t2426 0.156982
R11554 TOP.t2426 TOP.t2424 0.156982
R11555 TOP.t2424 TOP.t2422 0.156982
R11556 TOP.t2422 TOP.t2420 0.156982
R11557 TOP.t2420 TOP.t2418 0.156982
R11558 TOP.t2418 TOP.t2416 0.156982
R11559 TOP.t2416 TOP.t2414 0.156982
R11560 TOP.t2414 TOP.t2412 0.156982
R11561 TOP.t2412 TOP.t2410 0.156982
R11562 TOP.t2410 TOP.t5254 0.156982
R11563 TOP.t2408 TOP.t2406 0.156982
R11564 TOP.t2406 TOP.t2404 0.156982
R11565 TOP.t2404 TOP.t2402 0.156982
R11566 TOP.t2402 TOP.t2400 0.156982
R11567 TOP.t2400 TOP.t2398 0.156982
R11568 TOP.t2398 TOP.t2396 0.156982
R11569 TOP.t2396 TOP.t2394 0.156982
R11570 TOP.t2394 TOP.t2392 0.156982
R11571 TOP.t2392 TOP.t2390 0.156982
R11572 TOP.t2390 TOP.t2388 0.156982
R11573 TOP.t2388 TOP.t2386 0.156982
R11574 TOP.t2386 TOP.t2384 0.156982
R11575 TOP.t2384 TOP.t2382 0.156982
R11576 TOP.t2382 TOP.t2380 0.156982
R11577 TOP.t2380 TOP.t2378 0.156982
R11578 TOP.t2378 TOP.t2376 0.156982
R11579 TOP.t2376 TOP.t2374 0.156982
R11580 TOP.t2374 TOP.t2372 0.156982
R11581 TOP.t2372 TOP.t2370 0.156982
R11582 TOP.t2370 TOP.t2368 0.156982
R11583 TOP.t2368 TOP.t2366 0.156982
R11584 TOP.t2366 TOP.t2364 0.156982
R11585 TOP.t2364 TOP.t2362 0.156982
R11586 TOP.t2362 TOP.t2360 0.156982
R11587 TOP.t2360 TOP.t2358 0.156982
R11588 TOP.t2358 TOP.t2356 0.156982
R11589 TOP.t2356 TOP.t2354 0.156982
R11590 TOP.t2354 TOP.t2352 0.156982
R11591 TOP.t2352 TOP.t2350 0.156982
R11592 TOP.t2350 TOP.t2348 0.156982
R11593 TOP.t2348 TOP.t2346 0.156982
R11594 TOP.t2346 TOP.t2344 0.156982
R11595 TOP.t2344 TOP.t2342 0.156982
R11596 TOP.t2342 TOP.t2340 0.156982
R11597 TOP.t2340 TOP.t2338 0.156982
R11598 TOP.t2338 TOP.t2336 0.156982
R11599 TOP.t2336 TOP.t2334 0.156982
R11600 TOP.t2334 TOP.t2332 0.156982
R11601 TOP.t2332 TOP.t2330 0.156982
R11602 TOP.t2330 TOP.t2328 0.156982
R11603 TOP.t2328 TOP.t2326 0.156982
R11604 TOP.t2326 TOP.t2324 0.156982
R11605 TOP.t2324 TOP.t2322 0.156982
R11606 TOP.t2322 TOP.t2320 0.156982
R11607 TOP.t2320 TOP.t2318 0.156982
R11608 TOP.t2318 TOP.t2316 0.156982
R11609 TOP.t2316 TOP.t2314 0.156982
R11610 TOP.t2314 TOP.t2312 0.156982
R11611 TOP.t2312 TOP.t2310 0.156982
R11612 TOP.t2310 TOP.t2308 0.156982
R11613 TOP.t2308 TOP.t2306 0.156982
R11614 TOP.t2306 TOP.t2304 0.156982
R11615 TOP.t2304 TOP.t2302 0.156982
R11616 TOP.t2302 TOP.t2300 0.156982
R11617 TOP.t2300 TOP.t2298 0.156982
R11618 TOP.t2298 TOP.t2296 0.156982
R11619 TOP.t2296 TOP.t2294 0.156982
R11620 TOP.t2294 TOP.t2292 0.156982
R11621 TOP.t2292 TOP.t2290 0.156982
R11622 TOP.t2290 TOP.t2288 0.156982
R11623 TOP.t2288 TOP.t2286 0.156982
R11624 TOP.t2286 TOP.t2284 0.156982
R11625 TOP.t2284 TOP.t5252 0.156982
R11626 TOP.t2282 TOP.t2280 0.156982
R11627 TOP.t2280 TOP.t2278 0.156982
R11628 TOP.t2278 TOP.t2276 0.156982
R11629 TOP.t2276 TOP.t2274 0.156982
R11630 TOP.t2274 TOP.t2272 0.156982
R11631 TOP.t2272 TOP.t2270 0.156982
R11632 TOP.t2270 TOP.t2268 0.156982
R11633 TOP.t2268 TOP.t2266 0.156982
R11634 TOP.t2266 TOP.t2264 0.156982
R11635 TOP.t2264 TOP.t2262 0.156982
R11636 TOP.t2262 TOP.t2260 0.156982
R11637 TOP.t2260 TOP.t2258 0.156982
R11638 TOP.t2258 TOP.t2256 0.156982
R11639 TOP.t2256 TOP.t2254 0.156982
R11640 TOP.t2254 TOP.t2252 0.156982
R11641 TOP.t2252 TOP.t2250 0.156982
R11642 TOP.t2250 TOP.t2248 0.156982
R11643 TOP.t2248 TOP.t2246 0.156982
R11644 TOP.t2246 TOP.t2244 0.156982
R11645 TOP.t2244 TOP.t2242 0.156982
R11646 TOP.t2242 TOP.t2240 0.156982
R11647 TOP.t2240 TOP.t2238 0.156982
R11648 TOP.t2238 TOP.t2236 0.156982
R11649 TOP.t2236 TOP.t2234 0.156982
R11650 TOP.t2234 TOP.t2232 0.156982
R11651 TOP.t2232 TOP.t2230 0.156982
R11652 TOP.t2230 TOP.t2228 0.156982
R11653 TOP.t2228 TOP.t2226 0.156982
R11654 TOP.t2226 TOP.t2224 0.156982
R11655 TOP.t2224 TOP.t2222 0.156982
R11656 TOP.t2222 TOP.t2220 0.156982
R11657 TOP.t2220 TOP.t2218 0.156982
R11658 TOP.t2218 TOP.t2216 0.156982
R11659 TOP.t2216 TOP.t2214 0.156982
R11660 TOP.t2214 TOP.t2212 0.156982
R11661 TOP.t2212 TOP.t2210 0.156982
R11662 TOP.t2210 TOP.t2208 0.156982
R11663 TOP.t2208 TOP.t2206 0.156982
R11664 TOP.t2206 TOP.t2204 0.156982
R11665 TOP.t2204 TOP.t2202 0.156982
R11666 TOP.t2202 TOP.t2200 0.156982
R11667 TOP.t2200 TOP.t2198 0.156982
R11668 TOP.t2198 TOP.t2196 0.156982
R11669 TOP.t2196 TOP.t2194 0.156982
R11670 TOP.t2194 TOP.t2192 0.156982
R11671 TOP.t2192 TOP.t2190 0.156982
R11672 TOP.t2190 TOP.t2188 0.156982
R11673 TOP.t2188 TOP.t2186 0.156982
R11674 TOP.t2186 TOP.t2184 0.156982
R11675 TOP.t2184 TOP.t2182 0.156982
R11676 TOP.t2182 TOP.t2180 0.156982
R11677 TOP.t2180 TOP.t2178 0.156982
R11678 TOP.t2178 TOP.t2176 0.156982
R11679 TOP.t2176 TOP.t2174 0.156982
R11680 TOP.t2174 TOP.t2172 0.156982
R11681 TOP.t2172 TOP.t2170 0.156982
R11682 TOP.t2170 TOP.t2168 0.156982
R11683 TOP.t2168 TOP.t2166 0.156982
R11684 TOP.t2166 TOP.t2164 0.156982
R11685 TOP.t2164 TOP.t2162 0.156982
R11686 TOP.t2162 TOP.t2160 0.156982
R11687 TOP.t2160 TOP.t2158 0.156982
R11688 TOP.t2158 TOP.t5250 0.156982
R11689 TOP.t2156 TOP.t2154 0.156982
R11690 TOP.t2154 TOP.t2152 0.156982
R11691 TOP.t2152 TOP.t2150 0.156982
R11692 TOP.t2150 TOP.t2148 0.156982
R11693 TOP.t2148 TOP.t2146 0.156982
R11694 TOP.t2146 TOP.t2144 0.156982
R11695 TOP.t2144 TOP.t2142 0.156982
R11696 TOP.t2142 TOP.t2140 0.156982
R11697 TOP.t2140 TOP.t2138 0.156982
R11698 TOP.t2138 TOP.t2136 0.156982
R11699 TOP.t2136 TOP.t2134 0.156982
R11700 TOP.t2134 TOP.t2132 0.156982
R11701 TOP.t2132 TOP.t2130 0.156982
R11702 TOP.t2130 TOP.t2128 0.156982
R11703 TOP.t2128 TOP.t2126 0.156982
R11704 TOP.t2126 TOP.t2124 0.156982
R11705 TOP.t2124 TOP.t2122 0.156982
R11706 TOP.t2122 TOP.t2120 0.156982
R11707 TOP.t2120 TOP.t2118 0.156982
R11708 TOP.t2118 TOP.t2116 0.156982
R11709 TOP.t2116 TOP.t2114 0.156982
R11710 TOP.t2114 TOP.t2112 0.156982
R11711 TOP.t2112 TOP.t2110 0.156982
R11712 TOP.t2110 TOP.t2108 0.156982
R11713 TOP.t2108 TOP.t2106 0.156982
R11714 TOP.t2106 TOP.t2104 0.156982
R11715 TOP.t2104 TOP.t2102 0.156982
R11716 TOP.t2102 TOP.t2100 0.156982
R11717 TOP.t2100 TOP.t2098 0.156982
R11718 TOP.t2098 TOP.t2096 0.156982
R11719 TOP.t2096 TOP.t2094 0.156982
R11720 TOP.t2094 TOP.t2092 0.156982
R11721 TOP.t2092 TOP.t2090 0.156982
R11722 TOP.t2090 TOP.t2088 0.156982
R11723 TOP.t2088 TOP.t2086 0.156982
R11724 TOP.t2086 TOP.t2084 0.156982
R11725 TOP.t2084 TOP.t2082 0.156982
R11726 TOP.t2082 TOP.t2080 0.156982
R11727 TOP.t2080 TOP.t2078 0.156982
R11728 TOP.t2078 TOP.t2076 0.156982
R11729 TOP.t2076 TOP.t2074 0.156982
R11730 TOP.t2074 TOP.t2072 0.156982
R11731 TOP.t2072 TOP.t2070 0.156982
R11732 TOP.t2070 TOP.t2068 0.156982
R11733 TOP.t2068 TOP.t2066 0.156982
R11734 TOP.t2066 TOP.t2064 0.156982
R11735 TOP.t2064 TOP.t2062 0.156982
R11736 TOP.t2062 TOP.t2060 0.156982
R11737 TOP.t2060 TOP.t2058 0.156982
R11738 TOP.t2058 TOP.t2056 0.156982
R11739 TOP.t2056 TOP.t2054 0.156982
R11740 TOP.t2054 TOP.t2052 0.156982
R11741 TOP.t2052 TOP.t2050 0.156982
R11742 TOP.t2050 TOP.t2048 0.156982
R11743 TOP.t2048 TOP.t2046 0.156982
R11744 TOP.t2046 TOP.t2044 0.156982
R11745 TOP.t2044 TOP.t2042 0.156982
R11746 TOP.t2042 TOP.t2040 0.156982
R11747 TOP.t2040 TOP.t2038 0.156982
R11748 TOP.t2038 TOP.t2036 0.156982
R11749 TOP.t2036 TOP.t2034 0.156982
R11750 TOP.t2034 TOP.t2032 0.156982
R11751 TOP.t2032 TOP.t5248 0.156982
R11752 TOP.t2030 TOP.t2028 0.156982
R11753 TOP.t2028 TOP.t2026 0.156982
R11754 TOP.t2026 TOP.t2024 0.156982
R11755 TOP.t2024 TOP.t2022 0.156982
R11756 TOP.t2022 TOP.t2020 0.156982
R11757 TOP.t2020 TOP.t2018 0.156982
R11758 TOP.t2018 TOP.t2016 0.156982
R11759 TOP.t2016 TOP.t2014 0.156982
R11760 TOP.t2014 TOP.t2012 0.156982
R11761 TOP.t2012 TOP.t2010 0.156982
R11762 TOP.t2010 TOP.t2008 0.156982
R11763 TOP.t2008 TOP.t2006 0.156982
R11764 TOP.t2006 TOP.t2004 0.156982
R11765 TOP.t2004 TOP.t2002 0.156982
R11766 TOP.t2002 TOP.t2000 0.156982
R11767 TOP.t2000 TOP.t1998 0.156982
R11768 TOP.t1998 TOP.t1996 0.156982
R11769 TOP.t1996 TOP.t1994 0.156982
R11770 TOP.t1994 TOP.t1992 0.156982
R11771 TOP.t1992 TOP.t1990 0.156982
R11772 TOP.t1990 TOP.t1988 0.156982
R11773 TOP.t1988 TOP.t1986 0.156982
R11774 TOP.t1986 TOP.t1984 0.156982
R11775 TOP.t1984 TOP.t1982 0.156982
R11776 TOP.t1982 TOP.t1980 0.156982
R11777 TOP.t1980 TOP.t1978 0.156982
R11778 TOP.t1978 TOP.t1976 0.156982
R11779 TOP.t1976 TOP.t1974 0.156982
R11780 TOP.t1974 TOP.t1972 0.156982
R11781 TOP.t1972 TOP.t1970 0.156982
R11782 TOP.t1970 TOP.t1968 0.156982
R11783 TOP.t1968 TOP.t1966 0.156982
R11784 TOP.t1966 TOP.t1964 0.156982
R11785 TOP.t1964 TOP.t1962 0.156982
R11786 TOP.t1962 TOP.t1960 0.156982
R11787 TOP.t1960 TOP.t1958 0.156982
R11788 TOP.t1958 TOP.t1956 0.156982
R11789 TOP.t1956 TOP.t1954 0.156982
R11790 TOP.t1954 TOP.t1952 0.156982
R11791 TOP.t1952 TOP.t1950 0.156982
R11792 TOP.t1950 TOP.t1948 0.156982
R11793 TOP.t1948 TOP.t1946 0.156982
R11794 TOP.t1946 TOP.t1944 0.156982
R11795 TOP.t1944 TOP.t1942 0.156982
R11796 TOP.t1942 TOP.t1940 0.156982
R11797 TOP.t1940 TOP.t1938 0.156982
R11798 TOP.t1938 TOP.t1936 0.156982
R11799 TOP.t1936 TOP.t1934 0.156982
R11800 TOP.t1934 TOP.t1932 0.156982
R11801 TOP.t1932 TOP.t1930 0.156982
R11802 TOP.t1930 TOP.t1928 0.156982
R11803 TOP.t1928 TOP.t1926 0.156982
R11804 TOP.t1926 TOP.t1924 0.156982
R11805 TOP.t1924 TOP.t1922 0.156982
R11806 TOP.t1922 TOP.t1920 0.156982
R11807 TOP.t1920 TOP.t1918 0.156982
R11808 TOP.t1918 TOP.t1916 0.156982
R11809 TOP.t1916 TOP.t1914 0.156982
R11810 TOP.t1914 TOP.t1912 0.156982
R11811 TOP.t1912 TOP.t1910 0.156982
R11812 TOP.t1910 TOP.t1908 0.156982
R11813 TOP.t1908 TOP.t1906 0.156982
R11814 TOP.t1906 TOP.t6 0.156982
R11815 TOP.t1904 TOP.t1902 0.156982
R11816 TOP.t1902 TOP.t1900 0.156982
R11817 TOP.t1900 TOP.t1898 0.156982
R11818 TOP.t1898 TOP.t1896 0.156982
R11819 TOP.t1896 TOP.t1894 0.156982
R11820 TOP.t1894 TOP.t1892 0.156982
R11821 TOP.t1892 TOP.t1890 0.156982
R11822 TOP.t1890 TOP.t1888 0.156982
R11823 TOP.t1888 TOP.t1886 0.156982
R11824 TOP.t1886 TOP.t1884 0.156982
R11825 TOP.t1884 TOP.t1882 0.156982
R11826 TOP.t1882 TOP.t1880 0.156982
R11827 TOP.t1880 TOP.t1878 0.156982
R11828 TOP.t1878 TOP.t1876 0.156982
R11829 TOP.t1876 TOP.t1874 0.156982
R11830 TOP.t1874 TOP.t1872 0.156982
R11831 TOP.t1872 TOP.t1870 0.156982
R11832 TOP.t1870 TOP.t1868 0.156982
R11833 TOP.t1868 TOP.t1866 0.156982
R11834 TOP.t1866 TOP.t1864 0.156982
R11835 TOP.t1864 TOP.t1862 0.156982
R11836 TOP.t1862 TOP.t1860 0.156982
R11837 TOP.t1860 TOP.t1858 0.156982
R11838 TOP.t1858 TOP.t1856 0.156982
R11839 TOP.t1856 TOP.t1854 0.156982
R11840 TOP.t1854 TOP.t1852 0.156982
R11841 TOP.t1852 TOP.t1850 0.156982
R11842 TOP.t1850 TOP.t1848 0.156982
R11843 TOP.t1848 TOP.t1846 0.156982
R11844 TOP.t1846 TOP.t1844 0.156982
R11845 TOP.t1844 TOP.t1842 0.156982
R11846 TOP.t1842 TOP.t1840 0.156982
R11847 TOP.t1840 TOP.t1838 0.156982
R11848 TOP.t1838 TOP.t1836 0.156982
R11849 TOP.t1836 TOP.t1834 0.156982
R11850 TOP.t1834 TOP.t1832 0.156982
R11851 TOP.t1832 TOP.t1830 0.156982
R11852 TOP.t1830 TOP.t1828 0.156982
R11853 TOP.t1828 TOP.t1826 0.156982
R11854 TOP.t1826 TOP.t1824 0.156982
R11855 TOP.t1824 TOP.t1822 0.156982
R11856 TOP.t1822 TOP.t1820 0.156982
R11857 TOP.t1820 TOP.t1818 0.156982
R11858 TOP.t1818 TOP.t1816 0.156982
R11859 TOP.t1816 TOP.t1814 0.156982
R11860 TOP.t1814 TOP.t1812 0.156982
R11861 TOP.t1812 TOP.t1810 0.156982
R11862 TOP.t1810 TOP.t1808 0.156982
R11863 TOP.t1808 TOP.t1806 0.156982
R11864 TOP.t1806 TOP.t1804 0.156982
R11865 TOP.t1804 TOP.t1802 0.156982
R11866 TOP.t1802 TOP.t1800 0.156982
R11867 TOP.t1800 TOP.t1798 0.156982
R11868 TOP.t1798 TOP.t1796 0.156982
R11869 TOP.t1796 TOP.t1794 0.156982
R11870 TOP.t1794 TOP.t1792 0.156982
R11871 TOP.t1792 TOP.t1790 0.156982
R11872 TOP.t1790 TOP.t1788 0.156982
R11873 TOP.t1788 TOP.t1786 0.156982
R11874 TOP.t1786 TOP.t1784 0.156982
R11875 TOP.t1784 TOP.t1782 0.156982
R11876 TOP.t1782 TOP.t1780 0.156982
R11877 TOP.t1780 TOP.t4 0.156982
R11878 TOP.t1778 TOP.t1776 0.156982
R11879 TOP.t1776 TOP.t1774 0.156982
R11880 TOP.t1774 TOP.t1772 0.156982
R11881 TOP.t1772 TOP.t1770 0.156982
R11882 TOP.t1770 TOP.t1768 0.156982
R11883 TOP.t1768 TOP.t1766 0.156982
R11884 TOP.t1766 TOP.t1764 0.156982
R11885 TOP.t1764 TOP.t1762 0.156982
R11886 TOP.t1762 TOP.t1760 0.156982
R11887 TOP.t1760 TOP.t1758 0.156982
R11888 TOP.t1758 TOP.t1756 0.156982
R11889 TOP.t1756 TOP.t1754 0.156982
R11890 TOP.t1754 TOP.t1752 0.156982
R11891 TOP.t1752 TOP.t1750 0.156982
R11892 TOP.t1750 TOP.t1748 0.156982
R11893 TOP.t1748 TOP.t1746 0.156982
R11894 TOP.t1746 TOP.t1744 0.156982
R11895 TOP.t1744 TOP.t1742 0.156982
R11896 TOP.t1742 TOP.t1740 0.156982
R11897 TOP.t1740 TOP.t1738 0.156982
R11898 TOP.t1738 TOP.t1736 0.156982
R11899 TOP.t1736 TOP.t1734 0.156982
R11900 TOP.t1734 TOP.t1732 0.156982
R11901 TOP.t1732 TOP.t1730 0.156982
R11902 TOP.t1730 TOP.t1728 0.156982
R11903 TOP.t1728 TOP.t1726 0.156982
R11904 TOP.t1726 TOP.t1724 0.156982
R11905 TOP.t1724 TOP.t1722 0.156982
R11906 TOP.t1722 TOP.t1720 0.156982
R11907 TOP.t1720 TOP.t1718 0.156982
R11908 TOP.t1718 TOP.t1716 0.156982
R11909 TOP.t1716 TOP.t1714 0.156982
R11910 TOP.t1714 TOP.t1712 0.156982
R11911 TOP.t1712 TOP.t1710 0.156982
R11912 TOP.t1710 TOP.t1708 0.156982
R11913 TOP.t1708 TOP.t1706 0.156982
R11914 TOP.t1706 TOP.t1704 0.156982
R11915 TOP.t1704 TOP.t1702 0.156982
R11916 TOP.t1702 TOP.t1700 0.156982
R11917 TOP.t1700 TOP.t1698 0.156982
R11918 TOP.t1698 TOP.t1696 0.156982
R11919 TOP.t1696 TOP.t1694 0.156982
R11920 TOP.t1694 TOP.t1692 0.156982
R11921 TOP.t1692 TOP.t1690 0.156982
R11922 TOP.t1690 TOP.t1688 0.156982
R11923 TOP.t1688 TOP.t1686 0.156982
R11924 TOP.t1686 TOP.t1684 0.156982
R11925 TOP.t1684 TOP.t1682 0.156982
R11926 TOP.t1682 TOP.t1680 0.156982
R11927 TOP.t1680 TOP.t1678 0.156982
R11928 TOP.t1678 TOP.t1676 0.156982
R11929 TOP.t1676 TOP.t1674 0.156982
R11930 TOP.t1674 TOP.t1672 0.156982
R11931 TOP.t1672 TOP.t1670 0.156982
R11932 TOP.t1670 TOP.t1668 0.156982
R11933 TOP.t1668 TOP.t1666 0.156982
R11934 TOP.t1666 TOP.t1664 0.156982
R11935 TOP.t1664 TOP.t1662 0.156982
R11936 TOP.t1662 TOP.t1660 0.156982
R11937 TOP.t1660 TOP.t1658 0.156982
R11938 TOP.t1658 TOP.t1656 0.156982
R11939 TOP.t1656 TOP.t1654 0.156982
R11940 TOP.t1654 TOP.t2 0.156982
R11941 TOP.t1652 TOP.t1650 0.156982
R11942 TOP.t1650 TOP.t1648 0.156982
R11943 TOP.t1648 TOP.t1646 0.156982
R11944 TOP.t1646 TOP.t1644 0.156982
R11945 TOP.t1644 TOP.t1642 0.156982
R11946 TOP.t1642 TOP.t1640 0.156982
R11947 TOP.t1640 TOP.t1638 0.156982
R11948 TOP.t1638 TOP.t1636 0.156982
R11949 TOP.t1636 TOP.t1634 0.156982
R11950 TOP.t1634 TOP.t1632 0.156982
R11951 TOP.t1632 TOP.t1630 0.156982
R11952 TOP.t1630 TOP.t1628 0.156982
R11953 TOP.t1628 TOP.t1626 0.156982
R11954 TOP.t1626 TOP.t1624 0.156982
R11955 TOP.t1624 TOP.t1622 0.156982
R11956 TOP.t1622 TOP.t1620 0.156982
R11957 TOP.t1620 TOP.t1618 0.156982
R11958 TOP.t1618 TOP.t1616 0.156982
R11959 TOP.t1616 TOP.t1614 0.156982
R11960 TOP.t1614 TOP.t1612 0.156982
R11961 TOP.t1612 TOP.t1610 0.156982
R11962 TOP.t1610 TOP.t1608 0.156982
R11963 TOP.t1608 TOP.t1606 0.156982
R11964 TOP.t1606 TOP.t1604 0.156982
R11965 TOP.t1604 TOP.t1602 0.156982
R11966 TOP.t1602 TOP.t1600 0.156982
R11967 TOP.t1600 TOP.t1598 0.156982
R11968 TOP.t1598 TOP.t1596 0.156982
R11969 TOP.t1596 TOP.t1594 0.156982
R11970 TOP.t1594 TOP.t1592 0.156982
R11971 TOP.t1592 TOP.t1590 0.156982
R11972 TOP.t1590 TOP.t1588 0.156982
R11973 TOP.t1588 TOP.t1586 0.156982
R11974 TOP.t1586 TOP.t1584 0.156982
R11975 TOP.t1584 TOP.t1582 0.156982
R11976 TOP.t1582 TOP.t1580 0.156982
R11977 TOP.t1580 TOP.t1578 0.156982
R11978 TOP.t1578 TOP.t1576 0.156982
R11979 TOP.t1576 TOP.t1574 0.156982
R11980 TOP.t1574 TOP.t1572 0.156982
R11981 TOP.t1572 TOP.t1570 0.156982
R11982 TOP.t1570 TOP.t1568 0.156982
R11983 TOP.t1568 TOP.t1566 0.156982
R11984 TOP.t1566 TOP.t1564 0.156982
R11985 TOP.t1564 TOP.t1562 0.156982
R11986 TOP.t1562 TOP.t1560 0.156982
R11987 TOP.t1560 TOP.t1558 0.156982
R11988 TOP.t1558 TOP.t1556 0.156982
R11989 TOP.t1556 TOP.t1554 0.156982
R11990 TOP.t1554 TOP.t1552 0.156982
R11991 TOP.t1552 TOP.t1550 0.156982
R11992 TOP.t1550 TOP.t1548 0.156982
R11993 TOP.t1548 TOP.t1546 0.156982
R11994 TOP.t1546 TOP.t1544 0.156982
R11995 TOP.t1544 TOP.t1542 0.156982
R11996 TOP.t1542 TOP.t1540 0.156982
R11997 TOP.t1540 TOP.t1538 0.156982
R11998 TOP.t1538 TOP.t1536 0.156982
R11999 TOP.t1536 TOP.t1534 0.156982
R12000 TOP.t1534 TOP.t1532 0.156982
R12001 TOP.t1532 TOP.t1530 0.156982
R12002 TOP.t1530 TOP.t1528 0.156982
R12003 TOP.t1528 TOP.t0 0.156982
R12004 TOP.t1526 TOP.t1524 0.156982
R12005 TOP.t1524 TOP.t1522 0.156982
R12006 TOP.t1522 TOP.t1520 0.156982
R12007 TOP.t1520 TOP.t1518 0.156982
R12008 TOP.t1518 TOP.t1516 0.156982
R12009 TOP.t1516 TOP.t1514 0.156982
R12010 TOP.t1514 TOP.t1512 0.156982
R12011 TOP.t1512 TOP.t1510 0.156982
R12012 TOP.t1510 TOP.t1508 0.156982
R12013 TOP.t1508 TOP.t1506 0.156982
R12014 TOP.t1506 TOP.t1504 0.156982
R12015 TOP.t1504 TOP.t1502 0.156982
R12016 TOP.t1502 TOP.t1500 0.156982
R12017 TOP.t1500 TOP.t1498 0.156982
R12018 TOP.t1498 TOP.t1496 0.156982
R12019 TOP.t1496 TOP.t1494 0.156982
R12020 TOP.t1494 TOP.t1492 0.156982
R12021 TOP.t1492 TOP.t1490 0.156982
R12022 TOP.t1490 TOP.t1488 0.156982
R12023 TOP.t1488 TOP.t1486 0.156982
R12024 TOP.t1486 TOP.t1484 0.156982
R12025 TOP.t1484 TOP.t1482 0.156982
R12026 TOP.t1482 TOP.t1480 0.156982
R12027 TOP.t1480 TOP.t1478 0.156982
R12028 TOP.t1478 TOP.t1476 0.156982
R12029 TOP.t1476 TOP.t1474 0.156982
R12030 TOP.t1474 TOP.t1472 0.156982
R12031 TOP.t1472 TOP.t1470 0.156982
R12032 TOP.t1470 TOP.t1468 0.156982
R12033 TOP.t1468 TOP.t1466 0.156982
R12034 TOP.t1466 TOP.t1464 0.156982
R12035 TOP.t1464 TOP.t1462 0.156982
R12036 TOP.t1462 TOP.t1460 0.156982
R12037 TOP.t1460 TOP.t1458 0.156982
R12038 TOP.t1458 TOP.t1456 0.156982
R12039 TOP.t1456 TOP.t1454 0.156982
R12040 TOP.t1454 TOP.t1452 0.156982
R12041 TOP.t1452 TOP.t1450 0.156982
R12042 TOP.t1450 TOP.t1448 0.156982
R12043 TOP.t1448 TOP.t1446 0.156982
R12044 TOP.t1446 TOP.t1444 0.156982
R12045 TOP.t1444 TOP.t1442 0.156982
R12046 TOP.t1442 TOP.t1440 0.156982
R12047 TOP.t1440 TOP.t1438 0.156982
R12048 TOP.t1438 TOP.t1436 0.156982
R12049 TOP.t1436 TOP.t1434 0.156982
R12050 TOP.t1434 TOP.t1432 0.156982
R12051 TOP.t1432 TOP.t1430 0.156982
R12052 TOP.t1430 TOP.t1428 0.156982
R12053 TOP.t1428 TOP.t1426 0.156982
R12054 TOP.t1426 TOP.t1424 0.156982
R12055 TOP.t1424 TOP.t1422 0.156982
R12056 TOP.t1422 TOP.t1420 0.156982
R12057 TOP.t1420 TOP.t1418 0.156982
R12058 TOP.t1418 TOP.t1416 0.156982
R12059 TOP.t1416 TOP.t1414 0.156982
R12060 TOP.t1414 TOP.t1412 0.156982
R12061 TOP.t1412 TOP.t1410 0.156982
R12062 TOP.t1410 TOP.t1408 0.156982
R12063 TOP.t1408 TOP.t1406 0.156982
R12064 TOP.t1406 TOP.t1404 0.156982
R12065 TOP.t1404 TOP.t1402 0.156982
R12066 TOP.t1402 TOP.t7298 0.156982
R12067 TOP.t1400 TOP.t1398 0.156982
R12068 TOP.t1398 TOP.t1396 0.156982
R12069 TOP.t1396 TOP.t1394 0.156982
R12070 TOP.t1394 TOP.t1392 0.156982
R12071 TOP.t1392 TOP.t1390 0.156982
R12072 TOP.t1390 TOP.t1388 0.156982
R12073 TOP.t1388 TOP.t1386 0.156982
R12074 TOP.t1386 TOP.t1384 0.156982
R12075 TOP.t1384 TOP.t1382 0.156982
R12076 TOP.t1382 TOP.t1380 0.156982
R12077 TOP.t1380 TOP.t1378 0.156982
R12078 TOP.t1378 TOP.t1376 0.156982
R12079 TOP.t1376 TOP.t1374 0.156982
R12080 TOP.t1374 TOP.t1372 0.156982
R12081 TOP.t1372 TOP.t1370 0.156982
R12082 TOP.t1370 TOP.t1368 0.156982
R12083 TOP.t1368 TOP.t1366 0.156982
R12084 TOP.t1366 TOP.t1364 0.156982
R12085 TOP.t1364 TOP.t1362 0.156982
R12086 TOP.t1362 TOP.t1360 0.156982
R12087 TOP.t1360 TOP.t1358 0.156982
R12088 TOP.t1358 TOP.t1356 0.156982
R12089 TOP.t1356 TOP.t1354 0.156982
R12090 TOP.t1354 TOP.t1352 0.156982
R12091 TOP.t1352 TOP.t1350 0.156982
R12092 TOP.t1350 TOP.t1348 0.156982
R12093 TOP.t1348 TOP.t1346 0.156982
R12094 TOP.t1346 TOP.t1344 0.156982
R12095 TOP.t1344 TOP.t1342 0.156982
R12096 TOP.t1342 TOP.t1340 0.156982
R12097 TOP.t1340 TOP.t1338 0.156982
R12098 TOP.t1338 TOP.t1336 0.156982
R12099 TOP.t1336 TOP.t1334 0.156982
R12100 TOP.t1334 TOP.t1332 0.156982
R12101 TOP.t1332 TOP.t1330 0.156982
R12102 TOP.t1330 TOP.t1328 0.156982
R12103 TOP.t1328 TOP.t1326 0.156982
R12104 TOP.t1326 TOP.t1324 0.156982
R12105 TOP.t1324 TOP.t1322 0.156982
R12106 TOP.t1322 TOP.t1320 0.156982
R12107 TOP.t1320 TOP.t1318 0.156982
R12108 TOP.t1318 TOP.t1316 0.156982
R12109 TOP.t1316 TOP.t1314 0.156982
R12110 TOP.t1314 TOP.t1312 0.156982
R12111 TOP.t1312 TOP.t1310 0.156982
R12112 TOP.t1310 TOP.t1308 0.156982
R12113 TOP.t1308 TOP.t1306 0.156982
R12114 TOP.t1306 TOP.t1304 0.156982
R12115 TOP.t1304 TOP.t1302 0.156982
R12116 TOP.t1302 TOP.t1300 0.156982
R12117 TOP.t1300 TOP.t1298 0.156982
R12118 TOP.t1298 TOP.t1296 0.156982
R12119 TOP.t1296 TOP.t1294 0.156982
R12120 TOP.t1294 TOP.t1292 0.156982
R12121 TOP.t1292 TOP.t1290 0.156982
R12122 TOP.t1290 TOP.t1288 0.156982
R12123 TOP.t1288 TOP.t1286 0.156982
R12124 TOP.t1286 TOP.t1284 0.156982
R12125 TOP.t1284 TOP.t1282 0.156982
R12126 TOP.t1282 TOP.t1280 0.156982
R12127 TOP.t1280 TOP.t1278 0.156982
R12128 TOP.t1278 TOP.t1276 0.156982
R12129 TOP.t1276 TOP.t7296 0.156982
R12130 TOP.t1274 TOP.t1272 0.156982
R12131 TOP.t1272 TOP.t1270 0.156982
R12132 TOP.t1270 TOP.t1268 0.156982
R12133 TOP.t1268 TOP.t1266 0.156982
R12134 TOP.t1266 TOP.t1264 0.156982
R12135 TOP.t1264 TOP.t1262 0.156982
R12136 TOP.t1262 TOP.t1260 0.156982
R12137 TOP.t1260 TOP.t1258 0.156982
R12138 TOP.t1258 TOP.t1256 0.156982
R12139 TOP.t1256 TOP.t1254 0.156982
R12140 TOP.t1254 TOP.t1252 0.156982
R12141 TOP.t1252 TOP.t1250 0.156982
R12142 TOP.t1250 TOP.t1248 0.156982
R12143 TOP.t1248 TOP.t1246 0.156982
R12144 TOP.t1246 TOP.t1244 0.156982
R12145 TOP.t1244 TOP.t1242 0.156982
R12146 TOP.t1242 TOP.t1240 0.156982
R12147 TOP.t1240 TOP.t1238 0.156982
R12148 TOP.t1238 TOP.t1236 0.156982
R12149 TOP.t1236 TOP.t1234 0.156982
R12150 TOP.t1234 TOP.t1232 0.156982
R12151 TOP.t1232 TOP.t1230 0.156982
R12152 TOP.t1230 TOP.t1228 0.156982
R12153 TOP.t1228 TOP.t1226 0.156982
R12154 TOP.t1226 TOP.t1224 0.156982
R12155 TOP.t1224 TOP.t1222 0.156982
R12156 TOP.t1222 TOP.t1220 0.156982
R12157 TOP.t1220 TOP.t1218 0.156982
R12158 TOP.t1218 TOP.t1216 0.156982
R12159 TOP.t1216 TOP.t1214 0.156982
R12160 TOP.t1214 TOP.t1212 0.156982
R12161 TOP.t1212 TOP.t1210 0.156982
R12162 TOP.t1210 TOP.t1208 0.156982
R12163 TOP.t1208 TOP.t1206 0.156982
R12164 TOP.t1206 TOP.t1204 0.156982
R12165 TOP.t1204 TOP.t1202 0.156982
R12166 TOP.t1202 TOP.t1200 0.156982
R12167 TOP.t1200 TOP.t1198 0.156982
R12168 TOP.t1198 TOP.t1196 0.156982
R12169 TOP.t1196 TOP.t1194 0.156982
R12170 TOP.t1194 TOP.t1192 0.156982
R12171 TOP.t1192 TOP.t1190 0.156982
R12172 TOP.t1190 TOP.t1188 0.156982
R12173 TOP.t1188 TOP.t1186 0.156982
R12174 TOP.t1186 TOP.t1184 0.156982
R12175 TOP.t1184 TOP.t1182 0.156982
R12176 TOP.t1182 TOP.t1180 0.156982
R12177 TOP.t1180 TOP.t1178 0.156982
R12178 TOP.t1178 TOP.t1176 0.156982
R12179 TOP.t1176 TOP.t1174 0.156982
R12180 TOP.t1174 TOP.t1172 0.156982
R12181 TOP.t1172 TOP.t1170 0.156982
R12182 TOP.t1170 TOP.t1168 0.156982
R12183 TOP.t1168 TOP.t1166 0.156982
R12184 TOP.t1166 TOP.t1164 0.156982
R12185 TOP.t1164 TOP.t1162 0.156982
R12186 TOP.t1162 TOP.t1160 0.156982
R12187 TOP.t1160 TOP.t1158 0.156982
R12188 TOP.t1158 TOP.t1156 0.156982
R12189 TOP.t1156 TOP.t1154 0.156982
R12190 TOP.t1154 TOP.t1152 0.156982
R12191 TOP.t1152 TOP.t1150 0.156982
R12192 TOP.t1150 TOP.t7808 0.156982
R12193 TOP.t1148 TOP.t1146 0.156982
R12194 TOP.t1146 TOP.t1144 0.156982
R12195 TOP.t1144 TOP.t1142 0.156982
R12196 TOP.t1142 TOP.t1140 0.156982
R12197 TOP.t1140 TOP.t1138 0.156982
R12198 TOP.t1138 TOP.t1136 0.156982
R12199 TOP.t1136 TOP.t1134 0.156982
R12200 TOP.t1134 TOP.t1132 0.156982
R12201 TOP.t1132 TOP.t1130 0.156982
R12202 TOP.t1130 TOP.t1128 0.156982
R12203 TOP.t1128 TOP.t1126 0.156982
R12204 TOP.t1126 TOP.t1124 0.156982
R12205 TOP.t1124 TOP.t1122 0.156982
R12206 TOP.t1122 TOP.t1120 0.156982
R12207 TOP.t1120 TOP.t1118 0.156982
R12208 TOP.t1118 TOP.t1116 0.156982
R12209 TOP.t1116 TOP.t1114 0.156982
R12210 TOP.t1114 TOP.t1112 0.156982
R12211 TOP.t1112 TOP.t1110 0.156982
R12212 TOP.t1110 TOP.t1108 0.156982
R12213 TOP.t1108 TOP.t1106 0.156982
R12214 TOP.t1106 TOP.t1104 0.156982
R12215 TOP.t1104 TOP.t1102 0.156982
R12216 TOP.t1102 TOP.t1100 0.156982
R12217 TOP.t1100 TOP.t1098 0.156982
R12218 TOP.t1098 TOP.t1096 0.156982
R12219 TOP.t1096 TOP.t1094 0.156982
R12220 TOP.t1094 TOP.t1092 0.156982
R12221 TOP.t1092 TOP.t1090 0.156982
R12222 TOP.t1090 TOP.t1088 0.156982
R12223 TOP.t1088 TOP.t1086 0.156982
R12224 TOP.t1086 TOP.t1084 0.156982
R12225 TOP.t1084 TOP.t1082 0.156982
R12226 TOP.t1082 TOP.t1080 0.156982
R12227 TOP.t1080 TOP.t1078 0.156982
R12228 TOP.t1078 TOP.t1076 0.156982
R12229 TOP.t1076 TOP.t1074 0.156982
R12230 TOP.t1074 TOP.t1072 0.156982
R12231 TOP.t1072 TOP.t1070 0.156982
R12232 TOP.t1070 TOP.t1068 0.156982
R12233 TOP.t1068 TOP.t1066 0.156982
R12234 TOP.t1066 TOP.t1064 0.156982
R12235 TOP.t1064 TOP.t1062 0.156982
R12236 TOP.t1062 TOP.t1060 0.156982
R12237 TOP.t1060 TOP.t1058 0.156982
R12238 TOP.t1058 TOP.t1056 0.156982
R12239 TOP.t1056 TOP.t1054 0.156982
R12240 TOP.t1054 TOP.t1052 0.156982
R12241 TOP.t1052 TOP.t1050 0.156982
R12242 TOP.t1050 TOP.t1048 0.156982
R12243 TOP.t1048 TOP.t1046 0.156982
R12244 TOP.t1046 TOP.t1044 0.156982
R12245 TOP.t1044 TOP.t1042 0.156982
R12246 TOP.t1042 TOP.t1040 0.156982
R12247 TOP.t1040 TOP.t1038 0.156982
R12248 TOP.t1038 TOP.t1036 0.156982
R12249 TOP.t1036 TOP.t1034 0.156982
R12250 TOP.t1034 TOP.t1032 0.156982
R12251 TOP.t1032 TOP.t1030 0.156982
R12252 TOP.t1030 TOP.t1028 0.156982
R12253 TOP.t1028 TOP.t1026 0.156982
R12254 TOP.t1026 TOP.t1024 0.156982
R12255 TOP.t1024 TOP.t5120 0.156982
R12256 TOP.n62 TOP.t4996 0.1133
R12257 TOP TOP.n62 0.0443667
R12258 TOP.n61 TOP.t8062 0.0419706
R12259 TOP.n60 TOP.t7806 0.0419706
R12260 TOP.n59 TOP.t7804 0.0419706
R12261 TOP.n58 TOP.t1022 0.0419706
R12262 TOP.n57 TOP.t1020 0.0419706
R12263 TOP.n56 TOP.t1018 0.0419706
R12264 TOP.n55 TOP.t1016 0.0419706
R12265 TOP.n54 TOP.t7294 0.0419706
R12266 TOP.n53 TOP.t7292 0.0419706
R12267 TOP.n52 TOP.t7290 0.0419706
R12268 TOP.n51 TOP.t7288 0.0419706
R12269 TOP.n50 TOP.t7286 0.0419706
R12270 TOP.n49 TOP.t7284 0.0419706
R12271 TOP.n48 TOP.t7282 0.0419706
R12272 TOP.n47 TOP.t7280 0.0419706
R12273 TOP.n46 TOP.t3102 0.0419706
R12274 TOP.n45 TOP.t3100 0.0419706
R12275 TOP.n44 TOP.t3098 0.0419706
R12276 TOP.n43 TOP.t3096 0.0419706
R12277 TOP.n42 TOP.t3094 0.0419706
R12278 TOP.n41 TOP.t3092 0.0419706
R12279 TOP.n40 TOP.t3090 0.0419706
R12280 TOP.n39 TOP.t3088 0.0419706
R12281 TOP.n38 TOP.t3086 0.0419706
R12282 TOP.n37 TOP.t3084 0.0419706
R12283 TOP.n36 TOP.t3082 0.0419706
R12284 TOP.n35 TOP.t3080 0.0419706
R12285 TOP.n34 TOP.t3078 0.0419706
R12286 TOP.n33 TOP.t3076 0.0419706
R12287 TOP.n32 TOP.t3074 0.0419706
R12288 TOP.n31 TOP.t3072 0.0419706
R12289 TOP.n30 TOP.t5182 0.0419706
R12290 TOP.n29 TOP.t7934 0.0419706
R12291 TOP.n28 TOP.t7550 0.0419706
R12292 TOP.n27 TOP.t7424 0.0419706
R12293 TOP.n26 TOP.t510 0.0419706
R12294 TOP.n25 TOP.t384 0.0419706
R12295 TOP.n24 TOP.t258 0.0419706
R12296 TOP.n23 TOP.t132 0.0419706
R12297 TOP.n22 TOP.t6270 0.0419706
R12298 TOP.n21 TOP.t6144 0.0419706
R12299 TOP.n20 TOP.t6018 0.0419706
R12300 TOP.n19 TOP.t5892 0.0419706
R12301 TOP.n18 TOP.t5766 0.0419706
R12302 TOP.n17 TOP.t5640 0.0419706
R12303 TOP.n16 TOP.t5514 0.0419706
R12304 TOP.n15 TOP.t5388 0.0419706
R12305 TOP.n14 TOP.t3038 0.0419706
R12306 TOP.n13 TOP.t2912 0.0419706
R12307 TOP.n12 TOP.t2786 0.0419706
R12308 TOP.n11 TOP.t2660 0.0419706
R12309 TOP.n10 TOP.t2534 0.0419706
R12310 TOP.n9 TOP.t2408 0.0419706
R12311 TOP.n8 TOP.t2282 0.0419706
R12312 TOP.n7 TOP.t2156 0.0419706
R12313 TOP.n6 TOP.t2030 0.0419706
R12314 TOP.n5 TOP.t1904 0.0419706
R12315 TOP.n4 TOP.t1778 0.0419706
R12316 TOP.n3 TOP.t1652 0.0419706
R12317 TOP.n2 TOP.t1526 0.0419706
R12318 TOP.n1 TOP.t1400 0.0419706
R12319 TOP.n0 TOP.t1274 0.0419706
R12320 TOP TOP.t4994 0.0364412
R12321 TOP.n62 TOP 0.00824118
R12322 EDGE_BIAS.n258 EDGE_BIAS.t576 0.737901
R12323 EDGE_BIAS.n257 EDGE_BIAS.t570 0.737901
R12324 EDGE_BIAS.n256 EDGE_BIAS.t564 0.737901
R12325 EDGE_BIAS.n255 EDGE_BIAS.t558 0.737901
R12326 EDGE_BIAS.n254 EDGE_BIAS.t552 0.737901
R12327 EDGE_BIAS.n253 EDGE_BIAS.t546 0.737901
R12328 EDGE_BIAS.n252 EDGE_BIAS.t540 0.737901
R12329 EDGE_BIAS.n251 EDGE_BIAS.t534 0.737901
R12330 EDGE_BIAS.n250 EDGE_BIAS.t528 0.737901
R12331 EDGE_BIAS.n249 EDGE_BIAS.t522 0.737901
R12332 EDGE_BIAS.n248 EDGE_BIAS.t516 0.737901
R12333 EDGE_BIAS.n247 EDGE_BIAS.t510 0.737901
R12334 EDGE_BIAS.n246 EDGE_BIAS.t504 0.737901
R12335 EDGE_BIAS.n245 EDGE_BIAS.t498 0.737901
R12336 EDGE_BIAS.n244 EDGE_BIAS.t492 0.737901
R12337 EDGE_BIAS.n243 EDGE_BIAS.t486 0.737901
R12338 EDGE_BIAS.n242 EDGE_BIAS.t480 0.737901
R12339 EDGE_BIAS.n241 EDGE_BIAS.t474 0.737901
R12340 EDGE_BIAS.n240 EDGE_BIAS.t468 0.737901
R12341 EDGE_BIAS.n239 EDGE_BIAS.t462 0.737901
R12342 EDGE_BIAS.n238 EDGE_BIAS.t456 0.737901
R12343 EDGE_BIAS.n237 EDGE_BIAS.t450 0.737901
R12344 EDGE_BIAS.n236 EDGE_BIAS.t444 0.737901
R12345 EDGE_BIAS.n235 EDGE_BIAS.t438 0.737901
R12346 EDGE_BIAS.n234 EDGE_BIAS.t432 0.737901
R12347 EDGE_BIAS.n233 EDGE_BIAS.t426 0.737901
R12348 EDGE_BIAS.n232 EDGE_BIAS.t420 0.737901
R12349 EDGE_BIAS.n231 EDGE_BIAS.t414 0.737901
R12350 EDGE_BIAS.n230 EDGE_BIAS.t408 0.737901
R12351 EDGE_BIAS.n229 EDGE_BIAS.t402 0.737901
R12352 EDGE_BIAS.n228 EDGE_BIAS.t396 0.737901
R12353 EDGE_BIAS.n227 EDGE_BIAS.t390 0.737901
R12354 EDGE_BIAS.n226 EDGE_BIAS.t384 0.737901
R12355 EDGE_BIAS.n225 EDGE_BIAS.t378 0.737901
R12356 EDGE_BIAS.n224 EDGE_BIAS.t372 0.737901
R12357 EDGE_BIAS.n223 EDGE_BIAS.t366 0.737901
R12358 EDGE_BIAS.n222 EDGE_BIAS.t360 0.737901
R12359 EDGE_BIAS.n221 EDGE_BIAS.t354 0.737901
R12360 EDGE_BIAS.n220 EDGE_BIAS.t348 0.737901
R12361 EDGE_BIAS.n219 EDGE_BIAS.t342 0.737901
R12362 EDGE_BIAS.n218 EDGE_BIAS.t336 0.737901
R12363 EDGE_BIAS.n217 EDGE_BIAS.t330 0.737901
R12364 EDGE_BIAS.n216 EDGE_BIAS.t324 0.737901
R12365 EDGE_BIAS.n215 EDGE_BIAS.t318 0.737901
R12366 EDGE_BIAS.n214 EDGE_BIAS.t312 0.737901
R12367 EDGE_BIAS.n213 EDGE_BIAS.t306 0.737901
R12368 EDGE_BIAS.n212 EDGE_BIAS.t300 0.737901
R12369 EDGE_BIAS.n211 EDGE_BIAS.t294 0.737901
R12370 EDGE_BIAS.n210 EDGE_BIAS.t288 0.737901
R12371 EDGE_BIAS.n209 EDGE_BIAS.t282 0.737901
R12372 EDGE_BIAS.n208 EDGE_BIAS.t276 0.737901
R12373 EDGE_BIAS.n207 EDGE_BIAS.t270 0.737901
R12374 EDGE_BIAS.n206 EDGE_BIAS.t264 0.737901
R12375 EDGE_BIAS.n205 EDGE_BIAS.t258 0.737901
R12376 EDGE_BIAS.n204 EDGE_BIAS.t252 0.737901
R12377 EDGE_BIAS.n203 EDGE_BIAS.t246 0.737901
R12378 EDGE_BIAS.n202 EDGE_BIAS.t240 0.737901
R12379 EDGE_BIAS.n201 EDGE_BIAS.t234 0.737901
R12380 EDGE_BIAS.n200 EDGE_BIAS.t228 0.737901
R12381 EDGE_BIAS.n199 EDGE_BIAS.t222 0.737901
R12382 EDGE_BIAS.n198 EDGE_BIAS.t216 0.737901
R12383 EDGE_BIAS.n197 EDGE_BIAS.t210 0.737901
R12384 EDGE_BIAS.n196 EDGE_BIAS.t204 0.737901
R12385 EDGE_BIAS.n195 EDGE_BIAS.t198 0.737901
R12386 EDGE_BIAS.n129 EDGE_BIAS.t195 0.737901
R12387 EDGE_BIAS.n128 EDGE_BIAS.t201 0.737901
R12388 EDGE_BIAS.n127 EDGE_BIAS.t207 0.737901
R12389 EDGE_BIAS.n126 EDGE_BIAS.t213 0.737901
R12390 EDGE_BIAS.n125 EDGE_BIAS.t219 0.737901
R12391 EDGE_BIAS.n124 EDGE_BIAS.t225 0.737901
R12392 EDGE_BIAS.n123 EDGE_BIAS.t231 0.737901
R12393 EDGE_BIAS.n122 EDGE_BIAS.t237 0.737901
R12394 EDGE_BIAS.n121 EDGE_BIAS.t243 0.737901
R12395 EDGE_BIAS.n120 EDGE_BIAS.t249 0.737901
R12396 EDGE_BIAS.n119 EDGE_BIAS.t255 0.737901
R12397 EDGE_BIAS.n118 EDGE_BIAS.t261 0.737901
R12398 EDGE_BIAS.n117 EDGE_BIAS.t267 0.737901
R12399 EDGE_BIAS.n116 EDGE_BIAS.t273 0.737901
R12400 EDGE_BIAS.n115 EDGE_BIAS.t279 0.737901
R12401 EDGE_BIAS.n114 EDGE_BIAS.t285 0.737901
R12402 EDGE_BIAS.n113 EDGE_BIAS.t291 0.737901
R12403 EDGE_BIAS.n112 EDGE_BIAS.t297 0.737901
R12404 EDGE_BIAS.n111 EDGE_BIAS.t303 0.737901
R12405 EDGE_BIAS.n110 EDGE_BIAS.t309 0.737901
R12406 EDGE_BIAS.n109 EDGE_BIAS.t315 0.737901
R12407 EDGE_BIAS.n108 EDGE_BIAS.t321 0.737901
R12408 EDGE_BIAS.n107 EDGE_BIAS.t327 0.737901
R12409 EDGE_BIAS.n106 EDGE_BIAS.t333 0.737901
R12410 EDGE_BIAS.n105 EDGE_BIAS.t339 0.737901
R12411 EDGE_BIAS.n104 EDGE_BIAS.t345 0.737901
R12412 EDGE_BIAS.n103 EDGE_BIAS.t351 0.737901
R12413 EDGE_BIAS.n102 EDGE_BIAS.t357 0.737901
R12414 EDGE_BIAS.n101 EDGE_BIAS.t363 0.737901
R12415 EDGE_BIAS.n100 EDGE_BIAS.t369 0.737901
R12416 EDGE_BIAS.n99 EDGE_BIAS.t375 0.737901
R12417 EDGE_BIAS.n98 EDGE_BIAS.t381 0.737901
R12418 EDGE_BIAS.n97 EDGE_BIAS.t387 0.737901
R12419 EDGE_BIAS.n96 EDGE_BIAS.t393 0.737901
R12420 EDGE_BIAS.n95 EDGE_BIAS.t399 0.737901
R12421 EDGE_BIAS.n94 EDGE_BIAS.t405 0.737901
R12422 EDGE_BIAS.n93 EDGE_BIAS.t411 0.737901
R12423 EDGE_BIAS.n92 EDGE_BIAS.t417 0.737901
R12424 EDGE_BIAS.n91 EDGE_BIAS.t423 0.737901
R12425 EDGE_BIAS.n90 EDGE_BIAS.t429 0.737901
R12426 EDGE_BIAS.n89 EDGE_BIAS.t435 0.737901
R12427 EDGE_BIAS.n88 EDGE_BIAS.t441 0.737901
R12428 EDGE_BIAS.n87 EDGE_BIAS.t447 0.737901
R12429 EDGE_BIAS.n86 EDGE_BIAS.t453 0.737901
R12430 EDGE_BIAS.n85 EDGE_BIAS.t459 0.737901
R12431 EDGE_BIAS.n84 EDGE_BIAS.t465 0.737901
R12432 EDGE_BIAS.n83 EDGE_BIAS.t471 0.737901
R12433 EDGE_BIAS.n82 EDGE_BIAS.t477 0.737901
R12434 EDGE_BIAS.n81 EDGE_BIAS.t483 0.737901
R12435 EDGE_BIAS.n80 EDGE_BIAS.t489 0.737901
R12436 EDGE_BIAS.n79 EDGE_BIAS.t495 0.737901
R12437 EDGE_BIAS.n78 EDGE_BIAS.t501 0.737901
R12438 EDGE_BIAS.n77 EDGE_BIAS.t507 0.737901
R12439 EDGE_BIAS.n76 EDGE_BIAS.t513 0.737901
R12440 EDGE_BIAS.n75 EDGE_BIAS.t519 0.737901
R12441 EDGE_BIAS.n74 EDGE_BIAS.t525 0.737901
R12442 EDGE_BIAS.n73 EDGE_BIAS.t531 0.737901
R12443 EDGE_BIAS.n72 EDGE_BIAS.t537 0.737901
R12444 EDGE_BIAS.n71 EDGE_BIAS.t543 0.737901
R12445 EDGE_BIAS.n70 EDGE_BIAS.t549 0.737901
R12446 EDGE_BIAS.n69 EDGE_BIAS.t555 0.737901
R12447 EDGE_BIAS.n68 EDGE_BIAS.t561 0.737901
R12448 EDGE_BIAS.n67 EDGE_BIAS.t567 0.737901
R12449 EDGE_BIAS.n66 EDGE_BIAS.t573 0.737901
R12450 EDGE_BIAS.n65 EDGE_BIAS.t579 0.737901
R12451 EDGE_BIAS.n0 EDGE_BIAS.t585 0.737901
R12452 EDGE_BIAS.n1 EDGE_BIAS.t588 0.737901
R12453 EDGE_BIAS.n2 EDGE_BIAS.t591 0.737901
R12454 EDGE_BIAS.n3 EDGE_BIAS.t594 0.737901
R12455 EDGE_BIAS.n4 EDGE_BIAS.t597 0.737901
R12456 EDGE_BIAS.n5 EDGE_BIAS.t600 0.737901
R12457 EDGE_BIAS.n6 EDGE_BIAS.t603 0.737901
R12458 EDGE_BIAS.n7 EDGE_BIAS.t606 0.737901
R12459 EDGE_BIAS.n8 EDGE_BIAS.t609 0.737901
R12460 EDGE_BIAS.n9 EDGE_BIAS.t612 0.737901
R12461 EDGE_BIAS.n10 EDGE_BIAS.t615 0.737901
R12462 EDGE_BIAS.n11 EDGE_BIAS.t618 0.737901
R12463 EDGE_BIAS.n12 EDGE_BIAS.t621 0.737901
R12464 EDGE_BIAS.n13 EDGE_BIAS.t624 0.737901
R12465 EDGE_BIAS.n14 EDGE_BIAS.t627 0.737901
R12466 EDGE_BIAS.n15 EDGE_BIAS.t630 0.737901
R12467 EDGE_BIAS.n16 EDGE_BIAS.t633 0.737901
R12468 EDGE_BIAS.n17 EDGE_BIAS.t636 0.737901
R12469 EDGE_BIAS.n18 EDGE_BIAS.t639 0.737901
R12470 EDGE_BIAS.n19 EDGE_BIAS.t642 0.737901
R12471 EDGE_BIAS.n20 EDGE_BIAS.t645 0.737901
R12472 EDGE_BIAS.n21 EDGE_BIAS.t648 0.737901
R12473 EDGE_BIAS.n22 EDGE_BIAS.t651 0.737901
R12474 EDGE_BIAS.n23 EDGE_BIAS.t654 0.737901
R12475 EDGE_BIAS.n24 EDGE_BIAS.t657 0.737901
R12476 EDGE_BIAS.n25 EDGE_BIAS.t660 0.737901
R12477 EDGE_BIAS.n26 EDGE_BIAS.t663 0.737901
R12478 EDGE_BIAS.n27 EDGE_BIAS.t666 0.737901
R12479 EDGE_BIAS.n28 EDGE_BIAS.t669 0.737901
R12480 EDGE_BIAS.n29 EDGE_BIAS.t672 0.737901
R12481 EDGE_BIAS.n30 EDGE_BIAS.t675 0.737901
R12482 EDGE_BIAS.n31 EDGE_BIAS.t678 0.737901
R12483 EDGE_BIAS.n32 EDGE_BIAS.t681 0.737901
R12484 EDGE_BIAS.n33 EDGE_BIAS.t684 0.737901
R12485 EDGE_BIAS.n34 EDGE_BIAS.t687 0.737901
R12486 EDGE_BIAS.n35 EDGE_BIAS.t690 0.737901
R12487 EDGE_BIAS.n36 EDGE_BIAS.t693 0.737901
R12488 EDGE_BIAS.n37 EDGE_BIAS.t696 0.737901
R12489 EDGE_BIAS.n38 EDGE_BIAS.t699 0.737901
R12490 EDGE_BIAS.n39 EDGE_BIAS.t702 0.737901
R12491 EDGE_BIAS.n40 EDGE_BIAS.t705 0.737901
R12492 EDGE_BIAS.n41 EDGE_BIAS.t708 0.737901
R12493 EDGE_BIAS.n42 EDGE_BIAS.t711 0.737901
R12494 EDGE_BIAS.n43 EDGE_BIAS.t714 0.737901
R12495 EDGE_BIAS.n44 EDGE_BIAS.t717 0.737901
R12496 EDGE_BIAS.n45 EDGE_BIAS.t720 0.737901
R12497 EDGE_BIAS.n46 EDGE_BIAS.t723 0.737901
R12498 EDGE_BIAS.n47 EDGE_BIAS.t726 0.737901
R12499 EDGE_BIAS.n48 EDGE_BIAS.t729 0.737901
R12500 EDGE_BIAS.n49 EDGE_BIAS.t732 0.737901
R12501 EDGE_BIAS.n50 EDGE_BIAS.t735 0.737901
R12502 EDGE_BIAS.n51 EDGE_BIAS.t738 0.737901
R12503 EDGE_BIAS.n52 EDGE_BIAS.t741 0.737901
R12504 EDGE_BIAS.n53 EDGE_BIAS.t744 0.737901
R12505 EDGE_BIAS.n54 EDGE_BIAS.t747 0.737901
R12506 EDGE_BIAS.n55 EDGE_BIAS.t750 0.737901
R12507 EDGE_BIAS.n56 EDGE_BIAS.t753 0.737901
R12508 EDGE_BIAS.n57 EDGE_BIAS.t756 0.737901
R12509 EDGE_BIAS.n58 EDGE_BIAS.t759 0.737901
R12510 EDGE_BIAS.n59 EDGE_BIAS.t762 0.737901
R12511 EDGE_BIAS.n60 EDGE_BIAS.t765 0.737901
R12512 EDGE_BIAS.n61 EDGE_BIAS.t768 0.737901
R12513 EDGE_BIAS.n62 EDGE_BIAS.t771 0.737901
R12514 EDGE_BIAS.n63 EDGE_BIAS.t774 0.737901
R12515 EDGE_BIAS.n64 EDGE_BIAS.t777 0.737901
R12516 EDGE_BIAS.n130 EDGE_BIAS.t192 0.737901
R12517 EDGE_BIAS.n131 EDGE_BIAS.t189 0.737901
R12518 EDGE_BIAS.n132 EDGE_BIAS.t186 0.737901
R12519 EDGE_BIAS.n133 EDGE_BIAS.t183 0.737901
R12520 EDGE_BIAS.n134 EDGE_BIAS.t180 0.737901
R12521 EDGE_BIAS.n135 EDGE_BIAS.t177 0.737901
R12522 EDGE_BIAS.n136 EDGE_BIAS.t174 0.737901
R12523 EDGE_BIAS.n137 EDGE_BIAS.t171 0.737901
R12524 EDGE_BIAS.n138 EDGE_BIAS.t168 0.737901
R12525 EDGE_BIAS.n139 EDGE_BIAS.t165 0.737901
R12526 EDGE_BIAS.n140 EDGE_BIAS.t162 0.737901
R12527 EDGE_BIAS.n141 EDGE_BIAS.t159 0.737901
R12528 EDGE_BIAS.n142 EDGE_BIAS.t156 0.737901
R12529 EDGE_BIAS.n143 EDGE_BIAS.t153 0.737901
R12530 EDGE_BIAS.n144 EDGE_BIAS.t150 0.737901
R12531 EDGE_BIAS.n145 EDGE_BIAS.t147 0.737901
R12532 EDGE_BIAS.n146 EDGE_BIAS.t144 0.737901
R12533 EDGE_BIAS.n147 EDGE_BIAS.t141 0.737901
R12534 EDGE_BIAS.n148 EDGE_BIAS.t138 0.737901
R12535 EDGE_BIAS.n149 EDGE_BIAS.t135 0.737901
R12536 EDGE_BIAS.n150 EDGE_BIAS.t132 0.737901
R12537 EDGE_BIAS.n151 EDGE_BIAS.t129 0.737901
R12538 EDGE_BIAS.n152 EDGE_BIAS.t126 0.737901
R12539 EDGE_BIAS.n153 EDGE_BIAS.t123 0.737901
R12540 EDGE_BIAS.n154 EDGE_BIAS.t120 0.737901
R12541 EDGE_BIAS.n155 EDGE_BIAS.t117 0.737901
R12542 EDGE_BIAS.n156 EDGE_BIAS.t114 0.737901
R12543 EDGE_BIAS.n157 EDGE_BIAS.t111 0.737901
R12544 EDGE_BIAS.n158 EDGE_BIAS.t108 0.737901
R12545 EDGE_BIAS.n159 EDGE_BIAS.t105 0.737901
R12546 EDGE_BIAS.n160 EDGE_BIAS.t102 0.737901
R12547 EDGE_BIAS.n161 EDGE_BIAS.t99 0.737901
R12548 EDGE_BIAS.n162 EDGE_BIAS.t96 0.737901
R12549 EDGE_BIAS.n163 EDGE_BIAS.t93 0.737901
R12550 EDGE_BIAS.n164 EDGE_BIAS.t90 0.737901
R12551 EDGE_BIAS.n165 EDGE_BIAS.t87 0.737901
R12552 EDGE_BIAS.n166 EDGE_BIAS.t84 0.737901
R12553 EDGE_BIAS.n167 EDGE_BIAS.t81 0.737901
R12554 EDGE_BIAS.n168 EDGE_BIAS.t78 0.737901
R12555 EDGE_BIAS.n169 EDGE_BIAS.t75 0.737901
R12556 EDGE_BIAS.n170 EDGE_BIAS.t72 0.737901
R12557 EDGE_BIAS.n171 EDGE_BIAS.t69 0.737901
R12558 EDGE_BIAS.n172 EDGE_BIAS.t66 0.737901
R12559 EDGE_BIAS.n173 EDGE_BIAS.t63 0.737901
R12560 EDGE_BIAS.n174 EDGE_BIAS.t60 0.737901
R12561 EDGE_BIAS.n175 EDGE_BIAS.t57 0.737901
R12562 EDGE_BIAS.n176 EDGE_BIAS.t54 0.737901
R12563 EDGE_BIAS.n177 EDGE_BIAS.t51 0.737901
R12564 EDGE_BIAS.n178 EDGE_BIAS.t48 0.737901
R12565 EDGE_BIAS.n179 EDGE_BIAS.t45 0.737901
R12566 EDGE_BIAS.n180 EDGE_BIAS.t42 0.737901
R12567 EDGE_BIAS.n181 EDGE_BIAS.t39 0.737901
R12568 EDGE_BIAS.n182 EDGE_BIAS.t36 0.737901
R12569 EDGE_BIAS.n183 EDGE_BIAS.t33 0.737901
R12570 EDGE_BIAS.n184 EDGE_BIAS.t30 0.737901
R12571 EDGE_BIAS.n185 EDGE_BIAS.t27 0.737901
R12572 EDGE_BIAS.n186 EDGE_BIAS.t24 0.737901
R12573 EDGE_BIAS.n187 EDGE_BIAS.t21 0.737901
R12574 EDGE_BIAS.n188 EDGE_BIAS.t18 0.737901
R12575 EDGE_BIAS.n189 EDGE_BIAS.t15 0.737901
R12576 EDGE_BIAS.n190 EDGE_BIAS.t12 0.737901
R12577 EDGE_BIAS.n191 EDGE_BIAS.t9 0.737901
R12578 EDGE_BIAS.n192 EDGE_BIAS.t6 0.737901
R12579 EDGE_BIAS.n193 EDGE_BIAS.t3 0.737901
R12580 EDGE_BIAS.n194 EDGE_BIAS.t0 0.737901
R12581 EDGE_BIAS.n259 EDGE_BIAS.t582 0.737901
R12582 EDGE_BIAS.n259 EDGE_BIAS.n258 0.407833
R12583 EDGE_BIAS.n258 EDGE_BIAS.n257 0.407833
R12584 EDGE_BIAS.n257 EDGE_BIAS.n256 0.407833
R12585 EDGE_BIAS.n256 EDGE_BIAS.n255 0.407833
R12586 EDGE_BIAS.n255 EDGE_BIAS.n254 0.407833
R12587 EDGE_BIAS.n254 EDGE_BIAS.n253 0.407833
R12588 EDGE_BIAS.n253 EDGE_BIAS.n252 0.407833
R12589 EDGE_BIAS.n252 EDGE_BIAS.n251 0.407833
R12590 EDGE_BIAS.n251 EDGE_BIAS.n250 0.407833
R12591 EDGE_BIAS.n250 EDGE_BIAS.n249 0.407833
R12592 EDGE_BIAS.n249 EDGE_BIAS.n248 0.407833
R12593 EDGE_BIAS.n248 EDGE_BIAS.n247 0.407833
R12594 EDGE_BIAS.n247 EDGE_BIAS.n246 0.407833
R12595 EDGE_BIAS.n246 EDGE_BIAS.n245 0.407833
R12596 EDGE_BIAS.n245 EDGE_BIAS.n244 0.407833
R12597 EDGE_BIAS.n244 EDGE_BIAS.n243 0.407833
R12598 EDGE_BIAS.n243 EDGE_BIAS.n242 0.407833
R12599 EDGE_BIAS.n242 EDGE_BIAS.n241 0.407833
R12600 EDGE_BIAS.n241 EDGE_BIAS.n240 0.407833
R12601 EDGE_BIAS.n240 EDGE_BIAS.n239 0.407833
R12602 EDGE_BIAS.n239 EDGE_BIAS.n238 0.407833
R12603 EDGE_BIAS.n238 EDGE_BIAS.n237 0.407833
R12604 EDGE_BIAS.n237 EDGE_BIAS.n236 0.407833
R12605 EDGE_BIAS.n236 EDGE_BIAS.n235 0.407833
R12606 EDGE_BIAS.n235 EDGE_BIAS.n234 0.407833
R12607 EDGE_BIAS.n234 EDGE_BIAS.n233 0.407833
R12608 EDGE_BIAS.n233 EDGE_BIAS.n232 0.407833
R12609 EDGE_BIAS.n232 EDGE_BIAS.n231 0.407833
R12610 EDGE_BIAS.n231 EDGE_BIAS.n230 0.407833
R12611 EDGE_BIAS.n230 EDGE_BIAS.n229 0.407833
R12612 EDGE_BIAS.n229 EDGE_BIAS.n228 0.407833
R12613 EDGE_BIAS.n228 EDGE_BIAS.n227 0.407833
R12614 EDGE_BIAS.n227 EDGE_BIAS.n226 0.407833
R12615 EDGE_BIAS.n226 EDGE_BIAS.n225 0.407833
R12616 EDGE_BIAS.n225 EDGE_BIAS.n224 0.407833
R12617 EDGE_BIAS.n224 EDGE_BIAS.n223 0.407833
R12618 EDGE_BIAS.n223 EDGE_BIAS.n222 0.407833
R12619 EDGE_BIAS.n222 EDGE_BIAS.n221 0.407833
R12620 EDGE_BIAS.n221 EDGE_BIAS.n220 0.407833
R12621 EDGE_BIAS.n220 EDGE_BIAS.n219 0.407833
R12622 EDGE_BIAS.n219 EDGE_BIAS.n218 0.407833
R12623 EDGE_BIAS.n218 EDGE_BIAS.n217 0.407833
R12624 EDGE_BIAS.n217 EDGE_BIAS.n216 0.407833
R12625 EDGE_BIAS.n216 EDGE_BIAS.n215 0.407833
R12626 EDGE_BIAS.n215 EDGE_BIAS.n214 0.407833
R12627 EDGE_BIAS.n214 EDGE_BIAS.n213 0.407833
R12628 EDGE_BIAS.n213 EDGE_BIAS.n212 0.407833
R12629 EDGE_BIAS.n212 EDGE_BIAS.n211 0.407833
R12630 EDGE_BIAS.n211 EDGE_BIAS.n210 0.407833
R12631 EDGE_BIAS.n210 EDGE_BIAS.n209 0.407833
R12632 EDGE_BIAS.n209 EDGE_BIAS.n208 0.407833
R12633 EDGE_BIAS.n208 EDGE_BIAS.n207 0.407833
R12634 EDGE_BIAS.n207 EDGE_BIAS.n206 0.407833
R12635 EDGE_BIAS.n206 EDGE_BIAS.n205 0.407833
R12636 EDGE_BIAS.n205 EDGE_BIAS.n204 0.407833
R12637 EDGE_BIAS.n204 EDGE_BIAS.n203 0.407833
R12638 EDGE_BIAS.n203 EDGE_BIAS.n202 0.407833
R12639 EDGE_BIAS.n202 EDGE_BIAS.n201 0.407833
R12640 EDGE_BIAS.n201 EDGE_BIAS.n200 0.407833
R12641 EDGE_BIAS.n200 EDGE_BIAS.n199 0.407833
R12642 EDGE_BIAS.n199 EDGE_BIAS.n198 0.407833
R12643 EDGE_BIAS.n198 EDGE_BIAS.n197 0.407833
R12644 EDGE_BIAS.n197 EDGE_BIAS.n196 0.407833
R12645 EDGE_BIAS.n196 EDGE_BIAS.n195 0.407833
R12646 EDGE_BIAS.n195 EDGE_BIAS.n194 0.407833
R12647 EDGE_BIAS.n129 EDGE_BIAS.n128 0.407833
R12648 EDGE_BIAS.n128 EDGE_BIAS.n127 0.407833
R12649 EDGE_BIAS.n127 EDGE_BIAS.n126 0.407833
R12650 EDGE_BIAS.n126 EDGE_BIAS.n125 0.407833
R12651 EDGE_BIAS.n125 EDGE_BIAS.n124 0.407833
R12652 EDGE_BIAS.n124 EDGE_BIAS.n123 0.407833
R12653 EDGE_BIAS.n123 EDGE_BIAS.n122 0.407833
R12654 EDGE_BIAS.n122 EDGE_BIAS.n121 0.407833
R12655 EDGE_BIAS.n121 EDGE_BIAS.n120 0.407833
R12656 EDGE_BIAS.n120 EDGE_BIAS.n119 0.407833
R12657 EDGE_BIAS.n119 EDGE_BIAS.n118 0.407833
R12658 EDGE_BIAS.n118 EDGE_BIAS.n117 0.407833
R12659 EDGE_BIAS.n117 EDGE_BIAS.n116 0.407833
R12660 EDGE_BIAS.n116 EDGE_BIAS.n115 0.407833
R12661 EDGE_BIAS.n115 EDGE_BIAS.n114 0.407833
R12662 EDGE_BIAS.n114 EDGE_BIAS.n113 0.407833
R12663 EDGE_BIAS.n113 EDGE_BIAS.n112 0.407833
R12664 EDGE_BIAS.n112 EDGE_BIAS.n111 0.407833
R12665 EDGE_BIAS.n111 EDGE_BIAS.n110 0.407833
R12666 EDGE_BIAS.n110 EDGE_BIAS.n109 0.407833
R12667 EDGE_BIAS.n109 EDGE_BIAS.n108 0.407833
R12668 EDGE_BIAS.n108 EDGE_BIAS.n107 0.407833
R12669 EDGE_BIAS.n107 EDGE_BIAS.n106 0.407833
R12670 EDGE_BIAS.n106 EDGE_BIAS.n105 0.407833
R12671 EDGE_BIAS.n105 EDGE_BIAS.n104 0.407833
R12672 EDGE_BIAS.n104 EDGE_BIAS.n103 0.407833
R12673 EDGE_BIAS.n103 EDGE_BIAS.n102 0.407833
R12674 EDGE_BIAS.n102 EDGE_BIAS.n101 0.407833
R12675 EDGE_BIAS.n101 EDGE_BIAS.n100 0.407833
R12676 EDGE_BIAS.n100 EDGE_BIAS.n99 0.407833
R12677 EDGE_BIAS.n99 EDGE_BIAS.n98 0.407833
R12678 EDGE_BIAS.n98 EDGE_BIAS.n97 0.407833
R12679 EDGE_BIAS.n97 EDGE_BIAS.n96 0.407833
R12680 EDGE_BIAS.n96 EDGE_BIAS.n95 0.407833
R12681 EDGE_BIAS.n95 EDGE_BIAS.n94 0.407833
R12682 EDGE_BIAS.n94 EDGE_BIAS.n93 0.407833
R12683 EDGE_BIAS.n93 EDGE_BIAS.n92 0.407833
R12684 EDGE_BIAS.n92 EDGE_BIAS.n91 0.407833
R12685 EDGE_BIAS.n91 EDGE_BIAS.n90 0.407833
R12686 EDGE_BIAS.n90 EDGE_BIAS.n89 0.407833
R12687 EDGE_BIAS.n89 EDGE_BIAS.n88 0.407833
R12688 EDGE_BIAS.n88 EDGE_BIAS.n87 0.407833
R12689 EDGE_BIAS.n87 EDGE_BIAS.n86 0.407833
R12690 EDGE_BIAS.n86 EDGE_BIAS.n85 0.407833
R12691 EDGE_BIAS.n85 EDGE_BIAS.n84 0.407833
R12692 EDGE_BIAS.n84 EDGE_BIAS.n83 0.407833
R12693 EDGE_BIAS.n83 EDGE_BIAS.n82 0.407833
R12694 EDGE_BIAS.n82 EDGE_BIAS.n81 0.407833
R12695 EDGE_BIAS.n81 EDGE_BIAS.n80 0.407833
R12696 EDGE_BIAS.n80 EDGE_BIAS.n79 0.407833
R12697 EDGE_BIAS.n79 EDGE_BIAS.n78 0.407833
R12698 EDGE_BIAS.n78 EDGE_BIAS.n77 0.407833
R12699 EDGE_BIAS.n77 EDGE_BIAS.n76 0.407833
R12700 EDGE_BIAS.n76 EDGE_BIAS.n75 0.407833
R12701 EDGE_BIAS.n75 EDGE_BIAS.n74 0.407833
R12702 EDGE_BIAS.n74 EDGE_BIAS.n73 0.407833
R12703 EDGE_BIAS.n73 EDGE_BIAS.n72 0.407833
R12704 EDGE_BIAS.n72 EDGE_BIAS.n71 0.407833
R12705 EDGE_BIAS.n71 EDGE_BIAS.n70 0.407833
R12706 EDGE_BIAS.n70 EDGE_BIAS.n69 0.407833
R12707 EDGE_BIAS.n69 EDGE_BIAS.n68 0.407833
R12708 EDGE_BIAS.n68 EDGE_BIAS.n67 0.407833
R12709 EDGE_BIAS.n67 EDGE_BIAS.n66 0.407833
R12710 EDGE_BIAS.n66 EDGE_BIAS.n65 0.407833
R12711 EDGE_BIAS.n65 EDGE_BIAS.n64 0.407833
R12712 EDGE_BIAS.n194 EDGE_BIAS.t4 0.116894
R12713 EDGE_BIAS.n193 EDGE_BIAS.t7 0.116894
R12714 EDGE_BIAS.n192 EDGE_BIAS.t10 0.116894
R12715 EDGE_BIAS.n191 EDGE_BIAS.t13 0.116894
R12716 EDGE_BIAS.n190 EDGE_BIAS.t16 0.116894
R12717 EDGE_BIAS.n189 EDGE_BIAS.t19 0.116894
R12718 EDGE_BIAS.n188 EDGE_BIAS.t22 0.116894
R12719 EDGE_BIAS.n187 EDGE_BIAS.t25 0.116894
R12720 EDGE_BIAS.n186 EDGE_BIAS.t28 0.116894
R12721 EDGE_BIAS.n185 EDGE_BIAS.t31 0.116894
R12722 EDGE_BIAS.n184 EDGE_BIAS.t34 0.116894
R12723 EDGE_BIAS.n183 EDGE_BIAS.t37 0.116894
R12724 EDGE_BIAS.n182 EDGE_BIAS.t40 0.116894
R12725 EDGE_BIAS.n181 EDGE_BIAS.t43 0.116894
R12726 EDGE_BIAS.n180 EDGE_BIAS.t46 0.116894
R12727 EDGE_BIAS.n179 EDGE_BIAS.t49 0.116894
R12728 EDGE_BIAS.n178 EDGE_BIAS.t52 0.116894
R12729 EDGE_BIAS.n177 EDGE_BIAS.t55 0.116894
R12730 EDGE_BIAS.n176 EDGE_BIAS.t58 0.116894
R12731 EDGE_BIAS.n175 EDGE_BIAS.t61 0.116894
R12732 EDGE_BIAS.n174 EDGE_BIAS.t64 0.116894
R12733 EDGE_BIAS.n173 EDGE_BIAS.t67 0.116894
R12734 EDGE_BIAS.n172 EDGE_BIAS.t70 0.116894
R12735 EDGE_BIAS.n171 EDGE_BIAS.t73 0.116894
R12736 EDGE_BIAS.n170 EDGE_BIAS.t76 0.116894
R12737 EDGE_BIAS.n169 EDGE_BIAS.t79 0.116894
R12738 EDGE_BIAS.n168 EDGE_BIAS.t82 0.116894
R12739 EDGE_BIAS.n167 EDGE_BIAS.t85 0.116894
R12740 EDGE_BIAS.n166 EDGE_BIAS.t88 0.116894
R12741 EDGE_BIAS.n165 EDGE_BIAS.t91 0.116894
R12742 EDGE_BIAS.n164 EDGE_BIAS.t94 0.116894
R12743 EDGE_BIAS.n163 EDGE_BIAS.t97 0.116894
R12744 EDGE_BIAS.n162 EDGE_BIAS.t100 0.116894
R12745 EDGE_BIAS.n161 EDGE_BIAS.t103 0.116894
R12746 EDGE_BIAS.n160 EDGE_BIAS.t106 0.116894
R12747 EDGE_BIAS.n159 EDGE_BIAS.t109 0.116894
R12748 EDGE_BIAS.n158 EDGE_BIAS.t112 0.116894
R12749 EDGE_BIAS.n157 EDGE_BIAS.t115 0.116894
R12750 EDGE_BIAS.n156 EDGE_BIAS.t118 0.116894
R12751 EDGE_BIAS.n155 EDGE_BIAS.t121 0.116894
R12752 EDGE_BIAS.n154 EDGE_BIAS.t124 0.116894
R12753 EDGE_BIAS.n153 EDGE_BIAS.t127 0.116894
R12754 EDGE_BIAS.n152 EDGE_BIAS.t130 0.116894
R12755 EDGE_BIAS.n151 EDGE_BIAS.t133 0.116894
R12756 EDGE_BIAS.n150 EDGE_BIAS.t136 0.116894
R12757 EDGE_BIAS.n149 EDGE_BIAS.t139 0.116894
R12758 EDGE_BIAS.n148 EDGE_BIAS.t142 0.116894
R12759 EDGE_BIAS.n147 EDGE_BIAS.t145 0.116894
R12760 EDGE_BIAS.n146 EDGE_BIAS.t148 0.116894
R12761 EDGE_BIAS.n145 EDGE_BIAS.t151 0.116894
R12762 EDGE_BIAS.n144 EDGE_BIAS.t154 0.116894
R12763 EDGE_BIAS.n143 EDGE_BIAS.t157 0.116894
R12764 EDGE_BIAS.n142 EDGE_BIAS.t160 0.116894
R12765 EDGE_BIAS.n141 EDGE_BIAS.t163 0.116894
R12766 EDGE_BIAS.n140 EDGE_BIAS.t166 0.116894
R12767 EDGE_BIAS.n139 EDGE_BIAS.t169 0.116894
R12768 EDGE_BIAS.n138 EDGE_BIAS.t172 0.116894
R12769 EDGE_BIAS.n137 EDGE_BIAS.t175 0.116894
R12770 EDGE_BIAS.n136 EDGE_BIAS.t178 0.116894
R12771 EDGE_BIAS.n135 EDGE_BIAS.t181 0.116894
R12772 EDGE_BIAS.n134 EDGE_BIAS.t184 0.116894
R12773 EDGE_BIAS.n133 EDGE_BIAS.t187 0.116894
R12774 EDGE_BIAS.n132 EDGE_BIAS.t190 0.116894
R12775 EDGE_BIAS.n131 EDGE_BIAS.t193 0.116894
R12776 EDGE_BIAS.n130 EDGE_BIAS.t196 0.116894
R12777 EDGE_BIAS.t778 EDGE_BIAS.n63 0.116894
R12778 EDGE_BIAS.t775 EDGE_BIAS.n62 0.116894
R12779 EDGE_BIAS.t772 EDGE_BIAS.n61 0.116894
R12780 EDGE_BIAS.t769 EDGE_BIAS.n60 0.116894
R12781 EDGE_BIAS.t766 EDGE_BIAS.n59 0.116894
R12782 EDGE_BIAS.t763 EDGE_BIAS.n58 0.116894
R12783 EDGE_BIAS.t760 EDGE_BIAS.n57 0.116894
R12784 EDGE_BIAS.t757 EDGE_BIAS.n56 0.116894
R12785 EDGE_BIAS.t754 EDGE_BIAS.n55 0.116894
R12786 EDGE_BIAS.t751 EDGE_BIAS.n54 0.116894
R12787 EDGE_BIAS.t748 EDGE_BIAS.n53 0.116894
R12788 EDGE_BIAS.t745 EDGE_BIAS.n52 0.116894
R12789 EDGE_BIAS.t742 EDGE_BIAS.n51 0.116894
R12790 EDGE_BIAS.t739 EDGE_BIAS.n50 0.116894
R12791 EDGE_BIAS.t736 EDGE_BIAS.n49 0.116894
R12792 EDGE_BIAS.t733 EDGE_BIAS.n48 0.116894
R12793 EDGE_BIAS.t730 EDGE_BIAS.n47 0.116894
R12794 EDGE_BIAS.t727 EDGE_BIAS.n46 0.116894
R12795 EDGE_BIAS.t724 EDGE_BIAS.n45 0.116894
R12796 EDGE_BIAS.t721 EDGE_BIAS.n44 0.116894
R12797 EDGE_BIAS.t718 EDGE_BIAS.n43 0.116894
R12798 EDGE_BIAS.t715 EDGE_BIAS.n42 0.116894
R12799 EDGE_BIAS.t712 EDGE_BIAS.n41 0.116894
R12800 EDGE_BIAS.t709 EDGE_BIAS.n40 0.116894
R12801 EDGE_BIAS.t706 EDGE_BIAS.n39 0.116894
R12802 EDGE_BIAS.t703 EDGE_BIAS.n38 0.116894
R12803 EDGE_BIAS.t700 EDGE_BIAS.n37 0.116894
R12804 EDGE_BIAS.t697 EDGE_BIAS.n36 0.116894
R12805 EDGE_BIAS.t694 EDGE_BIAS.n35 0.116894
R12806 EDGE_BIAS.t691 EDGE_BIAS.n34 0.116894
R12807 EDGE_BIAS.t688 EDGE_BIAS.n33 0.116894
R12808 EDGE_BIAS.t685 EDGE_BIAS.n32 0.116894
R12809 EDGE_BIAS.t682 EDGE_BIAS.n31 0.116894
R12810 EDGE_BIAS.t679 EDGE_BIAS.n30 0.116894
R12811 EDGE_BIAS.t676 EDGE_BIAS.n29 0.116894
R12812 EDGE_BIAS.t673 EDGE_BIAS.n28 0.116894
R12813 EDGE_BIAS.t670 EDGE_BIAS.n27 0.116894
R12814 EDGE_BIAS.t667 EDGE_BIAS.n26 0.116894
R12815 EDGE_BIAS.t664 EDGE_BIAS.n25 0.116894
R12816 EDGE_BIAS.t661 EDGE_BIAS.n24 0.116894
R12817 EDGE_BIAS.t658 EDGE_BIAS.n23 0.116894
R12818 EDGE_BIAS.t655 EDGE_BIAS.n22 0.116894
R12819 EDGE_BIAS.t652 EDGE_BIAS.n21 0.116894
R12820 EDGE_BIAS.t649 EDGE_BIAS.n20 0.116894
R12821 EDGE_BIAS.t646 EDGE_BIAS.n19 0.116894
R12822 EDGE_BIAS.t643 EDGE_BIAS.n18 0.116894
R12823 EDGE_BIAS.t640 EDGE_BIAS.n17 0.116894
R12824 EDGE_BIAS.t637 EDGE_BIAS.n16 0.116894
R12825 EDGE_BIAS.t634 EDGE_BIAS.n15 0.116894
R12826 EDGE_BIAS.t631 EDGE_BIAS.n14 0.116894
R12827 EDGE_BIAS.t628 EDGE_BIAS.n13 0.116894
R12828 EDGE_BIAS.t625 EDGE_BIAS.n12 0.116894
R12829 EDGE_BIAS.t622 EDGE_BIAS.n11 0.116894
R12830 EDGE_BIAS.t619 EDGE_BIAS.n10 0.116894
R12831 EDGE_BIAS.t616 EDGE_BIAS.n9 0.116894
R12832 EDGE_BIAS.t613 EDGE_BIAS.n8 0.116894
R12833 EDGE_BIAS.t610 EDGE_BIAS.n7 0.116894
R12834 EDGE_BIAS.t607 EDGE_BIAS.n6 0.116894
R12835 EDGE_BIAS.t604 EDGE_BIAS.n5 0.116894
R12836 EDGE_BIAS.t601 EDGE_BIAS.n4 0.116894
R12837 EDGE_BIAS.t598 EDGE_BIAS.n3 0.116894
R12838 EDGE_BIAS.t595 EDGE_BIAS.n2 0.116894
R12839 EDGE_BIAS.t592 EDGE_BIAS.n1 0.116894
R12840 EDGE_BIAS.t589 EDGE_BIAS.n0 0.116894
R12841 EDGE_BIAS.n260 EDGE_BIAS.t586 0.1133
R12842 EDGE_BIAS EDGE_BIAS.n260 0.0443667
R12843 EDGE_BIAS.n258 EDGE_BIAS.t577 0.0405882
R12844 EDGE_BIAS.n257 EDGE_BIAS.t571 0.0405882
R12845 EDGE_BIAS.n256 EDGE_BIAS.t565 0.0405882
R12846 EDGE_BIAS.n255 EDGE_BIAS.t559 0.0405882
R12847 EDGE_BIAS.n254 EDGE_BIAS.t553 0.0405882
R12848 EDGE_BIAS.n253 EDGE_BIAS.t547 0.0405882
R12849 EDGE_BIAS.n252 EDGE_BIAS.t541 0.0405882
R12850 EDGE_BIAS.n251 EDGE_BIAS.t535 0.0405882
R12851 EDGE_BIAS.n250 EDGE_BIAS.t529 0.0405882
R12852 EDGE_BIAS.n249 EDGE_BIAS.t523 0.0405882
R12853 EDGE_BIAS.n248 EDGE_BIAS.t517 0.0405882
R12854 EDGE_BIAS.n247 EDGE_BIAS.t511 0.0405882
R12855 EDGE_BIAS.n246 EDGE_BIAS.t505 0.0405882
R12856 EDGE_BIAS.n245 EDGE_BIAS.t499 0.0405882
R12857 EDGE_BIAS.n244 EDGE_BIAS.t493 0.0405882
R12858 EDGE_BIAS.n243 EDGE_BIAS.t487 0.0405882
R12859 EDGE_BIAS.n242 EDGE_BIAS.t481 0.0405882
R12860 EDGE_BIAS.n241 EDGE_BIAS.t475 0.0405882
R12861 EDGE_BIAS.n240 EDGE_BIAS.t469 0.0405882
R12862 EDGE_BIAS.n239 EDGE_BIAS.t463 0.0405882
R12863 EDGE_BIAS.n238 EDGE_BIAS.t457 0.0405882
R12864 EDGE_BIAS.n237 EDGE_BIAS.t451 0.0405882
R12865 EDGE_BIAS.n236 EDGE_BIAS.t445 0.0405882
R12866 EDGE_BIAS.n235 EDGE_BIAS.t439 0.0405882
R12867 EDGE_BIAS.n234 EDGE_BIAS.t433 0.0405882
R12868 EDGE_BIAS.n233 EDGE_BIAS.t427 0.0405882
R12869 EDGE_BIAS.n232 EDGE_BIAS.t421 0.0405882
R12870 EDGE_BIAS.n231 EDGE_BIAS.t415 0.0405882
R12871 EDGE_BIAS.n230 EDGE_BIAS.t409 0.0405882
R12872 EDGE_BIAS.n229 EDGE_BIAS.t403 0.0405882
R12873 EDGE_BIAS.n228 EDGE_BIAS.t397 0.0405882
R12874 EDGE_BIAS.n227 EDGE_BIAS.t391 0.0405882
R12875 EDGE_BIAS.n226 EDGE_BIAS.t385 0.0405882
R12876 EDGE_BIAS.n225 EDGE_BIAS.t379 0.0405882
R12877 EDGE_BIAS.n224 EDGE_BIAS.t373 0.0405882
R12878 EDGE_BIAS.n223 EDGE_BIAS.t367 0.0405882
R12879 EDGE_BIAS.n222 EDGE_BIAS.t361 0.0405882
R12880 EDGE_BIAS.n221 EDGE_BIAS.t355 0.0405882
R12881 EDGE_BIAS.n220 EDGE_BIAS.t349 0.0405882
R12882 EDGE_BIAS.n219 EDGE_BIAS.t343 0.0405882
R12883 EDGE_BIAS.n218 EDGE_BIAS.t337 0.0405882
R12884 EDGE_BIAS.n217 EDGE_BIAS.t331 0.0405882
R12885 EDGE_BIAS.n216 EDGE_BIAS.t325 0.0405882
R12886 EDGE_BIAS.n215 EDGE_BIAS.t319 0.0405882
R12887 EDGE_BIAS.n214 EDGE_BIAS.t313 0.0405882
R12888 EDGE_BIAS.n213 EDGE_BIAS.t307 0.0405882
R12889 EDGE_BIAS.n212 EDGE_BIAS.t301 0.0405882
R12890 EDGE_BIAS.n211 EDGE_BIAS.t295 0.0405882
R12891 EDGE_BIAS.n210 EDGE_BIAS.t289 0.0405882
R12892 EDGE_BIAS.n209 EDGE_BIAS.t283 0.0405882
R12893 EDGE_BIAS.n208 EDGE_BIAS.t277 0.0405882
R12894 EDGE_BIAS.n207 EDGE_BIAS.t271 0.0405882
R12895 EDGE_BIAS.n206 EDGE_BIAS.t265 0.0405882
R12896 EDGE_BIAS.n205 EDGE_BIAS.t259 0.0405882
R12897 EDGE_BIAS.n204 EDGE_BIAS.t253 0.0405882
R12898 EDGE_BIAS.n203 EDGE_BIAS.t247 0.0405882
R12899 EDGE_BIAS.n202 EDGE_BIAS.t241 0.0405882
R12900 EDGE_BIAS.n201 EDGE_BIAS.t235 0.0405882
R12901 EDGE_BIAS.n200 EDGE_BIAS.t229 0.0405882
R12902 EDGE_BIAS.n199 EDGE_BIAS.t223 0.0405882
R12903 EDGE_BIAS.n198 EDGE_BIAS.t217 0.0405882
R12904 EDGE_BIAS.n197 EDGE_BIAS.t211 0.0405882
R12905 EDGE_BIAS.n196 EDGE_BIAS.t205 0.0405882
R12906 EDGE_BIAS.n195 EDGE_BIAS.t199 0.0405882
R12907 EDGE_BIAS.n194 EDGE_BIAS.t1 0.0405882
R12908 EDGE_BIAS.t4 EDGE_BIAS.n193 0.0405882
R12909 EDGE_BIAS.t7 EDGE_BIAS.n192 0.0405882
R12910 EDGE_BIAS.t10 EDGE_BIAS.n191 0.0405882
R12911 EDGE_BIAS.t13 EDGE_BIAS.n190 0.0405882
R12912 EDGE_BIAS.t16 EDGE_BIAS.n189 0.0405882
R12913 EDGE_BIAS.t19 EDGE_BIAS.n188 0.0405882
R12914 EDGE_BIAS.t22 EDGE_BIAS.n187 0.0405882
R12915 EDGE_BIAS.t25 EDGE_BIAS.n186 0.0405882
R12916 EDGE_BIAS.t28 EDGE_BIAS.n185 0.0405882
R12917 EDGE_BIAS.t31 EDGE_BIAS.n184 0.0405882
R12918 EDGE_BIAS.t34 EDGE_BIAS.n183 0.0405882
R12919 EDGE_BIAS.t37 EDGE_BIAS.n182 0.0405882
R12920 EDGE_BIAS.t40 EDGE_BIAS.n181 0.0405882
R12921 EDGE_BIAS.t43 EDGE_BIAS.n180 0.0405882
R12922 EDGE_BIAS.t46 EDGE_BIAS.n179 0.0405882
R12923 EDGE_BIAS.t49 EDGE_BIAS.n178 0.0405882
R12924 EDGE_BIAS.t52 EDGE_BIAS.n177 0.0405882
R12925 EDGE_BIAS.t55 EDGE_BIAS.n176 0.0405882
R12926 EDGE_BIAS.t58 EDGE_BIAS.n175 0.0405882
R12927 EDGE_BIAS.t61 EDGE_BIAS.n174 0.0405882
R12928 EDGE_BIAS.t64 EDGE_BIAS.n173 0.0405882
R12929 EDGE_BIAS.t67 EDGE_BIAS.n172 0.0405882
R12930 EDGE_BIAS.t70 EDGE_BIAS.n171 0.0405882
R12931 EDGE_BIAS.t73 EDGE_BIAS.n170 0.0405882
R12932 EDGE_BIAS.t76 EDGE_BIAS.n169 0.0405882
R12933 EDGE_BIAS.t79 EDGE_BIAS.n168 0.0405882
R12934 EDGE_BIAS.t82 EDGE_BIAS.n167 0.0405882
R12935 EDGE_BIAS.t85 EDGE_BIAS.n166 0.0405882
R12936 EDGE_BIAS.t88 EDGE_BIAS.n165 0.0405882
R12937 EDGE_BIAS.t91 EDGE_BIAS.n164 0.0405882
R12938 EDGE_BIAS.t94 EDGE_BIAS.n163 0.0405882
R12939 EDGE_BIAS.t97 EDGE_BIAS.n162 0.0405882
R12940 EDGE_BIAS.t100 EDGE_BIAS.n161 0.0405882
R12941 EDGE_BIAS.t103 EDGE_BIAS.n160 0.0405882
R12942 EDGE_BIAS.t106 EDGE_BIAS.n159 0.0405882
R12943 EDGE_BIAS.t109 EDGE_BIAS.n158 0.0405882
R12944 EDGE_BIAS.t112 EDGE_BIAS.n157 0.0405882
R12945 EDGE_BIAS.t115 EDGE_BIAS.n156 0.0405882
R12946 EDGE_BIAS.t118 EDGE_BIAS.n155 0.0405882
R12947 EDGE_BIAS.t121 EDGE_BIAS.n154 0.0405882
R12948 EDGE_BIAS.t124 EDGE_BIAS.n153 0.0405882
R12949 EDGE_BIAS.t127 EDGE_BIAS.n152 0.0405882
R12950 EDGE_BIAS.t130 EDGE_BIAS.n151 0.0405882
R12951 EDGE_BIAS.t133 EDGE_BIAS.n150 0.0405882
R12952 EDGE_BIAS.t136 EDGE_BIAS.n149 0.0405882
R12953 EDGE_BIAS.t139 EDGE_BIAS.n148 0.0405882
R12954 EDGE_BIAS.t142 EDGE_BIAS.n147 0.0405882
R12955 EDGE_BIAS.t145 EDGE_BIAS.n146 0.0405882
R12956 EDGE_BIAS.t148 EDGE_BIAS.n145 0.0405882
R12957 EDGE_BIAS.t151 EDGE_BIAS.n144 0.0405882
R12958 EDGE_BIAS.t154 EDGE_BIAS.n143 0.0405882
R12959 EDGE_BIAS.t157 EDGE_BIAS.n142 0.0405882
R12960 EDGE_BIAS.t160 EDGE_BIAS.n141 0.0405882
R12961 EDGE_BIAS.t163 EDGE_BIAS.n140 0.0405882
R12962 EDGE_BIAS.t166 EDGE_BIAS.n139 0.0405882
R12963 EDGE_BIAS.t169 EDGE_BIAS.n138 0.0405882
R12964 EDGE_BIAS.t172 EDGE_BIAS.n137 0.0405882
R12965 EDGE_BIAS.t175 EDGE_BIAS.n136 0.0405882
R12966 EDGE_BIAS.t178 EDGE_BIAS.n135 0.0405882
R12967 EDGE_BIAS.t181 EDGE_BIAS.n134 0.0405882
R12968 EDGE_BIAS.t184 EDGE_BIAS.n133 0.0405882
R12969 EDGE_BIAS.t187 EDGE_BIAS.n132 0.0405882
R12970 EDGE_BIAS.t190 EDGE_BIAS.n131 0.0405882
R12971 EDGE_BIAS.t193 EDGE_BIAS.n130 0.0405882
R12972 EDGE_BIAS.t196 EDGE_BIAS.n129 0.0405882
R12973 EDGE_BIAS.n128 EDGE_BIAS.t202 0.0405882
R12974 EDGE_BIAS.n127 EDGE_BIAS.t208 0.0405882
R12975 EDGE_BIAS.n126 EDGE_BIAS.t214 0.0405882
R12976 EDGE_BIAS.n125 EDGE_BIAS.t220 0.0405882
R12977 EDGE_BIAS.n124 EDGE_BIAS.t226 0.0405882
R12978 EDGE_BIAS.n123 EDGE_BIAS.t232 0.0405882
R12979 EDGE_BIAS.n122 EDGE_BIAS.t238 0.0405882
R12980 EDGE_BIAS.n121 EDGE_BIAS.t244 0.0405882
R12981 EDGE_BIAS.n120 EDGE_BIAS.t250 0.0405882
R12982 EDGE_BIAS.n119 EDGE_BIAS.t256 0.0405882
R12983 EDGE_BIAS.n118 EDGE_BIAS.t262 0.0405882
R12984 EDGE_BIAS.n117 EDGE_BIAS.t268 0.0405882
R12985 EDGE_BIAS.n116 EDGE_BIAS.t274 0.0405882
R12986 EDGE_BIAS.n115 EDGE_BIAS.t280 0.0405882
R12987 EDGE_BIAS.n114 EDGE_BIAS.t286 0.0405882
R12988 EDGE_BIAS.n113 EDGE_BIAS.t292 0.0405882
R12989 EDGE_BIAS.n112 EDGE_BIAS.t298 0.0405882
R12990 EDGE_BIAS.n111 EDGE_BIAS.t304 0.0405882
R12991 EDGE_BIAS.n110 EDGE_BIAS.t310 0.0405882
R12992 EDGE_BIAS.n109 EDGE_BIAS.t316 0.0405882
R12993 EDGE_BIAS.n108 EDGE_BIAS.t322 0.0405882
R12994 EDGE_BIAS.n107 EDGE_BIAS.t328 0.0405882
R12995 EDGE_BIAS.n106 EDGE_BIAS.t334 0.0405882
R12996 EDGE_BIAS.n105 EDGE_BIAS.t340 0.0405882
R12997 EDGE_BIAS.n104 EDGE_BIAS.t346 0.0405882
R12998 EDGE_BIAS.n103 EDGE_BIAS.t352 0.0405882
R12999 EDGE_BIAS.n102 EDGE_BIAS.t358 0.0405882
R13000 EDGE_BIAS.n101 EDGE_BIAS.t364 0.0405882
R13001 EDGE_BIAS.n100 EDGE_BIAS.t370 0.0405882
R13002 EDGE_BIAS.n99 EDGE_BIAS.t376 0.0405882
R13003 EDGE_BIAS.n98 EDGE_BIAS.t382 0.0405882
R13004 EDGE_BIAS.n97 EDGE_BIAS.t388 0.0405882
R13005 EDGE_BIAS.n96 EDGE_BIAS.t394 0.0405882
R13006 EDGE_BIAS.n95 EDGE_BIAS.t400 0.0405882
R13007 EDGE_BIAS.n94 EDGE_BIAS.t406 0.0405882
R13008 EDGE_BIAS.n93 EDGE_BIAS.t412 0.0405882
R13009 EDGE_BIAS.n92 EDGE_BIAS.t418 0.0405882
R13010 EDGE_BIAS.n91 EDGE_BIAS.t424 0.0405882
R13011 EDGE_BIAS.n90 EDGE_BIAS.t430 0.0405882
R13012 EDGE_BIAS.n89 EDGE_BIAS.t436 0.0405882
R13013 EDGE_BIAS.n88 EDGE_BIAS.t442 0.0405882
R13014 EDGE_BIAS.n87 EDGE_BIAS.t448 0.0405882
R13015 EDGE_BIAS.n86 EDGE_BIAS.t454 0.0405882
R13016 EDGE_BIAS.n85 EDGE_BIAS.t460 0.0405882
R13017 EDGE_BIAS.n84 EDGE_BIAS.t466 0.0405882
R13018 EDGE_BIAS.n83 EDGE_BIAS.t472 0.0405882
R13019 EDGE_BIAS.n82 EDGE_BIAS.t478 0.0405882
R13020 EDGE_BIAS.n81 EDGE_BIAS.t484 0.0405882
R13021 EDGE_BIAS.n80 EDGE_BIAS.t490 0.0405882
R13022 EDGE_BIAS.n79 EDGE_BIAS.t496 0.0405882
R13023 EDGE_BIAS.n78 EDGE_BIAS.t502 0.0405882
R13024 EDGE_BIAS.n77 EDGE_BIAS.t508 0.0405882
R13025 EDGE_BIAS.n76 EDGE_BIAS.t514 0.0405882
R13026 EDGE_BIAS.n75 EDGE_BIAS.t520 0.0405882
R13027 EDGE_BIAS.n74 EDGE_BIAS.t526 0.0405882
R13028 EDGE_BIAS.n73 EDGE_BIAS.t532 0.0405882
R13029 EDGE_BIAS.n72 EDGE_BIAS.t538 0.0405882
R13030 EDGE_BIAS.n71 EDGE_BIAS.t544 0.0405882
R13031 EDGE_BIAS.n70 EDGE_BIAS.t550 0.0405882
R13032 EDGE_BIAS.n69 EDGE_BIAS.t556 0.0405882
R13033 EDGE_BIAS.n68 EDGE_BIAS.t562 0.0405882
R13034 EDGE_BIAS.n67 EDGE_BIAS.t568 0.0405882
R13035 EDGE_BIAS.n66 EDGE_BIAS.t574 0.0405882
R13036 EDGE_BIAS.n65 EDGE_BIAS.t580 0.0405882
R13037 EDGE_BIAS.n64 EDGE_BIAS.t778 0.0405882
R13038 EDGE_BIAS.n63 EDGE_BIAS.t775 0.0405882
R13039 EDGE_BIAS.n62 EDGE_BIAS.t772 0.0405882
R13040 EDGE_BIAS.n61 EDGE_BIAS.t769 0.0405882
R13041 EDGE_BIAS.n60 EDGE_BIAS.t766 0.0405882
R13042 EDGE_BIAS.n59 EDGE_BIAS.t763 0.0405882
R13043 EDGE_BIAS.n58 EDGE_BIAS.t760 0.0405882
R13044 EDGE_BIAS.n57 EDGE_BIAS.t757 0.0405882
R13045 EDGE_BIAS.n56 EDGE_BIAS.t754 0.0405882
R13046 EDGE_BIAS.n55 EDGE_BIAS.t751 0.0405882
R13047 EDGE_BIAS.n54 EDGE_BIAS.t748 0.0405882
R13048 EDGE_BIAS.n53 EDGE_BIAS.t745 0.0405882
R13049 EDGE_BIAS.n52 EDGE_BIAS.t742 0.0405882
R13050 EDGE_BIAS.n51 EDGE_BIAS.t739 0.0405882
R13051 EDGE_BIAS.n50 EDGE_BIAS.t736 0.0405882
R13052 EDGE_BIAS.n49 EDGE_BIAS.t733 0.0405882
R13053 EDGE_BIAS.n48 EDGE_BIAS.t730 0.0405882
R13054 EDGE_BIAS.n47 EDGE_BIAS.t727 0.0405882
R13055 EDGE_BIAS.n46 EDGE_BIAS.t724 0.0405882
R13056 EDGE_BIAS.n45 EDGE_BIAS.t721 0.0405882
R13057 EDGE_BIAS.n44 EDGE_BIAS.t718 0.0405882
R13058 EDGE_BIAS.n43 EDGE_BIAS.t715 0.0405882
R13059 EDGE_BIAS.n42 EDGE_BIAS.t712 0.0405882
R13060 EDGE_BIAS.n41 EDGE_BIAS.t709 0.0405882
R13061 EDGE_BIAS.n40 EDGE_BIAS.t706 0.0405882
R13062 EDGE_BIAS.n39 EDGE_BIAS.t703 0.0405882
R13063 EDGE_BIAS.n38 EDGE_BIAS.t700 0.0405882
R13064 EDGE_BIAS.n37 EDGE_BIAS.t697 0.0405882
R13065 EDGE_BIAS.n36 EDGE_BIAS.t694 0.0405882
R13066 EDGE_BIAS.n35 EDGE_BIAS.t691 0.0405882
R13067 EDGE_BIAS.n34 EDGE_BIAS.t688 0.0405882
R13068 EDGE_BIAS.n33 EDGE_BIAS.t685 0.0405882
R13069 EDGE_BIAS.n32 EDGE_BIAS.t682 0.0405882
R13070 EDGE_BIAS.n31 EDGE_BIAS.t679 0.0405882
R13071 EDGE_BIAS.n30 EDGE_BIAS.t676 0.0405882
R13072 EDGE_BIAS.n29 EDGE_BIAS.t673 0.0405882
R13073 EDGE_BIAS.n28 EDGE_BIAS.t670 0.0405882
R13074 EDGE_BIAS.n27 EDGE_BIAS.t667 0.0405882
R13075 EDGE_BIAS.n26 EDGE_BIAS.t664 0.0405882
R13076 EDGE_BIAS.n25 EDGE_BIAS.t661 0.0405882
R13077 EDGE_BIAS.n24 EDGE_BIAS.t658 0.0405882
R13078 EDGE_BIAS.n23 EDGE_BIAS.t655 0.0405882
R13079 EDGE_BIAS.n22 EDGE_BIAS.t652 0.0405882
R13080 EDGE_BIAS.n21 EDGE_BIAS.t649 0.0405882
R13081 EDGE_BIAS.n20 EDGE_BIAS.t646 0.0405882
R13082 EDGE_BIAS.n19 EDGE_BIAS.t643 0.0405882
R13083 EDGE_BIAS.n18 EDGE_BIAS.t640 0.0405882
R13084 EDGE_BIAS.n17 EDGE_BIAS.t637 0.0405882
R13085 EDGE_BIAS.n16 EDGE_BIAS.t634 0.0405882
R13086 EDGE_BIAS.n15 EDGE_BIAS.t631 0.0405882
R13087 EDGE_BIAS.n14 EDGE_BIAS.t628 0.0405882
R13088 EDGE_BIAS.n13 EDGE_BIAS.t625 0.0405882
R13089 EDGE_BIAS.n12 EDGE_BIAS.t622 0.0405882
R13090 EDGE_BIAS.n11 EDGE_BIAS.t619 0.0405882
R13091 EDGE_BIAS.n10 EDGE_BIAS.t616 0.0405882
R13092 EDGE_BIAS.n9 EDGE_BIAS.t613 0.0405882
R13093 EDGE_BIAS.n8 EDGE_BIAS.t610 0.0405882
R13094 EDGE_BIAS.n7 EDGE_BIAS.t607 0.0405882
R13095 EDGE_BIAS.n6 EDGE_BIAS.t604 0.0405882
R13096 EDGE_BIAS.n5 EDGE_BIAS.t601 0.0405882
R13097 EDGE_BIAS.n4 EDGE_BIAS.t598 0.0405882
R13098 EDGE_BIAS.n3 EDGE_BIAS.t595 0.0405882
R13099 EDGE_BIAS.n2 EDGE_BIAS.t592 0.0405882
R13100 EDGE_BIAS.n1 EDGE_BIAS.t589 0.0405882
R13101 EDGE_BIAS.n0 EDGE_BIAS.t586 0.0405882
R13102 EDGE_BIAS EDGE_BIAS.t583 0.0364412
R13103 EDGE_BIAS.n259 EDGE_BIAS 0.00464706
R13104 EDGE_BIAS.n260 EDGE_BIAS.n259 0.00409412
C0 B2 B5 0.00179f
C1 B7 B1 2.18304f
C2 B11 B1 27.0414f
C3 TOP B9 0.64998p
C4 TOP B0 8.04523f
C5 B11 B7 11.5176f
C6 TOP B2 18.8578f
C7 B9 B4 7.38986f
C8 B4 B0 0.21387f
C9 B9 B1 7.07213f
C10 B1 B0 0.85142f
C11 B2 B4 0.0046f
C12 B7 B9 3.17486f
C13 B11 B9 11.7155f
C14 EDGE_BIAS B8 3.49125f
C15 B1 B2 11.0414f
C16 B7 B0 1.14058f
C17 B11 B0 13.9903f
C18 EDGE_BIAS B10 12.6376f
C19 B7 B2 2.42699f
C20 EDGE_BIAS B3 1.69285f
C21 B11 B2 28.1366f
C22 B6 B8 1.85114f
C23 B6 B10 6.1141f
C24 EDGE_BIAS DUMMY 0.8318f
C25 B6 B3 2.46714f
C26 B8 B5 3.91035f
C27 B9 B0 3.65477f
C28 B10 B5 14.3489f
C29 B6 DUMMY 0.22787f
C30 B3 B5 0.0046f
C31 B9 B2 7.3497f
C32 TOP B8 0.32499p
C33 B2 B0 0.21387f
C34 B5 DUMMY 0.27615f
C35 TOP B10 1.29996p
C36 TOP B3 24.1465f
C37 B8 B4 3.91035f
C38 TOP DUMMY 7.94496f
C39 B10 B4 14.3489f
C40 B8 B1 3.75071f
C41 B3 B4 5.29905f
C42 B10 B1 13.715f
C43 B4 DUMMY 0.21387f
C44 B7 B8 43.2062f
C45 B1 B3 0.0046f
C46 B11 B8 11.5652f
C47 B7 B10 5.91729f
C48 B11 B10 53.8385f
C49 B1 DUMMY 0.21387f
C50 B7 B3 2.75917f
C51 B11 B3 28.2925f
C52 B7 DUMMY 1.12173f
C53 EDGE_BIAS B6 20.0945f
C54 B11 DUMMY 13.9903f
C55 B8 B9 44.716f
C56 B8 B0 1.93432f
C57 EDGE_BIAS B5 1.69285f
C58 B9 B10 47.647f
C59 B10 B0 7.09567f
C60 B9 B3 7.38986f
C61 B8 B2 3.88949f
C62 B3 B0 0.21387f
C63 B6 B5 5.7937f
C64 B10 B2 14.2701f
C65 B9 DUMMY 3.65477f
C66 EDGE_BIAS TOP 28.0951f
C67 DUMMY B0 4.19174f
C68 B2 B3 6.86104f
C69 B2 DUMMY 0.21387f
C70 TOP B6 81.5502f
C71 EDGE_BIAS B4 1.69285f
C72 TOP B5 54.6765f
C73 EDGE_BIAS B1 1.68024f
C74 B6 B4 4.18835f
C75 EDGE_BIAS B7 3.1895f
C76 EDGE_BIAS B11 39.8576f
C77 B6 B1 1.45409f
C78 B4 B5 2.17927f
C79 B6 B7 37.2447f
C80 B1 B5 0
C81 B6 B11 12.0473f
C82 TOP B4 34.3218f
C83 B7 B5 4.71688f
C84 B11 B5 28.2925f
C85 EDGE_BIAS B9 6.28886f
C86 B8 B10 5.94575f
C87 EDGE_BIAS B0 0.82814f
C88 TOP B1 16.2546f
C89 B8 B3 3.91035f
C90 B10 B3 14.3489f
C91 B6 B9 3.26534f
C92 EDGE_BIAS B2 1.67822f
C93 TOP B7 0.16252p
C94 B8 DUMMY 1.93432f
C95 TOP B11 2.59504p
C96 B6 B0 0.22787f
C97 B1 B4 0.00179f
C98 B10 DUMMY 7.09567f
C99 B9 B5 7.38986f
C100 B3 DUMMY 0.21387f
C101 B6 B2 1.80611f
C102 B5 B0 1.0588f
C103 B7 B4 3.41174f
C104 B11 B4 28.2925f
C105 B0 VSUBS 24.1443f
C106 DUMMY VSUBS 24.7197f
C107 B5 VSUBS 52.3492f
C108 B4 VSUBS 48.5047f
C109 B3 VSUBS 48.888f
C110 B2 VSUBS 44.8884f
C111 B1 VSUBS 55.3983f
C112 B10 VSUBS 0.23533p
C113 B9 VSUBS 0.12915p
C114 B8 VSUBS 77.25789f
C115 B7 VSUBS 52.74039f
C116 B11 VSUBS 0.48539p
C117 B6 VSUBS 58.55628f
C118 TOP VSUBS 1.93373p
C119 EDGE_BIAS VSUBS 0.21342p
C120 EDGE_BIAS.t586 VSUBS 0.35535f
C121 EDGE_BIAS.n0 VSUBS 0.11936f
C122 EDGE_BIAS.t589 VSUBS 0.35596f
C123 EDGE_BIAS.n1 VSUBS 0.11936f
C124 EDGE_BIAS.t592 VSUBS 0.35596f
C125 EDGE_BIAS.n2 VSUBS 0.11936f
C126 EDGE_BIAS.t595 VSUBS 0.35596f
C127 EDGE_BIAS.n3 VSUBS 0.11936f
C128 EDGE_BIAS.t598 VSUBS 0.35596f
C129 EDGE_BIAS.n4 VSUBS 0.11936f
C130 EDGE_BIAS.t601 VSUBS 0.35596f
C131 EDGE_BIAS.n5 VSUBS 0.11936f
C132 EDGE_BIAS.t604 VSUBS 0.35596f
C133 EDGE_BIAS.n6 VSUBS 0.11936f
C134 EDGE_BIAS.t607 VSUBS 0.35596f
C135 EDGE_BIAS.n7 VSUBS 0.11936f
C136 EDGE_BIAS.t610 VSUBS 0.35596f
C137 EDGE_BIAS.n8 VSUBS 0.11936f
C138 EDGE_BIAS.t613 VSUBS 0.35596f
C139 EDGE_BIAS.n9 VSUBS 0.11936f
C140 EDGE_BIAS.t616 VSUBS 0.35596f
C141 EDGE_BIAS.n10 VSUBS 0.11936f
C142 EDGE_BIAS.t619 VSUBS 0.35596f
C143 EDGE_BIAS.n11 VSUBS 0.11936f
C144 EDGE_BIAS.t622 VSUBS 0.35596f
C145 EDGE_BIAS.n12 VSUBS 0.11936f
C146 EDGE_BIAS.t625 VSUBS 0.35596f
C147 EDGE_BIAS.n13 VSUBS 0.11936f
C148 EDGE_BIAS.t628 VSUBS 0.35596f
C149 EDGE_BIAS.n14 VSUBS 0.11936f
C150 EDGE_BIAS.t631 VSUBS 0.35596f
C151 EDGE_BIAS.n15 VSUBS 0.11936f
C152 EDGE_BIAS.t634 VSUBS 0.35596f
C153 EDGE_BIAS.n16 VSUBS 0.11936f
C154 EDGE_BIAS.t637 VSUBS 0.35596f
C155 EDGE_BIAS.n17 VSUBS 0.11936f
C156 EDGE_BIAS.t640 VSUBS 0.35596f
C157 EDGE_BIAS.n18 VSUBS 0.11936f
C158 EDGE_BIAS.t643 VSUBS 0.35596f
C159 EDGE_BIAS.n19 VSUBS 0.11936f
C160 EDGE_BIAS.t646 VSUBS 0.35596f
C161 EDGE_BIAS.n20 VSUBS 0.11936f
C162 EDGE_BIAS.t649 VSUBS 0.35596f
C163 EDGE_BIAS.n21 VSUBS 0.11936f
C164 EDGE_BIAS.t652 VSUBS 0.35596f
C165 EDGE_BIAS.n22 VSUBS 0.11936f
C166 EDGE_BIAS.t655 VSUBS 0.35596f
C167 EDGE_BIAS.n23 VSUBS 0.11936f
C168 EDGE_BIAS.t658 VSUBS 0.35596f
C169 EDGE_BIAS.n24 VSUBS 0.11936f
C170 EDGE_BIAS.t661 VSUBS 0.35596f
C171 EDGE_BIAS.n25 VSUBS 0.11936f
C172 EDGE_BIAS.t664 VSUBS 0.35596f
C173 EDGE_BIAS.n26 VSUBS 0.11936f
C174 EDGE_BIAS.t667 VSUBS 0.35596f
C175 EDGE_BIAS.n27 VSUBS 0.11936f
C176 EDGE_BIAS.t670 VSUBS 0.35596f
C177 EDGE_BIAS.n28 VSUBS 0.11936f
C178 EDGE_BIAS.t673 VSUBS 0.35596f
C179 EDGE_BIAS.n29 VSUBS 0.11936f
C180 EDGE_BIAS.t676 VSUBS 0.35596f
C181 EDGE_BIAS.n30 VSUBS 0.11936f
C182 EDGE_BIAS.t679 VSUBS 0.35596f
C183 EDGE_BIAS.n31 VSUBS 0.11936f
C184 EDGE_BIAS.t682 VSUBS 0.35596f
C185 EDGE_BIAS.n32 VSUBS 0.11936f
C186 EDGE_BIAS.t685 VSUBS 0.35596f
C187 EDGE_BIAS.n33 VSUBS 0.11936f
C188 EDGE_BIAS.t688 VSUBS 0.35596f
C189 EDGE_BIAS.n34 VSUBS 0.11936f
C190 EDGE_BIAS.t691 VSUBS 0.35596f
C191 EDGE_BIAS.n35 VSUBS 0.11936f
C192 EDGE_BIAS.t694 VSUBS 0.35596f
C193 EDGE_BIAS.n36 VSUBS 0.11936f
C194 EDGE_BIAS.t697 VSUBS 0.35596f
C195 EDGE_BIAS.n37 VSUBS 0.11936f
C196 EDGE_BIAS.t700 VSUBS 0.35596f
C197 EDGE_BIAS.n38 VSUBS 0.11936f
C198 EDGE_BIAS.t703 VSUBS 0.35596f
C199 EDGE_BIAS.n39 VSUBS 0.11936f
C200 EDGE_BIAS.t706 VSUBS 0.35596f
C201 EDGE_BIAS.n40 VSUBS 0.11936f
C202 EDGE_BIAS.t709 VSUBS 0.35596f
C203 EDGE_BIAS.n41 VSUBS 0.11936f
C204 EDGE_BIAS.t712 VSUBS 0.35596f
C205 EDGE_BIAS.n42 VSUBS 0.11936f
C206 EDGE_BIAS.t715 VSUBS 0.35596f
C207 EDGE_BIAS.n43 VSUBS 0.11936f
C208 EDGE_BIAS.t718 VSUBS 0.35596f
C209 EDGE_BIAS.n44 VSUBS 0.11936f
C210 EDGE_BIAS.t721 VSUBS 0.35596f
C211 EDGE_BIAS.n45 VSUBS 0.11936f
C212 EDGE_BIAS.t724 VSUBS 0.35596f
C213 EDGE_BIAS.n46 VSUBS 0.11936f
C214 EDGE_BIAS.t727 VSUBS 0.35596f
C215 EDGE_BIAS.n47 VSUBS 0.11936f
C216 EDGE_BIAS.t730 VSUBS 0.35596f
C217 EDGE_BIAS.n48 VSUBS 0.11936f
C218 EDGE_BIAS.t733 VSUBS 0.35596f
C219 EDGE_BIAS.n49 VSUBS 0.11936f
C220 EDGE_BIAS.t736 VSUBS 0.35596f
C221 EDGE_BIAS.n50 VSUBS 0.11936f
C222 EDGE_BIAS.t739 VSUBS 0.35596f
C223 EDGE_BIAS.n51 VSUBS 0.11936f
C224 EDGE_BIAS.t742 VSUBS 0.35596f
C225 EDGE_BIAS.n52 VSUBS 0.11936f
C226 EDGE_BIAS.t745 VSUBS 0.35596f
C227 EDGE_BIAS.n53 VSUBS 0.11936f
C228 EDGE_BIAS.t748 VSUBS 0.35596f
C229 EDGE_BIAS.n54 VSUBS 0.11936f
C230 EDGE_BIAS.t751 VSUBS 0.35596f
C231 EDGE_BIAS.n55 VSUBS 0.11936f
C232 EDGE_BIAS.t754 VSUBS 0.35596f
C233 EDGE_BIAS.n56 VSUBS 0.11936f
C234 EDGE_BIAS.t757 VSUBS 0.35596f
C235 EDGE_BIAS.n57 VSUBS 0.11936f
C236 EDGE_BIAS.t760 VSUBS 0.35596f
C237 EDGE_BIAS.n58 VSUBS 0.11936f
C238 EDGE_BIAS.t763 VSUBS 0.35596f
C239 EDGE_BIAS.n59 VSUBS 0.11936f
C240 EDGE_BIAS.t766 VSUBS 0.35596f
C241 EDGE_BIAS.n60 VSUBS 0.11936f
C242 EDGE_BIAS.t769 VSUBS 0.35596f
C243 EDGE_BIAS.n61 VSUBS 0.11936f
C244 EDGE_BIAS.t772 VSUBS 0.35596f
C245 EDGE_BIAS.n62 VSUBS 0.11936f
C246 EDGE_BIAS.t775 VSUBS 0.35596f
C247 EDGE_BIAS.n63 VSUBS 0.11936f
C248 EDGE_BIAS.t778 VSUBS 0.35596f
C249 EDGE_BIAS.n64 VSUBS 0.11151f
C250 EDGE_BIAS.t580 VSUBS 0.35983f
C251 EDGE_BIAS.n65 VSUBS 0.11679f
C252 EDGE_BIAS.t574 VSUBS 0.35983f
C253 EDGE_BIAS.n66 VSUBS 0.11679f
C254 EDGE_BIAS.t568 VSUBS 0.35983f
C255 EDGE_BIAS.n67 VSUBS 0.11679f
C256 EDGE_BIAS.t562 VSUBS 0.35983f
C257 EDGE_BIAS.n68 VSUBS 0.11679f
C258 EDGE_BIAS.t556 VSUBS 0.35983f
C259 EDGE_BIAS.n69 VSUBS 0.11679f
C260 EDGE_BIAS.t550 VSUBS 0.35983f
C261 EDGE_BIAS.n70 VSUBS 0.11679f
C262 EDGE_BIAS.t544 VSUBS 0.35983f
C263 EDGE_BIAS.n71 VSUBS 0.11679f
C264 EDGE_BIAS.t538 VSUBS 0.35983f
C265 EDGE_BIAS.n72 VSUBS 0.11679f
C266 EDGE_BIAS.t532 VSUBS 0.35983f
C267 EDGE_BIAS.n73 VSUBS 0.11679f
C268 EDGE_BIAS.t526 VSUBS 0.35983f
C269 EDGE_BIAS.n74 VSUBS 0.11679f
C270 EDGE_BIAS.t520 VSUBS 0.35983f
C271 EDGE_BIAS.n75 VSUBS 0.11679f
C272 EDGE_BIAS.t514 VSUBS 0.35983f
C273 EDGE_BIAS.n76 VSUBS 0.11679f
C274 EDGE_BIAS.t508 VSUBS 0.35983f
C275 EDGE_BIAS.n77 VSUBS 0.11679f
C276 EDGE_BIAS.t502 VSUBS 0.35983f
C277 EDGE_BIAS.n78 VSUBS 0.11679f
C278 EDGE_BIAS.t496 VSUBS 0.35983f
C279 EDGE_BIAS.n79 VSUBS 0.11679f
C280 EDGE_BIAS.t490 VSUBS 0.35983f
C281 EDGE_BIAS.n80 VSUBS 0.11679f
C282 EDGE_BIAS.t484 VSUBS 0.35983f
C283 EDGE_BIAS.n81 VSUBS 0.11679f
C284 EDGE_BIAS.t478 VSUBS 0.35983f
C285 EDGE_BIAS.n82 VSUBS 0.11679f
C286 EDGE_BIAS.t472 VSUBS 0.35983f
C287 EDGE_BIAS.n83 VSUBS 0.11679f
C288 EDGE_BIAS.t466 VSUBS 0.35983f
C289 EDGE_BIAS.n84 VSUBS 0.11679f
C290 EDGE_BIAS.t460 VSUBS 0.35983f
C291 EDGE_BIAS.n85 VSUBS 0.11679f
C292 EDGE_BIAS.t454 VSUBS 0.35983f
C293 EDGE_BIAS.n86 VSUBS 0.11679f
C294 EDGE_BIAS.t448 VSUBS 0.35983f
C295 EDGE_BIAS.n87 VSUBS 0.11679f
C296 EDGE_BIAS.t442 VSUBS 0.35983f
C297 EDGE_BIAS.n88 VSUBS 0.11679f
C298 EDGE_BIAS.t436 VSUBS 0.35983f
C299 EDGE_BIAS.n89 VSUBS 0.11679f
C300 EDGE_BIAS.t430 VSUBS 0.35983f
C301 EDGE_BIAS.n90 VSUBS 0.11679f
C302 EDGE_BIAS.t424 VSUBS 0.35983f
C303 EDGE_BIAS.n91 VSUBS 0.11679f
C304 EDGE_BIAS.t418 VSUBS 0.35983f
C305 EDGE_BIAS.n92 VSUBS 0.11679f
C306 EDGE_BIAS.t412 VSUBS 0.35983f
C307 EDGE_BIAS.n93 VSUBS 0.11679f
C308 EDGE_BIAS.t406 VSUBS 0.35983f
C309 EDGE_BIAS.n94 VSUBS 0.11679f
C310 EDGE_BIAS.t400 VSUBS 0.35983f
C311 EDGE_BIAS.n95 VSUBS 0.11679f
C312 EDGE_BIAS.t394 VSUBS 0.35983f
C313 EDGE_BIAS.n96 VSUBS 0.11679f
C314 EDGE_BIAS.t388 VSUBS 0.35983f
C315 EDGE_BIAS.n97 VSUBS 0.11679f
C316 EDGE_BIAS.t382 VSUBS 0.35983f
C317 EDGE_BIAS.n98 VSUBS 0.11679f
C318 EDGE_BIAS.t376 VSUBS 0.35983f
C319 EDGE_BIAS.n99 VSUBS 0.11679f
C320 EDGE_BIAS.t370 VSUBS 0.35983f
C321 EDGE_BIAS.n100 VSUBS 0.11679f
C322 EDGE_BIAS.t364 VSUBS 0.35983f
C323 EDGE_BIAS.n101 VSUBS 0.11679f
C324 EDGE_BIAS.t358 VSUBS 0.35983f
C325 EDGE_BIAS.n102 VSUBS 0.11679f
C326 EDGE_BIAS.t352 VSUBS 0.35983f
C327 EDGE_BIAS.n103 VSUBS 0.11679f
C328 EDGE_BIAS.t346 VSUBS 0.35983f
C329 EDGE_BIAS.n104 VSUBS 0.11679f
C330 EDGE_BIAS.t340 VSUBS 0.35983f
C331 EDGE_BIAS.n105 VSUBS 0.11679f
C332 EDGE_BIAS.t334 VSUBS 0.35983f
C333 EDGE_BIAS.n106 VSUBS 0.11679f
C334 EDGE_BIAS.t328 VSUBS 0.35983f
C335 EDGE_BIAS.n107 VSUBS 0.11679f
C336 EDGE_BIAS.t322 VSUBS 0.35983f
C337 EDGE_BIAS.n108 VSUBS 0.11679f
C338 EDGE_BIAS.t316 VSUBS 0.35983f
C339 EDGE_BIAS.n109 VSUBS 0.11679f
C340 EDGE_BIAS.t310 VSUBS 0.35983f
C341 EDGE_BIAS.n110 VSUBS 0.11679f
C342 EDGE_BIAS.t304 VSUBS 0.35983f
C343 EDGE_BIAS.n111 VSUBS 0.11679f
C344 EDGE_BIAS.t298 VSUBS 0.35983f
C345 EDGE_BIAS.n112 VSUBS 0.11679f
C346 EDGE_BIAS.t292 VSUBS 0.35983f
C347 EDGE_BIAS.n113 VSUBS 0.11679f
C348 EDGE_BIAS.t286 VSUBS 0.35983f
C349 EDGE_BIAS.n114 VSUBS 0.11679f
C350 EDGE_BIAS.t280 VSUBS 0.35983f
C351 EDGE_BIAS.n115 VSUBS 0.11679f
C352 EDGE_BIAS.t274 VSUBS 0.35983f
C353 EDGE_BIAS.n116 VSUBS 0.11679f
C354 EDGE_BIAS.t268 VSUBS 0.35983f
C355 EDGE_BIAS.n117 VSUBS 0.11679f
C356 EDGE_BIAS.t262 VSUBS 0.35983f
C357 EDGE_BIAS.n118 VSUBS 0.11679f
C358 EDGE_BIAS.t256 VSUBS 0.35983f
C359 EDGE_BIAS.n119 VSUBS 0.11679f
C360 EDGE_BIAS.t250 VSUBS 0.35983f
C361 EDGE_BIAS.n120 VSUBS 0.11679f
C362 EDGE_BIAS.t244 VSUBS 0.35983f
C363 EDGE_BIAS.n121 VSUBS 0.11679f
C364 EDGE_BIAS.t238 VSUBS 0.35983f
C365 EDGE_BIAS.n122 VSUBS 0.11679f
C366 EDGE_BIAS.t232 VSUBS 0.35983f
C367 EDGE_BIAS.n123 VSUBS 0.11679f
C368 EDGE_BIAS.t226 VSUBS 0.35983f
C369 EDGE_BIAS.n124 VSUBS 0.11679f
C370 EDGE_BIAS.t220 VSUBS 0.35983f
C371 EDGE_BIAS.n125 VSUBS 0.11679f
C372 EDGE_BIAS.t214 VSUBS 0.35983f
C373 EDGE_BIAS.n126 VSUBS 0.11679f
C374 EDGE_BIAS.t208 VSUBS 0.35983f
C375 EDGE_BIAS.n127 VSUBS 0.11679f
C376 EDGE_BIAS.t202 VSUBS 0.35983f
C377 EDGE_BIAS.n128 VSUBS 0.11679f
C378 EDGE_BIAS.n129 VSUBS 0.11151f
C379 EDGE_BIAS.t196 VSUBS 0.35596f
C380 EDGE_BIAS.n130 VSUBS 0.11936f
C381 EDGE_BIAS.t193 VSUBS 0.35596f
C382 EDGE_BIAS.n131 VSUBS 0.11936f
C383 EDGE_BIAS.t190 VSUBS 0.35596f
C384 EDGE_BIAS.n132 VSUBS 0.11936f
C385 EDGE_BIAS.t187 VSUBS 0.35596f
C386 EDGE_BIAS.n133 VSUBS 0.11936f
C387 EDGE_BIAS.t184 VSUBS 0.35596f
C388 EDGE_BIAS.n134 VSUBS 0.11936f
C389 EDGE_BIAS.t181 VSUBS 0.35596f
C390 EDGE_BIAS.n135 VSUBS 0.11936f
C391 EDGE_BIAS.t178 VSUBS 0.35596f
C392 EDGE_BIAS.n136 VSUBS 0.11936f
C393 EDGE_BIAS.t175 VSUBS 0.35596f
C394 EDGE_BIAS.n137 VSUBS 0.11936f
C395 EDGE_BIAS.t172 VSUBS 0.35596f
C396 EDGE_BIAS.n138 VSUBS 0.11936f
C397 EDGE_BIAS.t169 VSUBS 0.35596f
C398 EDGE_BIAS.n139 VSUBS 0.11936f
C399 EDGE_BIAS.t166 VSUBS 0.35596f
C400 EDGE_BIAS.n140 VSUBS 0.11936f
C401 EDGE_BIAS.t163 VSUBS 0.35596f
C402 EDGE_BIAS.n141 VSUBS 0.11936f
C403 EDGE_BIAS.t160 VSUBS 0.35596f
C404 EDGE_BIAS.n142 VSUBS 0.11936f
C405 EDGE_BIAS.t157 VSUBS 0.35596f
C406 EDGE_BIAS.n143 VSUBS 0.11936f
C407 EDGE_BIAS.t154 VSUBS 0.35596f
C408 EDGE_BIAS.n144 VSUBS 0.11936f
C409 EDGE_BIAS.t151 VSUBS 0.35596f
C410 EDGE_BIAS.n145 VSUBS 0.11936f
C411 EDGE_BIAS.t148 VSUBS 0.35596f
C412 EDGE_BIAS.n146 VSUBS 0.11936f
C413 EDGE_BIAS.t145 VSUBS 0.35596f
C414 EDGE_BIAS.n147 VSUBS 0.11936f
C415 EDGE_BIAS.t142 VSUBS 0.35596f
C416 EDGE_BIAS.n148 VSUBS 0.11936f
C417 EDGE_BIAS.t139 VSUBS 0.35596f
C418 EDGE_BIAS.n149 VSUBS 0.11936f
C419 EDGE_BIAS.t136 VSUBS 0.35596f
C420 EDGE_BIAS.n150 VSUBS 0.11936f
C421 EDGE_BIAS.t133 VSUBS 0.35596f
C422 EDGE_BIAS.n151 VSUBS 0.11936f
C423 EDGE_BIAS.t130 VSUBS 0.35596f
C424 EDGE_BIAS.n152 VSUBS 0.11936f
C425 EDGE_BIAS.t127 VSUBS 0.35596f
C426 EDGE_BIAS.n153 VSUBS 0.11936f
C427 EDGE_BIAS.t124 VSUBS 0.35596f
C428 EDGE_BIAS.n154 VSUBS 0.11936f
C429 EDGE_BIAS.t121 VSUBS 0.35596f
C430 EDGE_BIAS.n155 VSUBS 0.11936f
C431 EDGE_BIAS.t118 VSUBS 0.35596f
C432 EDGE_BIAS.n156 VSUBS 0.11936f
C433 EDGE_BIAS.t115 VSUBS 0.35596f
C434 EDGE_BIAS.n157 VSUBS 0.11936f
C435 EDGE_BIAS.t112 VSUBS 0.35596f
C436 EDGE_BIAS.n158 VSUBS 0.11936f
C437 EDGE_BIAS.t109 VSUBS 0.35596f
C438 EDGE_BIAS.n159 VSUBS 0.11936f
C439 EDGE_BIAS.t106 VSUBS 0.35596f
C440 EDGE_BIAS.n160 VSUBS 0.11936f
C441 EDGE_BIAS.t103 VSUBS 0.35596f
C442 EDGE_BIAS.n161 VSUBS 0.11936f
C443 EDGE_BIAS.t100 VSUBS 0.35596f
C444 EDGE_BIAS.n162 VSUBS 0.11936f
C445 EDGE_BIAS.t97 VSUBS 0.35596f
C446 EDGE_BIAS.n163 VSUBS 0.11936f
C447 EDGE_BIAS.t94 VSUBS 0.35596f
C448 EDGE_BIAS.n164 VSUBS 0.11936f
C449 EDGE_BIAS.t91 VSUBS 0.35596f
C450 EDGE_BIAS.n165 VSUBS 0.11936f
C451 EDGE_BIAS.t88 VSUBS 0.35596f
C452 EDGE_BIAS.n166 VSUBS 0.11936f
C453 EDGE_BIAS.t85 VSUBS 0.35596f
C454 EDGE_BIAS.n167 VSUBS 0.11936f
C455 EDGE_BIAS.t82 VSUBS 0.35596f
C456 EDGE_BIAS.n168 VSUBS 0.11936f
C457 EDGE_BIAS.t79 VSUBS 0.35596f
C458 EDGE_BIAS.n169 VSUBS 0.11936f
C459 EDGE_BIAS.t76 VSUBS 0.35596f
C460 EDGE_BIAS.n170 VSUBS 0.11936f
C461 EDGE_BIAS.t73 VSUBS 0.35596f
C462 EDGE_BIAS.n171 VSUBS 0.11936f
C463 EDGE_BIAS.t70 VSUBS 0.35596f
C464 EDGE_BIAS.n172 VSUBS 0.11936f
C465 EDGE_BIAS.t67 VSUBS 0.35596f
C466 EDGE_BIAS.n173 VSUBS 0.11936f
C467 EDGE_BIAS.t64 VSUBS 0.35596f
C468 EDGE_BIAS.n174 VSUBS 0.11936f
C469 EDGE_BIAS.t61 VSUBS 0.35596f
C470 EDGE_BIAS.n175 VSUBS 0.11936f
C471 EDGE_BIAS.t58 VSUBS 0.35596f
C472 EDGE_BIAS.n176 VSUBS 0.11936f
C473 EDGE_BIAS.t55 VSUBS 0.35596f
C474 EDGE_BIAS.n177 VSUBS 0.11936f
C475 EDGE_BIAS.t52 VSUBS 0.35596f
C476 EDGE_BIAS.n178 VSUBS 0.11936f
C477 EDGE_BIAS.t49 VSUBS 0.35596f
C478 EDGE_BIAS.n179 VSUBS 0.11936f
C479 EDGE_BIAS.t46 VSUBS 0.35596f
C480 EDGE_BIAS.n180 VSUBS 0.11936f
C481 EDGE_BIAS.t43 VSUBS 0.35596f
C482 EDGE_BIAS.n181 VSUBS 0.11936f
C483 EDGE_BIAS.t40 VSUBS 0.35596f
C484 EDGE_BIAS.n182 VSUBS 0.11936f
C485 EDGE_BIAS.t37 VSUBS 0.35596f
C486 EDGE_BIAS.n183 VSUBS 0.11936f
C487 EDGE_BIAS.t34 VSUBS 0.35596f
C488 EDGE_BIAS.n184 VSUBS 0.11936f
C489 EDGE_BIAS.t31 VSUBS 0.35596f
C490 EDGE_BIAS.n185 VSUBS 0.11936f
C491 EDGE_BIAS.t28 VSUBS 0.35596f
C492 EDGE_BIAS.n186 VSUBS 0.11936f
C493 EDGE_BIAS.t25 VSUBS 0.35596f
C494 EDGE_BIAS.n187 VSUBS 0.11936f
C495 EDGE_BIAS.t22 VSUBS 0.35596f
C496 EDGE_BIAS.n188 VSUBS 0.11936f
C497 EDGE_BIAS.t19 VSUBS 0.35596f
C498 EDGE_BIAS.n189 VSUBS 0.11936f
C499 EDGE_BIAS.t16 VSUBS 0.35596f
C500 EDGE_BIAS.n190 VSUBS 0.11936f
C501 EDGE_BIAS.t13 VSUBS 0.35596f
C502 EDGE_BIAS.n191 VSUBS 0.11936f
C503 EDGE_BIAS.t10 VSUBS 0.35596f
C504 EDGE_BIAS.n192 VSUBS 0.11936f
C505 EDGE_BIAS.t7 VSUBS 0.35596f
C506 EDGE_BIAS.n193 VSUBS 0.11936f
C507 EDGE_BIAS.t4 VSUBS 0.35596f
C508 EDGE_BIAS.t1 VSUBS 0.35983f
C509 EDGE_BIAS.n194 VSUBS 0.12464f
C510 EDGE_BIAS.t199 VSUBS 0.35983f
C511 EDGE_BIAS.n195 VSUBS 0.11679f
C512 EDGE_BIAS.t205 VSUBS 0.35983f
C513 EDGE_BIAS.n196 VSUBS 0.11679f
C514 EDGE_BIAS.t211 VSUBS 0.35983f
C515 EDGE_BIAS.n197 VSUBS 0.11679f
C516 EDGE_BIAS.t217 VSUBS 0.35983f
C517 EDGE_BIAS.n198 VSUBS 0.11679f
C518 EDGE_BIAS.t223 VSUBS 0.35983f
C519 EDGE_BIAS.n199 VSUBS 0.11679f
C520 EDGE_BIAS.t229 VSUBS 0.35983f
C521 EDGE_BIAS.n200 VSUBS 0.11679f
C522 EDGE_BIAS.t235 VSUBS 0.35983f
C523 EDGE_BIAS.n201 VSUBS 0.11679f
C524 EDGE_BIAS.t241 VSUBS 0.35983f
C525 EDGE_BIAS.n202 VSUBS 0.11679f
C526 EDGE_BIAS.t247 VSUBS 0.35983f
C527 EDGE_BIAS.n203 VSUBS 0.11679f
C528 EDGE_BIAS.t253 VSUBS 0.35983f
C529 EDGE_BIAS.n204 VSUBS 0.11679f
C530 EDGE_BIAS.t259 VSUBS 0.35983f
C531 EDGE_BIAS.n205 VSUBS 0.11679f
C532 EDGE_BIAS.t265 VSUBS 0.35983f
C533 EDGE_BIAS.n206 VSUBS 0.11679f
C534 EDGE_BIAS.t271 VSUBS 0.35983f
C535 EDGE_BIAS.n207 VSUBS 0.11679f
C536 EDGE_BIAS.t277 VSUBS 0.35983f
C537 EDGE_BIAS.n208 VSUBS 0.11679f
C538 EDGE_BIAS.t283 VSUBS 0.35983f
C539 EDGE_BIAS.n209 VSUBS 0.11679f
C540 EDGE_BIAS.t289 VSUBS 0.35983f
C541 EDGE_BIAS.n210 VSUBS 0.11679f
C542 EDGE_BIAS.t295 VSUBS 0.35983f
C543 EDGE_BIAS.n211 VSUBS 0.11679f
C544 EDGE_BIAS.t301 VSUBS 0.35983f
C545 EDGE_BIAS.n212 VSUBS 0.11679f
C546 EDGE_BIAS.t307 VSUBS 0.35983f
C547 EDGE_BIAS.n213 VSUBS 0.11679f
C548 EDGE_BIAS.t313 VSUBS 0.35983f
C549 EDGE_BIAS.n214 VSUBS 0.11679f
C550 EDGE_BIAS.t319 VSUBS 0.35983f
C551 EDGE_BIAS.n215 VSUBS 0.11679f
C552 EDGE_BIAS.t325 VSUBS 0.35983f
C553 EDGE_BIAS.n216 VSUBS 0.11679f
C554 EDGE_BIAS.t331 VSUBS 0.35983f
C555 EDGE_BIAS.n217 VSUBS 0.11679f
C556 EDGE_BIAS.t337 VSUBS 0.35983f
C557 EDGE_BIAS.n218 VSUBS 0.11679f
C558 EDGE_BIAS.t343 VSUBS 0.35983f
C559 EDGE_BIAS.n219 VSUBS 0.11679f
C560 EDGE_BIAS.t349 VSUBS 0.35983f
C561 EDGE_BIAS.n220 VSUBS 0.11679f
C562 EDGE_BIAS.t355 VSUBS 0.35983f
C563 EDGE_BIAS.n221 VSUBS 0.11679f
C564 EDGE_BIAS.t361 VSUBS 0.35983f
C565 EDGE_BIAS.n222 VSUBS 0.11679f
C566 EDGE_BIAS.t367 VSUBS 0.35983f
C567 EDGE_BIAS.n223 VSUBS 0.11679f
C568 EDGE_BIAS.t373 VSUBS 0.35983f
C569 EDGE_BIAS.n224 VSUBS 0.11679f
C570 EDGE_BIAS.t379 VSUBS 0.35983f
C571 EDGE_BIAS.n225 VSUBS 0.11679f
C572 EDGE_BIAS.t385 VSUBS 0.35983f
C573 EDGE_BIAS.n226 VSUBS 0.11679f
C574 EDGE_BIAS.t391 VSUBS 0.35983f
C575 EDGE_BIAS.n227 VSUBS 0.11679f
C576 EDGE_BIAS.t397 VSUBS 0.35983f
C577 EDGE_BIAS.n228 VSUBS 0.11679f
C578 EDGE_BIAS.t403 VSUBS 0.35983f
C579 EDGE_BIAS.n229 VSUBS 0.11679f
C580 EDGE_BIAS.t409 VSUBS 0.35983f
C581 EDGE_BIAS.n230 VSUBS 0.11679f
C582 EDGE_BIAS.t415 VSUBS 0.35983f
C583 EDGE_BIAS.n231 VSUBS 0.11679f
C584 EDGE_BIAS.t421 VSUBS 0.35983f
C585 EDGE_BIAS.n232 VSUBS 0.11679f
C586 EDGE_BIAS.t427 VSUBS 0.35983f
C587 EDGE_BIAS.n233 VSUBS 0.11679f
C588 EDGE_BIAS.t433 VSUBS 0.35983f
C589 EDGE_BIAS.n234 VSUBS 0.11679f
C590 EDGE_BIAS.t439 VSUBS 0.35983f
C591 EDGE_BIAS.n235 VSUBS 0.11679f
C592 EDGE_BIAS.t445 VSUBS 0.35983f
C593 EDGE_BIAS.n236 VSUBS 0.11679f
C594 EDGE_BIAS.t451 VSUBS 0.35983f
C595 EDGE_BIAS.n237 VSUBS 0.11679f
C596 EDGE_BIAS.t457 VSUBS 0.35983f
C597 EDGE_BIAS.n238 VSUBS 0.11679f
C598 EDGE_BIAS.t463 VSUBS 0.35983f
C599 EDGE_BIAS.n239 VSUBS 0.11679f
C600 EDGE_BIAS.t469 VSUBS 0.35983f
C601 EDGE_BIAS.n240 VSUBS 0.11679f
C602 EDGE_BIAS.t475 VSUBS 0.35983f
C603 EDGE_BIAS.n241 VSUBS 0.11679f
C604 EDGE_BIAS.t481 VSUBS 0.35983f
C605 EDGE_BIAS.n242 VSUBS 0.11679f
C606 EDGE_BIAS.t487 VSUBS 0.35983f
C607 EDGE_BIAS.n243 VSUBS 0.11679f
C608 EDGE_BIAS.t493 VSUBS 0.35983f
C609 EDGE_BIAS.n244 VSUBS 0.11679f
C610 EDGE_BIAS.t499 VSUBS 0.35983f
C611 EDGE_BIAS.n245 VSUBS 0.11679f
C612 EDGE_BIAS.t505 VSUBS 0.35983f
C613 EDGE_BIAS.n246 VSUBS 0.11679f
C614 EDGE_BIAS.t511 VSUBS 0.35983f
C615 EDGE_BIAS.n247 VSUBS 0.11679f
C616 EDGE_BIAS.t517 VSUBS 0.35983f
C617 EDGE_BIAS.n248 VSUBS 0.11679f
C618 EDGE_BIAS.t523 VSUBS 0.35983f
C619 EDGE_BIAS.n249 VSUBS 0.11679f
C620 EDGE_BIAS.t529 VSUBS 0.35983f
C621 EDGE_BIAS.n250 VSUBS 0.11679f
C622 EDGE_BIAS.t535 VSUBS 0.35983f
C623 EDGE_BIAS.n251 VSUBS 0.11679f
C624 EDGE_BIAS.t541 VSUBS 0.35983f
C625 EDGE_BIAS.n252 VSUBS 0.11679f
C626 EDGE_BIAS.t547 VSUBS 0.35983f
C627 EDGE_BIAS.n253 VSUBS 0.11679f
C628 EDGE_BIAS.t553 VSUBS 0.35983f
C629 EDGE_BIAS.n254 VSUBS 0.11679f
C630 EDGE_BIAS.t559 VSUBS 0.35983f
C631 EDGE_BIAS.n255 VSUBS 0.11679f
C632 EDGE_BIAS.t565 VSUBS 0.35983f
C633 EDGE_BIAS.n256 VSUBS 0.11679f
C634 EDGE_BIAS.t571 VSUBS 0.35983f
C635 EDGE_BIAS.n257 VSUBS 0.11679f
C636 EDGE_BIAS.t577 VSUBS 0.35983f
C637 EDGE_BIAS.n258 VSUBS 0.11679f
C638 EDGE_BIAS.t583 VSUBS 0.35293f
C639 EDGE_BIAS.n259 VSUBS 0.04574f
C640 EDGE_BIAS.n260 VSUBS 0.02199f
C641 TOP.t5120 VSUBS 2.53117f
C642 TOP.t1024 VSUBS 2.46629f
C643 TOP.t1026 VSUBS 2.24628f
C644 TOP.t1028 VSUBS 2.24628f
C645 TOP.t1030 VSUBS 2.24628f
C646 TOP.t1032 VSUBS 2.24628f
C647 TOP.t1034 VSUBS 2.24628f
C648 TOP.t1036 VSUBS 2.24628f
C649 TOP.t1038 VSUBS 2.24628f
C650 TOP.t1040 VSUBS 2.24628f
C651 TOP.t1042 VSUBS 2.24628f
C652 TOP.t1044 VSUBS 2.24628f
C653 TOP.t1046 VSUBS 2.24628f
C654 TOP.t1048 VSUBS 2.24628f
C655 TOP.t1050 VSUBS 2.24628f
C656 TOP.t1052 VSUBS 2.24628f
C657 TOP.t1054 VSUBS 2.24628f
C658 TOP.t1056 VSUBS 2.24628f
C659 TOP.t1058 VSUBS 2.24628f
C660 TOP.t1060 VSUBS 2.24628f
C661 TOP.t1062 VSUBS 2.24628f
C662 TOP.t1064 VSUBS 2.24628f
C663 TOP.t1066 VSUBS 2.24628f
C664 TOP.t1068 VSUBS 2.24628f
C665 TOP.t1070 VSUBS 2.24628f
C666 TOP.t1072 VSUBS 2.24628f
C667 TOP.t1074 VSUBS 2.24628f
C668 TOP.t1076 VSUBS 2.24628f
C669 TOP.t1078 VSUBS 2.24628f
C670 TOP.t1080 VSUBS 2.24628f
C671 TOP.t1082 VSUBS 2.24628f
C672 TOP.t1084 VSUBS 2.24628f
C673 TOP.t1086 VSUBS 2.24628f
C674 TOP.t1088 VSUBS 2.24628f
C675 TOP.t1090 VSUBS 2.24628f
C676 TOP.t1092 VSUBS 2.24628f
C677 TOP.t1094 VSUBS 2.24628f
C678 TOP.t1096 VSUBS 2.24628f
C679 TOP.t1098 VSUBS 2.24628f
C680 TOP.t1100 VSUBS 2.24628f
C681 TOP.t1102 VSUBS 2.24628f
C682 TOP.t1104 VSUBS 2.24628f
C683 TOP.t1106 VSUBS 2.24628f
C684 TOP.t1108 VSUBS 2.24628f
C685 TOP.t1110 VSUBS 2.24628f
C686 TOP.t1112 VSUBS 2.24628f
C687 TOP.t1114 VSUBS 2.24628f
C688 TOP.t1116 VSUBS 2.24628f
C689 TOP.t1118 VSUBS 2.24628f
C690 TOP.t1120 VSUBS 2.24628f
C691 TOP.t1122 VSUBS 2.24628f
C692 TOP.t1124 VSUBS 2.24628f
C693 TOP.t1126 VSUBS 2.24628f
C694 TOP.t1128 VSUBS 2.24628f
C695 TOP.t1130 VSUBS 2.24628f
C696 TOP.t1132 VSUBS 2.24628f
C697 TOP.t1134 VSUBS 2.24628f
C698 TOP.t1136 VSUBS 2.24628f
C699 TOP.t1138 VSUBS 2.24628f
C700 TOP.t1140 VSUBS 2.24628f
C701 TOP.t1142 VSUBS 2.24628f
C702 TOP.t1144 VSUBS 2.24628f
C703 TOP.t1146 VSUBS 2.24628f
C704 TOP.t1148 VSUBS 2.30579f
C705 TOP.t7808 VSUBS 2.66282f
C706 TOP.t1150 VSUBS 2.46629f
C707 TOP.t1152 VSUBS 2.24628f
C708 TOP.t1154 VSUBS 2.24628f
C709 TOP.t1156 VSUBS 2.24628f
C710 TOP.t1158 VSUBS 2.24628f
C711 TOP.t1160 VSUBS 2.24628f
C712 TOP.t1162 VSUBS 2.24628f
C713 TOP.t1164 VSUBS 2.24628f
C714 TOP.t1166 VSUBS 2.24628f
C715 TOP.t1168 VSUBS 2.24628f
C716 TOP.t1170 VSUBS 2.24628f
C717 TOP.t1172 VSUBS 2.24628f
C718 TOP.t1174 VSUBS 2.24628f
C719 TOP.t1176 VSUBS 2.24628f
C720 TOP.t1178 VSUBS 2.24628f
C721 TOP.t1180 VSUBS 2.24628f
C722 TOP.t1182 VSUBS 2.24628f
C723 TOP.t1184 VSUBS 2.24628f
C724 TOP.t1186 VSUBS 2.24628f
C725 TOP.t1188 VSUBS 2.24628f
C726 TOP.t1190 VSUBS 2.24628f
C727 TOP.t1192 VSUBS 2.24628f
C728 TOP.t1194 VSUBS 2.24628f
C729 TOP.t1196 VSUBS 2.24628f
C730 TOP.t1198 VSUBS 2.24628f
C731 TOP.t1200 VSUBS 2.24628f
C732 TOP.t1202 VSUBS 2.24628f
C733 TOP.t1204 VSUBS 2.24628f
C734 TOP.t1206 VSUBS 2.24628f
C735 TOP.t1208 VSUBS 2.24628f
C736 TOP.t1210 VSUBS 2.24628f
C737 TOP.t1212 VSUBS 2.24628f
C738 TOP.t1214 VSUBS 2.24628f
C739 TOP.t1216 VSUBS 2.24628f
C740 TOP.t1218 VSUBS 2.24628f
C741 TOP.t1220 VSUBS 2.24628f
C742 TOP.t1222 VSUBS 2.24628f
C743 TOP.t1224 VSUBS 2.24628f
C744 TOP.t1226 VSUBS 2.24628f
C745 TOP.t1228 VSUBS 2.24628f
C746 TOP.t1230 VSUBS 2.24628f
C747 TOP.t1232 VSUBS 2.24628f
C748 TOP.t1234 VSUBS 2.24628f
C749 TOP.t1236 VSUBS 2.24628f
C750 TOP.t1238 VSUBS 2.24628f
C751 TOP.t1240 VSUBS 2.24628f
C752 TOP.t1242 VSUBS 2.24628f
C753 TOP.t1244 VSUBS 2.24628f
C754 TOP.t1246 VSUBS 2.24628f
C755 TOP.t1248 VSUBS 2.24628f
C756 TOP.t1250 VSUBS 2.24628f
C757 TOP.t1252 VSUBS 2.24628f
C758 TOP.t1254 VSUBS 2.24628f
C759 TOP.t1256 VSUBS 2.24628f
C760 TOP.t1258 VSUBS 2.24628f
C761 TOP.t1260 VSUBS 2.24628f
C762 TOP.t1262 VSUBS 2.24628f
C763 TOP.t1264 VSUBS 2.24628f
C764 TOP.t1266 VSUBS 2.24628f
C765 TOP.t1268 VSUBS 2.24628f
C766 TOP.t1270 VSUBS 2.24628f
C767 TOP.t1272 VSUBS 2.24628f
C768 TOP.t1274 VSUBS 1.83284f
C769 TOP.n0 VSUBS 0.59615f
C770 TOP.t7296 VSUBS 2.65103f
C771 TOP.t1276 VSUBS 2.46629f
C772 TOP.t1278 VSUBS 2.24628f
C773 TOP.t1280 VSUBS 2.24628f
C774 TOP.t1282 VSUBS 2.24628f
C775 TOP.t1284 VSUBS 2.24628f
C776 TOP.t1286 VSUBS 2.24628f
C777 TOP.t1288 VSUBS 2.24628f
C778 TOP.t1290 VSUBS 2.24628f
C779 TOP.t1292 VSUBS 2.24628f
C780 TOP.t1294 VSUBS 2.24628f
C781 TOP.t1296 VSUBS 2.24628f
C782 TOP.t1298 VSUBS 2.24628f
C783 TOP.t1300 VSUBS 2.24628f
C784 TOP.t1302 VSUBS 2.24628f
C785 TOP.t1304 VSUBS 2.24628f
C786 TOP.t1306 VSUBS 2.24628f
C787 TOP.t1308 VSUBS 2.24628f
C788 TOP.t1310 VSUBS 2.24628f
C789 TOP.t1312 VSUBS 2.24628f
C790 TOP.t1314 VSUBS 2.24628f
C791 TOP.t1316 VSUBS 2.24628f
C792 TOP.t1318 VSUBS 2.24628f
C793 TOP.t1320 VSUBS 2.24628f
C794 TOP.t1322 VSUBS 2.24628f
C795 TOP.t1324 VSUBS 2.24628f
C796 TOP.t1326 VSUBS 2.24628f
C797 TOP.t1328 VSUBS 2.24628f
C798 TOP.t1330 VSUBS 2.24628f
C799 TOP.t1332 VSUBS 2.24628f
C800 TOP.t1334 VSUBS 2.24628f
C801 TOP.t1336 VSUBS 2.24628f
C802 TOP.t1338 VSUBS 2.24628f
C803 TOP.t1340 VSUBS 2.24628f
C804 TOP.t1342 VSUBS 2.24628f
C805 TOP.t1344 VSUBS 2.24628f
C806 TOP.t1346 VSUBS 2.24628f
C807 TOP.t1348 VSUBS 2.24628f
C808 TOP.t1350 VSUBS 2.24628f
C809 TOP.t1352 VSUBS 2.24628f
C810 TOP.t1354 VSUBS 2.24628f
C811 TOP.t1356 VSUBS 2.24628f
C812 TOP.t1358 VSUBS 2.24628f
C813 TOP.t1360 VSUBS 2.24628f
C814 TOP.t1362 VSUBS 2.24628f
C815 TOP.t1364 VSUBS 2.24628f
C816 TOP.t1366 VSUBS 2.24628f
C817 TOP.t1368 VSUBS 2.24628f
C818 TOP.t1370 VSUBS 2.24628f
C819 TOP.t1372 VSUBS 2.24628f
C820 TOP.t1374 VSUBS 2.24628f
C821 TOP.t1376 VSUBS 2.24628f
C822 TOP.t1378 VSUBS 2.24628f
C823 TOP.t1380 VSUBS 2.24628f
C824 TOP.t1382 VSUBS 2.24628f
C825 TOP.t1384 VSUBS 2.24628f
C826 TOP.t1386 VSUBS 2.24628f
C827 TOP.t1388 VSUBS 2.24628f
C828 TOP.t1390 VSUBS 2.24628f
C829 TOP.t1392 VSUBS 2.24628f
C830 TOP.t1394 VSUBS 2.24628f
C831 TOP.t1396 VSUBS 2.24628f
C832 TOP.t1398 VSUBS 2.24628f
C833 TOP.t1400 VSUBS 1.83284f
C834 TOP.n1 VSUBS 0.548f
C835 TOP.t7298 VSUBS 2.65103f
C836 TOP.t1402 VSUBS 2.46629f
C837 TOP.t1404 VSUBS 2.24628f
C838 TOP.t1406 VSUBS 2.24628f
C839 TOP.t1408 VSUBS 2.24628f
C840 TOP.t1410 VSUBS 2.24628f
C841 TOP.t1412 VSUBS 2.24628f
C842 TOP.t1414 VSUBS 2.24628f
C843 TOP.t1416 VSUBS 2.24628f
C844 TOP.t1418 VSUBS 2.24628f
C845 TOP.t1420 VSUBS 2.24628f
C846 TOP.t1422 VSUBS 2.24628f
C847 TOP.t1424 VSUBS 2.24628f
C848 TOP.t1426 VSUBS 2.24628f
C849 TOP.t1428 VSUBS 2.24628f
C850 TOP.t1430 VSUBS 2.24628f
C851 TOP.t1432 VSUBS 2.24628f
C852 TOP.t1434 VSUBS 2.24628f
C853 TOP.t1436 VSUBS 2.24628f
C854 TOP.t1438 VSUBS 2.24628f
C855 TOP.t1440 VSUBS 2.24628f
C856 TOP.t1442 VSUBS 2.24628f
C857 TOP.t1444 VSUBS 2.24628f
C858 TOP.t1446 VSUBS 2.24628f
C859 TOP.t1448 VSUBS 2.24628f
C860 TOP.t1450 VSUBS 2.24628f
C861 TOP.t1452 VSUBS 2.24628f
C862 TOP.t1454 VSUBS 2.24628f
C863 TOP.t1456 VSUBS 2.24628f
C864 TOP.t1458 VSUBS 2.24628f
C865 TOP.t1460 VSUBS 2.24628f
C866 TOP.t1462 VSUBS 2.24628f
C867 TOP.t1464 VSUBS 2.24628f
C868 TOP.t1466 VSUBS 2.24628f
C869 TOP.t1468 VSUBS 2.24628f
C870 TOP.t1470 VSUBS 2.24628f
C871 TOP.t1472 VSUBS 2.24628f
C872 TOP.t1474 VSUBS 2.24628f
C873 TOP.t1476 VSUBS 2.24628f
C874 TOP.t1478 VSUBS 2.24628f
C875 TOP.t1480 VSUBS 2.24628f
C876 TOP.t1482 VSUBS 2.24628f
C877 TOP.t1484 VSUBS 2.24628f
C878 TOP.t1486 VSUBS 2.24628f
C879 TOP.t1488 VSUBS 2.24628f
C880 TOP.t1490 VSUBS 2.24628f
C881 TOP.t1492 VSUBS 2.24628f
C882 TOP.t1494 VSUBS 2.24628f
C883 TOP.t1496 VSUBS 2.24628f
C884 TOP.t1498 VSUBS 2.24628f
C885 TOP.t1500 VSUBS 2.24628f
C886 TOP.t1502 VSUBS 2.24628f
C887 TOP.t1504 VSUBS 2.24628f
C888 TOP.t1506 VSUBS 2.24628f
C889 TOP.t1508 VSUBS 2.24628f
C890 TOP.t1510 VSUBS 2.24628f
C891 TOP.t1512 VSUBS 2.24628f
C892 TOP.t1514 VSUBS 2.24628f
C893 TOP.t1516 VSUBS 2.24628f
C894 TOP.t1518 VSUBS 2.24628f
C895 TOP.t1520 VSUBS 2.24628f
C896 TOP.t1522 VSUBS 2.24628f
C897 TOP.t1524 VSUBS 2.24628f
C898 TOP.t1526 VSUBS 1.83284f
C899 TOP.n2 VSUBS 0.548f
C900 TOP.t0 VSUBS 2.66056f
C901 TOP.t1528 VSUBS 2.46629f
C902 TOP.t1530 VSUBS 2.24628f
C903 TOP.t1532 VSUBS 2.24628f
C904 TOP.t1534 VSUBS 2.24628f
C905 TOP.t1536 VSUBS 2.24628f
C906 TOP.t1538 VSUBS 2.24628f
C907 TOP.t1540 VSUBS 2.24628f
C908 TOP.t1542 VSUBS 2.24628f
C909 TOP.t1544 VSUBS 2.24628f
C910 TOP.t1546 VSUBS 2.24628f
C911 TOP.t1548 VSUBS 2.24628f
C912 TOP.t1550 VSUBS 2.24628f
C913 TOP.t1552 VSUBS 2.24628f
C914 TOP.t1554 VSUBS 2.24628f
C915 TOP.t1556 VSUBS 2.24628f
C916 TOP.t1558 VSUBS 2.24628f
C917 TOP.t1560 VSUBS 2.24628f
C918 TOP.t1562 VSUBS 2.24628f
C919 TOP.t1564 VSUBS 2.24628f
C920 TOP.t1566 VSUBS 2.24628f
C921 TOP.t1568 VSUBS 2.24628f
C922 TOP.t1570 VSUBS 2.24628f
C923 TOP.t1572 VSUBS 2.24628f
C924 TOP.t1574 VSUBS 2.24628f
C925 TOP.t1576 VSUBS 2.24628f
C926 TOP.t1578 VSUBS 2.24628f
C927 TOP.t1580 VSUBS 2.24628f
C928 TOP.t1582 VSUBS 2.24628f
C929 TOP.t1584 VSUBS 2.24628f
C930 TOP.t1586 VSUBS 2.24628f
C931 TOP.t1588 VSUBS 2.24628f
C932 TOP.t1590 VSUBS 2.24628f
C933 TOP.t1592 VSUBS 2.24628f
C934 TOP.t1594 VSUBS 2.24628f
C935 TOP.t1596 VSUBS 2.24628f
C936 TOP.t1598 VSUBS 2.24628f
C937 TOP.t1600 VSUBS 2.24628f
C938 TOP.t1602 VSUBS 2.24628f
C939 TOP.t1604 VSUBS 2.24628f
C940 TOP.t1606 VSUBS 2.24628f
C941 TOP.t1608 VSUBS 2.24628f
C942 TOP.t1610 VSUBS 2.24628f
C943 TOP.t1612 VSUBS 2.24628f
C944 TOP.t1614 VSUBS 2.24628f
C945 TOP.t1616 VSUBS 2.24628f
C946 TOP.t1618 VSUBS 2.24628f
C947 TOP.t1620 VSUBS 2.24628f
C948 TOP.t1622 VSUBS 2.24628f
C949 TOP.t1624 VSUBS 2.24628f
C950 TOP.t1626 VSUBS 2.24628f
C951 TOP.t1628 VSUBS 2.24628f
C952 TOP.t1630 VSUBS 2.24628f
C953 TOP.t1632 VSUBS 2.24628f
C954 TOP.t1634 VSUBS 2.24628f
C955 TOP.t1636 VSUBS 2.24628f
C956 TOP.t1638 VSUBS 2.24628f
C957 TOP.t1640 VSUBS 2.24628f
C958 TOP.t1642 VSUBS 2.24628f
C959 TOP.t1644 VSUBS 2.24628f
C960 TOP.t1646 VSUBS 2.24628f
C961 TOP.t1648 VSUBS 2.24628f
C962 TOP.t1650 VSUBS 2.24628f
C963 TOP.t1652 VSUBS 1.83284f
C964 TOP.n3 VSUBS 0.548f
C965 TOP.t2 VSUBS 2.66056f
C966 TOP.t1654 VSUBS 2.46629f
C967 TOP.t1656 VSUBS 2.24628f
C968 TOP.t1658 VSUBS 2.24628f
C969 TOP.t1660 VSUBS 2.24628f
C970 TOP.t1662 VSUBS 2.24628f
C971 TOP.t1664 VSUBS 2.24628f
C972 TOP.t1666 VSUBS 2.24628f
C973 TOP.t1668 VSUBS 2.24628f
C974 TOP.t1670 VSUBS 2.24628f
C975 TOP.t1672 VSUBS 2.24628f
C976 TOP.t1674 VSUBS 2.24628f
C977 TOP.t1676 VSUBS 2.24628f
C978 TOP.t1678 VSUBS 2.24628f
C979 TOP.t1680 VSUBS 2.24628f
C980 TOP.t1682 VSUBS 2.24628f
C981 TOP.t1684 VSUBS 2.24628f
C982 TOP.t1686 VSUBS 2.24628f
C983 TOP.t1688 VSUBS 2.24628f
C984 TOP.t1690 VSUBS 2.24628f
C985 TOP.t1692 VSUBS 2.24628f
C986 TOP.t1694 VSUBS 2.24628f
C987 TOP.t1696 VSUBS 2.24628f
C988 TOP.t1698 VSUBS 2.24628f
C989 TOP.t1700 VSUBS 2.24628f
C990 TOP.t1702 VSUBS 2.24628f
C991 TOP.t1704 VSUBS 2.24628f
C992 TOP.t1706 VSUBS 2.24628f
C993 TOP.t1708 VSUBS 2.24628f
C994 TOP.t1710 VSUBS 2.24628f
C995 TOP.t1712 VSUBS 2.24628f
C996 TOP.t1714 VSUBS 2.24628f
C997 TOP.t1716 VSUBS 2.24628f
C998 TOP.t1718 VSUBS 2.24628f
C999 TOP.t1720 VSUBS 2.24628f
C1000 TOP.t1722 VSUBS 2.24628f
C1001 TOP.t1724 VSUBS 2.24628f
C1002 TOP.t1726 VSUBS 2.24628f
C1003 TOP.t1728 VSUBS 2.24628f
C1004 TOP.t1730 VSUBS 2.24628f
C1005 TOP.t1732 VSUBS 2.24628f
C1006 TOP.t1734 VSUBS 2.24628f
C1007 TOP.t1736 VSUBS 2.24628f
C1008 TOP.t1738 VSUBS 2.24628f
C1009 TOP.t1740 VSUBS 2.24628f
C1010 TOP.t1742 VSUBS 2.24628f
C1011 TOP.t1744 VSUBS 2.24628f
C1012 TOP.t1746 VSUBS 2.24628f
C1013 TOP.t1748 VSUBS 2.24628f
C1014 TOP.t1750 VSUBS 2.24628f
C1015 TOP.t1752 VSUBS 2.24628f
C1016 TOP.t1754 VSUBS 2.24628f
C1017 TOP.t1756 VSUBS 2.24628f
C1018 TOP.t1758 VSUBS 2.24628f
C1019 TOP.t1760 VSUBS 2.24628f
C1020 TOP.t1762 VSUBS 2.24628f
C1021 TOP.t1764 VSUBS 2.24628f
C1022 TOP.t1766 VSUBS 2.24628f
C1023 TOP.t1768 VSUBS 2.24628f
C1024 TOP.t1770 VSUBS 2.24628f
C1025 TOP.t1772 VSUBS 2.24628f
C1026 TOP.t1774 VSUBS 2.24628f
C1027 TOP.t1776 VSUBS 2.24628f
C1028 TOP.t1778 VSUBS 1.83284f
C1029 TOP.n4 VSUBS 0.548f
C1030 TOP.t4 VSUBS 2.66056f
C1031 TOP.t1780 VSUBS 2.46629f
C1032 TOP.t1782 VSUBS 2.24628f
C1033 TOP.t1784 VSUBS 2.24628f
C1034 TOP.t1786 VSUBS 2.24628f
C1035 TOP.t1788 VSUBS 2.24628f
C1036 TOP.t1790 VSUBS 2.24628f
C1037 TOP.t1792 VSUBS 2.24628f
C1038 TOP.t1794 VSUBS 2.24628f
C1039 TOP.t1796 VSUBS 2.24628f
C1040 TOP.t1798 VSUBS 2.24628f
C1041 TOP.t1800 VSUBS 2.24628f
C1042 TOP.t1802 VSUBS 2.24628f
C1043 TOP.t1804 VSUBS 2.24628f
C1044 TOP.t1806 VSUBS 2.24628f
C1045 TOP.t1808 VSUBS 2.24628f
C1046 TOP.t1810 VSUBS 2.24628f
C1047 TOP.t1812 VSUBS 2.24628f
C1048 TOP.t1814 VSUBS 2.24628f
C1049 TOP.t1816 VSUBS 2.24628f
C1050 TOP.t1818 VSUBS 2.24628f
C1051 TOP.t1820 VSUBS 2.24628f
C1052 TOP.t1822 VSUBS 2.24628f
C1053 TOP.t1824 VSUBS 2.24628f
C1054 TOP.t1826 VSUBS 2.24628f
C1055 TOP.t1828 VSUBS 2.24628f
C1056 TOP.t1830 VSUBS 2.24628f
C1057 TOP.t1832 VSUBS 2.24628f
C1058 TOP.t1834 VSUBS 2.24628f
C1059 TOP.t1836 VSUBS 2.24628f
C1060 TOP.t1838 VSUBS 2.24628f
C1061 TOP.t1840 VSUBS 2.24628f
C1062 TOP.t1842 VSUBS 2.24628f
C1063 TOP.t1844 VSUBS 2.24628f
C1064 TOP.t1846 VSUBS 2.24628f
C1065 TOP.t1848 VSUBS 2.24628f
C1066 TOP.t1850 VSUBS 2.24628f
C1067 TOP.t1852 VSUBS 2.24628f
C1068 TOP.t1854 VSUBS 2.24628f
C1069 TOP.t1856 VSUBS 2.24628f
C1070 TOP.t1858 VSUBS 2.24628f
C1071 TOP.t1860 VSUBS 2.24628f
C1072 TOP.t1862 VSUBS 2.24628f
C1073 TOP.t1864 VSUBS 2.24628f
C1074 TOP.t1866 VSUBS 2.24628f
C1075 TOP.t1868 VSUBS 2.24628f
C1076 TOP.t1870 VSUBS 2.24628f
C1077 TOP.t1872 VSUBS 2.24628f
C1078 TOP.t1874 VSUBS 2.24628f
C1079 TOP.t1876 VSUBS 2.24628f
C1080 TOP.t1878 VSUBS 2.24628f
C1081 TOP.t1880 VSUBS 2.24628f
C1082 TOP.t1882 VSUBS 2.24628f
C1083 TOP.t1884 VSUBS 2.24628f
C1084 TOP.t1886 VSUBS 2.24628f
C1085 TOP.t1888 VSUBS 2.24628f
C1086 TOP.t1890 VSUBS 2.24628f
C1087 TOP.t1892 VSUBS 2.24628f
C1088 TOP.t1894 VSUBS 2.24628f
C1089 TOP.t1896 VSUBS 2.24628f
C1090 TOP.t1898 VSUBS 2.24628f
C1091 TOP.t1900 VSUBS 2.24628f
C1092 TOP.t1902 VSUBS 2.24628f
C1093 TOP.t1904 VSUBS 1.83284f
C1094 TOP.n5 VSUBS 0.548f
C1095 TOP.t6 VSUBS 2.66056f
C1096 TOP.t1906 VSUBS 2.46629f
C1097 TOP.t1908 VSUBS 2.24628f
C1098 TOP.t1910 VSUBS 2.24628f
C1099 TOP.t1912 VSUBS 2.24628f
C1100 TOP.t1914 VSUBS 2.24628f
C1101 TOP.t1916 VSUBS 2.24628f
C1102 TOP.t1918 VSUBS 2.24628f
C1103 TOP.t1920 VSUBS 2.24628f
C1104 TOP.t1922 VSUBS 2.24628f
C1105 TOP.t1924 VSUBS 2.24628f
C1106 TOP.t1926 VSUBS 2.24628f
C1107 TOP.t1928 VSUBS 2.24628f
C1108 TOP.t1930 VSUBS 2.24628f
C1109 TOP.t1932 VSUBS 2.24628f
C1110 TOP.t1934 VSUBS 2.24628f
C1111 TOP.t1936 VSUBS 2.24628f
C1112 TOP.t1938 VSUBS 2.24628f
C1113 TOP.t1940 VSUBS 2.24628f
C1114 TOP.t1942 VSUBS 2.24628f
C1115 TOP.t1944 VSUBS 2.24628f
C1116 TOP.t1946 VSUBS 2.24628f
C1117 TOP.t1948 VSUBS 2.24628f
C1118 TOP.t1950 VSUBS 2.24628f
C1119 TOP.t1952 VSUBS 2.24628f
C1120 TOP.t1954 VSUBS 2.24628f
C1121 TOP.t1956 VSUBS 2.24628f
C1122 TOP.t1958 VSUBS 2.24628f
C1123 TOP.t1960 VSUBS 2.24628f
C1124 TOP.t1962 VSUBS 2.24628f
C1125 TOP.t1964 VSUBS 2.24628f
C1126 TOP.t1966 VSUBS 2.24628f
C1127 TOP.t1968 VSUBS 2.24628f
C1128 TOP.t1970 VSUBS 2.24628f
C1129 TOP.t1972 VSUBS 2.24628f
C1130 TOP.t1974 VSUBS 2.24628f
C1131 TOP.t1976 VSUBS 2.24628f
C1132 TOP.t1978 VSUBS 2.24628f
C1133 TOP.t1980 VSUBS 2.24628f
C1134 TOP.t1982 VSUBS 2.24628f
C1135 TOP.t1984 VSUBS 2.24628f
C1136 TOP.t1986 VSUBS 2.24628f
C1137 TOP.t1988 VSUBS 2.24628f
C1138 TOP.t1990 VSUBS 2.24628f
C1139 TOP.t1992 VSUBS 2.24628f
C1140 TOP.t1994 VSUBS 2.24628f
C1141 TOP.t1996 VSUBS 2.24628f
C1142 TOP.t1998 VSUBS 2.24628f
C1143 TOP.t2000 VSUBS 2.24628f
C1144 TOP.t2002 VSUBS 2.24628f
C1145 TOP.t2004 VSUBS 2.24628f
C1146 TOP.t2006 VSUBS 2.24628f
C1147 TOP.t2008 VSUBS 2.24628f
C1148 TOP.t2010 VSUBS 2.24628f
C1149 TOP.t2012 VSUBS 2.24628f
C1150 TOP.t2014 VSUBS 2.24628f
C1151 TOP.t2016 VSUBS 2.24628f
C1152 TOP.t2018 VSUBS 2.24628f
C1153 TOP.t2020 VSUBS 2.24628f
C1154 TOP.t2022 VSUBS 2.24628f
C1155 TOP.t2024 VSUBS 2.24628f
C1156 TOP.t2026 VSUBS 2.24628f
C1157 TOP.t2028 VSUBS 2.24628f
C1158 TOP.t2030 VSUBS 1.83284f
C1159 TOP.n6 VSUBS 0.548f
C1160 TOP.t5248 VSUBS 2.68639f
C1161 TOP.t2032 VSUBS 2.46629f
C1162 TOP.t2034 VSUBS 2.24628f
C1163 TOP.t2036 VSUBS 2.24628f
C1164 TOP.t2038 VSUBS 2.24628f
C1165 TOP.t2040 VSUBS 2.24628f
C1166 TOP.t2042 VSUBS 2.24628f
C1167 TOP.t2044 VSUBS 2.24628f
C1168 TOP.t2046 VSUBS 2.24628f
C1169 TOP.t2048 VSUBS 2.24628f
C1170 TOP.t2050 VSUBS 2.24628f
C1171 TOP.t2052 VSUBS 2.24628f
C1172 TOP.t2054 VSUBS 2.24628f
C1173 TOP.t2056 VSUBS 2.24628f
C1174 TOP.t2058 VSUBS 2.24628f
C1175 TOP.t2060 VSUBS 2.24628f
C1176 TOP.t2062 VSUBS 2.24628f
C1177 TOP.t2064 VSUBS 2.24628f
C1178 TOP.t2066 VSUBS 2.24628f
C1179 TOP.t2068 VSUBS 2.24628f
C1180 TOP.t2070 VSUBS 2.24628f
C1181 TOP.t2072 VSUBS 2.24628f
C1182 TOP.t2074 VSUBS 2.24628f
C1183 TOP.t2076 VSUBS 2.24628f
C1184 TOP.t2078 VSUBS 2.24628f
C1185 TOP.t2080 VSUBS 2.24628f
C1186 TOP.t2082 VSUBS 2.24628f
C1187 TOP.t2084 VSUBS 2.24628f
C1188 TOP.t2086 VSUBS 2.24628f
C1189 TOP.t2088 VSUBS 2.24628f
C1190 TOP.t2090 VSUBS 2.24628f
C1191 TOP.t2092 VSUBS 2.24628f
C1192 TOP.t2094 VSUBS 2.24628f
C1193 TOP.t2096 VSUBS 2.24628f
C1194 TOP.t2098 VSUBS 2.24628f
C1195 TOP.t2100 VSUBS 2.24628f
C1196 TOP.t2102 VSUBS 2.24628f
C1197 TOP.t2104 VSUBS 2.24628f
C1198 TOP.t2106 VSUBS 2.24628f
C1199 TOP.t2108 VSUBS 2.24628f
C1200 TOP.t2110 VSUBS 2.24628f
C1201 TOP.t2112 VSUBS 2.24628f
C1202 TOP.t2114 VSUBS 2.24628f
C1203 TOP.t2116 VSUBS 2.24628f
C1204 TOP.t2118 VSUBS 2.24628f
C1205 TOP.t2120 VSUBS 2.24628f
C1206 TOP.t2122 VSUBS 2.24628f
C1207 TOP.t2124 VSUBS 2.24628f
C1208 TOP.t2126 VSUBS 2.24628f
C1209 TOP.t2128 VSUBS 2.24628f
C1210 TOP.t2130 VSUBS 2.24628f
C1211 TOP.t2132 VSUBS 2.24628f
C1212 TOP.t2134 VSUBS 2.24628f
C1213 TOP.t2136 VSUBS 2.24628f
C1214 TOP.t2138 VSUBS 2.24628f
C1215 TOP.t2140 VSUBS 2.24628f
C1216 TOP.t2142 VSUBS 2.24628f
C1217 TOP.t2144 VSUBS 2.24628f
C1218 TOP.t2146 VSUBS 2.24628f
C1219 TOP.t2148 VSUBS 2.24628f
C1220 TOP.t2150 VSUBS 2.24628f
C1221 TOP.t2152 VSUBS 2.24628f
C1222 TOP.t2154 VSUBS 2.24628f
C1223 TOP.t2156 VSUBS 1.83284f
C1224 TOP.n7 VSUBS 0.548f
C1225 TOP.t5250 VSUBS 2.68639f
C1226 TOP.t2158 VSUBS 2.46629f
C1227 TOP.t2160 VSUBS 2.24628f
C1228 TOP.t2162 VSUBS 2.24628f
C1229 TOP.t2164 VSUBS 2.24628f
C1230 TOP.t2166 VSUBS 2.24628f
C1231 TOP.t2168 VSUBS 2.24628f
C1232 TOP.t2170 VSUBS 2.24628f
C1233 TOP.t2172 VSUBS 2.24628f
C1234 TOP.t2174 VSUBS 2.24628f
C1235 TOP.t2176 VSUBS 2.24628f
C1236 TOP.t2178 VSUBS 2.24628f
C1237 TOP.t2180 VSUBS 2.24628f
C1238 TOP.t2182 VSUBS 2.24628f
C1239 TOP.t2184 VSUBS 2.24628f
C1240 TOP.t2186 VSUBS 2.24628f
C1241 TOP.t2188 VSUBS 2.24628f
C1242 TOP.t2190 VSUBS 2.24628f
C1243 TOP.t2192 VSUBS 2.24628f
C1244 TOP.t2194 VSUBS 2.24628f
C1245 TOP.t2196 VSUBS 2.24628f
C1246 TOP.t2198 VSUBS 2.24628f
C1247 TOP.t2200 VSUBS 2.24628f
C1248 TOP.t2202 VSUBS 2.24628f
C1249 TOP.t2204 VSUBS 2.24628f
C1250 TOP.t2206 VSUBS 2.24628f
C1251 TOP.t2208 VSUBS 2.24628f
C1252 TOP.t2210 VSUBS 2.24628f
C1253 TOP.t2212 VSUBS 2.24628f
C1254 TOP.t2214 VSUBS 2.24628f
C1255 TOP.t2216 VSUBS 2.24628f
C1256 TOP.t2218 VSUBS 2.24628f
C1257 TOP.t2220 VSUBS 2.24628f
C1258 TOP.t2222 VSUBS 2.24628f
C1259 TOP.t2224 VSUBS 2.24628f
C1260 TOP.t2226 VSUBS 2.24628f
C1261 TOP.t2228 VSUBS 2.24628f
C1262 TOP.t2230 VSUBS 2.24628f
C1263 TOP.t2232 VSUBS 2.24628f
C1264 TOP.t2234 VSUBS 2.24628f
C1265 TOP.t2236 VSUBS 2.24628f
C1266 TOP.t2238 VSUBS 2.24628f
C1267 TOP.t2240 VSUBS 2.24628f
C1268 TOP.t2242 VSUBS 2.24628f
C1269 TOP.t2244 VSUBS 2.24628f
C1270 TOP.t2246 VSUBS 2.24628f
C1271 TOP.t2248 VSUBS 2.24628f
C1272 TOP.t2250 VSUBS 2.24628f
C1273 TOP.t2252 VSUBS 2.24628f
C1274 TOP.t2254 VSUBS 2.24628f
C1275 TOP.t2256 VSUBS 2.24628f
C1276 TOP.t2258 VSUBS 2.24628f
C1277 TOP.t2260 VSUBS 2.24628f
C1278 TOP.t2262 VSUBS 2.24628f
C1279 TOP.t2264 VSUBS 2.24628f
C1280 TOP.t2266 VSUBS 2.24628f
C1281 TOP.t2268 VSUBS 2.24628f
C1282 TOP.t2270 VSUBS 2.24628f
C1283 TOP.t2272 VSUBS 2.24628f
C1284 TOP.t2274 VSUBS 2.24628f
C1285 TOP.t2276 VSUBS 2.24628f
C1286 TOP.t2278 VSUBS 2.24628f
C1287 TOP.t2280 VSUBS 2.24628f
C1288 TOP.t2282 VSUBS 1.83284f
C1289 TOP.n8 VSUBS 0.548f
C1290 TOP.t5252 VSUBS 2.68639f
C1291 TOP.t2284 VSUBS 2.46629f
C1292 TOP.t2286 VSUBS 2.24628f
C1293 TOP.t2288 VSUBS 2.24628f
C1294 TOP.t2290 VSUBS 2.24628f
C1295 TOP.t2292 VSUBS 2.24628f
C1296 TOP.t2294 VSUBS 2.24628f
C1297 TOP.t2296 VSUBS 2.24628f
C1298 TOP.t2298 VSUBS 2.24628f
C1299 TOP.t2300 VSUBS 2.24628f
C1300 TOP.t2302 VSUBS 2.24628f
C1301 TOP.t2304 VSUBS 2.24628f
C1302 TOP.t2306 VSUBS 2.24628f
C1303 TOP.t2308 VSUBS 2.24628f
C1304 TOP.t2310 VSUBS 2.24628f
C1305 TOP.t2312 VSUBS 2.24628f
C1306 TOP.t2314 VSUBS 2.24628f
C1307 TOP.t2316 VSUBS 2.24628f
C1308 TOP.t2318 VSUBS 2.24628f
C1309 TOP.t2320 VSUBS 2.24628f
C1310 TOP.t2322 VSUBS 2.24628f
C1311 TOP.t2324 VSUBS 2.24628f
C1312 TOP.t2326 VSUBS 2.24628f
C1313 TOP.t2328 VSUBS 2.24628f
C1314 TOP.t2330 VSUBS 2.24628f
C1315 TOP.t2332 VSUBS 2.24628f
C1316 TOP.t2334 VSUBS 2.24628f
C1317 TOP.t2336 VSUBS 2.24628f
C1318 TOP.t2338 VSUBS 2.24628f
C1319 TOP.t2340 VSUBS 2.24628f
C1320 TOP.t2342 VSUBS 2.24628f
C1321 TOP.t2344 VSUBS 2.24628f
C1322 TOP.t2346 VSUBS 2.24628f
C1323 TOP.t2348 VSUBS 2.24628f
C1324 TOP.t2350 VSUBS 2.24628f
C1325 TOP.t2352 VSUBS 2.24628f
C1326 TOP.t2354 VSUBS 2.24628f
C1327 TOP.t2356 VSUBS 2.24628f
C1328 TOP.t2358 VSUBS 2.24628f
C1329 TOP.t2360 VSUBS 2.24628f
C1330 TOP.t2362 VSUBS 2.24628f
C1331 TOP.t2364 VSUBS 2.24628f
C1332 TOP.t2366 VSUBS 2.24628f
C1333 TOP.t2368 VSUBS 2.24628f
C1334 TOP.t2370 VSUBS 2.24628f
C1335 TOP.t2372 VSUBS 2.24628f
C1336 TOP.t2374 VSUBS 2.24628f
C1337 TOP.t2376 VSUBS 2.24628f
C1338 TOP.t2378 VSUBS 2.24628f
C1339 TOP.t2380 VSUBS 2.24628f
C1340 TOP.t2382 VSUBS 2.24628f
C1341 TOP.t2384 VSUBS 2.24628f
C1342 TOP.t2386 VSUBS 2.24628f
C1343 TOP.t2388 VSUBS 2.24628f
C1344 TOP.t2390 VSUBS 2.24628f
C1345 TOP.t2392 VSUBS 2.24628f
C1346 TOP.t2394 VSUBS 2.24628f
C1347 TOP.t2396 VSUBS 2.24628f
C1348 TOP.t2398 VSUBS 2.24628f
C1349 TOP.t2400 VSUBS 2.24628f
C1350 TOP.t2402 VSUBS 2.24628f
C1351 TOP.t2404 VSUBS 2.24628f
C1352 TOP.t2406 VSUBS 2.24628f
C1353 TOP.t2408 VSUBS 1.83284f
C1354 TOP.n9 VSUBS 0.548f
C1355 TOP.t5254 VSUBS 2.68639f
C1356 TOP.t2410 VSUBS 2.46629f
C1357 TOP.t2412 VSUBS 2.24628f
C1358 TOP.t2414 VSUBS 2.24628f
C1359 TOP.t2416 VSUBS 2.24628f
C1360 TOP.t2418 VSUBS 2.24628f
C1361 TOP.t2420 VSUBS 2.24628f
C1362 TOP.t2422 VSUBS 2.24628f
C1363 TOP.t2424 VSUBS 2.24628f
C1364 TOP.t2426 VSUBS 2.24628f
C1365 TOP.t2428 VSUBS 2.24628f
C1366 TOP.t2430 VSUBS 2.24628f
C1367 TOP.t2432 VSUBS 2.24628f
C1368 TOP.t2434 VSUBS 2.24628f
C1369 TOP.t2436 VSUBS 2.24628f
C1370 TOP.t2438 VSUBS 2.24628f
C1371 TOP.t2440 VSUBS 2.24628f
C1372 TOP.t2442 VSUBS 2.24628f
C1373 TOP.t2444 VSUBS 2.24628f
C1374 TOP.t2446 VSUBS 2.24628f
C1375 TOP.t2448 VSUBS 2.24628f
C1376 TOP.t2450 VSUBS 2.24628f
C1377 TOP.t2452 VSUBS 2.24628f
C1378 TOP.t2454 VSUBS 2.24628f
C1379 TOP.t2456 VSUBS 2.24628f
C1380 TOP.t2458 VSUBS 2.24628f
C1381 TOP.t2460 VSUBS 2.24628f
C1382 TOP.t2462 VSUBS 2.24628f
C1383 TOP.t2464 VSUBS 2.24628f
C1384 TOP.t2466 VSUBS 2.24628f
C1385 TOP.t2468 VSUBS 2.24628f
C1386 TOP.t2470 VSUBS 2.24628f
C1387 TOP.t2472 VSUBS 2.24628f
C1388 TOP.t2474 VSUBS 2.24628f
C1389 TOP.t2476 VSUBS 2.24628f
C1390 TOP.t2478 VSUBS 2.24628f
C1391 TOP.t2480 VSUBS 2.24628f
C1392 TOP.t2482 VSUBS 2.24628f
C1393 TOP.t2484 VSUBS 2.24628f
C1394 TOP.t2486 VSUBS 2.24628f
C1395 TOP.t2488 VSUBS 2.24628f
C1396 TOP.t2490 VSUBS 2.24628f
C1397 TOP.t2492 VSUBS 2.24628f
C1398 TOP.t2494 VSUBS 2.24628f
C1399 TOP.t2496 VSUBS 2.24628f
C1400 TOP.t2498 VSUBS 2.24628f
C1401 TOP.t2500 VSUBS 2.24628f
C1402 TOP.t2502 VSUBS 2.24628f
C1403 TOP.t2504 VSUBS 2.24628f
C1404 TOP.t2506 VSUBS 2.24628f
C1405 TOP.t2508 VSUBS 2.24628f
C1406 TOP.t2510 VSUBS 2.24628f
C1407 TOP.t2512 VSUBS 2.24628f
C1408 TOP.t2514 VSUBS 2.24628f
C1409 TOP.t2516 VSUBS 2.24628f
C1410 TOP.t2518 VSUBS 2.24628f
C1411 TOP.t2520 VSUBS 2.24628f
C1412 TOP.t2522 VSUBS 2.24628f
C1413 TOP.t2524 VSUBS 2.24628f
C1414 TOP.t2526 VSUBS 2.24628f
C1415 TOP.t2528 VSUBS 2.24628f
C1416 TOP.t2530 VSUBS 2.24628f
C1417 TOP.t2532 VSUBS 2.24628f
C1418 TOP.t2534 VSUBS 1.83284f
C1419 TOP.n10 VSUBS 0.548f
C1420 TOP.t5256 VSUBS 2.68639f
C1421 TOP.t2536 VSUBS 2.46629f
C1422 TOP.t2538 VSUBS 2.24628f
C1423 TOP.t2540 VSUBS 2.24628f
C1424 TOP.t2542 VSUBS 2.24628f
C1425 TOP.t2544 VSUBS 2.24628f
C1426 TOP.t2546 VSUBS 2.24628f
C1427 TOP.t2548 VSUBS 2.24628f
C1428 TOP.t2550 VSUBS 2.24628f
C1429 TOP.t2552 VSUBS 2.24628f
C1430 TOP.t2554 VSUBS 2.24628f
C1431 TOP.t2556 VSUBS 2.24628f
C1432 TOP.t2558 VSUBS 2.24628f
C1433 TOP.t2560 VSUBS 2.24628f
C1434 TOP.t2562 VSUBS 2.24628f
C1435 TOP.t2564 VSUBS 2.24628f
C1436 TOP.t2566 VSUBS 2.24628f
C1437 TOP.t2568 VSUBS 2.24628f
C1438 TOP.t2570 VSUBS 2.24628f
C1439 TOP.t2572 VSUBS 2.24628f
C1440 TOP.t2574 VSUBS 2.24628f
C1441 TOP.t2576 VSUBS 2.24628f
C1442 TOP.t2578 VSUBS 2.24628f
C1443 TOP.t2580 VSUBS 2.24628f
C1444 TOP.t2582 VSUBS 2.24628f
C1445 TOP.t2584 VSUBS 2.24628f
C1446 TOP.t2586 VSUBS 2.24628f
C1447 TOP.t2588 VSUBS 2.24628f
C1448 TOP.t2590 VSUBS 2.24628f
C1449 TOP.t2592 VSUBS 2.24628f
C1450 TOP.t2594 VSUBS 2.24628f
C1451 TOP.t2596 VSUBS 2.24628f
C1452 TOP.t2598 VSUBS 2.24628f
C1453 TOP.t2600 VSUBS 2.24628f
C1454 TOP.t2602 VSUBS 2.24628f
C1455 TOP.t2604 VSUBS 2.24628f
C1456 TOP.t2606 VSUBS 2.24628f
C1457 TOP.t2608 VSUBS 2.24628f
C1458 TOP.t2610 VSUBS 2.24628f
C1459 TOP.t2612 VSUBS 2.24628f
C1460 TOP.t2614 VSUBS 2.24628f
C1461 TOP.t2616 VSUBS 2.24628f
C1462 TOP.t2618 VSUBS 2.24628f
C1463 TOP.t2620 VSUBS 2.24628f
C1464 TOP.t2622 VSUBS 2.24628f
C1465 TOP.t2624 VSUBS 2.24628f
C1466 TOP.t2626 VSUBS 2.24628f
C1467 TOP.t2628 VSUBS 2.24628f
C1468 TOP.t2630 VSUBS 2.24628f
C1469 TOP.t2632 VSUBS 2.24628f
C1470 TOP.t2634 VSUBS 2.24628f
C1471 TOP.t2636 VSUBS 2.24628f
C1472 TOP.t2638 VSUBS 2.24628f
C1473 TOP.t2640 VSUBS 2.24628f
C1474 TOP.t2642 VSUBS 2.24628f
C1475 TOP.t2644 VSUBS 2.24628f
C1476 TOP.t2646 VSUBS 2.24628f
C1477 TOP.t2648 VSUBS 2.24628f
C1478 TOP.t2650 VSUBS 2.24628f
C1479 TOP.t2652 VSUBS 2.24628f
C1480 TOP.t2654 VSUBS 2.24628f
C1481 TOP.t2656 VSUBS 2.24628f
C1482 TOP.t2658 VSUBS 2.24628f
C1483 TOP.t2660 VSUBS 1.83284f
C1484 TOP.n11 VSUBS 0.548f
C1485 TOP.t5258 VSUBS 2.68639f
C1486 TOP.t2662 VSUBS 2.46629f
C1487 TOP.t2664 VSUBS 2.24628f
C1488 TOP.t2666 VSUBS 2.24628f
C1489 TOP.t2668 VSUBS 2.24628f
C1490 TOP.t2670 VSUBS 2.24628f
C1491 TOP.t2672 VSUBS 2.24628f
C1492 TOP.t2674 VSUBS 2.24628f
C1493 TOP.t2676 VSUBS 2.24628f
C1494 TOP.t2678 VSUBS 2.24628f
C1495 TOP.t2680 VSUBS 2.24628f
C1496 TOP.t2682 VSUBS 2.24628f
C1497 TOP.t2684 VSUBS 2.24628f
C1498 TOP.t2686 VSUBS 2.24628f
C1499 TOP.t2688 VSUBS 2.24628f
C1500 TOP.t2690 VSUBS 2.24628f
C1501 TOP.t2692 VSUBS 2.24628f
C1502 TOP.t2694 VSUBS 2.24628f
C1503 TOP.t2696 VSUBS 2.24628f
C1504 TOP.t2698 VSUBS 2.24628f
C1505 TOP.t2700 VSUBS 2.24628f
C1506 TOP.t2702 VSUBS 2.24628f
C1507 TOP.t2704 VSUBS 2.24628f
C1508 TOP.t2706 VSUBS 2.24628f
C1509 TOP.t2708 VSUBS 2.24628f
C1510 TOP.t2710 VSUBS 2.24628f
C1511 TOP.t2712 VSUBS 2.24628f
C1512 TOP.t2714 VSUBS 2.24628f
C1513 TOP.t2716 VSUBS 2.24628f
C1514 TOP.t2718 VSUBS 2.24628f
C1515 TOP.t2720 VSUBS 2.24628f
C1516 TOP.t2722 VSUBS 2.24628f
C1517 TOP.t2724 VSUBS 2.24628f
C1518 TOP.t2726 VSUBS 2.24628f
C1519 TOP.t2728 VSUBS 2.24628f
C1520 TOP.t2730 VSUBS 2.24628f
C1521 TOP.t2732 VSUBS 2.24628f
C1522 TOP.t2734 VSUBS 2.24628f
C1523 TOP.t2736 VSUBS 2.24628f
C1524 TOP.t2738 VSUBS 2.24628f
C1525 TOP.t2740 VSUBS 2.24628f
C1526 TOP.t2742 VSUBS 2.24628f
C1527 TOP.t2744 VSUBS 2.24628f
C1528 TOP.t2746 VSUBS 2.24628f
C1529 TOP.t2748 VSUBS 2.24628f
C1530 TOP.t2750 VSUBS 2.24628f
C1531 TOP.t2752 VSUBS 2.24628f
C1532 TOP.t2754 VSUBS 2.24628f
C1533 TOP.t2756 VSUBS 2.24628f
C1534 TOP.t2758 VSUBS 2.24628f
C1535 TOP.t2760 VSUBS 2.24628f
C1536 TOP.t2762 VSUBS 2.24628f
C1537 TOP.t2764 VSUBS 2.24628f
C1538 TOP.t2766 VSUBS 2.24628f
C1539 TOP.t2768 VSUBS 2.24628f
C1540 TOP.t2770 VSUBS 2.24628f
C1541 TOP.t2772 VSUBS 2.24628f
C1542 TOP.t2774 VSUBS 2.24628f
C1543 TOP.t2776 VSUBS 2.24628f
C1544 TOP.t2778 VSUBS 2.24628f
C1545 TOP.t2780 VSUBS 2.24628f
C1546 TOP.t2782 VSUBS 2.24628f
C1547 TOP.t2784 VSUBS 2.24628f
C1548 TOP.t2786 VSUBS 1.83284f
C1549 TOP.n12 VSUBS 0.548f
C1550 TOP.t5260 VSUBS 2.68639f
C1551 TOP.t2788 VSUBS 2.46629f
C1552 TOP.t2790 VSUBS 2.24628f
C1553 TOP.t2792 VSUBS 2.24628f
C1554 TOP.t2794 VSUBS 2.24628f
C1555 TOP.t2796 VSUBS 2.24628f
C1556 TOP.t2798 VSUBS 2.24628f
C1557 TOP.t2800 VSUBS 2.24628f
C1558 TOP.t2802 VSUBS 2.24628f
C1559 TOP.t2804 VSUBS 2.24628f
C1560 TOP.t2806 VSUBS 2.24628f
C1561 TOP.t2808 VSUBS 2.24628f
C1562 TOP.t2810 VSUBS 2.24628f
C1563 TOP.t2812 VSUBS 2.24628f
C1564 TOP.t2814 VSUBS 2.24628f
C1565 TOP.t2816 VSUBS 2.24628f
C1566 TOP.t2818 VSUBS 2.24628f
C1567 TOP.t2820 VSUBS 2.24628f
C1568 TOP.t2822 VSUBS 2.24628f
C1569 TOP.t2824 VSUBS 2.24628f
C1570 TOP.t2826 VSUBS 2.24628f
C1571 TOP.t2828 VSUBS 2.24628f
C1572 TOP.t2830 VSUBS 2.24628f
C1573 TOP.t2832 VSUBS 2.24628f
C1574 TOP.t2834 VSUBS 2.24628f
C1575 TOP.t2836 VSUBS 2.24628f
C1576 TOP.t2838 VSUBS 2.24628f
C1577 TOP.t2840 VSUBS 2.24628f
C1578 TOP.t2842 VSUBS 2.24628f
C1579 TOP.t2844 VSUBS 2.24628f
C1580 TOP.t2846 VSUBS 2.24628f
C1581 TOP.t2848 VSUBS 2.24628f
C1582 TOP.t2850 VSUBS 2.24628f
C1583 TOP.t2852 VSUBS 2.24628f
C1584 TOP.t2854 VSUBS 2.24628f
C1585 TOP.t2856 VSUBS 2.24628f
C1586 TOP.t2858 VSUBS 2.24628f
C1587 TOP.t2860 VSUBS 2.24628f
C1588 TOP.t2862 VSUBS 2.24628f
C1589 TOP.t2864 VSUBS 2.24628f
C1590 TOP.t2866 VSUBS 2.24628f
C1591 TOP.t2868 VSUBS 2.24628f
C1592 TOP.t2870 VSUBS 2.24628f
C1593 TOP.t2872 VSUBS 2.24628f
C1594 TOP.t2874 VSUBS 2.24628f
C1595 TOP.t2876 VSUBS 2.24628f
C1596 TOP.t2878 VSUBS 2.24628f
C1597 TOP.t2880 VSUBS 2.24628f
C1598 TOP.t2882 VSUBS 2.24628f
C1599 TOP.t2884 VSUBS 2.24628f
C1600 TOP.t2886 VSUBS 2.24628f
C1601 TOP.t2888 VSUBS 2.24628f
C1602 TOP.t2890 VSUBS 2.24628f
C1603 TOP.t2892 VSUBS 2.24628f
C1604 TOP.t2894 VSUBS 2.24628f
C1605 TOP.t2896 VSUBS 2.24628f
C1606 TOP.t2898 VSUBS 2.24628f
C1607 TOP.t2900 VSUBS 2.24628f
C1608 TOP.t2902 VSUBS 2.24628f
C1609 TOP.t2904 VSUBS 2.24628f
C1610 TOP.t2906 VSUBS 2.24628f
C1611 TOP.t2908 VSUBS 2.24628f
C1612 TOP.t2910 VSUBS 2.24628f
C1613 TOP.t2912 VSUBS 1.83284f
C1614 TOP.n13 VSUBS 0.548f
C1615 TOP.t5262 VSUBS 2.68639f
C1616 TOP.t2914 VSUBS 2.46629f
C1617 TOP.t2916 VSUBS 2.24628f
C1618 TOP.t2918 VSUBS 2.24628f
C1619 TOP.t2920 VSUBS 2.24628f
C1620 TOP.t2922 VSUBS 2.24628f
C1621 TOP.t2924 VSUBS 2.24628f
C1622 TOP.t2926 VSUBS 2.24628f
C1623 TOP.t2928 VSUBS 2.24628f
C1624 TOP.t2930 VSUBS 2.24628f
C1625 TOP.t2932 VSUBS 2.24628f
C1626 TOP.t2934 VSUBS 2.24628f
C1627 TOP.t2936 VSUBS 2.24628f
C1628 TOP.t2938 VSUBS 2.24628f
C1629 TOP.t2940 VSUBS 2.24628f
C1630 TOP.t2942 VSUBS 2.24628f
C1631 TOP.t2944 VSUBS 2.24628f
C1632 TOP.t2946 VSUBS 2.24628f
C1633 TOP.t2948 VSUBS 2.24628f
C1634 TOP.t2950 VSUBS 2.24628f
C1635 TOP.t2952 VSUBS 2.24628f
C1636 TOP.t2954 VSUBS 2.24628f
C1637 TOP.t2956 VSUBS 2.24628f
C1638 TOP.t2958 VSUBS 2.24628f
C1639 TOP.t2960 VSUBS 2.24628f
C1640 TOP.t2962 VSUBS 2.24628f
C1641 TOP.t2964 VSUBS 2.24628f
C1642 TOP.t2966 VSUBS 2.24628f
C1643 TOP.t2968 VSUBS 2.24628f
C1644 TOP.t2970 VSUBS 2.24628f
C1645 TOP.t2972 VSUBS 2.24628f
C1646 TOP.t2974 VSUBS 2.24628f
C1647 TOP.t2976 VSUBS 2.24628f
C1648 TOP.t2978 VSUBS 2.24628f
C1649 TOP.t2980 VSUBS 2.24628f
C1650 TOP.t2982 VSUBS 2.24628f
C1651 TOP.t2984 VSUBS 2.24628f
C1652 TOP.t2986 VSUBS 2.24628f
C1653 TOP.t2988 VSUBS 2.24628f
C1654 TOP.t2990 VSUBS 2.24628f
C1655 TOP.t2992 VSUBS 2.24628f
C1656 TOP.t2994 VSUBS 2.24628f
C1657 TOP.t2996 VSUBS 2.24628f
C1658 TOP.t2998 VSUBS 2.24628f
C1659 TOP.t3000 VSUBS 2.24628f
C1660 TOP.t3002 VSUBS 2.24628f
C1661 TOP.t3004 VSUBS 2.24628f
C1662 TOP.t3006 VSUBS 2.24628f
C1663 TOP.t3008 VSUBS 2.24628f
C1664 TOP.t3010 VSUBS 2.24628f
C1665 TOP.t3012 VSUBS 2.24628f
C1666 TOP.t3014 VSUBS 2.24628f
C1667 TOP.t3016 VSUBS 2.24628f
C1668 TOP.t3018 VSUBS 2.24628f
C1669 TOP.t3020 VSUBS 2.24628f
C1670 TOP.t3022 VSUBS 2.24628f
C1671 TOP.t3024 VSUBS 2.24628f
C1672 TOP.t3026 VSUBS 2.24628f
C1673 TOP.t3028 VSUBS 2.24628f
C1674 TOP.t3030 VSUBS 2.24628f
C1675 TOP.t3032 VSUBS 2.24628f
C1676 TOP.t3034 VSUBS 2.24628f
C1677 TOP.t3036 VSUBS 2.24628f
C1678 TOP.t3038 VSUBS 1.83284f
C1679 TOP.n14 VSUBS 0.548f
C1680 TOP.t3040 VSUBS 2.70561f
C1681 TOP.t5264 VSUBS 2.48846f
C1682 TOP.t5266 VSUBS 2.26428f
C1683 TOP.t5268 VSUBS 2.26428f
C1684 TOP.t5270 VSUBS 2.26428f
C1685 TOP.t5272 VSUBS 2.26428f
C1686 TOP.t5274 VSUBS 2.26428f
C1687 TOP.t5276 VSUBS 2.26428f
C1688 TOP.t5278 VSUBS 2.26428f
C1689 TOP.t5280 VSUBS 2.26428f
C1690 TOP.t5282 VSUBS 2.26428f
C1691 TOP.t5284 VSUBS 2.26428f
C1692 TOP.t5286 VSUBS 2.26428f
C1693 TOP.t5288 VSUBS 2.26428f
C1694 TOP.t5290 VSUBS 2.26428f
C1695 TOP.t5292 VSUBS 2.26428f
C1696 TOP.t5294 VSUBS 2.26428f
C1697 TOP.t5296 VSUBS 2.26428f
C1698 TOP.t5298 VSUBS 2.26428f
C1699 TOP.t5300 VSUBS 2.26428f
C1700 TOP.t5302 VSUBS 2.26428f
C1701 TOP.t5304 VSUBS 2.26428f
C1702 TOP.t5306 VSUBS 2.26428f
C1703 TOP.t5308 VSUBS 2.26428f
C1704 TOP.t5310 VSUBS 2.26428f
C1705 TOP.t5312 VSUBS 2.26428f
C1706 TOP.t5314 VSUBS 2.26428f
C1707 TOP.t5316 VSUBS 2.26428f
C1708 TOP.t5318 VSUBS 2.26428f
C1709 TOP.t5320 VSUBS 2.26428f
C1710 TOP.t5322 VSUBS 2.26428f
C1711 TOP.t5324 VSUBS 2.26428f
C1712 TOP.t5326 VSUBS 2.26428f
C1713 TOP.t5328 VSUBS 2.26428f
C1714 TOP.t5330 VSUBS 2.26428f
C1715 TOP.t5332 VSUBS 2.26428f
C1716 TOP.t5334 VSUBS 2.26428f
C1717 TOP.t5336 VSUBS 2.26428f
C1718 TOP.t5338 VSUBS 2.26428f
C1719 TOP.t5340 VSUBS 2.26428f
C1720 TOP.t5342 VSUBS 2.26428f
C1721 TOP.t5344 VSUBS 2.26428f
C1722 TOP.t5346 VSUBS 2.26428f
C1723 TOP.t5348 VSUBS 2.26428f
C1724 TOP.t5350 VSUBS 2.26428f
C1725 TOP.t5352 VSUBS 2.26428f
C1726 TOP.t5354 VSUBS 2.26428f
C1727 TOP.t5356 VSUBS 2.26428f
C1728 TOP.t5358 VSUBS 2.26428f
C1729 TOP.t5360 VSUBS 2.26428f
C1730 TOP.t5362 VSUBS 2.26428f
C1731 TOP.t5364 VSUBS 2.26428f
C1732 TOP.t5366 VSUBS 2.26428f
C1733 TOP.t5368 VSUBS 2.26428f
C1734 TOP.t5370 VSUBS 2.26428f
C1735 TOP.t5372 VSUBS 2.26428f
C1736 TOP.t5374 VSUBS 2.26428f
C1737 TOP.t5376 VSUBS 2.26428f
C1738 TOP.t5378 VSUBS 2.26428f
C1739 TOP.t5380 VSUBS 2.26428f
C1740 TOP.t5382 VSUBS 2.26428f
C1741 TOP.t5384 VSUBS 2.26428f
C1742 TOP.t5386 VSUBS 2.26428f
C1743 TOP.t5388 VSUBS 1.85085f
C1744 TOP.n15 VSUBS 0.548f
C1745 TOP.t3042 VSUBS 2.70561f
C1746 TOP.t5390 VSUBS 2.48846f
C1747 TOP.t5392 VSUBS 2.26428f
C1748 TOP.t5394 VSUBS 2.26428f
C1749 TOP.t5396 VSUBS 2.26428f
C1750 TOP.t5398 VSUBS 2.26428f
C1751 TOP.t5400 VSUBS 2.26428f
C1752 TOP.t5402 VSUBS 2.26428f
C1753 TOP.t5404 VSUBS 2.26428f
C1754 TOP.t5406 VSUBS 2.26428f
C1755 TOP.t5408 VSUBS 2.26428f
C1756 TOP.t5410 VSUBS 2.26428f
C1757 TOP.t5412 VSUBS 2.26428f
C1758 TOP.t5414 VSUBS 2.26428f
C1759 TOP.t5416 VSUBS 2.26428f
C1760 TOP.t5418 VSUBS 2.26428f
C1761 TOP.t5420 VSUBS 2.26428f
C1762 TOP.t5422 VSUBS 2.26428f
C1763 TOP.t5424 VSUBS 2.26428f
C1764 TOP.t5426 VSUBS 2.26428f
C1765 TOP.t5428 VSUBS 2.26428f
C1766 TOP.t5430 VSUBS 2.26428f
C1767 TOP.t5432 VSUBS 2.26428f
C1768 TOP.t5434 VSUBS 2.26428f
C1769 TOP.t5436 VSUBS 2.26428f
C1770 TOP.t5438 VSUBS 2.26428f
C1771 TOP.t5440 VSUBS 2.26428f
C1772 TOP.t5442 VSUBS 2.26428f
C1773 TOP.t5444 VSUBS 2.26428f
C1774 TOP.t5446 VSUBS 2.26428f
C1775 TOP.t5448 VSUBS 2.26428f
C1776 TOP.t5450 VSUBS 2.26428f
C1777 TOP.t5452 VSUBS 2.26428f
C1778 TOP.t5454 VSUBS 2.26428f
C1779 TOP.t5456 VSUBS 2.26428f
C1780 TOP.t5458 VSUBS 2.26428f
C1781 TOP.t5460 VSUBS 2.26428f
C1782 TOP.t5462 VSUBS 2.26428f
C1783 TOP.t5464 VSUBS 2.26428f
C1784 TOP.t5466 VSUBS 2.26428f
C1785 TOP.t5468 VSUBS 2.26428f
C1786 TOP.t5470 VSUBS 2.26428f
C1787 TOP.t5472 VSUBS 2.26428f
C1788 TOP.t5474 VSUBS 2.26428f
C1789 TOP.t5476 VSUBS 2.26428f
C1790 TOP.t5478 VSUBS 2.26428f
C1791 TOP.t5480 VSUBS 2.26428f
C1792 TOP.t5482 VSUBS 2.26428f
C1793 TOP.t5484 VSUBS 2.26428f
C1794 TOP.t5486 VSUBS 2.26428f
C1795 TOP.t5488 VSUBS 2.26428f
C1796 TOP.t5490 VSUBS 2.26428f
C1797 TOP.t5492 VSUBS 2.26428f
C1798 TOP.t5494 VSUBS 2.26428f
C1799 TOP.t5496 VSUBS 2.26428f
C1800 TOP.t5498 VSUBS 2.26428f
C1801 TOP.t5500 VSUBS 2.26428f
C1802 TOP.t5502 VSUBS 2.26428f
C1803 TOP.t5504 VSUBS 2.26428f
C1804 TOP.t5506 VSUBS 2.26428f
C1805 TOP.t5508 VSUBS 2.26428f
C1806 TOP.t5510 VSUBS 2.26428f
C1807 TOP.t5512 VSUBS 2.26428f
C1808 TOP.t5514 VSUBS 1.85085f
C1809 TOP.n16 VSUBS 0.548f
C1810 TOP.t3044 VSUBS 2.70561f
C1811 TOP.t5516 VSUBS 2.48846f
C1812 TOP.t5518 VSUBS 2.26428f
C1813 TOP.t5520 VSUBS 2.26428f
C1814 TOP.t5522 VSUBS 2.26428f
C1815 TOP.t5524 VSUBS 2.26428f
C1816 TOP.t5526 VSUBS 2.26428f
C1817 TOP.t5528 VSUBS 2.26428f
C1818 TOP.t5530 VSUBS 2.26428f
C1819 TOP.t5532 VSUBS 2.26428f
C1820 TOP.t5534 VSUBS 2.26428f
C1821 TOP.t5536 VSUBS 2.26428f
C1822 TOP.t5538 VSUBS 2.26428f
C1823 TOP.t5540 VSUBS 2.26428f
C1824 TOP.t5542 VSUBS 2.26428f
C1825 TOP.t5544 VSUBS 2.26428f
C1826 TOP.t5546 VSUBS 2.26428f
C1827 TOP.t5548 VSUBS 2.26428f
C1828 TOP.t5550 VSUBS 2.26428f
C1829 TOP.t5552 VSUBS 2.26428f
C1830 TOP.t5554 VSUBS 2.26428f
C1831 TOP.t5556 VSUBS 2.26428f
C1832 TOP.t5558 VSUBS 2.26428f
C1833 TOP.t5560 VSUBS 2.26428f
C1834 TOP.t5562 VSUBS 2.26428f
C1835 TOP.t5564 VSUBS 2.26428f
C1836 TOP.t5566 VSUBS 2.26428f
C1837 TOP.t5568 VSUBS 2.26428f
C1838 TOP.t5570 VSUBS 2.26428f
C1839 TOP.t5572 VSUBS 2.26428f
C1840 TOP.t5574 VSUBS 2.26428f
C1841 TOP.t5576 VSUBS 2.26428f
C1842 TOP.t5578 VSUBS 2.26428f
C1843 TOP.t5580 VSUBS 2.26428f
C1844 TOP.t5582 VSUBS 2.26428f
C1845 TOP.t5584 VSUBS 2.26428f
C1846 TOP.t5586 VSUBS 2.26428f
C1847 TOP.t5588 VSUBS 2.26428f
C1848 TOP.t5590 VSUBS 2.26428f
C1849 TOP.t5592 VSUBS 2.26428f
C1850 TOP.t5594 VSUBS 2.26428f
C1851 TOP.t5596 VSUBS 2.26428f
C1852 TOP.t5598 VSUBS 2.26428f
C1853 TOP.t5600 VSUBS 2.26428f
C1854 TOP.t5602 VSUBS 2.26428f
C1855 TOP.t5604 VSUBS 2.26428f
C1856 TOP.t5606 VSUBS 2.26428f
C1857 TOP.t5608 VSUBS 2.26428f
C1858 TOP.t5610 VSUBS 2.26428f
C1859 TOP.t5612 VSUBS 2.26428f
C1860 TOP.t5614 VSUBS 2.26428f
C1861 TOP.t5616 VSUBS 2.26428f
C1862 TOP.t5618 VSUBS 2.26428f
C1863 TOP.t5620 VSUBS 2.26428f
C1864 TOP.t5622 VSUBS 2.26428f
C1865 TOP.t5624 VSUBS 2.26428f
C1866 TOP.t5626 VSUBS 2.26428f
C1867 TOP.t5628 VSUBS 2.26428f
C1868 TOP.t5630 VSUBS 2.26428f
C1869 TOP.t5632 VSUBS 2.26428f
C1870 TOP.t5634 VSUBS 2.26428f
C1871 TOP.t5636 VSUBS 2.26428f
C1872 TOP.t5638 VSUBS 2.26428f
C1873 TOP.t5640 VSUBS 1.85085f
C1874 TOP.n17 VSUBS 0.548f
C1875 TOP.t3046 VSUBS 2.70561f
C1876 TOP.t5642 VSUBS 2.48846f
C1877 TOP.t5644 VSUBS 2.26428f
C1878 TOP.t5646 VSUBS 2.26428f
C1879 TOP.t5648 VSUBS 2.26428f
C1880 TOP.t5650 VSUBS 2.26428f
C1881 TOP.t5652 VSUBS 2.26428f
C1882 TOP.t5654 VSUBS 2.26428f
C1883 TOP.t5656 VSUBS 2.26428f
C1884 TOP.t5658 VSUBS 2.26428f
C1885 TOP.t5660 VSUBS 2.26428f
C1886 TOP.t5662 VSUBS 2.26428f
C1887 TOP.t5664 VSUBS 2.26428f
C1888 TOP.t5666 VSUBS 2.26428f
C1889 TOP.t5668 VSUBS 2.26428f
C1890 TOP.t5670 VSUBS 2.26428f
C1891 TOP.t5672 VSUBS 2.26428f
C1892 TOP.t5674 VSUBS 2.26428f
C1893 TOP.t5676 VSUBS 2.26428f
C1894 TOP.t5678 VSUBS 2.26428f
C1895 TOP.t5680 VSUBS 2.26428f
C1896 TOP.t5682 VSUBS 2.26428f
C1897 TOP.t5684 VSUBS 2.26428f
C1898 TOP.t5686 VSUBS 2.26428f
C1899 TOP.t5688 VSUBS 2.26428f
C1900 TOP.t5690 VSUBS 2.26428f
C1901 TOP.t5692 VSUBS 2.26428f
C1902 TOP.t5694 VSUBS 2.26428f
C1903 TOP.t5696 VSUBS 2.26428f
C1904 TOP.t5698 VSUBS 2.26428f
C1905 TOP.t5700 VSUBS 2.26428f
C1906 TOP.t5702 VSUBS 2.26428f
C1907 TOP.t5704 VSUBS 2.26428f
C1908 TOP.t5706 VSUBS 2.26428f
C1909 TOP.t5708 VSUBS 2.26428f
C1910 TOP.t5710 VSUBS 2.26428f
C1911 TOP.t5712 VSUBS 2.26428f
C1912 TOP.t5714 VSUBS 2.26428f
C1913 TOP.t5716 VSUBS 2.26428f
C1914 TOP.t5718 VSUBS 2.26428f
C1915 TOP.t5720 VSUBS 2.26428f
C1916 TOP.t5722 VSUBS 2.26428f
C1917 TOP.t5724 VSUBS 2.26428f
C1918 TOP.t5726 VSUBS 2.26428f
C1919 TOP.t5728 VSUBS 2.26428f
C1920 TOP.t5730 VSUBS 2.26428f
C1921 TOP.t5732 VSUBS 2.26428f
C1922 TOP.t5734 VSUBS 2.26428f
C1923 TOP.t5736 VSUBS 2.26428f
C1924 TOP.t5738 VSUBS 2.26428f
C1925 TOP.t5740 VSUBS 2.26428f
C1926 TOP.t5742 VSUBS 2.26428f
C1927 TOP.t5744 VSUBS 2.26428f
C1928 TOP.t5746 VSUBS 2.26428f
C1929 TOP.t5748 VSUBS 2.26428f
C1930 TOP.t5750 VSUBS 2.26428f
C1931 TOP.t5752 VSUBS 2.26428f
C1932 TOP.t5754 VSUBS 2.26428f
C1933 TOP.t5756 VSUBS 2.26428f
C1934 TOP.t5758 VSUBS 2.26428f
C1935 TOP.t5760 VSUBS 2.26428f
C1936 TOP.t5762 VSUBS 2.26428f
C1937 TOP.t5764 VSUBS 2.26428f
C1938 TOP.t5766 VSUBS 1.85085f
C1939 TOP.n18 VSUBS 0.548f
C1940 TOP.t3048 VSUBS 2.70561f
C1941 TOP.t5768 VSUBS 2.48846f
C1942 TOP.t5770 VSUBS 2.26428f
C1943 TOP.t5772 VSUBS 2.26428f
C1944 TOP.t5774 VSUBS 2.26428f
C1945 TOP.t5776 VSUBS 2.26428f
C1946 TOP.t5778 VSUBS 2.26428f
C1947 TOP.t5780 VSUBS 2.26428f
C1948 TOP.t5782 VSUBS 2.26428f
C1949 TOP.t5784 VSUBS 2.26428f
C1950 TOP.t5786 VSUBS 2.26428f
C1951 TOP.t5788 VSUBS 2.26428f
C1952 TOP.t5790 VSUBS 2.26428f
C1953 TOP.t5792 VSUBS 2.26428f
C1954 TOP.t5794 VSUBS 2.26428f
C1955 TOP.t5796 VSUBS 2.26428f
C1956 TOP.t5798 VSUBS 2.26428f
C1957 TOP.t5800 VSUBS 2.26428f
C1958 TOP.t5802 VSUBS 2.26428f
C1959 TOP.t5804 VSUBS 2.26428f
C1960 TOP.t5806 VSUBS 2.26428f
C1961 TOP.t5808 VSUBS 2.26428f
C1962 TOP.t5810 VSUBS 2.26428f
C1963 TOP.t5812 VSUBS 2.26428f
C1964 TOP.t5814 VSUBS 2.26428f
C1965 TOP.t5816 VSUBS 2.26428f
C1966 TOP.t5818 VSUBS 2.26428f
C1967 TOP.t5820 VSUBS 2.26428f
C1968 TOP.t5822 VSUBS 2.26428f
C1969 TOP.t5824 VSUBS 2.26428f
C1970 TOP.t5826 VSUBS 2.26428f
C1971 TOP.t5828 VSUBS 2.26428f
C1972 TOP.t5830 VSUBS 2.26428f
C1973 TOP.t5832 VSUBS 2.26428f
C1974 TOP.t5834 VSUBS 2.26428f
C1975 TOP.t5836 VSUBS 2.26428f
C1976 TOP.t5838 VSUBS 2.26428f
C1977 TOP.t5840 VSUBS 2.26428f
C1978 TOP.t5842 VSUBS 2.26428f
C1979 TOP.t5844 VSUBS 2.26428f
C1980 TOP.t5846 VSUBS 2.26428f
C1981 TOP.t5848 VSUBS 2.26428f
C1982 TOP.t5850 VSUBS 2.26428f
C1983 TOP.t5852 VSUBS 2.26428f
C1984 TOP.t5854 VSUBS 2.26428f
C1985 TOP.t5856 VSUBS 2.26428f
C1986 TOP.t5858 VSUBS 2.26428f
C1987 TOP.t5860 VSUBS 2.26428f
C1988 TOP.t5862 VSUBS 2.26428f
C1989 TOP.t5864 VSUBS 2.26428f
C1990 TOP.t5866 VSUBS 2.26428f
C1991 TOP.t5868 VSUBS 2.26428f
C1992 TOP.t5870 VSUBS 2.26428f
C1993 TOP.t5872 VSUBS 2.26428f
C1994 TOP.t5874 VSUBS 2.26428f
C1995 TOP.t5876 VSUBS 2.26428f
C1996 TOP.t5878 VSUBS 2.26428f
C1997 TOP.t5880 VSUBS 2.26428f
C1998 TOP.t5882 VSUBS 2.26428f
C1999 TOP.t5884 VSUBS 2.26428f
C2000 TOP.t5886 VSUBS 2.26428f
C2001 TOP.t5888 VSUBS 2.26428f
C2002 TOP.t5890 VSUBS 2.26428f
C2003 TOP.t5892 VSUBS 1.85085f
C2004 TOP.n19 VSUBS 0.548f
C2005 TOP.t3050 VSUBS 2.70561f
C2006 TOP.t5894 VSUBS 2.48846f
C2007 TOP.t5896 VSUBS 2.26428f
C2008 TOP.t5898 VSUBS 2.26428f
C2009 TOP.t5900 VSUBS 2.26428f
C2010 TOP.t5902 VSUBS 2.26428f
C2011 TOP.t5904 VSUBS 2.26428f
C2012 TOP.t5906 VSUBS 2.26428f
C2013 TOP.t5908 VSUBS 2.26428f
C2014 TOP.t5910 VSUBS 2.26428f
C2015 TOP.t5912 VSUBS 2.26428f
C2016 TOP.t5914 VSUBS 2.26428f
C2017 TOP.t5916 VSUBS 2.26428f
C2018 TOP.t5918 VSUBS 2.26428f
C2019 TOP.t5920 VSUBS 2.26428f
C2020 TOP.t5922 VSUBS 2.26428f
C2021 TOP.t5924 VSUBS 2.26428f
C2022 TOP.t5926 VSUBS 2.26428f
C2023 TOP.t5928 VSUBS 2.26428f
C2024 TOP.t5930 VSUBS 2.26428f
C2025 TOP.t5932 VSUBS 2.26428f
C2026 TOP.t5934 VSUBS 2.26428f
C2027 TOP.t5936 VSUBS 2.26428f
C2028 TOP.t5938 VSUBS 2.26428f
C2029 TOP.t5940 VSUBS 2.26428f
C2030 TOP.t5942 VSUBS 2.26428f
C2031 TOP.t5944 VSUBS 2.26428f
C2032 TOP.t5946 VSUBS 2.26428f
C2033 TOP.t5948 VSUBS 2.26428f
C2034 TOP.t5950 VSUBS 2.26428f
C2035 TOP.t5952 VSUBS 2.26428f
C2036 TOP.t5954 VSUBS 2.26428f
C2037 TOP.t5956 VSUBS 2.26428f
C2038 TOP.t5958 VSUBS 2.26428f
C2039 TOP.t5960 VSUBS 2.26428f
C2040 TOP.t5962 VSUBS 2.26428f
C2041 TOP.t5964 VSUBS 2.26428f
C2042 TOP.t5966 VSUBS 2.26428f
C2043 TOP.t5968 VSUBS 2.26428f
C2044 TOP.t5970 VSUBS 2.26428f
C2045 TOP.t5972 VSUBS 2.26428f
C2046 TOP.t5974 VSUBS 2.26428f
C2047 TOP.t5976 VSUBS 2.26428f
C2048 TOP.t5978 VSUBS 2.26428f
C2049 TOP.t5980 VSUBS 2.26428f
C2050 TOP.t5982 VSUBS 2.26428f
C2051 TOP.t5984 VSUBS 2.26428f
C2052 TOP.t5986 VSUBS 2.26428f
C2053 TOP.t5988 VSUBS 2.26428f
C2054 TOP.t5990 VSUBS 2.26428f
C2055 TOP.t5992 VSUBS 2.26428f
C2056 TOP.t5994 VSUBS 2.26428f
C2057 TOP.t5996 VSUBS 2.26428f
C2058 TOP.t5998 VSUBS 2.26428f
C2059 TOP.t6000 VSUBS 2.26428f
C2060 TOP.t6002 VSUBS 2.26428f
C2061 TOP.t6004 VSUBS 2.26428f
C2062 TOP.t6006 VSUBS 2.26428f
C2063 TOP.t6008 VSUBS 2.26428f
C2064 TOP.t6010 VSUBS 2.26428f
C2065 TOP.t6012 VSUBS 2.26428f
C2066 TOP.t6014 VSUBS 2.26428f
C2067 TOP.t6016 VSUBS 2.26428f
C2068 TOP.t6018 VSUBS 1.85085f
C2069 TOP.n20 VSUBS 0.548f
C2070 TOP.t3052 VSUBS 2.70561f
C2071 TOP.t6020 VSUBS 2.48846f
C2072 TOP.t6022 VSUBS 2.26428f
C2073 TOP.t6024 VSUBS 2.26428f
C2074 TOP.t6026 VSUBS 2.26428f
C2075 TOP.t6028 VSUBS 2.26428f
C2076 TOP.t6030 VSUBS 2.26428f
C2077 TOP.t6032 VSUBS 2.26428f
C2078 TOP.t6034 VSUBS 2.26428f
C2079 TOP.t6036 VSUBS 2.26428f
C2080 TOP.t6038 VSUBS 2.26428f
C2081 TOP.t6040 VSUBS 2.26428f
C2082 TOP.t6042 VSUBS 2.26428f
C2083 TOP.t6044 VSUBS 2.26428f
C2084 TOP.t6046 VSUBS 2.26428f
C2085 TOP.t6048 VSUBS 2.26428f
C2086 TOP.t6050 VSUBS 2.26428f
C2087 TOP.t6052 VSUBS 2.26428f
C2088 TOP.t6054 VSUBS 2.26428f
C2089 TOP.t6056 VSUBS 2.26428f
C2090 TOP.t6058 VSUBS 2.26428f
C2091 TOP.t6060 VSUBS 2.26428f
C2092 TOP.t6062 VSUBS 2.26428f
C2093 TOP.t6064 VSUBS 2.26428f
C2094 TOP.t6066 VSUBS 2.26428f
C2095 TOP.t6068 VSUBS 2.26428f
C2096 TOP.t6070 VSUBS 2.26428f
C2097 TOP.t6072 VSUBS 2.26428f
C2098 TOP.t6074 VSUBS 2.26428f
C2099 TOP.t6076 VSUBS 2.26428f
C2100 TOP.t6078 VSUBS 2.26428f
C2101 TOP.t6080 VSUBS 2.26428f
C2102 TOP.t6082 VSUBS 2.26428f
C2103 TOP.t6084 VSUBS 2.26428f
C2104 TOP.t6086 VSUBS 2.26428f
C2105 TOP.t6088 VSUBS 2.26428f
C2106 TOP.t6090 VSUBS 2.26428f
C2107 TOP.t6092 VSUBS 2.26428f
C2108 TOP.t6094 VSUBS 2.26428f
C2109 TOP.t6096 VSUBS 2.26428f
C2110 TOP.t6098 VSUBS 2.26428f
C2111 TOP.t6100 VSUBS 2.26428f
C2112 TOP.t6102 VSUBS 2.26428f
C2113 TOP.t6104 VSUBS 2.26428f
C2114 TOP.t6106 VSUBS 2.26428f
C2115 TOP.t6108 VSUBS 2.26428f
C2116 TOP.t6110 VSUBS 2.26428f
C2117 TOP.t6112 VSUBS 2.26428f
C2118 TOP.t6114 VSUBS 2.26428f
C2119 TOP.t6116 VSUBS 2.26428f
C2120 TOP.t6118 VSUBS 2.26428f
C2121 TOP.t6120 VSUBS 2.26428f
C2122 TOP.t6122 VSUBS 2.26428f
C2123 TOP.t6124 VSUBS 2.26428f
C2124 TOP.t6126 VSUBS 2.26428f
C2125 TOP.t6128 VSUBS 2.26428f
C2126 TOP.t6130 VSUBS 2.26428f
C2127 TOP.t6132 VSUBS 2.26428f
C2128 TOP.t6134 VSUBS 2.26428f
C2129 TOP.t6136 VSUBS 2.26428f
C2130 TOP.t6138 VSUBS 2.26428f
C2131 TOP.t6140 VSUBS 2.26428f
C2132 TOP.t6142 VSUBS 2.26428f
C2133 TOP.t6144 VSUBS 1.85085f
C2134 TOP.n21 VSUBS 0.548f
C2135 TOP.t3054 VSUBS 2.70561f
C2136 TOP.t6146 VSUBS 2.48846f
C2137 TOP.t6148 VSUBS 2.26428f
C2138 TOP.t6150 VSUBS 2.26428f
C2139 TOP.t6152 VSUBS 2.26428f
C2140 TOP.t6154 VSUBS 2.26428f
C2141 TOP.t6156 VSUBS 2.26428f
C2142 TOP.t6158 VSUBS 2.26428f
C2143 TOP.t6160 VSUBS 2.26428f
C2144 TOP.t6162 VSUBS 2.26428f
C2145 TOP.t6164 VSUBS 2.26428f
C2146 TOP.t6166 VSUBS 2.26428f
C2147 TOP.t6168 VSUBS 2.26428f
C2148 TOP.t6170 VSUBS 2.26428f
C2149 TOP.t6172 VSUBS 2.26428f
C2150 TOP.t6174 VSUBS 2.26428f
C2151 TOP.t6176 VSUBS 2.26428f
C2152 TOP.t6178 VSUBS 2.26428f
C2153 TOP.t6180 VSUBS 2.26428f
C2154 TOP.t6182 VSUBS 2.26428f
C2155 TOP.t6184 VSUBS 2.26428f
C2156 TOP.t6186 VSUBS 2.26428f
C2157 TOP.t6188 VSUBS 2.26428f
C2158 TOP.t6190 VSUBS 2.26428f
C2159 TOP.t6192 VSUBS 2.26428f
C2160 TOP.t6194 VSUBS 2.26428f
C2161 TOP.t6196 VSUBS 2.26428f
C2162 TOP.t6198 VSUBS 2.26428f
C2163 TOP.t6200 VSUBS 2.26428f
C2164 TOP.t6202 VSUBS 2.26428f
C2165 TOP.t6204 VSUBS 2.26428f
C2166 TOP.t6206 VSUBS 2.26428f
C2167 TOP.t6208 VSUBS 2.26428f
C2168 TOP.t6210 VSUBS 2.26428f
C2169 TOP.t6212 VSUBS 2.26428f
C2170 TOP.t6214 VSUBS 2.26428f
C2171 TOP.t6216 VSUBS 2.26428f
C2172 TOP.t6218 VSUBS 2.26428f
C2173 TOP.t6220 VSUBS 2.26428f
C2174 TOP.t6222 VSUBS 2.26428f
C2175 TOP.t6224 VSUBS 2.26428f
C2176 TOP.t6226 VSUBS 2.26428f
C2177 TOP.t6228 VSUBS 2.26428f
C2178 TOP.t6230 VSUBS 2.26428f
C2179 TOP.t6232 VSUBS 2.26428f
C2180 TOP.t6234 VSUBS 2.26428f
C2181 TOP.t6236 VSUBS 2.26428f
C2182 TOP.t6238 VSUBS 2.26428f
C2183 TOP.t6240 VSUBS 2.26428f
C2184 TOP.t6242 VSUBS 2.26428f
C2185 TOP.t6244 VSUBS 2.26428f
C2186 TOP.t6246 VSUBS 2.26428f
C2187 TOP.t6248 VSUBS 2.26428f
C2188 TOP.t6250 VSUBS 2.26428f
C2189 TOP.t6252 VSUBS 2.26428f
C2190 TOP.t6254 VSUBS 2.26428f
C2191 TOP.t6256 VSUBS 2.26428f
C2192 TOP.t6258 VSUBS 2.26428f
C2193 TOP.t6260 VSUBS 2.26428f
C2194 TOP.t6262 VSUBS 2.26428f
C2195 TOP.t6264 VSUBS 2.26428f
C2196 TOP.t6266 VSUBS 2.26428f
C2197 TOP.t6268 VSUBS 2.26428f
C2198 TOP.t6270 VSUBS 1.85085f
C2199 TOP.n22 VSUBS 0.548f
C2200 TOP.t3056 VSUBS 2.70561f
C2201 TOP.t8 VSUBS 2.50704f
C2202 TOP.t10 VSUBS 2.27937f
C2203 TOP.t12 VSUBS 2.27937f
C2204 TOP.t14 VSUBS 2.27937f
C2205 TOP.t16 VSUBS 2.27937f
C2206 TOP.t18 VSUBS 2.27937f
C2207 TOP.t20 VSUBS 2.27937f
C2208 TOP.t22 VSUBS 2.27937f
C2209 TOP.t24 VSUBS 2.27937f
C2210 TOP.t26 VSUBS 2.27937f
C2211 TOP.t28 VSUBS 2.27937f
C2212 TOP.t30 VSUBS 2.27937f
C2213 TOP.t32 VSUBS 2.27937f
C2214 TOP.t34 VSUBS 2.27937f
C2215 TOP.t36 VSUBS 2.27937f
C2216 TOP.t38 VSUBS 2.27937f
C2217 TOP.t40 VSUBS 2.27937f
C2218 TOP.t42 VSUBS 2.27937f
C2219 TOP.t44 VSUBS 2.27937f
C2220 TOP.t46 VSUBS 2.27937f
C2221 TOP.t48 VSUBS 2.27937f
C2222 TOP.t50 VSUBS 2.27937f
C2223 TOP.t52 VSUBS 2.27937f
C2224 TOP.t54 VSUBS 2.27937f
C2225 TOP.t56 VSUBS 2.27937f
C2226 TOP.t58 VSUBS 2.27937f
C2227 TOP.t60 VSUBS 2.27937f
C2228 TOP.t62 VSUBS 2.27937f
C2229 TOP.t64 VSUBS 2.27937f
C2230 TOP.t66 VSUBS 2.27937f
C2231 TOP.t68 VSUBS 2.27937f
C2232 TOP.t70 VSUBS 2.27937f
C2233 TOP.t72 VSUBS 2.27937f
C2234 TOP.t74 VSUBS 2.27937f
C2235 TOP.t76 VSUBS 2.27937f
C2236 TOP.t78 VSUBS 2.27937f
C2237 TOP.t80 VSUBS 2.27937f
C2238 TOP.t82 VSUBS 2.27937f
C2239 TOP.t84 VSUBS 2.27937f
C2240 TOP.t86 VSUBS 2.27937f
C2241 TOP.t88 VSUBS 2.27937f
C2242 TOP.t90 VSUBS 2.27937f
C2243 TOP.t92 VSUBS 2.27937f
C2244 TOP.t94 VSUBS 2.27937f
C2245 TOP.t96 VSUBS 2.27937f
C2246 TOP.t98 VSUBS 2.27937f
C2247 TOP.t100 VSUBS 2.27937f
C2248 TOP.t102 VSUBS 2.27937f
C2249 TOP.t104 VSUBS 2.27937f
C2250 TOP.t106 VSUBS 2.27937f
C2251 TOP.t108 VSUBS 2.27937f
C2252 TOP.t110 VSUBS 2.27937f
C2253 TOP.t112 VSUBS 2.27937f
C2254 TOP.t114 VSUBS 2.27937f
C2255 TOP.t116 VSUBS 2.27937f
C2256 TOP.t118 VSUBS 2.27937f
C2257 TOP.t120 VSUBS 2.27937f
C2258 TOP.t122 VSUBS 2.27937f
C2259 TOP.t124 VSUBS 2.27937f
C2260 TOP.t126 VSUBS 2.27937f
C2261 TOP.t128 VSUBS 2.27937f
C2262 TOP.t130 VSUBS 2.27937f
C2263 TOP.t132 VSUBS 1.86593f
C2264 TOP.n23 VSUBS 0.548f
C2265 TOP.t3058 VSUBS 2.70561f
C2266 TOP.t134 VSUBS 2.50704f
C2267 TOP.t136 VSUBS 2.27937f
C2268 TOP.t138 VSUBS 2.27937f
C2269 TOP.t140 VSUBS 2.27937f
C2270 TOP.t142 VSUBS 2.27937f
C2271 TOP.t144 VSUBS 2.27937f
C2272 TOP.t146 VSUBS 2.27937f
C2273 TOP.t148 VSUBS 2.27937f
C2274 TOP.t150 VSUBS 2.27937f
C2275 TOP.t152 VSUBS 2.27937f
C2276 TOP.t154 VSUBS 2.27937f
C2277 TOP.t156 VSUBS 2.27937f
C2278 TOP.t158 VSUBS 2.27937f
C2279 TOP.t160 VSUBS 2.27937f
C2280 TOP.t162 VSUBS 2.27937f
C2281 TOP.t164 VSUBS 2.27937f
C2282 TOP.t166 VSUBS 2.27937f
C2283 TOP.t168 VSUBS 2.27937f
C2284 TOP.t170 VSUBS 2.27937f
C2285 TOP.t172 VSUBS 2.27937f
C2286 TOP.t174 VSUBS 2.27937f
C2287 TOP.t176 VSUBS 2.27937f
C2288 TOP.t178 VSUBS 2.27937f
C2289 TOP.t180 VSUBS 2.27937f
C2290 TOP.t182 VSUBS 2.27937f
C2291 TOP.t184 VSUBS 2.27937f
C2292 TOP.t186 VSUBS 2.27937f
C2293 TOP.t188 VSUBS 2.27937f
C2294 TOP.t190 VSUBS 2.27937f
C2295 TOP.t192 VSUBS 2.27937f
C2296 TOP.t194 VSUBS 2.27937f
C2297 TOP.t196 VSUBS 2.27937f
C2298 TOP.t198 VSUBS 2.27937f
C2299 TOP.t200 VSUBS 2.27937f
C2300 TOP.t202 VSUBS 2.27937f
C2301 TOP.t204 VSUBS 2.27937f
C2302 TOP.t206 VSUBS 2.27937f
C2303 TOP.t208 VSUBS 2.27937f
C2304 TOP.t210 VSUBS 2.27937f
C2305 TOP.t212 VSUBS 2.27937f
C2306 TOP.t214 VSUBS 2.27937f
C2307 TOP.t216 VSUBS 2.27937f
C2308 TOP.t218 VSUBS 2.27937f
C2309 TOP.t220 VSUBS 2.27937f
C2310 TOP.t222 VSUBS 2.27937f
C2311 TOP.t224 VSUBS 2.27937f
C2312 TOP.t226 VSUBS 2.27937f
C2313 TOP.t228 VSUBS 2.27937f
C2314 TOP.t230 VSUBS 2.27937f
C2315 TOP.t232 VSUBS 2.27937f
C2316 TOP.t234 VSUBS 2.27937f
C2317 TOP.t236 VSUBS 2.27937f
C2318 TOP.t238 VSUBS 2.27937f
C2319 TOP.t240 VSUBS 2.27937f
C2320 TOP.t242 VSUBS 2.27937f
C2321 TOP.t244 VSUBS 2.27937f
C2322 TOP.t246 VSUBS 2.27937f
C2323 TOP.t248 VSUBS 2.27937f
C2324 TOP.t250 VSUBS 2.27937f
C2325 TOP.t252 VSUBS 2.27937f
C2326 TOP.t254 VSUBS 2.27937f
C2327 TOP.t256 VSUBS 2.27937f
C2328 TOP.t258 VSUBS 1.86593f
C2329 TOP.n24 VSUBS 0.548f
C2330 TOP.t3060 VSUBS 2.70561f
C2331 TOP.t260 VSUBS 2.50704f
C2332 TOP.t262 VSUBS 2.27937f
C2333 TOP.t264 VSUBS 2.27937f
C2334 TOP.t266 VSUBS 2.27937f
C2335 TOP.t268 VSUBS 2.27937f
C2336 TOP.t270 VSUBS 2.27937f
C2337 TOP.t272 VSUBS 2.27937f
C2338 TOP.t274 VSUBS 2.27937f
C2339 TOP.t276 VSUBS 2.27937f
C2340 TOP.t278 VSUBS 2.27937f
C2341 TOP.t280 VSUBS 2.27937f
C2342 TOP.t282 VSUBS 2.27937f
C2343 TOP.t284 VSUBS 2.27937f
C2344 TOP.t286 VSUBS 2.27937f
C2345 TOP.t288 VSUBS 2.27937f
C2346 TOP.t290 VSUBS 2.27937f
C2347 TOP.t292 VSUBS 2.27937f
C2348 TOP.t294 VSUBS 2.27937f
C2349 TOP.t296 VSUBS 2.27937f
C2350 TOP.t298 VSUBS 2.27937f
C2351 TOP.t300 VSUBS 2.27937f
C2352 TOP.t302 VSUBS 2.27937f
C2353 TOP.t304 VSUBS 2.27937f
C2354 TOP.t306 VSUBS 2.27937f
C2355 TOP.t308 VSUBS 2.27937f
C2356 TOP.t310 VSUBS 2.27937f
C2357 TOP.t312 VSUBS 2.27937f
C2358 TOP.t314 VSUBS 2.27937f
C2359 TOP.t316 VSUBS 2.27937f
C2360 TOP.t318 VSUBS 2.27937f
C2361 TOP.t320 VSUBS 2.27937f
C2362 TOP.t322 VSUBS 2.27937f
C2363 TOP.t324 VSUBS 2.27937f
C2364 TOP.t326 VSUBS 2.27937f
C2365 TOP.t328 VSUBS 2.27937f
C2366 TOP.t330 VSUBS 2.27937f
C2367 TOP.t332 VSUBS 2.27937f
C2368 TOP.t334 VSUBS 2.27937f
C2369 TOP.t336 VSUBS 2.27937f
C2370 TOP.t338 VSUBS 2.27937f
C2371 TOP.t340 VSUBS 2.27937f
C2372 TOP.t342 VSUBS 2.27937f
C2373 TOP.t344 VSUBS 2.27937f
C2374 TOP.t346 VSUBS 2.27937f
C2375 TOP.t348 VSUBS 2.27937f
C2376 TOP.t350 VSUBS 2.27937f
C2377 TOP.t352 VSUBS 2.27937f
C2378 TOP.t354 VSUBS 2.27937f
C2379 TOP.t356 VSUBS 2.27937f
C2380 TOP.t358 VSUBS 2.27937f
C2381 TOP.t360 VSUBS 2.27937f
C2382 TOP.t362 VSUBS 2.27937f
C2383 TOP.t364 VSUBS 2.27937f
C2384 TOP.t366 VSUBS 2.27937f
C2385 TOP.t368 VSUBS 2.27937f
C2386 TOP.t370 VSUBS 2.27937f
C2387 TOP.t372 VSUBS 2.27937f
C2388 TOP.t374 VSUBS 2.27937f
C2389 TOP.t376 VSUBS 2.27937f
C2390 TOP.t378 VSUBS 2.27937f
C2391 TOP.t380 VSUBS 2.27937f
C2392 TOP.t382 VSUBS 2.27937f
C2393 TOP.t384 VSUBS 1.86593f
C2394 TOP.n25 VSUBS 0.548f
C2395 TOP.t3062 VSUBS 2.70561f
C2396 TOP.t386 VSUBS 2.50704f
C2397 TOP.t388 VSUBS 2.27937f
C2398 TOP.t390 VSUBS 2.27937f
C2399 TOP.t392 VSUBS 2.27937f
C2400 TOP.t394 VSUBS 2.27937f
C2401 TOP.t396 VSUBS 2.27937f
C2402 TOP.t398 VSUBS 2.27937f
C2403 TOP.t400 VSUBS 2.27937f
C2404 TOP.t402 VSUBS 2.27937f
C2405 TOP.t404 VSUBS 2.27937f
C2406 TOP.t406 VSUBS 2.27937f
C2407 TOP.t408 VSUBS 2.27937f
C2408 TOP.t410 VSUBS 2.27937f
C2409 TOP.t412 VSUBS 2.27937f
C2410 TOP.t414 VSUBS 2.27937f
C2411 TOP.t416 VSUBS 2.27937f
C2412 TOP.t418 VSUBS 2.27937f
C2413 TOP.t420 VSUBS 2.27937f
C2414 TOP.t422 VSUBS 2.27937f
C2415 TOP.t424 VSUBS 2.27937f
C2416 TOP.t426 VSUBS 2.27937f
C2417 TOP.t428 VSUBS 2.27937f
C2418 TOP.t430 VSUBS 2.27937f
C2419 TOP.t432 VSUBS 2.27937f
C2420 TOP.t434 VSUBS 2.27937f
C2421 TOP.t436 VSUBS 2.27937f
C2422 TOP.t438 VSUBS 2.27937f
C2423 TOP.t440 VSUBS 2.27937f
C2424 TOP.t442 VSUBS 2.27937f
C2425 TOP.t444 VSUBS 2.27937f
C2426 TOP.t446 VSUBS 2.27937f
C2427 TOP.t448 VSUBS 2.27937f
C2428 TOP.t450 VSUBS 2.27937f
C2429 TOP.t452 VSUBS 2.27937f
C2430 TOP.t454 VSUBS 2.27937f
C2431 TOP.t456 VSUBS 2.27937f
C2432 TOP.t458 VSUBS 2.27937f
C2433 TOP.t460 VSUBS 2.27937f
C2434 TOP.t462 VSUBS 2.27937f
C2435 TOP.t464 VSUBS 2.27937f
C2436 TOP.t466 VSUBS 2.27937f
C2437 TOP.t468 VSUBS 2.27937f
C2438 TOP.t470 VSUBS 2.27937f
C2439 TOP.t472 VSUBS 2.27937f
C2440 TOP.t474 VSUBS 2.27937f
C2441 TOP.t476 VSUBS 2.27937f
C2442 TOP.t478 VSUBS 2.27937f
C2443 TOP.t480 VSUBS 2.27937f
C2444 TOP.t482 VSUBS 2.27937f
C2445 TOP.t484 VSUBS 2.27937f
C2446 TOP.t486 VSUBS 2.27937f
C2447 TOP.t488 VSUBS 2.27937f
C2448 TOP.t490 VSUBS 2.27937f
C2449 TOP.t492 VSUBS 2.27937f
C2450 TOP.t494 VSUBS 2.27937f
C2451 TOP.t496 VSUBS 2.27937f
C2452 TOP.t498 VSUBS 2.27937f
C2453 TOP.t500 VSUBS 2.27937f
C2454 TOP.t502 VSUBS 2.27937f
C2455 TOP.t504 VSUBS 2.27937f
C2456 TOP.t506 VSUBS 2.27937f
C2457 TOP.t508 VSUBS 2.27937f
C2458 TOP.t510 VSUBS 1.86593f
C2459 TOP.n26 VSUBS 0.548f
C2460 TOP.t3064 VSUBS 2.70561f
C2461 TOP.t7300 VSUBS 2.54105f
C2462 TOP.t7302 VSUBS 2.30699f
C2463 TOP.t7304 VSUBS 2.30699f
C2464 TOP.t7306 VSUBS 2.30699f
C2465 TOP.t7308 VSUBS 2.30699f
C2466 TOP.t7310 VSUBS 2.30699f
C2467 TOP.t7312 VSUBS 2.30699f
C2468 TOP.t7314 VSUBS 2.30699f
C2469 TOP.t7316 VSUBS 2.30699f
C2470 TOP.t7318 VSUBS 2.30699f
C2471 TOP.t7320 VSUBS 2.30699f
C2472 TOP.t7322 VSUBS 2.30699f
C2473 TOP.t7324 VSUBS 2.30699f
C2474 TOP.t7326 VSUBS 2.30699f
C2475 TOP.t7328 VSUBS 2.30699f
C2476 TOP.t7330 VSUBS 2.30699f
C2477 TOP.t7332 VSUBS 2.30699f
C2478 TOP.t7334 VSUBS 2.30699f
C2479 TOP.t7336 VSUBS 2.30699f
C2480 TOP.t7338 VSUBS 2.30699f
C2481 TOP.t7340 VSUBS 2.30699f
C2482 TOP.t7342 VSUBS 2.30699f
C2483 TOP.t7344 VSUBS 2.30699f
C2484 TOP.t7346 VSUBS 2.30699f
C2485 TOP.t7348 VSUBS 2.30699f
C2486 TOP.t7350 VSUBS 2.30699f
C2487 TOP.t7352 VSUBS 2.30699f
C2488 TOP.t7354 VSUBS 2.30699f
C2489 TOP.t7356 VSUBS 2.30699f
C2490 TOP.t7358 VSUBS 2.30699f
C2491 TOP.t7360 VSUBS 2.30699f
C2492 TOP.t7362 VSUBS 2.30699f
C2493 TOP.t7364 VSUBS 2.30699f
C2494 TOP.t7366 VSUBS 2.30699f
C2495 TOP.t7368 VSUBS 2.30699f
C2496 TOP.t7370 VSUBS 2.30699f
C2497 TOP.t7372 VSUBS 2.30699f
C2498 TOP.t7374 VSUBS 2.30699f
C2499 TOP.t7376 VSUBS 2.30699f
C2500 TOP.t7378 VSUBS 2.30699f
C2501 TOP.t7380 VSUBS 2.30699f
C2502 TOP.t7382 VSUBS 2.30699f
C2503 TOP.t7384 VSUBS 2.30699f
C2504 TOP.t7386 VSUBS 2.30699f
C2505 TOP.t7388 VSUBS 2.30699f
C2506 TOP.t7390 VSUBS 2.30699f
C2507 TOP.t7392 VSUBS 2.30699f
C2508 TOP.t7394 VSUBS 2.30699f
C2509 TOP.t7396 VSUBS 2.30699f
C2510 TOP.t7398 VSUBS 2.30699f
C2511 TOP.t7400 VSUBS 2.30699f
C2512 TOP.t7402 VSUBS 2.30699f
C2513 TOP.t7404 VSUBS 2.30699f
C2514 TOP.t7406 VSUBS 2.30699f
C2515 TOP.t7408 VSUBS 2.30699f
C2516 TOP.t7410 VSUBS 2.30699f
C2517 TOP.t7412 VSUBS 2.30699f
C2518 TOP.t7414 VSUBS 2.30699f
C2519 TOP.t7416 VSUBS 2.30699f
C2520 TOP.t7418 VSUBS 2.30699f
C2521 TOP.t7420 VSUBS 2.30699f
C2522 TOP.t7422 VSUBS 2.30699f
C2523 TOP.t7424 VSUBS 1.89355f
C2524 TOP.n27 VSUBS 0.548f
C2525 TOP.t3066 VSUBS 2.70561f
C2526 TOP.t7426 VSUBS 2.54105f
C2527 TOP.t7428 VSUBS 2.30699f
C2528 TOP.t7430 VSUBS 2.30699f
C2529 TOP.t7432 VSUBS 2.30699f
C2530 TOP.t7434 VSUBS 2.30699f
C2531 TOP.t7436 VSUBS 2.30699f
C2532 TOP.t7438 VSUBS 2.30699f
C2533 TOP.t7440 VSUBS 2.30699f
C2534 TOP.t7442 VSUBS 2.30699f
C2535 TOP.t7444 VSUBS 2.30699f
C2536 TOP.t7446 VSUBS 2.30699f
C2537 TOP.t7448 VSUBS 2.30699f
C2538 TOP.t7450 VSUBS 2.30699f
C2539 TOP.t7452 VSUBS 2.30699f
C2540 TOP.t7454 VSUBS 2.30699f
C2541 TOP.t7456 VSUBS 2.30699f
C2542 TOP.t7458 VSUBS 2.30699f
C2543 TOP.t7460 VSUBS 2.30699f
C2544 TOP.t7462 VSUBS 2.30699f
C2545 TOP.t7464 VSUBS 2.30699f
C2546 TOP.t7466 VSUBS 2.30699f
C2547 TOP.t7468 VSUBS 2.30699f
C2548 TOP.t7470 VSUBS 2.30699f
C2549 TOP.t7472 VSUBS 2.30699f
C2550 TOP.t7474 VSUBS 2.30699f
C2551 TOP.t7476 VSUBS 2.30699f
C2552 TOP.t7478 VSUBS 2.30699f
C2553 TOP.t7480 VSUBS 2.30699f
C2554 TOP.t7482 VSUBS 2.30699f
C2555 TOP.t7484 VSUBS 2.30699f
C2556 TOP.t7486 VSUBS 2.30699f
C2557 TOP.t7488 VSUBS 2.30699f
C2558 TOP.t7490 VSUBS 2.30699f
C2559 TOP.t7492 VSUBS 2.30699f
C2560 TOP.t7494 VSUBS 2.30699f
C2561 TOP.t7496 VSUBS 2.30699f
C2562 TOP.t7498 VSUBS 2.30699f
C2563 TOP.t7500 VSUBS 2.30699f
C2564 TOP.t7502 VSUBS 2.30699f
C2565 TOP.t7504 VSUBS 2.30699f
C2566 TOP.t7506 VSUBS 2.30699f
C2567 TOP.t7508 VSUBS 2.30699f
C2568 TOP.t7510 VSUBS 2.30699f
C2569 TOP.t7512 VSUBS 2.30699f
C2570 TOP.t7514 VSUBS 2.30699f
C2571 TOP.t7516 VSUBS 2.30699f
C2572 TOP.t7518 VSUBS 2.30699f
C2573 TOP.t7520 VSUBS 2.30699f
C2574 TOP.t7522 VSUBS 2.30699f
C2575 TOP.t7524 VSUBS 2.30699f
C2576 TOP.t7526 VSUBS 2.30699f
C2577 TOP.t7528 VSUBS 2.30699f
C2578 TOP.t7530 VSUBS 2.30699f
C2579 TOP.t7532 VSUBS 2.30699f
C2580 TOP.t7534 VSUBS 2.30699f
C2581 TOP.t7536 VSUBS 2.30699f
C2582 TOP.t7538 VSUBS 2.30699f
C2583 TOP.t7540 VSUBS 2.30699f
C2584 TOP.t7542 VSUBS 2.30699f
C2585 TOP.t7544 VSUBS 2.30699f
C2586 TOP.t7546 VSUBS 2.30699f
C2587 TOP.t7548 VSUBS 2.30699f
C2588 TOP.t7550 VSUBS 1.89355f
C2589 TOP.n28 VSUBS 0.548f
C2590 TOP.t3068 VSUBS 2.70561f
C2591 TOP.t7810 VSUBS 2.59685f
C2592 TOP.t7812 VSUBS 2.35231f
C2593 TOP.t7814 VSUBS 2.35231f
C2594 TOP.t7816 VSUBS 2.35231f
C2595 TOP.t7818 VSUBS 2.35231f
C2596 TOP.t7820 VSUBS 2.35231f
C2597 TOP.t7822 VSUBS 2.35231f
C2598 TOP.t7824 VSUBS 2.35231f
C2599 TOP.t7826 VSUBS 2.35231f
C2600 TOP.t7828 VSUBS 2.35231f
C2601 TOP.t7830 VSUBS 2.35231f
C2602 TOP.t7832 VSUBS 2.35231f
C2603 TOP.t7834 VSUBS 2.35231f
C2604 TOP.t7836 VSUBS 2.35231f
C2605 TOP.t7838 VSUBS 2.35231f
C2606 TOP.t7840 VSUBS 2.35231f
C2607 TOP.t7842 VSUBS 2.35231f
C2608 TOP.t7844 VSUBS 2.35231f
C2609 TOP.t7846 VSUBS 2.35231f
C2610 TOP.t7848 VSUBS 2.35231f
C2611 TOP.t7850 VSUBS 2.35231f
C2612 TOP.t7852 VSUBS 2.35231f
C2613 TOP.t7854 VSUBS 2.35231f
C2614 TOP.t7856 VSUBS 2.35231f
C2615 TOP.t7858 VSUBS 2.35231f
C2616 TOP.t7860 VSUBS 2.35231f
C2617 TOP.t7862 VSUBS 2.35231f
C2618 TOP.t7864 VSUBS 2.35231f
C2619 TOP.t7866 VSUBS 2.35231f
C2620 TOP.t7868 VSUBS 2.35231f
C2621 TOP.t7870 VSUBS 2.35231f
C2622 TOP.t7872 VSUBS 2.35231f
C2623 TOP.t7874 VSUBS 2.35231f
C2624 TOP.t7876 VSUBS 2.35231f
C2625 TOP.t7878 VSUBS 2.35231f
C2626 TOP.t7880 VSUBS 2.35231f
C2627 TOP.t7882 VSUBS 2.35231f
C2628 TOP.t7884 VSUBS 2.35231f
C2629 TOP.t7886 VSUBS 2.35231f
C2630 TOP.t7888 VSUBS 2.35231f
C2631 TOP.t7890 VSUBS 2.35231f
C2632 TOP.t7892 VSUBS 2.35231f
C2633 TOP.t7894 VSUBS 2.35231f
C2634 TOP.t7896 VSUBS 2.35231f
C2635 TOP.t7898 VSUBS 2.35231f
C2636 TOP.t7900 VSUBS 2.35231f
C2637 TOP.t7902 VSUBS 2.35231f
C2638 TOP.t7904 VSUBS 2.35231f
C2639 TOP.t7906 VSUBS 2.35231f
C2640 TOP.t7908 VSUBS 2.35231f
C2641 TOP.t7910 VSUBS 2.35231f
C2642 TOP.t7912 VSUBS 2.35231f
C2643 TOP.t7914 VSUBS 2.35231f
C2644 TOP.t7916 VSUBS 2.35231f
C2645 TOP.t7918 VSUBS 2.35231f
C2646 TOP.t7920 VSUBS 2.35231f
C2647 TOP.t7922 VSUBS 2.35231f
C2648 TOP.t7924 VSUBS 2.35231f
C2649 TOP.t7926 VSUBS 2.35231f
C2650 TOP.t7928 VSUBS 2.35231f
C2651 TOP.t7930 VSUBS 2.35231f
C2652 TOP.t7932 VSUBS 2.35231f
C2653 TOP.t7934 VSUBS 1.93887f
C2654 TOP.n29 VSUBS 0.548f
C2655 TOP.t3070 VSUBS 2.70561f
C2656 TOP.t8146 VSUBS 36.76504f
C2657 TOP.t8184 VSUBS 2.64625f
C2658 TOP.t8186 VSUBS 3.01403f
C2659 TOP.t8130 VSUBS 2.93187f
C2660 TOP.t8132 VSUBS 2.58168f
C2661 TOP.t8134 VSUBS 2.63347f
C2662 TOP.t8136 VSUBS 2.94305f
C2663 TOP.t8152 VSUBS 2.88574f
C2664 TOP.t8154 VSUBS 2.58692f
C2665 TOP.t8156 VSUBS 2.58692f
C2666 TOP.t8158 VSUBS 2.53694f
C2667 TOP.t8160 VSUBS 2.58692f
C2668 TOP.t8162 VSUBS 2.58692f
C2669 TOP.t8164 VSUBS 2.58692f
C2670 TOP.t8166 VSUBS 2.88574f
C2671 TOP.t8066 VSUBS 2.83294f
C2672 TOP.t8068 VSUBS 2.54404f
C2673 TOP.t8070 VSUBS 2.54404f
C2674 TOP.t8072 VSUBS 2.54404f
C2675 TOP.t8074 VSUBS 2.54404f
C2676 TOP.t8076 VSUBS 2.54404f
C2677 TOP.t8078 VSUBS 2.54404f
C2678 TOP.t8080 VSUBS 2.49572f
C2679 TOP.t8082 VSUBS 2.54404f
C2680 TOP.t8084 VSUBS 2.54404f
C2681 TOP.t8086 VSUBS 2.54404f
C2682 TOP.t8088 VSUBS 2.54404f
C2683 TOP.t8090 VSUBS 2.54404f
C2684 TOP.t8092 VSUBS 2.54404f
C2685 TOP.t8094 VSUBS 2.54404f
C2686 TOP.t8096 VSUBS 2.83294f
C2687 TOP.t8150 VSUBS 28.84394f
C2688 TOP.t5122 VSUBS 2.52859f
C2689 TOP.t5124 VSUBS 2.29688f
C2690 TOP.t5126 VSUBS 2.29688f
C2691 TOP.t5128 VSUBS 2.29688f
C2692 TOP.t5130 VSUBS 2.29688f
C2693 TOP.t5132 VSUBS 2.29688f
C2694 TOP.t5134 VSUBS 2.29688f
C2695 TOP.t5136 VSUBS 2.29688f
C2696 TOP.t5138 VSUBS 2.29688f
C2697 TOP.t5140 VSUBS 2.29688f
C2698 TOP.t5142 VSUBS 2.29688f
C2699 TOP.t5144 VSUBS 2.29688f
C2700 TOP.t5146 VSUBS 2.29688f
C2701 TOP.t5148 VSUBS 2.29688f
C2702 TOP.t5150 VSUBS 2.29688f
C2703 TOP.t5152 VSUBS 2.29688f
C2704 TOP.t5154 VSUBS 2.29688f
C2705 TOP.t5156 VSUBS 2.29688f
C2706 TOP.t5158 VSUBS 2.29688f
C2707 TOP.t5160 VSUBS 2.29688f
C2708 TOP.t5162 VSUBS 2.29688f
C2709 TOP.t5164 VSUBS 2.29688f
C2710 TOP.t5166 VSUBS 2.29688f
C2711 TOP.t5168 VSUBS 2.29688f
C2712 TOP.t5170 VSUBS 2.29688f
C2713 TOP.t5172 VSUBS 2.29688f
C2714 TOP.t5174 VSUBS 2.29688f
C2715 TOP.t5176 VSUBS 2.29688f
C2716 TOP.t5178 VSUBS 2.29688f
C2717 TOP.t5180 VSUBS 2.29688f
C2718 TOP.t5182 VSUBS 1.88344f
C2719 TOP.n30 VSUBS 0.548f
C2720 TOP.t5184 VSUBS 2.16895f
C2721 TOP.t5186 VSUBS 2.29688f
C2722 TOP.t5188 VSUBS 2.29688f
C2723 TOP.t5190 VSUBS 2.29688f
C2724 TOP.t5192 VSUBS 2.29688f
C2725 TOP.t5194 VSUBS 2.29688f
C2726 TOP.t5196 VSUBS 2.29688f
C2727 TOP.t5198 VSUBS 2.29688f
C2728 TOP.t5200 VSUBS 2.29688f
C2729 TOP.t5202 VSUBS 2.29688f
C2730 TOP.t5204 VSUBS 2.29688f
C2731 TOP.t5206 VSUBS 2.29688f
C2732 TOP.t5208 VSUBS 2.29688f
C2733 TOP.t5210 VSUBS 2.29688f
C2734 TOP.t5212 VSUBS 2.29688f
C2735 TOP.t5214 VSUBS 2.29688f
C2736 TOP.t5216 VSUBS 2.29688f
C2737 TOP.t5218 VSUBS 2.29688f
C2738 TOP.t5220 VSUBS 2.29688f
C2739 TOP.t5222 VSUBS 2.29688f
C2740 TOP.t5224 VSUBS 2.29688f
C2741 TOP.t5226 VSUBS 2.29688f
C2742 TOP.t5228 VSUBS 2.29688f
C2743 TOP.t5230 VSUBS 2.29688f
C2744 TOP.t5232 VSUBS 2.29688f
C2745 TOP.t5234 VSUBS 2.29688f
C2746 TOP.t5236 VSUBS 2.29688f
C2747 TOP.t5238 VSUBS 2.29688f
C2748 TOP.t5240 VSUBS 2.29688f
C2749 TOP.t5242 VSUBS 2.29688f
C2750 TOP.t5244 VSUBS 2.52859f
C2751 TOP.t8064 VSUBS 30.88524f
C2752 TOP.t8098 VSUBS 2.83294f
C2753 TOP.t8100 VSUBS 2.54404f
C2754 TOP.t8102 VSUBS 2.54404f
C2755 TOP.t8104 VSUBS 2.54404f
C2756 TOP.t8106 VSUBS 2.54404f
C2757 TOP.t8108 VSUBS 2.54404f
C2758 TOP.t8110 VSUBS 2.54404f
C2759 TOP.t8112 VSUBS 2.49572f
C2760 TOP.t8114 VSUBS 2.54404f
C2761 TOP.t8116 VSUBS 2.54404f
C2762 TOP.t8118 VSUBS 2.54404f
C2763 TOP.t8120 VSUBS 2.54404f
C2764 TOP.t8122 VSUBS 2.54404f
C2765 TOP.t8124 VSUBS 2.54404f
C2766 TOP.t8126 VSUBS 2.54404f
C2767 TOP.t8128 VSUBS 2.83294f
C2768 TOP.t8168 VSUBS 2.88574f
C2769 TOP.t8170 VSUBS 2.58692f
C2770 TOP.t8172 VSUBS 2.58692f
C2771 TOP.t8174 VSUBS 2.53694f
C2772 TOP.t8176 VSUBS 2.58692f
C2773 TOP.t8178 VSUBS 2.58692f
C2774 TOP.t8180 VSUBS 2.58692f
C2775 TOP.t8182 VSUBS 2.88574f
C2776 TOP.t8138 VSUBS 2.93187f
C2777 TOP.t8140 VSUBS 2.58168f
C2778 TOP.t8142 VSUBS 2.63347f
C2779 TOP.t8144 VSUBS 2.94305f
C2780 TOP.t8188 VSUBS 2.64625f
C2781 TOP.t8190 VSUBS 3.01403f
C2782 TOP.t8148 VSUBS 35.79464f
C2783 TOP.t3072 VSUBS 2.44165f
C2784 TOP.n31 VSUBS 0.548f
C2785 TOP.t7936 VSUBS 2.22438f
C2786 TOP.t7938 VSUBS 2.35231f
C2787 TOP.t7940 VSUBS 2.35231f
C2788 TOP.t7942 VSUBS 2.35231f
C2789 TOP.t7944 VSUBS 2.35231f
C2790 TOP.t7946 VSUBS 2.35231f
C2791 TOP.t7948 VSUBS 2.35231f
C2792 TOP.t7950 VSUBS 2.35231f
C2793 TOP.t7952 VSUBS 2.35231f
C2794 TOP.t7954 VSUBS 2.35231f
C2795 TOP.t7956 VSUBS 2.35231f
C2796 TOP.t7958 VSUBS 2.35231f
C2797 TOP.t7960 VSUBS 2.35231f
C2798 TOP.t7962 VSUBS 2.35231f
C2799 TOP.t7964 VSUBS 2.35231f
C2800 TOP.t7966 VSUBS 2.35231f
C2801 TOP.t7968 VSUBS 2.35231f
C2802 TOP.t7970 VSUBS 2.35231f
C2803 TOP.t7972 VSUBS 2.35231f
C2804 TOP.t7974 VSUBS 2.35231f
C2805 TOP.t7976 VSUBS 2.35231f
C2806 TOP.t7978 VSUBS 2.35231f
C2807 TOP.t7980 VSUBS 2.35231f
C2808 TOP.t7982 VSUBS 2.35231f
C2809 TOP.t7984 VSUBS 2.35231f
C2810 TOP.t7986 VSUBS 2.35231f
C2811 TOP.t7988 VSUBS 2.35231f
C2812 TOP.t7990 VSUBS 2.35231f
C2813 TOP.t7992 VSUBS 2.35231f
C2814 TOP.t7994 VSUBS 2.35231f
C2815 TOP.t7996 VSUBS 2.35231f
C2816 TOP.t7998 VSUBS 2.35231f
C2817 TOP.t8000 VSUBS 2.35231f
C2818 TOP.t8002 VSUBS 2.35231f
C2819 TOP.t8004 VSUBS 2.35231f
C2820 TOP.t8006 VSUBS 2.35231f
C2821 TOP.t8008 VSUBS 2.35231f
C2822 TOP.t8010 VSUBS 2.35231f
C2823 TOP.t8012 VSUBS 2.35231f
C2824 TOP.t8014 VSUBS 2.35231f
C2825 TOP.t8016 VSUBS 2.35231f
C2826 TOP.t8018 VSUBS 2.35231f
C2827 TOP.t8020 VSUBS 2.35231f
C2828 TOP.t8022 VSUBS 2.35231f
C2829 TOP.t8024 VSUBS 2.35231f
C2830 TOP.t8026 VSUBS 2.35231f
C2831 TOP.t8028 VSUBS 2.35231f
C2832 TOP.t8030 VSUBS 2.35231f
C2833 TOP.t8032 VSUBS 2.35231f
C2834 TOP.t8034 VSUBS 2.35231f
C2835 TOP.t8036 VSUBS 2.35231f
C2836 TOP.t8038 VSUBS 2.35231f
C2837 TOP.t8040 VSUBS 2.35231f
C2838 TOP.t8042 VSUBS 2.35231f
C2839 TOP.t8044 VSUBS 2.35231f
C2840 TOP.t8046 VSUBS 2.35231f
C2841 TOP.t8048 VSUBS 2.35231f
C2842 TOP.t8050 VSUBS 2.35231f
C2843 TOP.t8052 VSUBS 2.35231f
C2844 TOP.t8054 VSUBS 2.35231f
C2845 TOP.t8056 VSUBS 2.35231f
C2846 TOP.t8058 VSUBS 2.35231f
C2847 TOP.t8060 VSUBS 2.59685f
C2848 TOP.t3074 VSUBS 2.44165f
C2849 TOP.n32 VSUBS 0.548f
C2850 TOP.t7552 VSUBS 2.17906f
C2851 TOP.t7554 VSUBS 2.30699f
C2852 TOP.t7556 VSUBS 2.30699f
C2853 TOP.t7558 VSUBS 2.30699f
C2854 TOP.t7560 VSUBS 2.30699f
C2855 TOP.t7562 VSUBS 2.30699f
C2856 TOP.t7564 VSUBS 2.30699f
C2857 TOP.t7566 VSUBS 2.30699f
C2858 TOP.t7568 VSUBS 2.30699f
C2859 TOP.t7570 VSUBS 2.30699f
C2860 TOP.t7572 VSUBS 2.30699f
C2861 TOP.t7574 VSUBS 2.30699f
C2862 TOP.t7576 VSUBS 2.30699f
C2863 TOP.t7578 VSUBS 2.30699f
C2864 TOP.t7580 VSUBS 2.30699f
C2865 TOP.t7582 VSUBS 2.30699f
C2866 TOP.t7584 VSUBS 2.30699f
C2867 TOP.t7586 VSUBS 2.30699f
C2868 TOP.t7588 VSUBS 2.30699f
C2869 TOP.t7590 VSUBS 2.30699f
C2870 TOP.t7592 VSUBS 2.30699f
C2871 TOP.t7594 VSUBS 2.30699f
C2872 TOP.t7596 VSUBS 2.30699f
C2873 TOP.t7598 VSUBS 2.30699f
C2874 TOP.t7600 VSUBS 2.30699f
C2875 TOP.t7602 VSUBS 2.30699f
C2876 TOP.t7604 VSUBS 2.30699f
C2877 TOP.t7606 VSUBS 2.30699f
C2878 TOP.t7608 VSUBS 2.30699f
C2879 TOP.t7610 VSUBS 2.30699f
C2880 TOP.t7612 VSUBS 2.30699f
C2881 TOP.t7614 VSUBS 2.30699f
C2882 TOP.t7616 VSUBS 2.30699f
C2883 TOP.t7618 VSUBS 2.30699f
C2884 TOP.t7620 VSUBS 2.30699f
C2885 TOP.t7622 VSUBS 2.30699f
C2886 TOP.t7624 VSUBS 2.30699f
C2887 TOP.t7626 VSUBS 2.30699f
C2888 TOP.t7628 VSUBS 2.30699f
C2889 TOP.t7630 VSUBS 2.30699f
C2890 TOP.t7632 VSUBS 2.30699f
C2891 TOP.t7634 VSUBS 2.30699f
C2892 TOP.t7636 VSUBS 2.30699f
C2893 TOP.t7638 VSUBS 2.30699f
C2894 TOP.t7640 VSUBS 2.30699f
C2895 TOP.t7642 VSUBS 2.30699f
C2896 TOP.t7644 VSUBS 2.30699f
C2897 TOP.t7646 VSUBS 2.30699f
C2898 TOP.t7648 VSUBS 2.30699f
C2899 TOP.t7650 VSUBS 2.30699f
C2900 TOP.t7652 VSUBS 2.30699f
C2901 TOP.t7654 VSUBS 2.30699f
C2902 TOP.t7656 VSUBS 2.30699f
C2903 TOP.t7658 VSUBS 2.30699f
C2904 TOP.t7660 VSUBS 2.30699f
C2905 TOP.t7662 VSUBS 2.30699f
C2906 TOP.t7664 VSUBS 2.30699f
C2907 TOP.t7666 VSUBS 2.30699f
C2908 TOP.t7668 VSUBS 2.30699f
C2909 TOP.t7670 VSUBS 2.30699f
C2910 TOP.t7672 VSUBS 2.30699f
C2911 TOP.t7674 VSUBS 2.30699f
C2912 TOP.t7676 VSUBS 2.54105f
C2913 TOP.t3076 VSUBS 2.44165f
C2914 TOP.n33 VSUBS 0.548f
C2915 TOP.t7678 VSUBS 2.17906f
C2916 TOP.t7680 VSUBS 2.30699f
C2917 TOP.t7682 VSUBS 2.30699f
C2918 TOP.t7684 VSUBS 2.30699f
C2919 TOP.t7686 VSUBS 2.30699f
C2920 TOP.t7688 VSUBS 2.30699f
C2921 TOP.t7690 VSUBS 2.30699f
C2922 TOP.t7692 VSUBS 2.30699f
C2923 TOP.t7694 VSUBS 2.30699f
C2924 TOP.t7696 VSUBS 2.30699f
C2925 TOP.t7698 VSUBS 2.30699f
C2926 TOP.t7700 VSUBS 2.30699f
C2927 TOP.t7702 VSUBS 2.30699f
C2928 TOP.t7704 VSUBS 2.30699f
C2929 TOP.t7706 VSUBS 2.30699f
C2930 TOP.t7708 VSUBS 2.30699f
C2931 TOP.t7710 VSUBS 2.30699f
C2932 TOP.t7712 VSUBS 2.30699f
C2933 TOP.t7714 VSUBS 2.30699f
C2934 TOP.t7716 VSUBS 2.30699f
C2935 TOP.t7718 VSUBS 2.30699f
C2936 TOP.t7720 VSUBS 2.30699f
C2937 TOP.t7722 VSUBS 2.30699f
C2938 TOP.t7724 VSUBS 2.30699f
C2939 TOP.t7726 VSUBS 2.30699f
C2940 TOP.t7728 VSUBS 2.30699f
C2941 TOP.t7730 VSUBS 2.30699f
C2942 TOP.t7732 VSUBS 2.30699f
C2943 TOP.t7734 VSUBS 2.30699f
C2944 TOP.t7736 VSUBS 2.30699f
C2945 TOP.t7738 VSUBS 2.30699f
C2946 TOP.t7740 VSUBS 2.30699f
C2947 TOP.t7742 VSUBS 2.30699f
C2948 TOP.t7744 VSUBS 2.30699f
C2949 TOP.t7746 VSUBS 2.30699f
C2950 TOP.t7748 VSUBS 2.30699f
C2951 TOP.t7750 VSUBS 2.30699f
C2952 TOP.t7752 VSUBS 2.30699f
C2953 TOP.t7754 VSUBS 2.30699f
C2954 TOP.t7756 VSUBS 2.30699f
C2955 TOP.t7758 VSUBS 2.30699f
C2956 TOP.t7760 VSUBS 2.30699f
C2957 TOP.t7762 VSUBS 2.30699f
C2958 TOP.t7764 VSUBS 2.30699f
C2959 TOP.t7766 VSUBS 2.30699f
C2960 TOP.t7768 VSUBS 2.30699f
C2961 TOP.t7770 VSUBS 2.30699f
C2962 TOP.t7772 VSUBS 2.30699f
C2963 TOP.t7774 VSUBS 2.30699f
C2964 TOP.t7776 VSUBS 2.30699f
C2965 TOP.t7778 VSUBS 2.30699f
C2966 TOP.t7780 VSUBS 2.30699f
C2967 TOP.t7782 VSUBS 2.30699f
C2968 TOP.t7784 VSUBS 2.30699f
C2969 TOP.t7786 VSUBS 2.30699f
C2970 TOP.t7788 VSUBS 2.30699f
C2971 TOP.t7790 VSUBS 2.30699f
C2972 TOP.t7792 VSUBS 2.30699f
C2973 TOP.t7794 VSUBS 2.30699f
C2974 TOP.t7796 VSUBS 2.30699f
C2975 TOP.t7798 VSUBS 2.30699f
C2976 TOP.t7800 VSUBS 2.30699f
C2977 TOP.t7802 VSUBS 2.54105f
C2978 TOP.t3078 VSUBS 2.44165f
C2979 TOP.n34 VSUBS 0.548f
C2980 TOP.t512 VSUBS 2.15144f
C2981 TOP.t514 VSUBS 2.27937f
C2982 TOP.t516 VSUBS 2.27937f
C2983 TOP.t518 VSUBS 2.27937f
C2984 TOP.t520 VSUBS 2.27937f
C2985 TOP.t522 VSUBS 2.27937f
C2986 TOP.t524 VSUBS 2.27937f
C2987 TOP.t526 VSUBS 2.27937f
C2988 TOP.t528 VSUBS 2.27937f
C2989 TOP.t530 VSUBS 2.27937f
C2990 TOP.t532 VSUBS 2.27937f
C2991 TOP.t534 VSUBS 2.27937f
C2992 TOP.t536 VSUBS 2.27937f
C2993 TOP.t538 VSUBS 2.27937f
C2994 TOP.t540 VSUBS 2.27937f
C2995 TOP.t542 VSUBS 2.27937f
C2996 TOP.t544 VSUBS 2.27937f
C2997 TOP.t546 VSUBS 2.27937f
C2998 TOP.t548 VSUBS 2.27937f
C2999 TOP.t550 VSUBS 2.27937f
C3000 TOP.t552 VSUBS 2.27937f
C3001 TOP.t554 VSUBS 2.27937f
C3002 TOP.t556 VSUBS 2.27937f
C3003 TOP.t558 VSUBS 2.27937f
C3004 TOP.t560 VSUBS 2.27937f
C3005 TOP.t562 VSUBS 2.27937f
C3006 TOP.t564 VSUBS 2.27937f
C3007 TOP.t566 VSUBS 2.27937f
C3008 TOP.t568 VSUBS 2.27937f
C3009 TOP.t570 VSUBS 2.27937f
C3010 TOP.t572 VSUBS 2.27937f
C3011 TOP.t574 VSUBS 2.27937f
C3012 TOP.t576 VSUBS 2.27937f
C3013 TOP.t578 VSUBS 2.27937f
C3014 TOP.t580 VSUBS 2.27937f
C3015 TOP.t582 VSUBS 2.27937f
C3016 TOP.t584 VSUBS 2.27937f
C3017 TOP.t586 VSUBS 2.27937f
C3018 TOP.t588 VSUBS 2.27937f
C3019 TOP.t590 VSUBS 2.27937f
C3020 TOP.t592 VSUBS 2.27937f
C3021 TOP.t594 VSUBS 2.27937f
C3022 TOP.t596 VSUBS 2.27937f
C3023 TOP.t598 VSUBS 2.27937f
C3024 TOP.t600 VSUBS 2.27937f
C3025 TOP.t602 VSUBS 2.27937f
C3026 TOP.t604 VSUBS 2.27937f
C3027 TOP.t606 VSUBS 2.27937f
C3028 TOP.t608 VSUBS 2.27937f
C3029 TOP.t610 VSUBS 2.27937f
C3030 TOP.t612 VSUBS 2.27937f
C3031 TOP.t614 VSUBS 2.27937f
C3032 TOP.t616 VSUBS 2.27937f
C3033 TOP.t618 VSUBS 2.27937f
C3034 TOP.t620 VSUBS 2.27937f
C3035 TOP.t622 VSUBS 2.27937f
C3036 TOP.t624 VSUBS 2.27937f
C3037 TOP.t626 VSUBS 2.27937f
C3038 TOP.t628 VSUBS 2.27937f
C3039 TOP.t630 VSUBS 2.27937f
C3040 TOP.t632 VSUBS 2.27937f
C3041 TOP.t634 VSUBS 2.27937f
C3042 TOP.t636 VSUBS 2.50704f
C3043 TOP.t3080 VSUBS 2.44165f
C3044 TOP.n35 VSUBS 0.548f
C3045 TOP.t638 VSUBS 2.15144f
C3046 TOP.t640 VSUBS 2.27937f
C3047 TOP.t642 VSUBS 2.27937f
C3048 TOP.t644 VSUBS 2.27937f
C3049 TOP.t646 VSUBS 2.27937f
C3050 TOP.t648 VSUBS 2.27937f
C3051 TOP.t650 VSUBS 2.27937f
C3052 TOP.t652 VSUBS 2.27937f
C3053 TOP.t654 VSUBS 2.27937f
C3054 TOP.t656 VSUBS 2.27937f
C3055 TOP.t658 VSUBS 2.27937f
C3056 TOP.t660 VSUBS 2.27937f
C3057 TOP.t662 VSUBS 2.27937f
C3058 TOP.t664 VSUBS 2.27937f
C3059 TOP.t666 VSUBS 2.27937f
C3060 TOP.t668 VSUBS 2.27937f
C3061 TOP.t670 VSUBS 2.27937f
C3062 TOP.t672 VSUBS 2.27937f
C3063 TOP.t674 VSUBS 2.27937f
C3064 TOP.t676 VSUBS 2.27937f
C3065 TOP.t678 VSUBS 2.27937f
C3066 TOP.t680 VSUBS 2.27937f
C3067 TOP.t682 VSUBS 2.27937f
C3068 TOP.t684 VSUBS 2.27937f
C3069 TOP.t686 VSUBS 2.27937f
C3070 TOP.t688 VSUBS 2.27937f
C3071 TOP.t690 VSUBS 2.27937f
C3072 TOP.t692 VSUBS 2.27937f
C3073 TOP.t694 VSUBS 2.27937f
C3074 TOP.t696 VSUBS 2.27937f
C3075 TOP.t698 VSUBS 2.27937f
C3076 TOP.t700 VSUBS 2.27937f
C3077 TOP.t702 VSUBS 2.27937f
C3078 TOP.t704 VSUBS 2.27937f
C3079 TOP.t706 VSUBS 2.27937f
C3080 TOP.t708 VSUBS 2.27937f
C3081 TOP.t710 VSUBS 2.27937f
C3082 TOP.t712 VSUBS 2.27937f
C3083 TOP.t714 VSUBS 2.27937f
C3084 TOP.t716 VSUBS 2.27937f
C3085 TOP.t718 VSUBS 2.27937f
C3086 TOP.t720 VSUBS 2.27937f
C3087 TOP.t722 VSUBS 2.27937f
C3088 TOP.t724 VSUBS 2.27937f
C3089 TOP.t726 VSUBS 2.27937f
C3090 TOP.t728 VSUBS 2.27937f
C3091 TOP.t730 VSUBS 2.27937f
C3092 TOP.t732 VSUBS 2.27937f
C3093 TOP.t734 VSUBS 2.27937f
C3094 TOP.t736 VSUBS 2.27937f
C3095 TOP.t738 VSUBS 2.27937f
C3096 TOP.t740 VSUBS 2.27937f
C3097 TOP.t742 VSUBS 2.27937f
C3098 TOP.t744 VSUBS 2.27937f
C3099 TOP.t746 VSUBS 2.27937f
C3100 TOP.t748 VSUBS 2.27937f
C3101 TOP.t750 VSUBS 2.27937f
C3102 TOP.t752 VSUBS 2.27937f
C3103 TOP.t754 VSUBS 2.27937f
C3104 TOP.t756 VSUBS 2.27937f
C3105 TOP.t758 VSUBS 2.27937f
C3106 TOP.t760 VSUBS 2.27937f
C3107 TOP.t762 VSUBS 2.50704f
C3108 TOP.t3082 VSUBS 2.44165f
C3109 TOP.n36 VSUBS 0.548f
C3110 TOP.t764 VSUBS 2.15144f
C3111 TOP.t766 VSUBS 2.27937f
C3112 TOP.t768 VSUBS 2.27937f
C3113 TOP.t770 VSUBS 2.27937f
C3114 TOP.t772 VSUBS 2.27937f
C3115 TOP.t774 VSUBS 2.27937f
C3116 TOP.t776 VSUBS 2.27937f
C3117 TOP.t778 VSUBS 2.27937f
C3118 TOP.t780 VSUBS 2.27937f
C3119 TOP.t782 VSUBS 2.27937f
C3120 TOP.t784 VSUBS 2.27937f
C3121 TOP.t786 VSUBS 2.27937f
C3122 TOP.t788 VSUBS 2.27937f
C3123 TOP.t790 VSUBS 2.27937f
C3124 TOP.t792 VSUBS 2.27937f
C3125 TOP.t794 VSUBS 2.27937f
C3126 TOP.t796 VSUBS 2.27937f
C3127 TOP.t798 VSUBS 2.27937f
C3128 TOP.t800 VSUBS 2.27937f
C3129 TOP.t802 VSUBS 2.27937f
C3130 TOP.t804 VSUBS 2.27937f
C3131 TOP.t806 VSUBS 2.27937f
C3132 TOP.t808 VSUBS 2.27937f
C3133 TOP.t810 VSUBS 2.27937f
C3134 TOP.t812 VSUBS 2.27937f
C3135 TOP.t814 VSUBS 2.27937f
C3136 TOP.t816 VSUBS 2.27937f
C3137 TOP.t818 VSUBS 2.27937f
C3138 TOP.t820 VSUBS 2.27937f
C3139 TOP.t822 VSUBS 2.27937f
C3140 TOP.t824 VSUBS 2.27937f
C3141 TOP.t826 VSUBS 2.27937f
C3142 TOP.t828 VSUBS 2.27937f
C3143 TOP.t830 VSUBS 2.27937f
C3144 TOP.t832 VSUBS 2.27937f
C3145 TOP.t834 VSUBS 2.27937f
C3146 TOP.t836 VSUBS 2.27937f
C3147 TOP.t838 VSUBS 2.27937f
C3148 TOP.t840 VSUBS 2.27937f
C3149 TOP.t842 VSUBS 2.27937f
C3150 TOP.t844 VSUBS 2.27937f
C3151 TOP.t846 VSUBS 2.27937f
C3152 TOP.t848 VSUBS 2.27937f
C3153 TOP.t850 VSUBS 2.27937f
C3154 TOP.t852 VSUBS 2.27937f
C3155 TOP.t854 VSUBS 2.27937f
C3156 TOP.t856 VSUBS 2.27937f
C3157 TOP.t858 VSUBS 2.27937f
C3158 TOP.t860 VSUBS 2.27937f
C3159 TOP.t862 VSUBS 2.27937f
C3160 TOP.t864 VSUBS 2.27937f
C3161 TOP.t866 VSUBS 2.27937f
C3162 TOP.t868 VSUBS 2.27937f
C3163 TOP.t870 VSUBS 2.27937f
C3164 TOP.t872 VSUBS 2.27937f
C3165 TOP.t874 VSUBS 2.27937f
C3166 TOP.t876 VSUBS 2.27937f
C3167 TOP.t878 VSUBS 2.27937f
C3168 TOP.t880 VSUBS 2.27937f
C3169 TOP.t882 VSUBS 2.27937f
C3170 TOP.t884 VSUBS 2.27937f
C3171 TOP.t886 VSUBS 2.27937f
C3172 TOP.t888 VSUBS 2.50704f
C3173 TOP.t3084 VSUBS 2.44165f
C3174 TOP.n37 VSUBS 0.548f
C3175 TOP.t890 VSUBS 2.15144f
C3176 TOP.t892 VSUBS 2.27937f
C3177 TOP.t894 VSUBS 2.27937f
C3178 TOP.t896 VSUBS 2.27937f
C3179 TOP.t898 VSUBS 2.27937f
C3180 TOP.t900 VSUBS 2.27937f
C3181 TOP.t902 VSUBS 2.27937f
C3182 TOP.t904 VSUBS 2.27937f
C3183 TOP.t906 VSUBS 2.27937f
C3184 TOP.t908 VSUBS 2.27937f
C3185 TOP.t910 VSUBS 2.27937f
C3186 TOP.t912 VSUBS 2.27937f
C3187 TOP.t914 VSUBS 2.27937f
C3188 TOP.t916 VSUBS 2.27937f
C3189 TOP.t918 VSUBS 2.27937f
C3190 TOP.t920 VSUBS 2.27937f
C3191 TOP.t922 VSUBS 2.27937f
C3192 TOP.t924 VSUBS 2.27937f
C3193 TOP.t926 VSUBS 2.27937f
C3194 TOP.t928 VSUBS 2.27937f
C3195 TOP.t930 VSUBS 2.27937f
C3196 TOP.t932 VSUBS 2.27937f
C3197 TOP.t934 VSUBS 2.27937f
C3198 TOP.t936 VSUBS 2.27937f
C3199 TOP.t938 VSUBS 2.27937f
C3200 TOP.t940 VSUBS 2.27937f
C3201 TOP.t942 VSUBS 2.27937f
C3202 TOP.t944 VSUBS 2.27937f
C3203 TOP.t946 VSUBS 2.27937f
C3204 TOP.t948 VSUBS 2.27937f
C3205 TOP.t950 VSUBS 2.27937f
C3206 TOP.t952 VSUBS 2.27937f
C3207 TOP.t954 VSUBS 2.27937f
C3208 TOP.t956 VSUBS 2.27937f
C3209 TOP.t958 VSUBS 2.27937f
C3210 TOP.t960 VSUBS 2.27937f
C3211 TOP.t962 VSUBS 2.27937f
C3212 TOP.t964 VSUBS 2.27937f
C3213 TOP.t966 VSUBS 2.27937f
C3214 TOP.t968 VSUBS 2.27937f
C3215 TOP.t970 VSUBS 2.27937f
C3216 TOP.t972 VSUBS 2.27937f
C3217 TOP.t974 VSUBS 2.27937f
C3218 TOP.t976 VSUBS 2.27937f
C3219 TOP.t978 VSUBS 2.27937f
C3220 TOP.t980 VSUBS 2.27937f
C3221 TOP.t982 VSUBS 2.27937f
C3222 TOP.t984 VSUBS 2.27937f
C3223 TOP.t986 VSUBS 2.27937f
C3224 TOP.t988 VSUBS 2.27937f
C3225 TOP.t990 VSUBS 2.27937f
C3226 TOP.t992 VSUBS 2.27937f
C3227 TOP.t994 VSUBS 2.27937f
C3228 TOP.t996 VSUBS 2.27937f
C3229 TOP.t998 VSUBS 2.27937f
C3230 TOP.t1000 VSUBS 2.27937f
C3231 TOP.t1002 VSUBS 2.27937f
C3232 TOP.t1004 VSUBS 2.27937f
C3233 TOP.t1006 VSUBS 2.27937f
C3234 TOP.t1008 VSUBS 2.27937f
C3235 TOP.t1010 VSUBS 2.27937f
C3236 TOP.t1012 VSUBS 2.27937f
C3237 TOP.t1014 VSUBS 2.50704f
C3238 TOP.t3086 VSUBS 2.44165f
C3239 TOP.n38 VSUBS 0.548f
C3240 TOP.t6272 VSUBS 2.13635f
C3241 TOP.t6274 VSUBS 2.26428f
C3242 TOP.t6276 VSUBS 2.26428f
C3243 TOP.t6278 VSUBS 2.26428f
C3244 TOP.t6280 VSUBS 2.26428f
C3245 TOP.t6282 VSUBS 2.26428f
C3246 TOP.t6284 VSUBS 2.26428f
C3247 TOP.t6286 VSUBS 2.26428f
C3248 TOP.t6288 VSUBS 2.26428f
C3249 TOP.t6290 VSUBS 2.26428f
C3250 TOP.t6292 VSUBS 2.26428f
C3251 TOP.t6294 VSUBS 2.26428f
C3252 TOP.t6296 VSUBS 2.26428f
C3253 TOP.t6298 VSUBS 2.26428f
C3254 TOP.t6300 VSUBS 2.26428f
C3255 TOP.t6302 VSUBS 2.26428f
C3256 TOP.t6304 VSUBS 2.26428f
C3257 TOP.t6306 VSUBS 2.26428f
C3258 TOP.t6308 VSUBS 2.26428f
C3259 TOP.t6310 VSUBS 2.26428f
C3260 TOP.t6312 VSUBS 2.26428f
C3261 TOP.t6314 VSUBS 2.26428f
C3262 TOP.t6316 VSUBS 2.26428f
C3263 TOP.t6318 VSUBS 2.26428f
C3264 TOP.t6320 VSUBS 2.26428f
C3265 TOP.t6322 VSUBS 2.26428f
C3266 TOP.t6324 VSUBS 2.26428f
C3267 TOP.t6326 VSUBS 2.26428f
C3268 TOP.t6328 VSUBS 2.26428f
C3269 TOP.t6330 VSUBS 2.26428f
C3270 TOP.t6332 VSUBS 2.26428f
C3271 TOP.t6334 VSUBS 2.26428f
C3272 TOP.t6336 VSUBS 2.26428f
C3273 TOP.t6338 VSUBS 2.26428f
C3274 TOP.t6340 VSUBS 2.26428f
C3275 TOP.t6342 VSUBS 2.26428f
C3276 TOP.t6344 VSUBS 2.26428f
C3277 TOP.t6346 VSUBS 2.26428f
C3278 TOP.t6348 VSUBS 2.26428f
C3279 TOP.t6350 VSUBS 2.26428f
C3280 TOP.t6352 VSUBS 2.26428f
C3281 TOP.t6354 VSUBS 2.26428f
C3282 TOP.t6356 VSUBS 2.26428f
C3283 TOP.t6358 VSUBS 2.26428f
C3284 TOP.t6360 VSUBS 2.26428f
C3285 TOP.t6362 VSUBS 2.26428f
C3286 TOP.t6364 VSUBS 2.26428f
C3287 TOP.t6366 VSUBS 2.26428f
C3288 TOP.t6368 VSUBS 2.26428f
C3289 TOP.t6370 VSUBS 2.26428f
C3290 TOP.t6372 VSUBS 2.26428f
C3291 TOP.t6374 VSUBS 2.26428f
C3292 TOP.t6376 VSUBS 2.26428f
C3293 TOP.t6378 VSUBS 2.26428f
C3294 TOP.t6380 VSUBS 2.26428f
C3295 TOP.t6382 VSUBS 2.26428f
C3296 TOP.t6384 VSUBS 2.26428f
C3297 TOP.t6386 VSUBS 2.26428f
C3298 TOP.t6388 VSUBS 2.26428f
C3299 TOP.t6390 VSUBS 2.26428f
C3300 TOP.t6392 VSUBS 2.26428f
C3301 TOP.t6394 VSUBS 2.26428f
C3302 TOP.t6396 VSUBS 2.48846f
C3303 TOP.t3088 VSUBS 2.44165f
C3304 TOP.n39 VSUBS 0.548f
C3305 TOP.t6398 VSUBS 2.13635f
C3306 TOP.t6400 VSUBS 2.26428f
C3307 TOP.t6402 VSUBS 2.26428f
C3308 TOP.t6404 VSUBS 2.26428f
C3309 TOP.t6406 VSUBS 2.26428f
C3310 TOP.t6408 VSUBS 2.26428f
C3311 TOP.t6410 VSUBS 2.26428f
C3312 TOP.t6412 VSUBS 2.26428f
C3313 TOP.t6414 VSUBS 2.26428f
C3314 TOP.t6416 VSUBS 2.26428f
C3315 TOP.t6418 VSUBS 2.26428f
C3316 TOP.t6420 VSUBS 2.26428f
C3317 TOP.t6422 VSUBS 2.26428f
C3318 TOP.t6424 VSUBS 2.26428f
C3319 TOP.t6426 VSUBS 2.26428f
C3320 TOP.t6428 VSUBS 2.26428f
C3321 TOP.t6430 VSUBS 2.26428f
C3322 TOP.t6432 VSUBS 2.26428f
C3323 TOP.t6434 VSUBS 2.26428f
C3324 TOP.t6436 VSUBS 2.26428f
C3325 TOP.t6438 VSUBS 2.26428f
C3326 TOP.t6440 VSUBS 2.26428f
C3327 TOP.t6442 VSUBS 2.26428f
C3328 TOP.t6444 VSUBS 2.26428f
C3329 TOP.t6446 VSUBS 2.26428f
C3330 TOP.t6448 VSUBS 2.26428f
C3331 TOP.t6450 VSUBS 2.26428f
C3332 TOP.t6452 VSUBS 2.26428f
C3333 TOP.t6454 VSUBS 2.26428f
C3334 TOP.t6456 VSUBS 2.26428f
C3335 TOP.t6458 VSUBS 2.26428f
C3336 TOP.t6460 VSUBS 2.26428f
C3337 TOP.t6462 VSUBS 2.26428f
C3338 TOP.t6464 VSUBS 2.26428f
C3339 TOP.t6466 VSUBS 2.26428f
C3340 TOP.t6468 VSUBS 2.26428f
C3341 TOP.t6470 VSUBS 2.26428f
C3342 TOP.t6472 VSUBS 2.26428f
C3343 TOP.t6474 VSUBS 2.26428f
C3344 TOP.t6476 VSUBS 2.26428f
C3345 TOP.t6478 VSUBS 2.26428f
C3346 TOP.t6480 VSUBS 2.26428f
C3347 TOP.t6482 VSUBS 2.26428f
C3348 TOP.t6484 VSUBS 2.26428f
C3349 TOP.t6486 VSUBS 2.26428f
C3350 TOP.t6488 VSUBS 2.26428f
C3351 TOP.t6490 VSUBS 2.26428f
C3352 TOP.t6492 VSUBS 2.26428f
C3353 TOP.t6494 VSUBS 2.26428f
C3354 TOP.t6496 VSUBS 2.26428f
C3355 TOP.t6498 VSUBS 2.26428f
C3356 TOP.t6500 VSUBS 2.26428f
C3357 TOP.t6502 VSUBS 2.26428f
C3358 TOP.t6504 VSUBS 2.26428f
C3359 TOP.t6506 VSUBS 2.26428f
C3360 TOP.t6508 VSUBS 2.26428f
C3361 TOP.t6510 VSUBS 2.26428f
C3362 TOP.t6512 VSUBS 2.26428f
C3363 TOP.t6514 VSUBS 2.26428f
C3364 TOP.t6516 VSUBS 2.26428f
C3365 TOP.t6518 VSUBS 2.26428f
C3366 TOP.t6520 VSUBS 2.26428f
C3367 TOP.t6522 VSUBS 2.48846f
C3368 TOP.t3090 VSUBS 2.44165f
C3369 TOP.n40 VSUBS 0.548f
C3370 TOP.t6524 VSUBS 2.13635f
C3371 TOP.t6526 VSUBS 2.26428f
C3372 TOP.t6528 VSUBS 2.26428f
C3373 TOP.t6530 VSUBS 2.26428f
C3374 TOP.t6532 VSUBS 2.26428f
C3375 TOP.t6534 VSUBS 2.26428f
C3376 TOP.t6536 VSUBS 2.26428f
C3377 TOP.t6538 VSUBS 2.26428f
C3378 TOP.t6540 VSUBS 2.26428f
C3379 TOP.t6542 VSUBS 2.26428f
C3380 TOP.t6544 VSUBS 2.26428f
C3381 TOP.t6546 VSUBS 2.26428f
C3382 TOP.t6548 VSUBS 2.26428f
C3383 TOP.t6550 VSUBS 2.26428f
C3384 TOP.t6552 VSUBS 2.26428f
C3385 TOP.t6554 VSUBS 2.26428f
C3386 TOP.t6556 VSUBS 2.26428f
C3387 TOP.t6558 VSUBS 2.26428f
C3388 TOP.t6560 VSUBS 2.26428f
C3389 TOP.t6562 VSUBS 2.26428f
C3390 TOP.t6564 VSUBS 2.26428f
C3391 TOP.t6566 VSUBS 2.26428f
C3392 TOP.t6568 VSUBS 2.26428f
C3393 TOP.t6570 VSUBS 2.26428f
C3394 TOP.t6572 VSUBS 2.26428f
C3395 TOP.t6574 VSUBS 2.26428f
C3396 TOP.t6576 VSUBS 2.26428f
C3397 TOP.t6578 VSUBS 2.26428f
C3398 TOP.t6580 VSUBS 2.26428f
C3399 TOP.t6582 VSUBS 2.26428f
C3400 TOP.t6584 VSUBS 2.26428f
C3401 TOP.t6586 VSUBS 2.26428f
C3402 TOP.t6588 VSUBS 2.26428f
C3403 TOP.t6590 VSUBS 2.26428f
C3404 TOP.t6592 VSUBS 2.26428f
C3405 TOP.t6594 VSUBS 2.26428f
C3406 TOP.t6596 VSUBS 2.26428f
C3407 TOP.t6598 VSUBS 2.26428f
C3408 TOP.t6600 VSUBS 2.26428f
C3409 TOP.t6602 VSUBS 2.26428f
C3410 TOP.t6604 VSUBS 2.26428f
C3411 TOP.t6606 VSUBS 2.26428f
C3412 TOP.t6608 VSUBS 2.26428f
C3413 TOP.t6610 VSUBS 2.26428f
C3414 TOP.t6612 VSUBS 2.26428f
C3415 TOP.t6614 VSUBS 2.26428f
C3416 TOP.t6616 VSUBS 2.26428f
C3417 TOP.t6618 VSUBS 2.26428f
C3418 TOP.t6620 VSUBS 2.26428f
C3419 TOP.t6622 VSUBS 2.26428f
C3420 TOP.t6624 VSUBS 2.26428f
C3421 TOP.t6626 VSUBS 2.26428f
C3422 TOP.t6628 VSUBS 2.26428f
C3423 TOP.t6630 VSUBS 2.26428f
C3424 TOP.t6632 VSUBS 2.26428f
C3425 TOP.t6634 VSUBS 2.26428f
C3426 TOP.t6636 VSUBS 2.26428f
C3427 TOP.t6638 VSUBS 2.26428f
C3428 TOP.t6640 VSUBS 2.26428f
C3429 TOP.t6642 VSUBS 2.26428f
C3430 TOP.t6644 VSUBS 2.26428f
C3431 TOP.t6646 VSUBS 2.26428f
C3432 TOP.t6648 VSUBS 2.48846f
C3433 TOP.t3092 VSUBS 2.44165f
C3434 TOP.n41 VSUBS 0.548f
C3435 TOP.t6650 VSUBS 2.13635f
C3436 TOP.t6652 VSUBS 2.26428f
C3437 TOP.t6654 VSUBS 2.26428f
C3438 TOP.t6656 VSUBS 2.26428f
C3439 TOP.t6658 VSUBS 2.26428f
C3440 TOP.t6660 VSUBS 2.26428f
C3441 TOP.t6662 VSUBS 2.26428f
C3442 TOP.t6664 VSUBS 2.26428f
C3443 TOP.t6666 VSUBS 2.26428f
C3444 TOP.t6668 VSUBS 2.26428f
C3445 TOP.t6670 VSUBS 2.26428f
C3446 TOP.t6672 VSUBS 2.26428f
C3447 TOP.t6674 VSUBS 2.26428f
C3448 TOP.t6676 VSUBS 2.26428f
C3449 TOP.t6678 VSUBS 2.26428f
C3450 TOP.t6680 VSUBS 2.26428f
C3451 TOP.t6682 VSUBS 2.26428f
C3452 TOP.t6684 VSUBS 2.26428f
C3453 TOP.t6686 VSUBS 2.26428f
C3454 TOP.t6688 VSUBS 2.26428f
C3455 TOP.t6690 VSUBS 2.26428f
C3456 TOP.t6692 VSUBS 2.26428f
C3457 TOP.t6694 VSUBS 2.26428f
C3458 TOP.t6696 VSUBS 2.26428f
C3459 TOP.t6698 VSUBS 2.26428f
C3460 TOP.t6700 VSUBS 2.26428f
C3461 TOP.t6702 VSUBS 2.26428f
C3462 TOP.t6704 VSUBS 2.26428f
C3463 TOP.t6706 VSUBS 2.26428f
C3464 TOP.t6708 VSUBS 2.26428f
C3465 TOP.t6710 VSUBS 2.26428f
C3466 TOP.t6712 VSUBS 2.26428f
C3467 TOP.t6714 VSUBS 2.26428f
C3468 TOP.t6716 VSUBS 2.26428f
C3469 TOP.t6718 VSUBS 2.26428f
C3470 TOP.t6720 VSUBS 2.26428f
C3471 TOP.t6722 VSUBS 2.26428f
C3472 TOP.t6724 VSUBS 2.26428f
C3473 TOP.t6726 VSUBS 2.26428f
C3474 TOP.t6728 VSUBS 2.26428f
C3475 TOP.t6730 VSUBS 2.26428f
C3476 TOP.t6732 VSUBS 2.26428f
C3477 TOP.t6734 VSUBS 2.26428f
C3478 TOP.t6736 VSUBS 2.26428f
C3479 TOP.t6738 VSUBS 2.26428f
C3480 TOP.t6740 VSUBS 2.26428f
C3481 TOP.t6742 VSUBS 2.26428f
C3482 TOP.t6744 VSUBS 2.26428f
C3483 TOP.t6746 VSUBS 2.26428f
C3484 TOP.t6748 VSUBS 2.26428f
C3485 TOP.t6750 VSUBS 2.26428f
C3486 TOP.t6752 VSUBS 2.26428f
C3487 TOP.t6754 VSUBS 2.26428f
C3488 TOP.t6756 VSUBS 2.26428f
C3489 TOP.t6758 VSUBS 2.26428f
C3490 TOP.t6760 VSUBS 2.26428f
C3491 TOP.t6762 VSUBS 2.26428f
C3492 TOP.t6764 VSUBS 2.26428f
C3493 TOP.t6766 VSUBS 2.26428f
C3494 TOP.t6768 VSUBS 2.26428f
C3495 TOP.t6770 VSUBS 2.26428f
C3496 TOP.t6772 VSUBS 2.26428f
C3497 TOP.t6774 VSUBS 2.48846f
C3498 TOP.t3094 VSUBS 2.44165f
C3499 TOP.n42 VSUBS 0.548f
C3500 TOP.t6776 VSUBS 2.13635f
C3501 TOP.t6778 VSUBS 2.26428f
C3502 TOP.t6780 VSUBS 2.26428f
C3503 TOP.t6782 VSUBS 2.26428f
C3504 TOP.t6784 VSUBS 2.26428f
C3505 TOP.t6786 VSUBS 2.26428f
C3506 TOP.t6788 VSUBS 2.26428f
C3507 TOP.t6790 VSUBS 2.26428f
C3508 TOP.t6792 VSUBS 2.26428f
C3509 TOP.t6794 VSUBS 2.26428f
C3510 TOP.t6796 VSUBS 2.26428f
C3511 TOP.t6798 VSUBS 2.26428f
C3512 TOP.t6800 VSUBS 2.26428f
C3513 TOP.t6802 VSUBS 2.26428f
C3514 TOP.t6804 VSUBS 2.26428f
C3515 TOP.t6806 VSUBS 2.26428f
C3516 TOP.t6808 VSUBS 2.26428f
C3517 TOP.t6810 VSUBS 2.26428f
C3518 TOP.t6812 VSUBS 2.26428f
C3519 TOP.t6814 VSUBS 2.26428f
C3520 TOP.t6816 VSUBS 2.26428f
C3521 TOP.t6818 VSUBS 2.26428f
C3522 TOP.t6820 VSUBS 2.26428f
C3523 TOP.t6822 VSUBS 2.26428f
C3524 TOP.t6824 VSUBS 2.26428f
C3525 TOP.t6826 VSUBS 2.26428f
C3526 TOP.t6828 VSUBS 2.26428f
C3527 TOP.t6830 VSUBS 2.26428f
C3528 TOP.t6832 VSUBS 2.26428f
C3529 TOP.t6834 VSUBS 2.26428f
C3530 TOP.t6836 VSUBS 2.26428f
C3531 TOP.t6838 VSUBS 2.26428f
C3532 TOP.t6840 VSUBS 2.26428f
C3533 TOP.t6842 VSUBS 2.26428f
C3534 TOP.t6844 VSUBS 2.26428f
C3535 TOP.t6846 VSUBS 2.26428f
C3536 TOP.t6848 VSUBS 2.26428f
C3537 TOP.t6850 VSUBS 2.26428f
C3538 TOP.t6852 VSUBS 2.26428f
C3539 TOP.t6854 VSUBS 2.26428f
C3540 TOP.t6856 VSUBS 2.26428f
C3541 TOP.t6858 VSUBS 2.26428f
C3542 TOP.t6860 VSUBS 2.26428f
C3543 TOP.t6862 VSUBS 2.26428f
C3544 TOP.t6864 VSUBS 2.26428f
C3545 TOP.t6866 VSUBS 2.26428f
C3546 TOP.t6868 VSUBS 2.26428f
C3547 TOP.t6870 VSUBS 2.26428f
C3548 TOP.t6872 VSUBS 2.26428f
C3549 TOP.t6874 VSUBS 2.26428f
C3550 TOP.t6876 VSUBS 2.26428f
C3551 TOP.t6878 VSUBS 2.26428f
C3552 TOP.t6880 VSUBS 2.26428f
C3553 TOP.t6882 VSUBS 2.26428f
C3554 TOP.t6884 VSUBS 2.26428f
C3555 TOP.t6886 VSUBS 2.26428f
C3556 TOP.t6888 VSUBS 2.26428f
C3557 TOP.t6890 VSUBS 2.26428f
C3558 TOP.t6892 VSUBS 2.26428f
C3559 TOP.t6894 VSUBS 2.26428f
C3560 TOP.t6896 VSUBS 2.26428f
C3561 TOP.t6898 VSUBS 2.26428f
C3562 TOP.t6900 VSUBS 2.48846f
C3563 TOP.t3096 VSUBS 2.44165f
C3564 TOP.n43 VSUBS 0.548f
C3565 TOP.t6902 VSUBS 2.13635f
C3566 TOP.t6904 VSUBS 2.26428f
C3567 TOP.t6906 VSUBS 2.26428f
C3568 TOP.t6908 VSUBS 2.26428f
C3569 TOP.t6910 VSUBS 2.26428f
C3570 TOP.t6912 VSUBS 2.26428f
C3571 TOP.t6914 VSUBS 2.26428f
C3572 TOP.t6916 VSUBS 2.26428f
C3573 TOP.t6918 VSUBS 2.26428f
C3574 TOP.t6920 VSUBS 2.26428f
C3575 TOP.t6922 VSUBS 2.26428f
C3576 TOP.t6924 VSUBS 2.26428f
C3577 TOP.t6926 VSUBS 2.26428f
C3578 TOP.t6928 VSUBS 2.26428f
C3579 TOP.t6930 VSUBS 2.26428f
C3580 TOP.t6932 VSUBS 2.26428f
C3581 TOP.t6934 VSUBS 2.26428f
C3582 TOP.t6936 VSUBS 2.26428f
C3583 TOP.t6938 VSUBS 2.26428f
C3584 TOP.t6940 VSUBS 2.26428f
C3585 TOP.t6942 VSUBS 2.26428f
C3586 TOP.t6944 VSUBS 2.26428f
C3587 TOP.t6946 VSUBS 2.26428f
C3588 TOP.t6948 VSUBS 2.26428f
C3589 TOP.t6950 VSUBS 2.26428f
C3590 TOP.t6952 VSUBS 2.26428f
C3591 TOP.t6954 VSUBS 2.26428f
C3592 TOP.t6956 VSUBS 2.26428f
C3593 TOP.t6958 VSUBS 2.26428f
C3594 TOP.t6960 VSUBS 2.26428f
C3595 TOP.t6962 VSUBS 2.26428f
C3596 TOP.t6964 VSUBS 2.26428f
C3597 TOP.t6966 VSUBS 2.26428f
C3598 TOP.t6968 VSUBS 2.26428f
C3599 TOP.t6970 VSUBS 2.26428f
C3600 TOP.t6972 VSUBS 2.26428f
C3601 TOP.t6974 VSUBS 2.26428f
C3602 TOP.t6976 VSUBS 2.26428f
C3603 TOP.t6978 VSUBS 2.26428f
C3604 TOP.t6980 VSUBS 2.26428f
C3605 TOP.t6982 VSUBS 2.26428f
C3606 TOP.t6984 VSUBS 2.26428f
C3607 TOP.t6986 VSUBS 2.26428f
C3608 TOP.t6988 VSUBS 2.26428f
C3609 TOP.t6990 VSUBS 2.26428f
C3610 TOP.t6992 VSUBS 2.26428f
C3611 TOP.t6994 VSUBS 2.26428f
C3612 TOP.t6996 VSUBS 2.26428f
C3613 TOP.t6998 VSUBS 2.26428f
C3614 TOP.t7000 VSUBS 2.26428f
C3615 TOP.t7002 VSUBS 2.26428f
C3616 TOP.t7004 VSUBS 2.26428f
C3617 TOP.t7006 VSUBS 2.26428f
C3618 TOP.t7008 VSUBS 2.26428f
C3619 TOP.t7010 VSUBS 2.26428f
C3620 TOP.t7012 VSUBS 2.26428f
C3621 TOP.t7014 VSUBS 2.26428f
C3622 TOP.t7016 VSUBS 2.26428f
C3623 TOP.t7018 VSUBS 2.26428f
C3624 TOP.t7020 VSUBS 2.26428f
C3625 TOP.t7022 VSUBS 2.26428f
C3626 TOP.t7024 VSUBS 2.26428f
C3627 TOP.t7026 VSUBS 2.48846f
C3628 TOP.t3098 VSUBS 2.44165f
C3629 TOP.n44 VSUBS 0.548f
C3630 TOP.t7028 VSUBS 2.13635f
C3631 TOP.t7030 VSUBS 2.26428f
C3632 TOP.t7032 VSUBS 2.26428f
C3633 TOP.t7034 VSUBS 2.26428f
C3634 TOP.t7036 VSUBS 2.26428f
C3635 TOP.t7038 VSUBS 2.26428f
C3636 TOP.t7040 VSUBS 2.26428f
C3637 TOP.t7042 VSUBS 2.26428f
C3638 TOP.t7044 VSUBS 2.26428f
C3639 TOP.t7046 VSUBS 2.26428f
C3640 TOP.t7048 VSUBS 2.26428f
C3641 TOP.t7050 VSUBS 2.26428f
C3642 TOP.t7052 VSUBS 2.26428f
C3643 TOP.t7054 VSUBS 2.26428f
C3644 TOP.t7056 VSUBS 2.26428f
C3645 TOP.t7058 VSUBS 2.26428f
C3646 TOP.t7060 VSUBS 2.26428f
C3647 TOP.t7062 VSUBS 2.26428f
C3648 TOP.t7064 VSUBS 2.26428f
C3649 TOP.t7066 VSUBS 2.26428f
C3650 TOP.t7068 VSUBS 2.26428f
C3651 TOP.t7070 VSUBS 2.26428f
C3652 TOP.t7072 VSUBS 2.26428f
C3653 TOP.t7074 VSUBS 2.26428f
C3654 TOP.t7076 VSUBS 2.26428f
C3655 TOP.t7078 VSUBS 2.26428f
C3656 TOP.t7080 VSUBS 2.26428f
C3657 TOP.t7082 VSUBS 2.26428f
C3658 TOP.t7084 VSUBS 2.26428f
C3659 TOP.t7086 VSUBS 2.26428f
C3660 TOP.t7088 VSUBS 2.26428f
C3661 TOP.t7090 VSUBS 2.26428f
C3662 TOP.t7092 VSUBS 2.26428f
C3663 TOP.t7094 VSUBS 2.26428f
C3664 TOP.t7096 VSUBS 2.26428f
C3665 TOP.t7098 VSUBS 2.26428f
C3666 TOP.t7100 VSUBS 2.26428f
C3667 TOP.t7102 VSUBS 2.26428f
C3668 TOP.t7104 VSUBS 2.26428f
C3669 TOP.t7106 VSUBS 2.26428f
C3670 TOP.t7108 VSUBS 2.26428f
C3671 TOP.t7110 VSUBS 2.26428f
C3672 TOP.t7112 VSUBS 2.26428f
C3673 TOP.t7114 VSUBS 2.26428f
C3674 TOP.t7116 VSUBS 2.26428f
C3675 TOP.t7118 VSUBS 2.26428f
C3676 TOP.t7120 VSUBS 2.26428f
C3677 TOP.t7122 VSUBS 2.26428f
C3678 TOP.t7124 VSUBS 2.26428f
C3679 TOP.t7126 VSUBS 2.26428f
C3680 TOP.t7128 VSUBS 2.26428f
C3681 TOP.t7130 VSUBS 2.26428f
C3682 TOP.t7132 VSUBS 2.26428f
C3683 TOP.t7134 VSUBS 2.26428f
C3684 TOP.t7136 VSUBS 2.26428f
C3685 TOP.t7138 VSUBS 2.26428f
C3686 TOP.t7140 VSUBS 2.26428f
C3687 TOP.t7142 VSUBS 2.26428f
C3688 TOP.t7144 VSUBS 2.26428f
C3689 TOP.t7146 VSUBS 2.26428f
C3690 TOP.t7148 VSUBS 2.26428f
C3691 TOP.t7150 VSUBS 2.26428f
C3692 TOP.t7152 VSUBS 2.48846f
C3693 TOP.t3100 VSUBS 2.44165f
C3694 TOP.n45 VSUBS 0.548f
C3695 TOP.t7154 VSUBS 2.13635f
C3696 TOP.t7156 VSUBS 2.26428f
C3697 TOP.t7158 VSUBS 2.26428f
C3698 TOP.t7160 VSUBS 2.26428f
C3699 TOP.t7162 VSUBS 2.26428f
C3700 TOP.t7164 VSUBS 2.26428f
C3701 TOP.t7166 VSUBS 2.26428f
C3702 TOP.t7168 VSUBS 2.26428f
C3703 TOP.t7170 VSUBS 2.26428f
C3704 TOP.t7172 VSUBS 2.26428f
C3705 TOP.t7174 VSUBS 2.26428f
C3706 TOP.t7176 VSUBS 2.26428f
C3707 TOP.t7178 VSUBS 2.26428f
C3708 TOP.t7180 VSUBS 2.26428f
C3709 TOP.t7182 VSUBS 2.26428f
C3710 TOP.t7184 VSUBS 2.26428f
C3711 TOP.t7186 VSUBS 2.26428f
C3712 TOP.t7188 VSUBS 2.26428f
C3713 TOP.t7190 VSUBS 2.26428f
C3714 TOP.t7192 VSUBS 2.26428f
C3715 TOP.t7194 VSUBS 2.26428f
C3716 TOP.t7196 VSUBS 2.26428f
C3717 TOP.t7198 VSUBS 2.26428f
C3718 TOP.t7200 VSUBS 2.26428f
C3719 TOP.t7202 VSUBS 2.26428f
C3720 TOP.t7204 VSUBS 2.26428f
C3721 TOP.t7206 VSUBS 2.26428f
C3722 TOP.t7208 VSUBS 2.26428f
C3723 TOP.t7210 VSUBS 2.26428f
C3724 TOP.t7212 VSUBS 2.26428f
C3725 TOP.t7214 VSUBS 2.26428f
C3726 TOP.t7216 VSUBS 2.26428f
C3727 TOP.t7218 VSUBS 2.26428f
C3728 TOP.t7220 VSUBS 2.26428f
C3729 TOP.t7222 VSUBS 2.26428f
C3730 TOP.t7224 VSUBS 2.26428f
C3731 TOP.t7226 VSUBS 2.26428f
C3732 TOP.t7228 VSUBS 2.26428f
C3733 TOP.t7230 VSUBS 2.26428f
C3734 TOP.t7232 VSUBS 2.26428f
C3735 TOP.t7234 VSUBS 2.26428f
C3736 TOP.t7236 VSUBS 2.26428f
C3737 TOP.t7238 VSUBS 2.26428f
C3738 TOP.t7240 VSUBS 2.26428f
C3739 TOP.t7242 VSUBS 2.26428f
C3740 TOP.t7244 VSUBS 2.26428f
C3741 TOP.t7246 VSUBS 2.26428f
C3742 TOP.t7248 VSUBS 2.26428f
C3743 TOP.t7250 VSUBS 2.26428f
C3744 TOP.t7252 VSUBS 2.26428f
C3745 TOP.t7254 VSUBS 2.26428f
C3746 TOP.t7256 VSUBS 2.26428f
C3747 TOP.t7258 VSUBS 2.26428f
C3748 TOP.t7260 VSUBS 2.26428f
C3749 TOP.t7262 VSUBS 2.26428f
C3750 TOP.t7264 VSUBS 2.26428f
C3751 TOP.t7266 VSUBS 2.26428f
C3752 TOP.t7268 VSUBS 2.26428f
C3753 TOP.t7270 VSUBS 2.26428f
C3754 TOP.t7272 VSUBS 2.26428f
C3755 TOP.t7274 VSUBS 2.26428f
C3756 TOP.t7276 VSUBS 2.26428f
C3757 TOP.t7278 VSUBS 2.48846f
C3758 TOP.t3102 VSUBS 2.46712f
C3759 TOP.n46 VSUBS 0.548f
C3760 TOP.t3104 VSUBS 2.11835f
C3761 TOP.t3106 VSUBS 2.24628f
C3762 TOP.t3108 VSUBS 2.24628f
C3763 TOP.t3110 VSUBS 2.24628f
C3764 TOP.t3112 VSUBS 2.24628f
C3765 TOP.t3114 VSUBS 2.24628f
C3766 TOP.t3116 VSUBS 2.24628f
C3767 TOP.t3118 VSUBS 2.24628f
C3768 TOP.t3120 VSUBS 2.24628f
C3769 TOP.t3122 VSUBS 2.24628f
C3770 TOP.t3124 VSUBS 2.24628f
C3771 TOP.t3126 VSUBS 2.24628f
C3772 TOP.t3128 VSUBS 2.24628f
C3773 TOP.t3130 VSUBS 2.24628f
C3774 TOP.t3132 VSUBS 2.24628f
C3775 TOP.t3134 VSUBS 2.24628f
C3776 TOP.t3136 VSUBS 2.24628f
C3777 TOP.t3138 VSUBS 2.24628f
C3778 TOP.t3140 VSUBS 2.24628f
C3779 TOP.t3142 VSUBS 2.24628f
C3780 TOP.t3144 VSUBS 2.24628f
C3781 TOP.t3146 VSUBS 2.24628f
C3782 TOP.t3148 VSUBS 2.24628f
C3783 TOP.t3150 VSUBS 2.24628f
C3784 TOP.t3152 VSUBS 2.24628f
C3785 TOP.t3154 VSUBS 2.24628f
C3786 TOP.t3156 VSUBS 2.24628f
C3787 TOP.t3158 VSUBS 2.24628f
C3788 TOP.t3160 VSUBS 2.24628f
C3789 TOP.t3162 VSUBS 2.24628f
C3790 TOP.t3164 VSUBS 2.24628f
C3791 TOP.t3166 VSUBS 2.24628f
C3792 TOP.t3168 VSUBS 2.24628f
C3793 TOP.t3170 VSUBS 2.24628f
C3794 TOP.t3172 VSUBS 2.24628f
C3795 TOP.t3174 VSUBS 2.24628f
C3796 TOP.t3176 VSUBS 2.24628f
C3797 TOP.t3178 VSUBS 2.24628f
C3798 TOP.t3180 VSUBS 2.24628f
C3799 TOP.t3182 VSUBS 2.24628f
C3800 TOP.t3184 VSUBS 2.24628f
C3801 TOP.t3186 VSUBS 2.24628f
C3802 TOP.t3188 VSUBS 2.24628f
C3803 TOP.t3190 VSUBS 2.24628f
C3804 TOP.t3192 VSUBS 2.24628f
C3805 TOP.t3194 VSUBS 2.24628f
C3806 TOP.t3196 VSUBS 2.24628f
C3807 TOP.t3198 VSUBS 2.24628f
C3808 TOP.t3200 VSUBS 2.24628f
C3809 TOP.t3202 VSUBS 2.24628f
C3810 TOP.t3204 VSUBS 2.24628f
C3811 TOP.t3206 VSUBS 2.24628f
C3812 TOP.t3208 VSUBS 2.24628f
C3813 TOP.t3210 VSUBS 2.24628f
C3814 TOP.t3212 VSUBS 2.24628f
C3815 TOP.t3214 VSUBS 2.24628f
C3816 TOP.t3216 VSUBS 2.24628f
C3817 TOP.t3218 VSUBS 2.24628f
C3818 TOP.t3220 VSUBS 2.24628f
C3819 TOP.t3222 VSUBS 2.24628f
C3820 TOP.t3224 VSUBS 2.24628f
C3821 TOP.t3226 VSUBS 2.24628f
C3822 TOP.t3228 VSUBS 2.46629f
C3823 TOP.t7280 VSUBS 2.42297f
C3824 TOP.n47 VSUBS 0.548f
C3825 TOP.t3230 VSUBS 2.11835f
C3826 TOP.t3232 VSUBS 2.24628f
C3827 TOP.t3234 VSUBS 2.24628f
C3828 TOP.t3236 VSUBS 2.24628f
C3829 TOP.t3238 VSUBS 2.24628f
C3830 TOP.t3240 VSUBS 2.24628f
C3831 TOP.t3242 VSUBS 2.24628f
C3832 TOP.t3244 VSUBS 2.24628f
C3833 TOP.t3246 VSUBS 2.24628f
C3834 TOP.t3248 VSUBS 2.24628f
C3835 TOP.t3250 VSUBS 2.24628f
C3836 TOP.t3252 VSUBS 2.24628f
C3837 TOP.t3254 VSUBS 2.24628f
C3838 TOP.t3256 VSUBS 2.24628f
C3839 TOP.t3258 VSUBS 2.24628f
C3840 TOP.t3260 VSUBS 2.24628f
C3841 TOP.t3262 VSUBS 2.24628f
C3842 TOP.t3264 VSUBS 2.24628f
C3843 TOP.t3266 VSUBS 2.24628f
C3844 TOP.t3268 VSUBS 2.24628f
C3845 TOP.t3270 VSUBS 2.24628f
C3846 TOP.t3272 VSUBS 2.24628f
C3847 TOP.t3274 VSUBS 2.24628f
C3848 TOP.t3276 VSUBS 2.24628f
C3849 TOP.t3278 VSUBS 2.24628f
C3850 TOP.t3280 VSUBS 2.24628f
C3851 TOP.t3282 VSUBS 2.24628f
C3852 TOP.t3284 VSUBS 2.24628f
C3853 TOP.t3286 VSUBS 2.24628f
C3854 TOP.t3288 VSUBS 2.24628f
C3855 TOP.t3290 VSUBS 2.24628f
C3856 TOP.t3292 VSUBS 2.24628f
C3857 TOP.t3294 VSUBS 2.24628f
C3858 TOP.t3296 VSUBS 2.24628f
C3859 TOP.t3298 VSUBS 2.24628f
C3860 TOP.t3300 VSUBS 2.24628f
C3861 TOP.t3302 VSUBS 2.24628f
C3862 TOP.t3304 VSUBS 2.24628f
C3863 TOP.t3306 VSUBS 2.24628f
C3864 TOP.t3308 VSUBS 2.24628f
C3865 TOP.t3310 VSUBS 2.24628f
C3866 TOP.t3312 VSUBS 2.24628f
C3867 TOP.t3314 VSUBS 2.24628f
C3868 TOP.t3316 VSUBS 2.24628f
C3869 TOP.t3318 VSUBS 2.24628f
C3870 TOP.t3320 VSUBS 2.24628f
C3871 TOP.t3322 VSUBS 2.24628f
C3872 TOP.t3324 VSUBS 2.24628f
C3873 TOP.t3326 VSUBS 2.24628f
C3874 TOP.t3328 VSUBS 2.24628f
C3875 TOP.t3330 VSUBS 2.24628f
C3876 TOP.t3332 VSUBS 2.24628f
C3877 TOP.t3334 VSUBS 2.24628f
C3878 TOP.t3336 VSUBS 2.24628f
C3879 TOP.t3338 VSUBS 2.24628f
C3880 TOP.t3340 VSUBS 2.24628f
C3881 TOP.t3342 VSUBS 2.24628f
C3882 TOP.t3344 VSUBS 2.24628f
C3883 TOP.t3346 VSUBS 2.24628f
C3884 TOP.t3348 VSUBS 2.24628f
C3885 TOP.t3350 VSUBS 2.24628f
C3886 TOP.t3352 VSUBS 2.24628f
C3887 TOP.t3354 VSUBS 2.46629f
C3888 TOP.t7282 VSUBS 2.42297f
C3889 TOP.n48 VSUBS 0.548f
C3890 TOP.t3356 VSUBS 2.11835f
C3891 TOP.t3358 VSUBS 2.24628f
C3892 TOP.t3360 VSUBS 2.24628f
C3893 TOP.t3362 VSUBS 2.24628f
C3894 TOP.t3364 VSUBS 2.24628f
C3895 TOP.t3366 VSUBS 2.24628f
C3896 TOP.t3368 VSUBS 2.24628f
C3897 TOP.t3370 VSUBS 2.24628f
C3898 TOP.t3372 VSUBS 2.24628f
C3899 TOP.t3374 VSUBS 2.24628f
C3900 TOP.t3376 VSUBS 2.24628f
C3901 TOP.t3378 VSUBS 2.24628f
C3902 TOP.t3380 VSUBS 2.24628f
C3903 TOP.t3382 VSUBS 2.24628f
C3904 TOP.t3384 VSUBS 2.24628f
C3905 TOP.t3386 VSUBS 2.24628f
C3906 TOP.t3388 VSUBS 2.24628f
C3907 TOP.t3390 VSUBS 2.24628f
C3908 TOP.t3392 VSUBS 2.24628f
C3909 TOP.t3394 VSUBS 2.24628f
C3910 TOP.t3396 VSUBS 2.24628f
C3911 TOP.t3398 VSUBS 2.24628f
C3912 TOP.t3400 VSUBS 2.24628f
C3913 TOP.t3402 VSUBS 2.24628f
C3914 TOP.t3404 VSUBS 2.24628f
C3915 TOP.t3406 VSUBS 2.24628f
C3916 TOP.t3408 VSUBS 2.24628f
C3917 TOP.t3410 VSUBS 2.24628f
C3918 TOP.t3412 VSUBS 2.24628f
C3919 TOP.t3414 VSUBS 2.24628f
C3920 TOP.t3416 VSUBS 2.24628f
C3921 TOP.t3418 VSUBS 2.24628f
C3922 TOP.t3420 VSUBS 2.24628f
C3923 TOP.t3422 VSUBS 2.24628f
C3924 TOP.t3424 VSUBS 2.24628f
C3925 TOP.t3426 VSUBS 2.24628f
C3926 TOP.t3428 VSUBS 2.24628f
C3927 TOP.t3430 VSUBS 2.24628f
C3928 TOP.t3432 VSUBS 2.24628f
C3929 TOP.t3434 VSUBS 2.24628f
C3930 TOP.t3436 VSUBS 2.24628f
C3931 TOP.t3438 VSUBS 2.24628f
C3932 TOP.t3440 VSUBS 2.24628f
C3933 TOP.t3442 VSUBS 2.24628f
C3934 TOP.t3444 VSUBS 2.24628f
C3935 TOP.t3446 VSUBS 2.24628f
C3936 TOP.t3448 VSUBS 2.24628f
C3937 TOP.t3450 VSUBS 2.24628f
C3938 TOP.t3452 VSUBS 2.24628f
C3939 TOP.t3454 VSUBS 2.24628f
C3940 TOP.t3456 VSUBS 2.24628f
C3941 TOP.t3458 VSUBS 2.24628f
C3942 TOP.t3460 VSUBS 2.24628f
C3943 TOP.t3462 VSUBS 2.24628f
C3944 TOP.t3464 VSUBS 2.24628f
C3945 TOP.t3466 VSUBS 2.24628f
C3946 TOP.t3468 VSUBS 2.24628f
C3947 TOP.t3470 VSUBS 2.24628f
C3948 TOP.t3472 VSUBS 2.24628f
C3949 TOP.t3474 VSUBS 2.24628f
C3950 TOP.t3476 VSUBS 2.24628f
C3951 TOP.t3478 VSUBS 2.24628f
C3952 TOP.t3480 VSUBS 2.46629f
C3953 TOP.t7284 VSUBS 2.42297f
C3954 TOP.n49 VSUBS 0.548f
C3955 TOP.t3482 VSUBS 2.11835f
C3956 TOP.t3484 VSUBS 2.24628f
C3957 TOP.t3486 VSUBS 2.24628f
C3958 TOP.t3488 VSUBS 2.24628f
C3959 TOP.t3490 VSUBS 2.24628f
C3960 TOP.t3492 VSUBS 2.24628f
C3961 TOP.t3494 VSUBS 2.24628f
C3962 TOP.t3496 VSUBS 2.24628f
C3963 TOP.t3498 VSUBS 2.24628f
C3964 TOP.t3500 VSUBS 2.24628f
C3965 TOP.t3502 VSUBS 2.24628f
C3966 TOP.t3504 VSUBS 2.24628f
C3967 TOP.t3506 VSUBS 2.24628f
C3968 TOP.t3508 VSUBS 2.24628f
C3969 TOP.t3510 VSUBS 2.24628f
C3970 TOP.t3512 VSUBS 2.24628f
C3971 TOP.t3514 VSUBS 2.24628f
C3972 TOP.t3516 VSUBS 2.24628f
C3973 TOP.t3518 VSUBS 2.24628f
C3974 TOP.t3520 VSUBS 2.24628f
C3975 TOP.t3522 VSUBS 2.24628f
C3976 TOP.t3524 VSUBS 2.24628f
C3977 TOP.t3526 VSUBS 2.24628f
C3978 TOP.t3528 VSUBS 2.24628f
C3979 TOP.t3530 VSUBS 2.24628f
C3980 TOP.t3532 VSUBS 2.24628f
C3981 TOP.t3534 VSUBS 2.24628f
C3982 TOP.t3536 VSUBS 2.24628f
C3983 TOP.t3538 VSUBS 2.24628f
C3984 TOP.t3540 VSUBS 2.24628f
C3985 TOP.t3542 VSUBS 2.24628f
C3986 TOP.t3544 VSUBS 2.24628f
C3987 TOP.t3546 VSUBS 2.24628f
C3988 TOP.t3548 VSUBS 2.24628f
C3989 TOP.t3550 VSUBS 2.24628f
C3990 TOP.t3552 VSUBS 2.24628f
C3991 TOP.t3554 VSUBS 2.24628f
C3992 TOP.t3556 VSUBS 2.24628f
C3993 TOP.t3558 VSUBS 2.24628f
C3994 TOP.t3560 VSUBS 2.24628f
C3995 TOP.t3562 VSUBS 2.24628f
C3996 TOP.t3564 VSUBS 2.24628f
C3997 TOP.t3566 VSUBS 2.24628f
C3998 TOP.t3568 VSUBS 2.24628f
C3999 TOP.t3570 VSUBS 2.24628f
C4000 TOP.t3572 VSUBS 2.24628f
C4001 TOP.t3574 VSUBS 2.24628f
C4002 TOP.t3576 VSUBS 2.24628f
C4003 TOP.t3578 VSUBS 2.24628f
C4004 TOP.t3580 VSUBS 2.24628f
C4005 TOP.t3582 VSUBS 2.24628f
C4006 TOP.t3584 VSUBS 2.24628f
C4007 TOP.t3586 VSUBS 2.24628f
C4008 TOP.t3588 VSUBS 2.24628f
C4009 TOP.t3590 VSUBS 2.24628f
C4010 TOP.t3592 VSUBS 2.24628f
C4011 TOP.t3594 VSUBS 2.24628f
C4012 TOP.t3596 VSUBS 2.24628f
C4013 TOP.t3598 VSUBS 2.24628f
C4014 TOP.t3600 VSUBS 2.24628f
C4015 TOP.t3602 VSUBS 2.24628f
C4016 TOP.t3604 VSUBS 2.24628f
C4017 TOP.t3606 VSUBS 2.46629f
C4018 TOP.t7286 VSUBS 2.42297f
C4019 TOP.n50 VSUBS 0.548f
C4020 TOP.t3608 VSUBS 2.11835f
C4021 TOP.t3610 VSUBS 2.24628f
C4022 TOP.t3612 VSUBS 2.24628f
C4023 TOP.t3614 VSUBS 2.24628f
C4024 TOP.t3616 VSUBS 2.24628f
C4025 TOP.t3618 VSUBS 2.24628f
C4026 TOP.t3620 VSUBS 2.24628f
C4027 TOP.t3622 VSUBS 2.24628f
C4028 TOP.t3624 VSUBS 2.24628f
C4029 TOP.t3626 VSUBS 2.24628f
C4030 TOP.t3628 VSUBS 2.24628f
C4031 TOP.t3630 VSUBS 2.24628f
C4032 TOP.t3632 VSUBS 2.24628f
C4033 TOP.t3634 VSUBS 2.24628f
C4034 TOP.t3636 VSUBS 2.24628f
C4035 TOP.t3638 VSUBS 2.24628f
C4036 TOP.t3640 VSUBS 2.24628f
C4037 TOP.t3642 VSUBS 2.24628f
C4038 TOP.t3644 VSUBS 2.24628f
C4039 TOP.t3646 VSUBS 2.24628f
C4040 TOP.t3648 VSUBS 2.24628f
C4041 TOP.t3650 VSUBS 2.24628f
C4042 TOP.t3652 VSUBS 2.24628f
C4043 TOP.t3654 VSUBS 2.24628f
C4044 TOP.t3656 VSUBS 2.24628f
C4045 TOP.t3658 VSUBS 2.24628f
C4046 TOP.t3660 VSUBS 2.24628f
C4047 TOP.t3662 VSUBS 2.24628f
C4048 TOP.t3664 VSUBS 2.24628f
C4049 TOP.t3666 VSUBS 2.24628f
C4050 TOP.t3668 VSUBS 2.24628f
C4051 TOP.t3670 VSUBS 2.24628f
C4052 TOP.t3672 VSUBS 2.24628f
C4053 TOP.t3674 VSUBS 2.24628f
C4054 TOP.t3676 VSUBS 2.24628f
C4055 TOP.t3678 VSUBS 2.24628f
C4056 TOP.t3680 VSUBS 2.24628f
C4057 TOP.t3682 VSUBS 2.24628f
C4058 TOP.t3684 VSUBS 2.24628f
C4059 TOP.t3686 VSUBS 2.24628f
C4060 TOP.t3688 VSUBS 2.24628f
C4061 TOP.t3690 VSUBS 2.24628f
C4062 TOP.t3692 VSUBS 2.24628f
C4063 TOP.t3694 VSUBS 2.24628f
C4064 TOP.t3696 VSUBS 2.24628f
C4065 TOP.t3698 VSUBS 2.24628f
C4066 TOP.t3700 VSUBS 2.24628f
C4067 TOP.t3702 VSUBS 2.24628f
C4068 TOP.t3704 VSUBS 2.24628f
C4069 TOP.t3706 VSUBS 2.24628f
C4070 TOP.t3708 VSUBS 2.24628f
C4071 TOP.t3710 VSUBS 2.24628f
C4072 TOP.t3712 VSUBS 2.24628f
C4073 TOP.t3714 VSUBS 2.24628f
C4074 TOP.t3716 VSUBS 2.24628f
C4075 TOP.t3718 VSUBS 2.24628f
C4076 TOP.t3720 VSUBS 2.24628f
C4077 TOP.t3722 VSUBS 2.24628f
C4078 TOP.t3724 VSUBS 2.24628f
C4079 TOP.t3726 VSUBS 2.24628f
C4080 TOP.t3728 VSUBS 2.24628f
C4081 TOP.t3730 VSUBS 2.24628f
C4082 TOP.t3732 VSUBS 2.46629f
C4083 TOP.t7288 VSUBS 2.42297f
C4084 TOP.n51 VSUBS 0.548f
C4085 TOP.t3734 VSUBS 2.11835f
C4086 TOP.t3736 VSUBS 2.24628f
C4087 TOP.t3738 VSUBS 2.24628f
C4088 TOP.t3740 VSUBS 2.24628f
C4089 TOP.t3742 VSUBS 2.24628f
C4090 TOP.t3744 VSUBS 2.24628f
C4091 TOP.t3746 VSUBS 2.24628f
C4092 TOP.t3748 VSUBS 2.24628f
C4093 TOP.t3750 VSUBS 2.24628f
C4094 TOP.t3752 VSUBS 2.24628f
C4095 TOP.t3754 VSUBS 2.24628f
C4096 TOP.t3756 VSUBS 2.24628f
C4097 TOP.t3758 VSUBS 2.24628f
C4098 TOP.t3760 VSUBS 2.24628f
C4099 TOP.t3762 VSUBS 2.24628f
C4100 TOP.t3764 VSUBS 2.24628f
C4101 TOP.t3766 VSUBS 2.24628f
C4102 TOP.t3768 VSUBS 2.24628f
C4103 TOP.t3770 VSUBS 2.24628f
C4104 TOP.t3772 VSUBS 2.24628f
C4105 TOP.t3774 VSUBS 2.24628f
C4106 TOP.t3776 VSUBS 2.24628f
C4107 TOP.t3778 VSUBS 2.24628f
C4108 TOP.t3780 VSUBS 2.24628f
C4109 TOP.t3782 VSUBS 2.24628f
C4110 TOP.t3784 VSUBS 2.24628f
C4111 TOP.t3786 VSUBS 2.24628f
C4112 TOP.t3788 VSUBS 2.24628f
C4113 TOP.t3790 VSUBS 2.24628f
C4114 TOP.t3792 VSUBS 2.24628f
C4115 TOP.t3794 VSUBS 2.24628f
C4116 TOP.t3796 VSUBS 2.24628f
C4117 TOP.t3798 VSUBS 2.24628f
C4118 TOP.t3800 VSUBS 2.24628f
C4119 TOP.t3802 VSUBS 2.24628f
C4120 TOP.t3804 VSUBS 2.24628f
C4121 TOP.t3806 VSUBS 2.24628f
C4122 TOP.t3808 VSUBS 2.24628f
C4123 TOP.t3810 VSUBS 2.24628f
C4124 TOP.t3812 VSUBS 2.24628f
C4125 TOP.t3814 VSUBS 2.24628f
C4126 TOP.t3816 VSUBS 2.24628f
C4127 TOP.t3818 VSUBS 2.24628f
C4128 TOP.t3820 VSUBS 2.24628f
C4129 TOP.t3822 VSUBS 2.24628f
C4130 TOP.t3824 VSUBS 2.24628f
C4131 TOP.t3826 VSUBS 2.24628f
C4132 TOP.t3828 VSUBS 2.24628f
C4133 TOP.t3830 VSUBS 2.24628f
C4134 TOP.t3832 VSUBS 2.24628f
C4135 TOP.t3834 VSUBS 2.24628f
C4136 TOP.t3836 VSUBS 2.24628f
C4137 TOP.t3838 VSUBS 2.24628f
C4138 TOP.t3840 VSUBS 2.24628f
C4139 TOP.t3842 VSUBS 2.24628f
C4140 TOP.t3844 VSUBS 2.24628f
C4141 TOP.t3846 VSUBS 2.24628f
C4142 TOP.t3848 VSUBS 2.24628f
C4143 TOP.t3850 VSUBS 2.24628f
C4144 TOP.t3852 VSUBS 2.24628f
C4145 TOP.t3854 VSUBS 2.24628f
C4146 TOP.t3856 VSUBS 2.24628f
C4147 TOP.t3858 VSUBS 2.46629f
C4148 TOP.t7290 VSUBS 2.42297f
C4149 TOP.n52 VSUBS 0.548f
C4150 TOP.t3860 VSUBS 2.11835f
C4151 TOP.t3862 VSUBS 2.24628f
C4152 TOP.t3864 VSUBS 2.24628f
C4153 TOP.t3866 VSUBS 2.24628f
C4154 TOP.t3868 VSUBS 2.24628f
C4155 TOP.t3870 VSUBS 2.24628f
C4156 TOP.t3872 VSUBS 2.24628f
C4157 TOP.t3874 VSUBS 2.24628f
C4158 TOP.t3876 VSUBS 2.24628f
C4159 TOP.t3878 VSUBS 2.24628f
C4160 TOP.t3880 VSUBS 2.24628f
C4161 TOP.t3882 VSUBS 2.24628f
C4162 TOP.t3884 VSUBS 2.24628f
C4163 TOP.t3886 VSUBS 2.24628f
C4164 TOP.t3888 VSUBS 2.24628f
C4165 TOP.t3890 VSUBS 2.24628f
C4166 TOP.t3892 VSUBS 2.24628f
C4167 TOP.t3894 VSUBS 2.24628f
C4168 TOP.t3896 VSUBS 2.24628f
C4169 TOP.t3898 VSUBS 2.24628f
C4170 TOP.t3900 VSUBS 2.24628f
C4171 TOP.t3902 VSUBS 2.24628f
C4172 TOP.t3904 VSUBS 2.24628f
C4173 TOP.t3906 VSUBS 2.24628f
C4174 TOP.t3908 VSUBS 2.24628f
C4175 TOP.t3910 VSUBS 2.24628f
C4176 TOP.t3912 VSUBS 2.24628f
C4177 TOP.t3914 VSUBS 2.24628f
C4178 TOP.t3916 VSUBS 2.24628f
C4179 TOP.t3918 VSUBS 2.24628f
C4180 TOP.t3920 VSUBS 2.24628f
C4181 TOP.t3922 VSUBS 2.24628f
C4182 TOP.t3924 VSUBS 2.24628f
C4183 TOP.t3926 VSUBS 2.24628f
C4184 TOP.t3928 VSUBS 2.24628f
C4185 TOP.t3930 VSUBS 2.24628f
C4186 TOP.t3932 VSUBS 2.24628f
C4187 TOP.t3934 VSUBS 2.24628f
C4188 TOP.t3936 VSUBS 2.24628f
C4189 TOP.t3938 VSUBS 2.24628f
C4190 TOP.t3940 VSUBS 2.24628f
C4191 TOP.t3942 VSUBS 2.24628f
C4192 TOP.t3944 VSUBS 2.24628f
C4193 TOP.t3946 VSUBS 2.24628f
C4194 TOP.t3948 VSUBS 2.24628f
C4195 TOP.t3950 VSUBS 2.24628f
C4196 TOP.t3952 VSUBS 2.24628f
C4197 TOP.t3954 VSUBS 2.24628f
C4198 TOP.t3956 VSUBS 2.24628f
C4199 TOP.t3958 VSUBS 2.24628f
C4200 TOP.t3960 VSUBS 2.24628f
C4201 TOP.t3962 VSUBS 2.24628f
C4202 TOP.t3964 VSUBS 2.24628f
C4203 TOP.t3966 VSUBS 2.24628f
C4204 TOP.t3968 VSUBS 2.24628f
C4205 TOP.t3970 VSUBS 2.24628f
C4206 TOP.t3972 VSUBS 2.24628f
C4207 TOP.t3974 VSUBS 2.24628f
C4208 TOP.t3976 VSUBS 2.24628f
C4209 TOP.t3978 VSUBS 2.24628f
C4210 TOP.t3980 VSUBS 2.24628f
C4211 TOP.t3982 VSUBS 2.24628f
C4212 TOP.t3984 VSUBS 2.46629f
C4213 TOP.t7292 VSUBS 2.42297f
C4214 TOP.n53 VSUBS 0.548f
C4215 TOP.t3986 VSUBS 2.11835f
C4216 TOP.t3988 VSUBS 2.24628f
C4217 TOP.t3990 VSUBS 2.24628f
C4218 TOP.t3992 VSUBS 2.24628f
C4219 TOP.t3994 VSUBS 2.24628f
C4220 TOP.t3996 VSUBS 2.24628f
C4221 TOP.t3998 VSUBS 2.24628f
C4222 TOP.t4000 VSUBS 2.24628f
C4223 TOP.t4002 VSUBS 2.24628f
C4224 TOP.t4004 VSUBS 2.24628f
C4225 TOP.t4006 VSUBS 2.24628f
C4226 TOP.t4008 VSUBS 2.24628f
C4227 TOP.t4010 VSUBS 2.24628f
C4228 TOP.t4012 VSUBS 2.24628f
C4229 TOP.t4014 VSUBS 2.24628f
C4230 TOP.t4016 VSUBS 2.24628f
C4231 TOP.t4018 VSUBS 2.24628f
C4232 TOP.t4020 VSUBS 2.24628f
C4233 TOP.t4022 VSUBS 2.24628f
C4234 TOP.t4024 VSUBS 2.24628f
C4235 TOP.t4026 VSUBS 2.24628f
C4236 TOP.t4028 VSUBS 2.24628f
C4237 TOP.t4030 VSUBS 2.24628f
C4238 TOP.t4032 VSUBS 2.24628f
C4239 TOP.t4034 VSUBS 2.24628f
C4240 TOP.t4036 VSUBS 2.24628f
C4241 TOP.t4038 VSUBS 2.24628f
C4242 TOP.t4040 VSUBS 2.24628f
C4243 TOP.t4042 VSUBS 2.24628f
C4244 TOP.t4044 VSUBS 2.24628f
C4245 TOP.t4046 VSUBS 2.24628f
C4246 TOP.t4048 VSUBS 2.24628f
C4247 TOP.t4050 VSUBS 2.24628f
C4248 TOP.t4052 VSUBS 2.24628f
C4249 TOP.t4054 VSUBS 2.24628f
C4250 TOP.t4056 VSUBS 2.24628f
C4251 TOP.t4058 VSUBS 2.24628f
C4252 TOP.t4060 VSUBS 2.24628f
C4253 TOP.t4062 VSUBS 2.24628f
C4254 TOP.t4064 VSUBS 2.24628f
C4255 TOP.t4066 VSUBS 2.24628f
C4256 TOP.t4068 VSUBS 2.24628f
C4257 TOP.t4070 VSUBS 2.24628f
C4258 TOP.t4072 VSUBS 2.24628f
C4259 TOP.t4074 VSUBS 2.24628f
C4260 TOP.t4076 VSUBS 2.24628f
C4261 TOP.t4078 VSUBS 2.24628f
C4262 TOP.t4080 VSUBS 2.24628f
C4263 TOP.t4082 VSUBS 2.24628f
C4264 TOP.t4084 VSUBS 2.24628f
C4265 TOP.t4086 VSUBS 2.24628f
C4266 TOP.t4088 VSUBS 2.24628f
C4267 TOP.t4090 VSUBS 2.24628f
C4268 TOP.t4092 VSUBS 2.24628f
C4269 TOP.t4094 VSUBS 2.24628f
C4270 TOP.t4096 VSUBS 2.24628f
C4271 TOP.t4098 VSUBS 2.24628f
C4272 TOP.t4100 VSUBS 2.24628f
C4273 TOP.t4102 VSUBS 2.24628f
C4274 TOP.t4104 VSUBS 2.24628f
C4275 TOP.t4106 VSUBS 2.24628f
C4276 TOP.t4108 VSUBS 2.24628f
C4277 TOP.t4110 VSUBS 2.46629f
C4278 TOP.t7294 VSUBS 2.45029f
C4279 TOP.n54 VSUBS 0.548f
C4280 TOP.t4112 VSUBS 2.11835f
C4281 TOP.t4114 VSUBS 2.24628f
C4282 TOP.t4116 VSUBS 2.24628f
C4283 TOP.t4118 VSUBS 2.24628f
C4284 TOP.t4120 VSUBS 2.24628f
C4285 TOP.t4122 VSUBS 2.24628f
C4286 TOP.t4124 VSUBS 2.24628f
C4287 TOP.t4126 VSUBS 2.24628f
C4288 TOP.t4128 VSUBS 2.24628f
C4289 TOP.t4130 VSUBS 2.24628f
C4290 TOP.t4132 VSUBS 2.24628f
C4291 TOP.t4134 VSUBS 2.24628f
C4292 TOP.t4136 VSUBS 2.24628f
C4293 TOP.t4138 VSUBS 2.24628f
C4294 TOP.t4140 VSUBS 2.24628f
C4295 TOP.t4142 VSUBS 2.24628f
C4296 TOP.t4144 VSUBS 2.24628f
C4297 TOP.t4146 VSUBS 2.24628f
C4298 TOP.t4148 VSUBS 2.24628f
C4299 TOP.t4150 VSUBS 2.24628f
C4300 TOP.t4152 VSUBS 2.24628f
C4301 TOP.t4154 VSUBS 2.24628f
C4302 TOP.t4156 VSUBS 2.24628f
C4303 TOP.t4158 VSUBS 2.24628f
C4304 TOP.t4160 VSUBS 2.24628f
C4305 TOP.t4162 VSUBS 2.24628f
C4306 TOP.t4164 VSUBS 2.24628f
C4307 TOP.t4166 VSUBS 2.24628f
C4308 TOP.t4168 VSUBS 2.24628f
C4309 TOP.t4170 VSUBS 2.24628f
C4310 TOP.t4172 VSUBS 2.24628f
C4311 TOP.t4174 VSUBS 2.24628f
C4312 TOP.t4176 VSUBS 2.24628f
C4313 TOP.t4178 VSUBS 2.24628f
C4314 TOP.t4180 VSUBS 2.24628f
C4315 TOP.t4182 VSUBS 2.24628f
C4316 TOP.t4184 VSUBS 2.24628f
C4317 TOP.t4186 VSUBS 2.24628f
C4318 TOP.t4188 VSUBS 2.24628f
C4319 TOP.t4190 VSUBS 2.24628f
C4320 TOP.t4192 VSUBS 2.24628f
C4321 TOP.t4194 VSUBS 2.24628f
C4322 TOP.t4196 VSUBS 2.24628f
C4323 TOP.t4198 VSUBS 2.24628f
C4324 TOP.t4200 VSUBS 2.24628f
C4325 TOP.t4202 VSUBS 2.24628f
C4326 TOP.t4204 VSUBS 2.24628f
C4327 TOP.t4206 VSUBS 2.24628f
C4328 TOP.t4208 VSUBS 2.24628f
C4329 TOP.t4210 VSUBS 2.24628f
C4330 TOP.t4212 VSUBS 2.24628f
C4331 TOP.t4214 VSUBS 2.24628f
C4332 TOP.t4216 VSUBS 2.24628f
C4333 TOP.t4218 VSUBS 2.24628f
C4334 TOP.t4220 VSUBS 2.24628f
C4335 TOP.t4222 VSUBS 2.24628f
C4336 TOP.t4224 VSUBS 2.24628f
C4337 TOP.t4226 VSUBS 2.24628f
C4338 TOP.t4228 VSUBS 2.24628f
C4339 TOP.t4230 VSUBS 2.24628f
C4340 TOP.t4232 VSUBS 2.24628f
C4341 TOP.t4234 VSUBS 2.24628f
C4342 TOP.t4236 VSUBS 2.46629f
C4343 TOP.t1016 VSUBS 2.39768f
C4344 TOP.n55 VSUBS 0.548f
C4345 TOP.t4238 VSUBS 2.11835f
C4346 TOP.t4240 VSUBS 2.24628f
C4347 TOP.t4242 VSUBS 2.24628f
C4348 TOP.t4244 VSUBS 2.24628f
C4349 TOP.t4246 VSUBS 2.24628f
C4350 TOP.t4248 VSUBS 2.24628f
C4351 TOP.t4250 VSUBS 2.24628f
C4352 TOP.t4252 VSUBS 2.24628f
C4353 TOP.t4254 VSUBS 2.24628f
C4354 TOP.t4256 VSUBS 2.24628f
C4355 TOP.t4258 VSUBS 2.24628f
C4356 TOP.t4260 VSUBS 2.24628f
C4357 TOP.t4262 VSUBS 2.24628f
C4358 TOP.t4264 VSUBS 2.24628f
C4359 TOP.t4266 VSUBS 2.24628f
C4360 TOP.t4268 VSUBS 2.24628f
C4361 TOP.t4270 VSUBS 2.24628f
C4362 TOP.t4272 VSUBS 2.24628f
C4363 TOP.t4274 VSUBS 2.24628f
C4364 TOP.t4276 VSUBS 2.24628f
C4365 TOP.t4278 VSUBS 2.24628f
C4366 TOP.t4280 VSUBS 2.24628f
C4367 TOP.t4282 VSUBS 2.24628f
C4368 TOP.t4284 VSUBS 2.24628f
C4369 TOP.t4286 VSUBS 2.24628f
C4370 TOP.t4288 VSUBS 2.24628f
C4371 TOP.t4290 VSUBS 2.24628f
C4372 TOP.t4292 VSUBS 2.24628f
C4373 TOP.t4294 VSUBS 2.24628f
C4374 TOP.t4296 VSUBS 2.24628f
C4375 TOP.t4298 VSUBS 2.24628f
C4376 TOP.t4300 VSUBS 2.24628f
C4377 TOP.t4302 VSUBS 2.24628f
C4378 TOP.t4304 VSUBS 2.24628f
C4379 TOP.t4306 VSUBS 2.24628f
C4380 TOP.t4308 VSUBS 2.24628f
C4381 TOP.t4310 VSUBS 2.24628f
C4382 TOP.t4312 VSUBS 2.24628f
C4383 TOP.t4314 VSUBS 2.24628f
C4384 TOP.t4316 VSUBS 2.24628f
C4385 TOP.t4318 VSUBS 2.24628f
C4386 TOP.t4320 VSUBS 2.24628f
C4387 TOP.t4322 VSUBS 2.24628f
C4388 TOP.t4324 VSUBS 2.24628f
C4389 TOP.t4326 VSUBS 2.24628f
C4390 TOP.t4328 VSUBS 2.24628f
C4391 TOP.t4330 VSUBS 2.24628f
C4392 TOP.t4332 VSUBS 2.24628f
C4393 TOP.t4334 VSUBS 2.24628f
C4394 TOP.t4336 VSUBS 2.24628f
C4395 TOP.t4338 VSUBS 2.24628f
C4396 TOP.t4340 VSUBS 2.24628f
C4397 TOP.t4342 VSUBS 2.24628f
C4398 TOP.t4344 VSUBS 2.24628f
C4399 TOP.t4346 VSUBS 2.24628f
C4400 TOP.t4348 VSUBS 2.24628f
C4401 TOP.t4350 VSUBS 2.24628f
C4402 TOP.t4352 VSUBS 2.24628f
C4403 TOP.t4354 VSUBS 2.24628f
C4404 TOP.t4356 VSUBS 2.24628f
C4405 TOP.t4358 VSUBS 2.24628f
C4406 TOP.t4360 VSUBS 2.24628f
C4407 TOP.t4362 VSUBS 2.46629f
C4408 TOP.t1018 VSUBS 2.39768f
C4409 TOP.n56 VSUBS 0.548f
C4410 TOP.t4364 VSUBS 2.11835f
C4411 TOP.t4366 VSUBS 2.24628f
C4412 TOP.t4368 VSUBS 2.24628f
C4413 TOP.t4370 VSUBS 2.24628f
C4414 TOP.t4372 VSUBS 2.24628f
C4415 TOP.t4374 VSUBS 2.24628f
C4416 TOP.t4376 VSUBS 2.24628f
C4417 TOP.t4378 VSUBS 2.24628f
C4418 TOP.t4380 VSUBS 2.24628f
C4419 TOP.t4382 VSUBS 2.24628f
C4420 TOP.t4384 VSUBS 2.24628f
C4421 TOP.t4386 VSUBS 2.24628f
C4422 TOP.t4388 VSUBS 2.24628f
C4423 TOP.t4390 VSUBS 2.24628f
C4424 TOP.t4392 VSUBS 2.24628f
C4425 TOP.t4394 VSUBS 2.24628f
C4426 TOP.t4396 VSUBS 2.24628f
C4427 TOP.t4398 VSUBS 2.24628f
C4428 TOP.t4400 VSUBS 2.24628f
C4429 TOP.t4402 VSUBS 2.24628f
C4430 TOP.t4404 VSUBS 2.24628f
C4431 TOP.t4406 VSUBS 2.24628f
C4432 TOP.t4408 VSUBS 2.24628f
C4433 TOP.t4410 VSUBS 2.24628f
C4434 TOP.t4412 VSUBS 2.24628f
C4435 TOP.t4414 VSUBS 2.24628f
C4436 TOP.t4416 VSUBS 2.24628f
C4437 TOP.t4418 VSUBS 2.24628f
C4438 TOP.t4420 VSUBS 2.24628f
C4439 TOP.t4422 VSUBS 2.24628f
C4440 TOP.t4424 VSUBS 2.24628f
C4441 TOP.t4426 VSUBS 2.24628f
C4442 TOP.t4428 VSUBS 2.24628f
C4443 TOP.t4430 VSUBS 2.24628f
C4444 TOP.t4432 VSUBS 2.24628f
C4445 TOP.t4434 VSUBS 2.24628f
C4446 TOP.t4436 VSUBS 2.24628f
C4447 TOP.t4438 VSUBS 2.24628f
C4448 TOP.t4440 VSUBS 2.24628f
C4449 TOP.t4442 VSUBS 2.24628f
C4450 TOP.t4444 VSUBS 2.24628f
C4451 TOP.t4446 VSUBS 2.24628f
C4452 TOP.t4448 VSUBS 2.24628f
C4453 TOP.t4450 VSUBS 2.24628f
C4454 TOP.t4452 VSUBS 2.24628f
C4455 TOP.t4454 VSUBS 2.24628f
C4456 TOP.t4456 VSUBS 2.24628f
C4457 TOP.t4458 VSUBS 2.24628f
C4458 TOP.t4460 VSUBS 2.24628f
C4459 TOP.t4462 VSUBS 2.24628f
C4460 TOP.t4464 VSUBS 2.24628f
C4461 TOP.t4466 VSUBS 2.24628f
C4462 TOP.t4468 VSUBS 2.24628f
C4463 TOP.t4470 VSUBS 2.24628f
C4464 TOP.t4472 VSUBS 2.24628f
C4465 TOP.t4474 VSUBS 2.24628f
C4466 TOP.t4476 VSUBS 2.24628f
C4467 TOP.t4478 VSUBS 2.24628f
C4468 TOP.t4480 VSUBS 2.24628f
C4469 TOP.t4482 VSUBS 2.24628f
C4470 TOP.t4484 VSUBS 2.24628f
C4471 TOP.t4486 VSUBS 2.24628f
C4472 TOP.t4488 VSUBS 2.46629f
C4473 TOP.t1020 VSUBS 2.39768f
C4474 TOP.n57 VSUBS 0.548f
C4475 TOP.t4490 VSUBS 2.11835f
C4476 TOP.t4492 VSUBS 2.24628f
C4477 TOP.t4494 VSUBS 2.24628f
C4478 TOP.t4496 VSUBS 2.24628f
C4479 TOP.t4498 VSUBS 2.24628f
C4480 TOP.t4500 VSUBS 2.24628f
C4481 TOP.t4502 VSUBS 2.24628f
C4482 TOP.t4504 VSUBS 2.24628f
C4483 TOP.t4506 VSUBS 2.24628f
C4484 TOP.t4508 VSUBS 2.24628f
C4485 TOP.t4510 VSUBS 2.24628f
C4486 TOP.t4512 VSUBS 2.24628f
C4487 TOP.t4514 VSUBS 2.24628f
C4488 TOP.t4516 VSUBS 2.24628f
C4489 TOP.t4518 VSUBS 2.24628f
C4490 TOP.t4520 VSUBS 2.24628f
C4491 TOP.t4522 VSUBS 2.24628f
C4492 TOP.t4524 VSUBS 2.24628f
C4493 TOP.t4526 VSUBS 2.24628f
C4494 TOP.t4528 VSUBS 2.24628f
C4495 TOP.t4530 VSUBS 2.24628f
C4496 TOP.t4532 VSUBS 2.24628f
C4497 TOP.t4534 VSUBS 2.24628f
C4498 TOP.t4536 VSUBS 2.24628f
C4499 TOP.t4538 VSUBS 2.24628f
C4500 TOP.t4540 VSUBS 2.24628f
C4501 TOP.t4542 VSUBS 2.24628f
C4502 TOP.t4544 VSUBS 2.24628f
C4503 TOP.t4546 VSUBS 2.24628f
C4504 TOP.t4548 VSUBS 2.24628f
C4505 TOP.t4550 VSUBS 2.24628f
C4506 TOP.t4552 VSUBS 2.24628f
C4507 TOP.t4554 VSUBS 2.24628f
C4508 TOP.t4556 VSUBS 2.24628f
C4509 TOP.t4558 VSUBS 2.24628f
C4510 TOP.t4560 VSUBS 2.24628f
C4511 TOP.t4562 VSUBS 2.24628f
C4512 TOP.t4564 VSUBS 2.24628f
C4513 TOP.t4566 VSUBS 2.24628f
C4514 TOP.t4568 VSUBS 2.24628f
C4515 TOP.t4570 VSUBS 2.24628f
C4516 TOP.t4572 VSUBS 2.24628f
C4517 TOP.t4574 VSUBS 2.24628f
C4518 TOP.t4576 VSUBS 2.24628f
C4519 TOP.t4578 VSUBS 2.24628f
C4520 TOP.t4580 VSUBS 2.24628f
C4521 TOP.t4582 VSUBS 2.24628f
C4522 TOP.t4584 VSUBS 2.24628f
C4523 TOP.t4586 VSUBS 2.24628f
C4524 TOP.t4588 VSUBS 2.24628f
C4525 TOP.t4590 VSUBS 2.24628f
C4526 TOP.t4592 VSUBS 2.24628f
C4527 TOP.t4594 VSUBS 2.24628f
C4528 TOP.t4596 VSUBS 2.24628f
C4529 TOP.t4598 VSUBS 2.24628f
C4530 TOP.t4600 VSUBS 2.24628f
C4531 TOP.t4602 VSUBS 2.24628f
C4532 TOP.t4604 VSUBS 2.24628f
C4533 TOP.t4606 VSUBS 2.24628f
C4534 TOP.t4608 VSUBS 2.24628f
C4535 TOP.t4610 VSUBS 2.24628f
C4536 TOP.t4612 VSUBS 2.24628f
C4537 TOP.t4614 VSUBS 2.46629f
C4538 TOP.t1022 VSUBS 2.42714f
C4539 TOP.n58 VSUBS 0.548f
C4540 TOP.t4616 VSUBS 2.11835f
C4541 TOP.t4618 VSUBS 2.24628f
C4542 TOP.t4620 VSUBS 2.24628f
C4543 TOP.t4622 VSUBS 2.24628f
C4544 TOP.t4624 VSUBS 2.24628f
C4545 TOP.t4626 VSUBS 2.24628f
C4546 TOP.t4628 VSUBS 2.24628f
C4547 TOP.t4630 VSUBS 2.24628f
C4548 TOP.t4632 VSUBS 2.24628f
C4549 TOP.t4634 VSUBS 2.24628f
C4550 TOP.t4636 VSUBS 2.24628f
C4551 TOP.t4638 VSUBS 2.24628f
C4552 TOP.t4640 VSUBS 2.24628f
C4553 TOP.t4642 VSUBS 2.24628f
C4554 TOP.t4644 VSUBS 2.24628f
C4555 TOP.t4646 VSUBS 2.24628f
C4556 TOP.t4648 VSUBS 2.24628f
C4557 TOP.t4650 VSUBS 2.24628f
C4558 TOP.t4652 VSUBS 2.24628f
C4559 TOP.t4654 VSUBS 2.24628f
C4560 TOP.t4656 VSUBS 2.24628f
C4561 TOP.t4658 VSUBS 2.24628f
C4562 TOP.t4660 VSUBS 2.24628f
C4563 TOP.t4662 VSUBS 2.24628f
C4564 TOP.t4664 VSUBS 2.24628f
C4565 TOP.t4666 VSUBS 2.24628f
C4566 TOP.t4668 VSUBS 2.24628f
C4567 TOP.t4670 VSUBS 2.24628f
C4568 TOP.t4672 VSUBS 2.24628f
C4569 TOP.t4674 VSUBS 2.24628f
C4570 TOP.t4676 VSUBS 2.24628f
C4571 TOP.t4678 VSUBS 2.24628f
C4572 TOP.t4680 VSUBS 2.24628f
C4573 TOP.t4682 VSUBS 2.24628f
C4574 TOP.t4684 VSUBS 2.24628f
C4575 TOP.t4686 VSUBS 2.24628f
C4576 TOP.t4688 VSUBS 2.24628f
C4577 TOP.t4690 VSUBS 2.24628f
C4578 TOP.t4692 VSUBS 2.24628f
C4579 TOP.t4694 VSUBS 2.24628f
C4580 TOP.t4696 VSUBS 2.24628f
C4581 TOP.t4698 VSUBS 2.24628f
C4582 TOP.t4700 VSUBS 2.24628f
C4583 TOP.t4702 VSUBS 2.24628f
C4584 TOP.t4704 VSUBS 2.24628f
C4585 TOP.t4706 VSUBS 2.24628f
C4586 TOP.t4708 VSUBS 2.24628f
C4587 TOP.t4710 VSUBS 2.24628f
C4588 TOP.t4712 VSUBS 2.24628f
C4589 TOP.t4714 VSUBS 2.24628f
C4590 TOP.t4716 VSUBS 2.24628f
C4591 TOP.t4718 VSUBS 2.24628f
C4592 TOP.t4720 VSUBS 2.24628f
C4593 TOP.t4722 VSUBS 2.24628f
C4594 TOP.t4724 VSUBS 2.24628f
C4595 TOP.t4726 VSUBS 2.24628f
C4596 TOP.t4728 VSUBS 2.24628f
C4597 TOP.t4730 VSUBS 2.24628f
C4598 TOP.t4732 VSUBS 2.24628f
C4599 TOP.t4734 VSUBS 2.24628f
C4600 TOP.t4736 VSUBS 2.24628f
C4601 TOP.t4738 VSUBS 2.24628f
C4602 TOP.t4740 VSUBS 2.46629f
C4603 TOP.t7804 VSUBS 2.38907f
C4604 TOP.n59 VSUBS 0.548f
C4605 TOP.t4742 VSUBS 2.11835f
C4606 TOP.t4744 VSUBS 2.24628f
C4607 TOP.t4746 VSUBS 2.24628f
C4608 TOP.t4748 VSUBS 2.24628f
C4609 TOP.t4750 VSUBS 2.24628f
C4610 TOP.t4752 VSUBS 2.24628f
C4611 TOP.t4754 VSUBS 2.24628f
C4612 TOP.t4756 VSUBS 2.24628f
C4613 TOP.t4758 VSUBS 2.24628f
C4614 TOP.t4760 VSUBS 2.24628f
C4615 TOP.t4762 VSUBS 2.24628f
C4616 TOP.t4764 VSUBS 2.24628f
C4617 TOP.t4766 VSUBS 2.24628f
C4618 TOP.t4768 VSUBS 2.24628f
C4619 TOP.t4770 VSUBS 2.24628f
C4620 TOP.t4772 VSUBS 2.24628f
C4621 TOP.t4774 VSUBS 2.24628f
C4622 TOP.t4776 VSUBS 2.24628f
C4623 TOP.t4778 VSUBS 2.24628f
C4624 TOP.t4780 VSUBS 2.24628f
C4625 TOP.t4782 VSUBS 2.24628f
C4626 TOP.t4784 VSUBS 2.24628f
C4627 TOP.t4786 VSUBS 2.24628f
C4628 TOP.t4788 VSUBS 2.24628f
C4629 TOP.t4790 VSUBS 2.24628f
C4630 TOP.t4792 VSUBS 2.24628f
C4631 TOP.t4794 VSUBS 2.24628f
C4632 TOP.t4796 VSUBS 2.24628f
C4633 TOP.t4798 VSUBS 2.24628f
C4634 TOP.t4800 VSUBS 2.24628f
C4635 TOP.t4802 VSUBS 2.24628f
C4636 TOP.t4804 VSUBS 2.24628f
C4637 TOP.t4806 VSUBS 2.24628f
C4638 TOP.t4808 VSUBS 2.24628f
C4639 TOP.t4810 VSUBS 2.24628f
C4640 TOP.t4812 VSUBS 2.24628f
C4641 TOP.t4814 VSUBS 2.24628f
C4642 TOP.t4816 VSUBS 2.24628f
C4643 TOP.t4818 VSUBS 2.24628f
C4644 TOP.t4820 VSUBS 2.24628f
C4645 TOP.t4822 VSUBS 2.24628f
C4646 TOP.t4824 VSUBS 2.24628f
C4647 TOP.t4826 VSUBS 2.24628f
C4648 TOP.t4828 VSUBS 2.24628f
C4649 TOP.t4830 VSUBS 2.24628f
C4650 TOP.t4832 VSUBS 2.24628f
C4651 TOP.t4834 VSUBS 2.24628f
C4652 TOP.t4836 VSUBS 2.24628f
C4653 TOP.t4838 VSUBS 2.24628f
C4654 TOP.t4840 VSUBS 2.24628f
C4655 TOP.t4842 VSUBS 2.24628f
C4656 TOP.t4844 VSUBS 2.24628f
C4657 TOP.t4846 VSUBS 2.24628f
C4658 TOP.t4848 VSUBS 2.24628f
C4659 TOP.t4850 VSUBS 2.24628f
C4660 TOP.t4852 VSUBS 2.24628f
C4661 TOP.t4854 VSUBS 2.24628f
C4662 TOP.t4856 VSUBS 2.24628f
C4663 TOP.t4858 VSUBS 2.24628f
C4664 TOP.t4860 VSUBS 2.24628f
C4665 TOP.t4862 VSUBS 2.24628f
C4666 TOP.t4864 VSUBS 2.24628f
C4667 TOP.t4866 VSUBS 2.46629f
C4668 TOP.t7806 VSUBS 2.42163f
C4669 TOP.n60 VSUBS 0.548f
C4670 TOP.t4868 VSUBS 2.11835f
C4671 TOP.t4870 VSUBS 2.24628f
C4672 TOP.t4872 VSUBS 2.24628f
C4673 TOP.t4874 VSUBS 2.24628f
C4674 TOP.t4876 VSUBS 2.24628f
C4675 TOP.t4878 VSUBS 2.24628f
C4676 TOP.t4880 VSUBS 2.24628f
C4677 TOP.t4882 VSUBS 2.24628f
C4678 TOP.t4884 VSUBS 2.24628f
C4679 TOP.t4886 VSUBS 2.24628f
C4680 TOP.t4888 VSUBS 2.24628f
C4681 TOP.t4890 VSUBS 2.24628f
C4682 TOP.t4892 VSUBS 2.24628f
C4683 TOP.t4894 VSUBS 2.24628f
C4684 TOP.t4896 VSUBS 2.24628f
C4685 TOP.t4898 VSUBS 2.24628f
C4686 TOP.t4900 VSUBS 2.24628f
C4687 TOP.t4902 VSUBS 2.24628f
C4688 TOP.t4904 VSUBS 2.24628f
C4689 TOP.t4906 VSUBS 2.24628f
C4690 TOP.t4908 VSUBS 2.24628f
C4691 TOP.t4910 VSUBS 2.24628f
C4692 TOP.t4912 VSUBS 2.24628f
C4693 TOP.t4914 VSUBS 2.24628f
C4694 TOP.t4916 VSUBS 2.24628f
C4695 TOP.t4918 VSUBS 2.24628f
C4696 TOP.t4920 VSUBS 2.24628f
C4697 TOP.t4922 VSUBS 2.24628f
C4698 TOP.t4924 VSUBS 2.24628f
C4699 TOP.t4926 VSUBS 2.24628f
C4700 TOP.t4928 VSUBS 2.24628f
C4701 TOP.t4930 VSUBS 2.24628f
C4702 TOP.t4932 VSUBS 2.24628f
C4703 TOP.t4934 VSUBS 2.24628f
C4704 TOP.t4936 VSUBS 2.24628f
C4705 TOP.t4938 VSUBS 2.24628f
C4706 TOP.t4940 VSUBS 2.24628f
C4707 TOP.t4942 VSUBS 2.24628f
C4708 TOP.t4944 VSUBS 2.24628f
C4709 TOP.t4946 VSUBS 2.24628f
C4710 TOP.t4948 VSUBS 2.24628f
C4711 TOP.t4950 VSUBS 2.24628f
C4712 TOP.t4952 VSUBS 2.24628f
C4713 TOP.t4954 VSUBS 2.24628f
C4714 TOP.t4956 VSUBS 2.24628f
C4715 TOP.t4958 VSUBS 2.24628f
C4716 TOP.t4960 VSUBS 2.24628f
C4717 TOP.t4962 VSUBS 2.24628f
C4718 TOP.t4964 VSUBS 2.24628f
C4719 TOP.t4966 VSUBS 2.24628f
C4720 TOP.t4968 VSUBS 2.24628f
C4721 TOP.t4970 VSUBS 2.24628f
C4722 TOP.t4972 VSUBS 2.24628f
C4723 TOP.t4974 VSUBS 2.24628f
C4724 TOP.t4976 VSUBS 2.24628f
C4725 TOP.t4978 VSUBS 2.24628f
C4726 TOP.t4980 VSUBS 2.24628f
C4727 TOP.t4982 VSUBS 2.24628f
C4728 TOP.t4984 VSUBS 2.24628f
C4729 TOP.t4986 VSUBS 2.24628f
C4730 TOP.t4988 VSUBS 2.24628f
C4731 TOP.t4990 VSUBS 2.24628f
C4732 TOP.t4992 VSUBS 2.46629f
C4733 TOP.t8062 VSUBS 10.0641f
C4734 TOP.n61 VSUBS 0.59615f
C4735 TOP.t5246 VSUBS 10.47995f
C4736 TOP.t5118 VSUBS 2.46629f
C4737 TOP.t5116 VSUBS 2.24628f
C4738 TOP.t5114 VSUBS 2.24628f
C4739 TOP.t5112 VSUBS 2.24628f
C4740 TOP.t5110 VSUBS 2.24628f
C4741 TOP.t5108 VSUBS 2.24628f
C4742 TOP.t5106 VSUBS 2.24628f
C4743 TOP.t5104 VSUBS 2.24628f
C4744 TOP.t5102 VSUBS 2.24628f
C4745 TOP.t5100 VSUBS 2.24628f
C4746 TOP.t5098 VSUBS 2.24628f
C4747 TOP.t5096 VSUBS 2.24628f
C4748 TOP.t5094 VSUBS 2.24628f
C4749 TOP.t5092 VSUBS 2.24628f
C4750 TOP.t5090 VSUBS 2.24628f
C4751 TOP.t5088 VSUBS 2.24628f
C4752 TOP.t5086 VSUBS 2.24628f
C4753 TOP.t5084 VSUBS 2.24628f
C4754 TOP.t5082 VSUBS 2.24628f
C4755 TOP.t5080 VSUBS 2.24628f
C4756 TOP.t5078 VSUBS 2.24628f
C4757 TOP.t5076 VSUBS 2.24628f
C4758 TOP.t5074 VSUBS 2.24628f
C4759 TOP.t5072 VSUBS 2.24628f
C4760 TOP.t5070 VSUBS 2.24628f
C4761 TOP.t5068 VSUBS 2.24628f
C4762 TOP.t5066 VSUBS 2.24628f
C4763 TOP.t5064 VSUBS 2.24628f
C4764 TOP.t5062 VSUBS 2.24628f
C4765 TOP.t5060 VSUBS 2.24628f
C4766 TOP.t5058 VSUBS 2.24628f
C4767 TOP.t5056 VSUBS 2.24628f
C4768 TOP.t5054 VSUBS 2.24628f
C4769 TOP.t5052 VSUBS 2.24628f
C4770 TOP.t5050 VSUBS 2.24628f
C4771 TOP.t5048 VSUBS 2.24628f
C4772 TOP.t5046 VSUBS 2.24628f
C4773 TOP.t5044 VSUBS 2.24628f
C4774 TOP.t5042 VSUBS 2.24628f
C4775 TOP.t5040 VSUBS 2.24628f
C4776 TOP.t5038 VSUBS 2.24628f
C4777 TOP.t5036 VSUBS 2.24628f
C4778 TOP.t5034 VSUBS 2.24628f
C4779 TOP.t5032 VSUBS 2.24628f
C4780 TOP.t5030 VSUBS 2.24628f
C4781 TOP.t5028 VSUBS 2.24628f
C4782 TOP.t5026 VSUBS 2.24628f
C4783 TOP.t5024 VSUBS 2.24628f
C4784 TOP.t5022 VSUBS 2.24628f
C4785 TOP.t5020 VSUBS 2.24628f
C4786 TOP.t5018 VSUBS 2.24628f
C4787 TOP.t5016 VSUBS 2.24628f
C4788 TOP.t5014 VSUBS 2.24628f
C4789 TOP.t5012 VSUBS 2.24628f
C4790 TOP.t5010 VSUBS 2.24628f
C4791 TOP.t5008 VSUBS 2.24628f
C4792 TOP.t5006 VSUBS 2.24628f
C4793 TOP.t5004 VSUBS 2.24628f
C4794 TOP.t5002 VSUBS 2.24628f
C4795 TOP.t5000 VSUBS 2.24628f
C4796 TOP.t4998 VSUBS 2.24628f
C4797 TOP.t4996 VSUBS 2.0955f
C4798 TOP.t4994 VSUBS 1.65439f
C4799 TOP.n62 VSUBS 0.20543f
C4800 B6.n0 VSUBS 0.52963f
C4801 B6.n1 VSUBS 0.42309f
C4802 B6.n2 VSUBS 0.42309f
C4803 B6.n3 VSUBS 0.42309f
C4804 B6.n4 VSUBS 0.42309f
C4805 B6.n5 VSUBS 0.42309f
C4806 B6.n6 VSUBS 0.42309f
C4807 B6.n7 VSUBS 0.42309f
C4808 B6.n8 VSUBS 0.42309f
C4809 B6.n9 VSUBS 0.42309f
C4810 B6.n10 VSUBS 0.42309f
C4811 B6.n11 VSUBS 0.42309f
C4812 B6.n12 VSUBS 0.42309f
C4813 B6.n13 VSUBS 0.42309f
C4814 B6.n14 VSUBS 0.42309f
C4815 B6.n15 VSUBS 0.42309f
C4816 B6.n16 VSUBS 0.42309f
C4817 B6.n17 VSUBS 0.42309f
C4818 B6.n18 VSUBS 0.42309f
C4819 B6.n19 VSUBS 0.42309f
C4820 B6.n20 VSUBS 0.42309f
C4821 B6.n21 VSUBS 0.42309f
C4822 B6.n22 VSUBS 0.42309f
C4823 B6.n23 VSUBS 0.42309f
C4824 B6.n24 VSUBS 0.42309f
C4825 B6.n25 VSUBS 0.42309f
C4826 B6.n26 VSUBS 0.42309f
C4827 B6.n27 VSUBS 0.42309f
C4828 B6.n28 VSUBS 0.42309f
C4829 B6.n29 VSUBS 0.55017f
C4830 B6.n30 VSUBS 41.412f
C4831 B6.n31 VSUBS 0.52963f
C4832 B6.n32 VSUBS 0.42309f
C4833 B6.n33 VSUBS 0.42309f
C4834 B6.n34 VSUBS 0.42309f
C4835 B6.n35 VSUBS 0.42309f
C4836 B6.n36 VSUBS 0.42309f
C4837 B6.n37 VSUBS 0.42309f
C4838 B6.n38 VSUBS 0.42309f
C4839 B6.n39 VSUBS 0.42309f
C4840 B6.n40 VSUBS 0.42309f
C4841 B6.n41 VSUBS 0.42309f
C4842 B6.n42 VSUBS 0.42309f
C4843 B6.n43 VSUBS 0.42309f
C4844 B6.n44 VSUBS 0.42309f
C4845 B6.n45 VSUBS 0.42309f
C4846 B6.n46 VSUBS 0.42309f
C4847 B6.n47 VSUBS 0.42309f
C4848 B6.n48 VSUBS 0.42309f
C4849 B6.n49 VSUBS 0.42309f
C4850 B6.n50 VSUBS 0.42309f
C4851 B6.n51 VSUBS 0.42309f
C4852 B6.n52 VSUBS 0.42309f
C4853 B6.n53 VSUBS 0.42309f
C4854 B6.n54 VSUBS 0.42309f
C4855 B6.n55 VSUBS 0.42309f
C4856 B6.n56 VSUBS 0.42309f
C4857 B6.n57 VSUBS 0.42309f
C4858 B6.n58 VSUBS 0.42309f
C4859 B6.n59 VSUBS 0.42309f
C4860 B6.n60 VSUBS 8.97599f
C4861 B6.n61 VSUBS 21.1149f
C4862 B11.n0 VSUBS 2.05829f
C4863 B11.n1 VSUBS 1.16845f
C4864 B11.n2 VSUBS 1.16845f
C4865 B11.n3 VSUBS 1.16845f
C4866 B11.n4 VSUBS 1.16845f
C4867 B11.n5 VSUBS 1.16845f
C4868 B11.n6 VSUBS 1.16845f
C4869 B11.n7 VSUBS 1.16845f
C4870 B11.n8 VSUBS 1.16845f
C4871 B11.n9 VSUBS 1.16845f
C4872 B11.n10 VSUBS 1.16845f
C4873 B11.n11 VSUBS 1.16845f
C4874 B11.n12 VSUBS 1.16845f
C4875 B11.n13 VSUBS 1.16845f
C4876 B11.n14 VSUBS 6.69121f
C4877 B11.n15 VSUBS 0.50287f
C4878 B11.n16 VSUBS 0.40171f
C4879 B11.n17 VSUBS 0.40171f
C4880 B11.n18 VSUBS 0.40171f
C4881 B11.n19 VSUBS 0.40171f
C4882 B11.n20 VSUBS 0.40171f
C4883 B11.n21 VSUBS 0.40171f
C4884 B11.n22 VSUBS 0.40171f
C4885 B11.n23 VSUBS 0.40171f
C4886 B11.n24 VSUBS 0.40171f
C4887 B11.n25 VSUBS 0.40171f
C4888 B11.n26 VSUBS 0.40171f
C4889 B11.n27 VSUBS 0.40171f
C4890 B11.n28 VSUBS 0.40171f
C4891 B11.n29 VSUBS 0.40171f
C4892 B11.n30 VSUBS 0.40171f
C4893 B11.n31 VSUBS 0.40171f
C4894 B11.n32 VSUBS 0.40171f
C4895 B11.n33 VSUBS 0.40171f
C4896 B11.n34 VSUBS 0.40171f
C4897 B11.n35 VSUBS 0.40171f
C4898 B11.n36 VSUBS 0.40171f
C4899 B11.n37 VSUBS 0.40171f
C4900 B11.n38 VSUBS 0.40171f
C4901 B11.n39 VSUBS 0.40171f
C4902 B11.n40 VSUBS 0.40171f
C4903 B11.n41 VSUBS 0.40171f
C4904 B11.n42 VSUBS 0.40171f
C4905 B11.n43 VSUBS 0.40171f
C4906 B11.n44 VSUBS 0.40171f
C4907 B11.n45 VSUBS 0.40171f
C4908 B11.n46 VSUBS 0.40171f
C4909 B11.n47 VSUBS 0.40171f
C4910 B11.n48 VSUBS 0.40171f
C4911 B11.n49 VSUBS 0.40171f
C4912 B11.n50 VSUBS 0.40171f
C4913 B11.n51 VSUBS 0.40171f
C4914 B11.n52 VSUBS 0.40171f
C4915 B11.n53 VSUBS 0.40171f
C4916 B11.n54 VSUBS 0.40171f
C4917 B11.n55 VSUBS 0.40171f
C4918 B11.n56 VSUBS 0.40171f
C4919 B11.n57 VSUBS 0.40171f
C4920 B11.n58 VSUBS 0.40171f
C4921 B11.n59 VSUBS 0.40171f
C4922 B11.n60 VSUBS 0.40171f
C4923 B11.n61 VSUBS 0.40171f
C4924 B11.n62 VSUBS 0.40171f
C4925 B11.n63 VSUBS 0.40171f
C4926 B11.n64 VSUBS 0.40171f
C4927 B11.n65 VSUBS 0.40171f
C4928 B11.n66 VSUBS 0.40171f
C4929 B11.n67 VSUBS 0.40171f
C4930 B11.n68 VSUBS 0.40171f
C4931 B11.n69 VSUBS 0.40171f
C4932 B11.n70 VSUBS 0.40171f
C4933 B11.n71 VSUBS 0.40171f
C4934 B11.n72 VSUBS 0.40171f
C4935 B11.n73 VSUBS 0.40171f
C4936 B11.n74 VSUBS 0.40171f
C4937 B11.n75 VSUBS 0.40171f
C4938 B11.n76 VSUBS 0.74614f
C4939 B11.n77 VSUBS 6.63442f
C4940 B11.n78 VSUBS 0.50287f
C4941 B11.n79 VSUBS 0.40171f
C4942 B11.n80 VSUBS 0.40171f
C4943 B11.n81 VSUBS 0.40171f
C4944 B11.n82 VSUBS 0.40171f
C4945 B11.n83 VSUBS 0.40171f
C4946 B11.n84 VSUBS 0.40171f
C4947 B11.n85 VSUBS 0.40171f
C4948 B11.n86 VSUBS 0.40171f
C4949 B11.n87 VSUBS 0.40171f
C4950 B11.n88 VSUBS 0.40171f
C4951 B11.n89 VSUBS 0.40171f
C4952 B11.n90 VSUBS 0.40171f
C4953 B11.n91 VSUBS 0.40171f
C4954 B11.n92 VSUBS 0.40171f
C4955 B11.n93 VSUBS 0.40171f
C4956 B11.n94 VSUBS 0.40171f
C4957 B11.n95 VSUBS 0.40171f
C4958 B11.n96 VSUBS 0.40171f
C4959 B11.n97 VSUBS 0.40171f
C4960 B11.n98 VSUBS 0.40171f
C4961 B11.n99 VSUBS 0.40171f
C4962 B11.n100 VSUBS 0.40171f
C4963 B11.n101 VSUBS 0.40171f
C4964 B11.n102 VSUBS 0.40171f
C4965 B11.n103 VSUBS 0.40171f
C4966 B11.n104 VSUBS 0.40171f
C4967 B11.n105 VSUBS 0.40171f
C4968 B11.n106 VSUBS 0.40171f
C4969 B11.n107 VSUBS 0.40171f
C4970 B11.n108 VSUBS 0.40171f
C4971 B11.n109 VSUBS 0.40171f
C4972 B11.n110 VSUBS 0.40171f
C4973 B11.n111 VSUBS 0.40171f
C4974 B11.n112 VSUBS 0.40171f
C4975 B11.n113 VSUBS 0.40171f
C4976 B11.n114 VSUBS 0.40171f
C4977 B11.n115 VSUBS 0.40171f
C4978 B11.n116 VSUBS 0.40171f
C4979 B11.n117 VSUBS 0.40171f
C4980 B11.n118 VSUBS 0.40171f
C4981 B11.n119 VSUBS 0.40171f
C4982 B11.n120 VSUBS 0.40171f
C4983 B11.n121 VSUBS 0.40171f
C4984 B11.n122 VSUBS 0.40171f
C4985 B11.n123 VSUBS 0.40171f
C4986 B11.n124 VSUBS 0.40171f
C4987 B11.n125 VSUBS 0.40171f
C4988 B11.n126 VSUBS 0.40171f
C4989 B11.n127 VSUBS 0.40171f
C4990 B11.n128 VSUBS 0.40171f
C4991 B11.n129 VSUBS 0.40171f
C4992 B11.n130 VSUBS 0.40171f
C4993 B11.n131 VSUBS 0.40171f
C4994 B11.n132 VSUBS 0.40171f
C4995 B11.n133 VSUBS 0.40171f
C4996 B11.n134 VSUBS 0.40171f
C4997 B11.n135 VSUBS 0.40171f
C4998 B11.n136 VSUBS 0.40171f
C4999 B11.n137 VSUBS 0.40171f
C5000 B11.n138 VSUBS 0.40171f
C5001 B11.n139 VSUBS 0.74614f
C5002 B11.n140 VSUBS 1.11165f
C5003 B11.n141 VSUBS 0.50287f
C5004 B11.n142 VSUBS 0.40171f
C5005 B11.n143 VSUBS 0.40171f
C5006 B11.n144 VSUBS 0.40171f
C5007 B11.n145 VSUBS 0.40171f
C5008 B11.n146 VSUBS 0.40171f
C5009 B11.n147 VSUBS 0.40171f
C5010 B11.n148 VSUBS 0.40171f
C5011 B11.n149 VSUBS 0.40171f
C5012 B11.n150 VSUBS 0.40171f
C5013 B11.n151 VSUBS 0.40171f
C5014 B11.n152 VSUBS 0.40171f
C5015 B11.n153 VSUBS 0.40171f
C5016 B11.n154 VSUBS 0.40171f
C5017 B11.n155 VSUBS 0.40171f
C5018 B11.n156 VSUBS 0.40171f
C5019 B11.n157 VSUBS 0.40171f
C5020 B11.n158 VSUBS 0.40171f
C5021 B11.n159 VSUBS 0.40171f
C5022 B11.n160 VSUBS 0.40171f
C5023 B11.n161 VSUBS 0.40171f
C5024 B11.n162 VSUBS 0.40171f
C5025 B11.n163 VSUBS 0.40171f
C5026 B11.n164 VSUBS 0.40171f
C5027 B11.n165 VSUBS 0.40171f
C5028 B11.n166 VSUBS 0.40171f
C5029 B11.n167 VSUBS 0.40171f
C5030 B11.n168 VSUBS 0.40171f
C5031 B11.n169 VSUBS 0.40171f
C5032 B11.n170 VSUBS 0.40171f
C5033 B11.n171 VSUBS 0.40171f
C5034 B11.n172 VSUBS 0.40171f
C5035 B11.n173 VSUBS 0.40171f
C5036 B11.n174 VSUBS 0.40171f
C5037 B11.n175 VSUBS 0.40171f
C5038 B11.n176 VSUBS 0.40171f
C5039 B11.n177 VSUBS 0.40171f
C5040 B11.n178 VSUBS 0.40171f
C5041 B11.n179 VSUBS 0.40171f
C5042 B11.n180 VSUBS 0.40171f
C5043 B11.n181 VSUBS 0.40171f
C5044 B11.n182 VSUBS 0.40171f
C5045 B11.n183 VSUBS 0.40171f
C5046 B11.n184 VSUBS 0.40171f
C5047 B11.n185 VSUBS 0.40171f
C5048 B11.n186 VSUBS 0.40171f
C5049 B11.n187 VSUBS 0.40171f
C5050 B11.n188 VSUBS 0.40171f
C5051 B11.n189 VSUBS 0.40171f
C5052 B11.n190 VSUBS 0.40171f
C5053 B11.n191 VSUBS 0.40171f
C5054 B11.n192 VSUBS 0.40171f
C5055 B11.n193 VSUBS 0.40171f
C5056 B11.n194 VSUBS 0.40171f
C5057 B11.n195 VSUBS 0.40171f
C5058 B11.n196 VSUBS 0.40171f
C5059 B11.n197 VSUBS 0.40171f
C5060 B11.n198 VSUBS 0.40171f
C5061 B11.n199 VSUBS 0.40171f
C5062 B11.n200 VSUBS 0.40171f
C5063 B11.n201 VSUBS 0.40171f
C5064 B11.n202 VSUBS 0.74614f
C5065 B11.n203 VSUBS 1.11165f
C5066 B11.n204 VSUBS 0.50287f
C5067 B11.n205 VSUBS 0.40171f
C5068 B11.n206 VSUBS 0.40171f
C5069 B11.n207 VSUBS 0.40171f
C5070 B11.n208 VSUBS 0.40171f
C5071 B11.n209 VSUBS 0.40171f
C5072 B11.n210 VSUBS 0.40171f
C5073 B11.n211 VSUBS 0.40171f
C5074 B11.n212 VSUBS 0.40171f
C5075 B11.n213 VSUBS 0.40171f
C5076 B11.n214 VSUBS 0.40171f
C5077 B11.n215 VSUBS 0.40171f
C5078 B11.n216 VSUBS 0.40171f
C5079 B11.n217 VSUBS 0.40171f
C5080 B11.n218 VSUBS 0.40171f
C5081 B11.n219 VSUBS 0.40171f
C5082 B11.n220 VSUBS 0.40171f
C5083 B11.n221 VSUBS 0.40171f
C5084 B11.n222 VSUBS 0.40171f
C5085 B11.n223 VSUBS 0.40171f
C5086 B11.n224 VSUBS 0.40171f
C5087 B11.n225 VSUBS 0.40171f
C5088 B11.n226 VSUBS 0.40171f
C5089 B11.n227 VSUBS 0.40171f
C5090 B11.n228 VSUBS 0.40171f
C5091 B11.n229 VSUBS 0.40171f
C5092 B11.n230 VSUBS 0.40171f
C5093 B11.n231 VSUBS 0.40171f
C5094 B11.n232 VSUBS 0.40171f
C5095 B11.n233 VSUBS 0.40171f
C5096 B11.n234 VSUBS 0.40171f
C5097 B11.n235 VSUBS 0.40171f
C5098 B11.n236 VSUBS 0.40171f
C5099 B11.n237 VSUBS 0.40171f
C5100 B11.n238 VSUBS 0.40171f
C5101 B11.n239 VSUBS 0.40171f
C5102 B11.n240 VSUBS 0.40171f
C5103 B11.n241 VSUBS 0.40171f
C5104 B11.n242 VSUBS 0.40171f
C5105 B11.n243 VSUBS 0.40171f
C5106 B11.n244 VSUBS 0.40171f
C5107 B11.n245 VSUBS 0.40171f
C5108 B11.n246 VSUBS 0.40171f
C5109 B11.n247 VSUBS 0.40171f
C5110 B11.n248 VSUBS 0.40171f
C5111 B11.n249 VSUBS 0.40171f
C5112 B11.n250 VSUBS 0.40171f
C5113 B11.n251 VSUBS 0.40171f
C5114 B11.n252 VSUBS 0.40171f
C5115 B11.n253 VSUBS 0.40171f
C5116 B11.n254 VSUBS 0.40171f
C5117 B11.n255 VSUBS 0.40171f
C5118 B11.n256 VSUBS 0.40171f
C5119 B11.n257 VSUBS 0.40171f
C5120 B11.n258 VSUBS 0.40171f
C5121 B11.n259 VSUBS 0.40171f
C5122 B11.n260 VSUBS 0.40171f
C5123 B11.n261 VSUBS 0.40171f
C5124 B11.n262 VSUBS 0.40171f
C5125 B11.n263 VSUBS 0.40171f
C5126 B11.n264 VSUBS 0.40171f
C5127 B11.n265 VSUBS 0.74614f
C5128 B11.n266 VSUBS 1.11165f
C5129 B11.n267 VSUBS 0.50287f
C5130 B11.n268 VSUBS 0.40171f
C5131 B11.n269 VSUBS 0.40171f
C5132 B11.n270 VSUBS 0.40171f
C5133 B11.n271 VSUBS 0.40171f
C5134 B11.n272 VSUBS 0.40171f
C5135 B11.n273 VSUBS 0.40171f
C5136 B11.n274 VSUBS 0.40171f
C5137 B11.n275 VSUBS 0.40171f
C5138 B11.n276 VSUBS 0.40171f
C5139 B11.n277 VSUBS 0.40171f
C5140 B11.n278 VSUBS 0.40171f
C5141 B11.n279 VSUBS 0.40171f
C5142 B11.n280 VSUBS 0.40171f
C5143 B11.n281 VSUBS 0.40171f
C5144 B11.n282 VSUBS 0.40171f
C5145 B11.n283 VSUBS 0.40171f
C5146 B11.n284 VSUBS 0.40171f
C5147 B11.n285 VSUBS 0.40171f
C5148 B11.n286 VSUBS 0.40171f
C5149 B11.n287 VSUBS 0.40171f
C5150 B11.n288 VSUBS 0.40171f
C5151 B11.n289 VSUBS 0.40171f
C5152 B11.n290 VSUBS 0.40171f
C5153 B11.n291 VSUBS 0.40171f
C5154 B11.n292 VSUBS 0.40171f
C5155 B11.n293 VSUBS 0.40171f
C5156 B11.n294 VSUBS 0.40171f
C5157 B11.n295 VSUBS 0.40171f
C5158 B11.n296 VSUBS 0.40171f
C5159 B11.n297 VSUBS 0.40171f
C5160 B11.n298 VSUBS 0.40171f
C5161 B11.n299 VSUBS 0.40171f
C5162 B11.n300 VSUBS 0.40171f
C5163 B11.n301 VSUBS 0.40171f
C5164 B11.n302 VSUBS 0.40171f
C5165 B11.n303 VSUBS 0.40171f
C5166 B11.n304 VSUBS 0.40171f
C5167 B11.n305 VSUBS 0.40171f
C5168 B11.n306 VSUBS 0.40171f
C5169 B11.n307 VSUBS 0.40171f
C5170 B11.n308 VSUBS 0.40171f
C5171 B11.n309 VSUBS 0.40171f
C5172 B11.n310 VSUBS 0.40171f
C5173 B11.n311 VSUBS 0.40171f
C5174 B11.n312 VSUBS 0.40171f
C5175 B11.n313 VSUBS 0.40171f
C5176 B11.n314 VSUBS 0.40171f
C5177 B11.n315 VSUBS 0.40171f
C5178 B11.n316 VSUBS 0.40171f
C5179 B11.n317 VSUBS 0.40171f
C5180 B11.n318 VSUBS 0.40171f
C5181 B11.n319 VSUBS 0.40171f
C5182 B11.n320 VSUBS 0.40171f
C5183 B11.n321 VSUBS 0.40171f
C5184 B11.n322 VSUBS 0.40171f
C5185 B11.n323 VSUBS 0.40171f
C5186 B11.n324 VSUBS 0.40171f
C5187 B11.n325 VSUBS 0.40171f
C5188 B11.n326 VSUBS 0.40171f
C5189 B11.n327 VSUBS 0.40171f
C5190 B11.n328 VSUBS 0.74614f
C5191 B11.n329 VSUBS 1.11165f
C5192 B11.n330 VSUBS 0.50287f
C5193 B11.n331 VSUBS 0.40171f
C5194 B11.n332 VSUBS 0.40171f
C5195 B11.n333 VSUBS 0.40171f
C5196 B11.n334 VSUBS 0.40171f
C5197 B11.n335 VSUBS 0.40171f
C5198 B11.n336 VSUBS 0.40171f
C5199 B11.n337 VSUBS 0.40171f
C5200 B11.n338 VSUBS 0.40171f
C5201 B11.n339 VSUBS 0.40171f
C5202 B11.n340 VSUBS 0.40171f
C5203 B11.n341 VSUBS 0.40171f
C5204 B11.n342 VSUBS 0.40171f
C5205 B11.n343 VSUBS 0.40171f
C5206 B11.n344 VSUBS 0.40171f
C5207 B11.n345 VSUBS 0.40171f
C5208 B11.n346 VSUBS 0.40171f
C5209 B11.n347 VSUBS 0.40171f
C5210 B11.n348 VSUBS 0.40171f
C5211 B11.n349 VSUBS 0.40171f
C5212 B11.n350 VSUBS 0.40171f
C5213 B11.n351 VSUBS 0.40171f
C5214 B11.n352 VSUBS 0.40171f
C5215 B11.n353 VSUBS 0.40171f
C5216 B11.n354 VSUBS 0.40171f
C5217 B11.n355 VSUBS 0.40171f
C5218 B11.n356 VSUBS 0.40171f
C5219 B11.n357 VSUBS 0.40171f
C5220 B11.n358 VSUBS 0.40171f
C5221 B11.n359 VSUBS 0.40171f
C5222 B11.n360 VSUBS 0.40171f
C5223 B11.n361 VSUBS 0.40171f
C5224 B11.n362 VSUBS 0.40171f
C5225 B11.n363 VSUBS 0.40171f
C5226 B11.n364 VSUBS 0.40171f
C5227 B11.n365 VSUBS 0.40171f
C5228 B11.n366 VSUBS 0.40171f
C5229 B11.n367 VSUBS 0.40171f
C5230 B11.n368 VSUBS 0.40171f
C5231 B11.n369 VSUBS 0.40171f
C5232 B11.n370 VSUBS 0.40171f
C5233 B11.n371 VSUBS 0.40171f
C5234 B11.n372 VSUBS 0.40171f
C5235 B11.n373 VSUBS 0.40171f
C5236 B11.n374 VSUBS 0.40171f
C5237 B11.n375 VSUBS 0.40171f
C5238 B11.n376 VSUBS 0.40171f
C5239 B11.n377 VSUBS 0.40171f
C5240 B11.n378 VSUBS 0.40171f
C5241 B11.n379 VSUBS 0.40171f
C5242 B11.n380 VSUBS 0.40171f
C5243 B11.n381 VSUBS 0.40171f
C5244 B11.n382 VSUBS 0.40171f
C5245 B11.n383 VSUBS 0.40171f
C5246 B11.n384 VSUBS 0.40171f
C5247 B11.n385 VSUBS 0.40171f
C5248 B11.n386 VSUBS 0.40171f
C5249 B11.n387 VSUBS 0.40171f
C5250 B11.n388 VSUBS 0.40171f
C5251 B11.n389 VSUBS 0.40171f
C5252 B11.n390 VSUBS 0.40171f
C5253 B11.n391 VSUBS 0.74614f
C5254 B11.n392 VSUBS 1.11165f
C5255 B11.n393 VSUBS 0.50287f
C5256 B11.n394 VSUBS 0.40171f
C5257 B11.n395 VSUBS 0.40171f
C5258 B11.n396 VSUBS 0.40171f
C5259 B11.n397 VSUBS 0.40171f
C5260 B11.n398 VSUBS 0.40171f
C5261 B11.n399 VSUBS 0.40171f
C5262 B11.n400 VSUBS 0.40171f
C5263 B11.n401 VSUBS 0.40171f
C5264 B11.n402 VSUBS 0.40171f
C5265 B11.n403 VSUBS 0.40171f
C5266 B11.n404 VSUBS 0.40171f
C5267 B11.n405 VSUBS 0.40171f
C5268 B11.n406 VSUBS 0.40171f
C5269 B11.n407 VSUBS 0.40171f
C5270 B11.n408 VSUBS 0.40171f
C5271 B11.n409 VSUBS 0.40171f
C5272 B11.n410 VSUBS 0.40171f
C5273 B11.n411 VSUBS 0.40171f
C5274 B11.n412 VSUBS 0.40171f
C5275 B11.n413 VSUBS 0.40171f
C5276 B11.n414 VSUBS 0.40171f
C5277 B11.n415 VSUBS 0.40171f
C5278 B11.n416 VSUBS 0.40171f
C5279 B11.n417 VSUBS 0.40171f
C5280 B11.n418 VSUBS 0.40171f
C5281 B11.n419 VSUBS 0.40171f
C5282 B11.n420 VSUBS 0.40171f
C5283 B11.n421 VSUBS 0.40171f
C5284 B11.n422 VSUBS 0.40171f
C5285 B11.n423 VSUBS 0.40171f
C5286 B11.n424 VSUBS 0.40171f
C5287 B11.n425 VSUBS 0.40171f
C5288 B11.n426 VSUBS 0.40171f
C5289 B11.n427 VSUBS 0.40171f
C5290 B11.n428 VSUBS 0.40171f
C5291 B11.n429 VSUBS 0.40171f
C5292 B11.n430 VSUBS 0.40171f
C5293 B11.n431 VSUBS 0.40171f
C5294 B11.n432 VSUBS 0.40171f
C5295 B11.n433 VSUBS 0.40171f
C5296 B11.n434 VSUBS 0.40171f
C5297 B11.n435 VSUBS 0.40171f
C5298 B11.n436 VSUBS 0.40171f
C5299 B11.n437 VSUBS 0.40171f
C5300 B11.n438 VSUBS 0.40171f
C5301 B11.n439 VSUBS 0.40171f
C5302 B11.n440 VSUBS 0.40171f
C5303 B11.n441 VSUBS 0.40171f
C5304 B11.n442 VSUBS 0.40171f
C5305 B11.n443 VSUBS 0.40171f
C5306 B11.n444 VSUBS 0.40171f
C5307 B11.n445 VSUBS 0.40171f
C5308 B11.n446 VSUBS 0.40171f
C5309 B11.n447 VSUBS 0.40171f
C5310 B11.n448 VSUBS 0.40171f
C5311 B11.n449 VSUBS 0.40171f
C5312 B11.n450 VSUBS 0.40171f
C5313 B11.n451 VSUBS 0.40171f
C5314 B11.n452 VSUBS 0.40171f
C5315 B11.n453 VSUBS 0.40171f
C5316 B11.n454 VSUBS 0.74614f
C5317 B11.n455 VSUBS 1.11165f
C5318 B11.n456 VSUBS 0.50287f
C5319 B11.n457 VSUBS 0.40171f
C5320 B11.n458 VSUBS 0.40171f
C5321 B11.n459 VSUBS 0.40171f
C5322 B11.n460 VSUBS 0.40171f
C5323 B11.n461 VSUBS 0.40171f
C5324 B11.n462 VSUBS 0.40171f
C5325 B11.n463 VSUBS 0.40171f
C5326 B11.n464 VSUBS 0.40171f
C5327 B11.n465 VSUBS 0.40171f
C5328 B11.n466 VSUBS 0.40171f
C5329 B11.n467 VSUBS 0.40171f
C5330 B11.n468 VSUBS 0.40171f
C5331 B11.n469 VSUBS 0.40171f
C5332 B11.n470 VSUBS 0.40171f
C5333 B11.n471 VSUBS 0.40171f
C5334 B11.n472 VSUBS 0.40171f
C5335 B11.n473 VSUBS 0.40171f
C5336 B11.n474 VSUBS 0.40171f
C5337 B11.n475 VSUBS 0.40171f
C5338 B11.n476 VSUBS 0.40171f
C5339 B11.n477 VSUBS 0.40171f
C5340 B11.n478 VSUBS 0.40171f
C5341 B11.n479 VSUBS 0.40171f
C5342 B11.n480 VSUBS 0.40171f
C5343 B11.n481 VSUBS 0.40171f
C5344 B11.n482 VSUBS 0.40171f
C5345 B11.n483 VSUBS 0.40171f
C5346 B11.n484 VSUBS 0.40171f
C5347 B11.n485 VSUBS 0.40171f
C5348 B11.n486 VSUBS 0.40171f
C5349 B11.n487 VSUBS 0.40171f
C5350 B11.n488 VSUBS 0.40171f
C5351 B11.n489 VSUBS 0.40171f
C5352 B11.n490 VSUBS 0.40171f
C5353 B11.n491 VSUBS 0.40171f
C5354 B11.n492 VSUBS 0.40171f
C5355 B11.n493 VSUBS 0.40171f
C5356 B11.n494 VSUBS 0.40171f
C5357 B11.n495 VSUBS 0.40171f
C5358 B11.n496 VSUBS 0.40171f
C5359 B11.n497 VSUBS 0.40171f
C5360 B11.n498 VSUBS 0.40171f
C5361 B11.n499 VSUBS 0.40171f
C5362 B11.n500 VSUBS 0.40171f
C5363 B11.n501 VSUBS 0.40171f
C5364 B11.n502 VSUBS 0.40171f
C5365 B11.n503 VSUBS 0.40171f
C5366 B11.n504 VSUBS 0.40171f
C5367 B11.n505 VSUBS 0.40171f
C5368 B11.n506 VSUBS 0.40171f
C5369 B11.n507 VSUBS 0.40171f
C5370 B11.n508 VSUBS 0.40171f
C5371 B11.n509 VSUBS 0.40171f
C5372 B11.n510 VSUBS 0.40171f
C5373 B11.n511 VSUBS 0.40171f
C5374 B11.n512 VSUBS 0.40171f
C5375 B11.n513 VSUBS 0.40171f
C5376 B11.n514 VSUBS 0.40171f
C5377 B11.n515 VSUBS 0.40171f
C5378 B11.n516 VSUBS 0.40171f
C5379 B11.n517 VSUBS 0.74614f
C5380 B11.n518 VSUBS 1.11165f
C5381 B11.n519 VSUBS 0.50287f
C5382 B11.n520 VSUBS 0.40171f
C5383 B11.n521 VSUBS 0.40171f
C5384 B11.n522 VSUBS 0.40171f
C5385 B11.n523 VSUBS 0.40171f
C5386 B11.n524 VSUBS 0.40171f
C5387 B11.n525 VSUBS 0.40171f
C5388 B11.n526 VSUBS 0.40171f
C5389 B11.n527 VSUBS 0.40171f
C5390 B11.n528 VSUBS 0.40171f
C5391 B11.n529 VSUBS 0.40171f
C5392 B11.n530 VSUBS 0.40171f
C5393 B11.n531 VSUBS 0.40171f
C5394 B11.n532 VSUBS 0.40171f
C5395 B11.n533 VSUBS 0.40171f
C5396 B11.n534 VSUBS 0.40171f
C5397 B11.n535 VSUBS 0.40171f
C5398 B11.n536 VSUBS 0.40171f
C5399 B11.n537 VSUBS 0.40171f
C5400 B11.n538 VSUBS 0.40171f
C5401 B11.n539 VSUBS 0.40171f
C5402 B11.n540 VSUBS 0.40171f
C5403 B11.n541 VSUBS 0.40171f
C5404 B11.n542 VSUBS 0.40171f
C5405 B11.n543 VSUBS 0.40171f
C5406 B11.n544 VSUBS 0.40171f
C5407 B11.n545 VSUBS 0.40171f
C5408 B11.n546 VSUBS 0.40171f
C5409 B11.n547 VSUBS 0.40171f
C5410 B11.n548 VSUBS 0.40171f
C5411 B11.n549 VSUBS 0.40171f
C5412 B11.n550 VSUBS 0.40171f
C5413 B11.n551 VSUBS 0.40171f
C5414 B11.n552 VSUBS 0.40171f
C5415 B11.n553 VSUBS 0.40171f
C5416 B11.n554 VSUBS 0.40171f
C5417 B11.n555 VSUBS 0.40171f
C5418 B11.n556 VSUBS 0.40171f
C5419 B11.n557 VSUBS 0.40171f
C5420 B11.n558 VSUBS 0.40171f
C5421 B11.n559 VSUBS 0.40171f
C5422 B11.n560 VSUBS 0.40171f
C5423 B11.n561 VSUBS 0.40171f
C5424 B11.n562 VSUBS 0.40171f
C5425 B11.n563 VSUBS 0.40171f
C5426 B11.n564 VSUBS 0.40171f
C5427 B11.n565 VSUBS 0.40171f
C5428 B11.n566 VSUBS 0.40171f
C5429 B11.n567 VSUBS 0.40171f
C5430 B11.n568 VSUBS 0.40171f
C5431 B11.n569 VSUBS 0.40171f
C5432 B11.n570 VSUBS 0.40171f
C5433 B11.n571 VSUBS 0.40171f
C5434 B11.n572 VSUBS 0.40171f
C5435 B11.n573 VSUBS 0.40171f
C5436 B11.n574 VSUBS 0.40171f
C5437 B11.n575 VSUBS 0.40171f
C5438 B11.n576 VSUBS 0.40171f
C5439 B11.n577 VSUBS 0.40171f
C5440 B11.n578 VSUBS 0.40171f
C5441 B11.n579 VSUBS 0.40171f
C5442 B11.n580 VSUBS 0.74614f
C5443 B11.n581 VSUBS 1.11165f
C5444 B11.n582 VSUBS 0.50287f
C5445 B11.n583 VSUBS 0.40171f
C5446 B11.n584 VSUBS 0.40171f
C5447 B11.n585 VSUBS 0.40171f
C5448 B11.n586 VSUBS 0.40171f
C5449 B11.n587 VSUBS 0.40171f
C5450 B11.n588 VSUBS 0.40171f
C5451 B11.n589 VSUBS 0.40171f
C5452 B11.n590 VSUBS 0.40171f
C5453 B11.n591 VSUBS 0.40171f
C5454 B11.n592 VSUBS 0.40171f
C5455 B11.n593 VSUBS 0.40171f
C5456 B11.n594 VSUBS 0.40171f
C5457 B11.n595 VSUBS 0.40171f
C5458 B11.n596 VSUBS 0.40171f
C5459 B11.n597 VSUBS 0.40171f
C5460 B11.n598 VSUBS 0.40171f
C5461 B11.n599 VSUBS 0.40171f
C5462 B11.n600 VSUBS 0.40171f
C5463 B11.n601 VSUBS 0.40171f
C5464 B11.n602 VSUBS 0.40171f
C5465 B11.n603 VSUBS 0.40171f
C5466 B11.n604 VSUBS 0.40171f
C5467 B11.n605 VSUBS 0.40171f
C5468 B11.n606 VSUBS 0.40171f
C5469 B11.n607 VSUBS 0.40171f
C5470 B11.n608 VSUBS 0.40171f
C5471 B11.n609 VSUBS 0.40171f
C5472 B11.n610 VSUBS 0.40171f
C5473 B11.n611 VSUBS 0.40171f
C5474 B11.n612 VSUBS 0.40171f
C5475 B11.n613 VSUBS 0.40171f
C5476 B11.n614 VSUBS 0.40171f
C5477 B11.n615 VSUBS 0.40171f
C5478 B11.n616 VSUBS 0.40171f
C5479 B11.n617 VSUBS 0.40171f
C5480 B11.n618 VSUBS 0.40171f
C5481 B11.n619 VSUBS 0.40171f
C5482 B11.n620 VSUBS 0.40171f
C5483 B11.n621 VSUBS 0.40171f
C5484 B11.n622 VSUBS 0.40171f
C5485 B11.n623 VSUBS 0.40171f
C5486 B11.n624 VSUBS 0.40171f
C5487 B11.n625 VSUBS 0.40171f
C5488 B11.n626 VSUBS 0.40171f
C5489 B11.n627 VSUBS 0.40171f
C5490 B11.n628 VSUBS 0.40171f
C5491 B11.n629 VSUBS 0.40171f
C5492 B11.n630 VSUBS 0.40171f
C5493 B11.n631 VSUBS 0.40171f
C5494 B11.n632 VSUBS 0.40171f
C5495 B11.n633 VSUBS 0.40171f
C5496 B11.n634 VSUBS 0.40171f
C5497 B11.n635 VSUBS 0.40171f
C5498 B11.n636 VSUBS 0.40171f
C5499 B11.n637 VSUBS 0.40171f
C5500 B11.n638 VSUBS 0.40171f
C5501 B11.n639 VSUBS 0.40171f
C5502 B11.n640 VSUBS 0.40171f
C5503 B11.n641 VSUBS 0.40171f
C5504 B11.n642 VSUBS 0.40171f
C5505 B11.n643 VSUBS 0.74614f
C5506 B11.n644 VSUBS 1.11165f
C5507 B11.n645 VSUBS 0.50287f
C5508 B11.n646 VSUBS 0.40171f
C5509 B11.n647 VSUBS 0.40171f
C5510 B11.n648 VSUBS 0.40171f
C5511 B11.n649 VSUBS 0.40171f
C5512 B11.n650 VSUBS 0.40171f
C5513 B11.n651 VSUBS 0.40171f
C5514 B11.n652 VSUBS 0.40171f
C5515 B11.n653 VSUBS 0.40171f
C5516 B11.n654 VSUBS 0.40171f
C5517 B11.n655 VSUBS 0.40171f
C5518 B11.n656 VSUBS 0.40171f
C5519 B11.n657 VSUBS 0.40171f
C5520 B11.n658 VSUBS 0.40171f
C5521 B11.n659 VSUBS 0.40171f
C5522 B11.n660 VSUBS 0.40171f
C5523 B11.n661 VSUBS 0.40171f
C5524 B11.n662 VSUBS 0.40171f
C5525 B11.n663 VSUBS 0.40171f
C5526 B11.n664 VSUBS 0.40171f
C5527 B11.n665 VSUBS 0.40171f
C5528 B11.n666 VSUBS 0.40171f
C5529 B11.n667 VSUBS 0.40171f
C5530 B11.n668 VSUBS 0.40171f
C5531 B11.n669 VSUBS 0.40171f
C5532 B11.n670 VSUBS 0.40171f
C5533 B11.n671 VSUBS 0.40171f
C5534 B11.n672 VSUBS 0.40171f
C5535 B11.n673 VSUBS 0.40171f
C5536 B11.n674 VSUBS 0.40171f
C5537 B11.n675 VSUBS 0.40171f
C5538 B11.n676 VSUBS 0.40171f
C5539 B11.n677 VSUBS 0.40171f
C5540 B11.n678 VSUBS 0.40171f
C5541 B11.n679 VSUBS 0.40171f
C5542 B11.n680 VSUBS 0.40171f
C5543 B11.n681 VSUBS 0.40171f
C5544 B11.n682 VSUBS 0.40171f
C5545 B11.n683 VSUBS 0.40171f
C5546 B11.n684 VSUBS 0.40171f
C5547 B11.n685 VSUBS 0.40171f
C5548 B11.n686 VSUBS 0.40171f
C5549 B11.n687 VSUBS 0.40171f
C5550 B11.n688 VSUBS 0.40171f
C5551 B11.n689 VSUBS 0.40171f
C5552 B11.n690 VSUBS 0.40171f
C5553 B11.n691 VSUBS 0.40171f
C5554 B11.n692 VSUBS 0.40171f
C5555 B11.n693 VSUBS 0.40171f
C5556 B11.n694 VSUBS 0.40171f
C5557 B11.n695 VSUBS 0.40171f
C5558 B11.n696 VSUBS 0.40171f
C5559 B11.n697 VSUBS 0.40171f
C5560 B11.n698 VSUBS 0.40171f
C5561 B11.n699 VSUBS 0.40171f
C5562 B11.n700 VSUBS 0.40171f
C5563 B11.n701 VSUBS 0.40171f
C5564 B11.n702 VSUBS 0.40171f
C5565 B11.n703 VSUBS 0.40171f
C5566 B11.n704 VSUBS 0.40171f
C5567 B11.n705 VSUBS 0.40171f
C5568 B11.n706 VSUBS 0.74614f
C5569 B11.n707 VSUBS 1.11165f
C5570 B11.n708 VSUBS 0.50287f
C5571 B11.n709 VSUBS 0.40171f
C5572 B11.n710 VSUBS 0.40171f
C5573 B11.n711 VSUBS 0.40171f
C5574 B11.n712 VSUBS 0.40171f
C5575 B11.n713 VSUBS 0.40171f
C5576 B11.n714 VSUBS 0.40171f
C5577 B11.n715 VSUBS 0.40171f
C5578 B11.n716 VSUBS 0.40171f
C5579 B11.n717 VSUBS 0.40171f
C5580 B11.n718 VSUBS 0.40171f
C5581 B11.n719 VSUBS 0.40171f
C5582 B11.n720 VSUBS 0.40171f
C5583 B11.n721 VSUBS 0.40171f
C5584 B11.n722 VSUBS 0.40171f
C5585 B11.n723 VSUBS 0.40171f
C5586 B11.n724 VSUBS 0.40171f
C5587 B11.n725 VSUBS 0.40171f
C5588 B11.n726 VSUBS 0.40171f
C5589 B11.n727 VSUBS 0.40171f
C5590 B11.n728 VSUBS 0.40171f
C5591 B11.n729 VSUBS 0.40171f
C5592 B11.n730 VSUBS 0.40171f
C5593 B11.n731 VSUBS 0.40171f
C5594 B11.n732 VSUBS 0.40171f
C5595 B11.n733 VSUBS 0.40171f
C5596 B11.n734 VSUBS 0.40171f
C5597 B11.n735 VSUBS 0.40171f
C5598 B11.n736 VSUBS 0.40171f
C5599 B11.n737 VSUBS 0.40171f
C5600 B11.n738 VSUBS 0.40171f
C5601 B11.n739 VSUBS 0.40171f
C5602 B11.n740 VSUBS 0.40171f
C5603 B11.n741 VSUBS 0.40171f
C5604 B11.n742 VSUBS 0.40171f
C5605 B11.n743 VSUBS 0.40171f
C5606 B11.n744 VSUBS 0.40171f
C5607 B11.n745 VSUBS 0.40171f
C5608 B11.n746 VSUBS 0.40171f
C5609 B11.n747 VSUBS 0.40171f
C5610 B11.n748 VSUBS 0.40171f
C5611 B11.n749 VSUBS 0.40171f
C5612 B11.n750 VSUBS 0.40171f
C5613 B11.n751 VSUBS 0.40171f
C5614 B11.n752 VSUBS 0.40171f
C5615 B11.n753 VSUBS 0.40171f
C5616 B11.n754 VSUBS 0.40171f
C5617 B11.n755 VSUBS 0.40171f
C5618 B11.n756 VSUBS 0.40171f
C5619 B11.n757 VSUBS 0.40171f
C5620 B11.n758 VSUBS 0.40171f
C5621 B11.n759 VSUBS 0.40171f
C5622 B11.n760 VSUBS 0.40171f
C5623 B11.n761 VSUBS 0.40171f
C5624 B11.n762 VSUBS 0.40171f
C5625 B11.n763 VSUBS 0.40171f
C5626 B11.n764 VSUBS 0.40171f
C5627 B11.n765 VSUBS 0.40171f
C5628 B11.n766 VSUBS 0.40171f
C5629 B11.n767 VSUBS 0.40171f
C5630 B11.n768 VSUBS 0.40171f
C5631 B11.n769 VSUBS 0.74614f
C5632 B11.n770 VSUBS 1.11165f
C5633 B11.n771 VSUBS 0.50287f
C5634 B11.n772 VSUBS 0.40171f
C5635 B11.n773 VSUBS 0.40171f
C5636 B11.n774 VSUBS 0.40171f
C5637 B11.n775 VSUBS 0.40171f
C5638 B11.n776 VSUBS 0.40171f
C5639 B11.n777 VSUBS 0.40171f
C5640 B11.n778 VSUBS 0.40171f
C5641 B11.n779 VSUBS 0.40171f
C5642 B11.n780 VSUBS 0.40171f
C5643 B11.n781 VSUBS 0.40171f
C5644 B11.n782 VSUBS 0.40171f
C5645 B11.n783 VSUBS 0.40171f
C5646 B11.n784 VSUBS 0.40171f
C5647 B11.n785 VSUBS 0.40171f
C5648 B11.n786 VSUBS 0.40171f
C5649 B11.n787 VSUBS 0.40171f
C5650 B11.n788 VSUBS 0.40171f
C5651 B11.n789 VSUBS 0.40171f
C5652 B11.n790 VSUBS 0.40171f
C5653 B11.n791 VSUBS 0.40171f
C5654 B11.n792 VSUBS 0.40171f
C5655 B11.n793 VSUBS 0.40171f
C5656 B11.n794 VSUBS 0.40171f
C5657 B11.n795 VSUBS 0.40171f
C5658 B11.n796 VSUBS 0.40171f
C5659 B11.n797 VSUBS 0.40171f
C5660 B11.n798 VSUBS 0.40171f
C5661 B11.n799 VSUBS 0.40171f
C5662 B11.n800 VSUBS 0.40171f
C5663 B11.n801 VSUBS 0.40171f
C5664 B11.n802 VSUBS 0.40171f
C5665 B11.n803 VSUBS 0.40171f
C5666 B11.n804 VSUBS 0.40171f
C5667 B11.n805 VSUBS 0.40171f
C5668 B11.n806 VSUBS 0.40171f
C5669 B11.n807 VSUBS 0.40171f
C5670 B11.n808 VSUBS 0.40171f
C5671 B11.n809 VSUBS 0.40171f
C5672 B11.n810 VSUBS 0.40171f
C5673 B11.n811 VSUBS 0.40171f
C5674 B11.n812 VSUBS 0.40171f
C5675 B11.n813 VSUBS 0.40171f
C5676 B11.n814 VSUBS 0.40171f
C5677 B11.n815 VSUBS 0.40171f
C5678 B11.n816 VSUBS 0.40171f
C5679 B11.n817 VSUBS 0.40171f
C5680 B11.n818 VSUBS 0.40171f
C5681 B11.n819 VSUBS 0.40171f
C5682 B11.n820 VSUBS 0.40171f
C5683 B11.n821 VSUBS 0.40171f
C5684 B11.n822 VSUBS 0.40171f
C5685 B11.n823 VSUBS 0.40171f
C5686 B11.n824 VSUBS 0.40171f
C5687 B11.n825 VSUBS 0.40171f
C5688 B11.n826 VSUBS 0.40171f
C5689 B11.n827 VSUBS 0.40171f
C5690 B11.n828 VSUBS 0.40171f
C5691 B11.n829 VSUBS 0.40171f
C5692 B11.n830 VSUBS 0.40171f
C5693 B11.n831 VSUBS 0.40171f
C5694 B11.n832 VSUBS 0.74614f
C5695 B11.n833 VSUBS 1.11165f
C5696 B11.n834 VSUBS 0.50287f
C5697 B11.n835 VSUBS 0.40171f
C5698 B11.n836 VSUBS 0.40171f
C5699 B11.n837 VSUBS 0.40171f
C5700 B11.n838 VSUBS 0.40171f
C5701 B11.n839 VSUBS 0.40171f
C5702 B11.n840 VSUBS 0.40171f
C5703 B11.n841 VSUBS 0.40171f
C5704 B11.n842 VSUBS 0.40171f
C5705 B11.n843 VSUBS 0.40171f
C5706 B11.n844 VSUBS 0.40171f
C5707 B11.n845 VSUBS 0.40171f
C5708 B11.n846 VSUBS 0.40171f
C5709 B11.n847 VSUBS 0.40171f
C5710 B11.n848 VSUBS 0.40171f
C5711 B11.n849 VSUBS 0.40171f
C5712 B11.n850 VSUBS 0.40171f
C5713 B11.n851 VSUBS 0.40171f
C5714 B11.n852 VSUBS 0.40171f
C5715 B11.n853 VSUBS 0.40171f
C5716 B11.n854 VSUBS 0.40171f
C5717 B11.n855 VSUBS 0.40171f
C5718 B11.n856 VSUBS 0.40171f
C5719 B11.n857 VSUBS 0.40171f
C5720 B11.n858 VSUBS 0.40171f
C5721 B11.n859 VSUBS 0.40171f
C5722 B11.n860 VSUBS 0.40171f
C5723 B11.n861 VSUBS 0.40171f
C5724 B11.n862 VSUBS 0.40171f
C5725 B11.n863 VSUBS 0.40171f
C5726 B11.n864 VSUBS 0.40171f
C5727 B11.n865 VSUBS 0.40171f
C5728 B11.n866 VSUBS 0.40171f
C5729 B11.n867 VSUBS 0.40171f
C5730 B11.n868 VSUBS 0.40171f
C5731 B11.n869 VSUBS 0.40171f
C5732 B11.n870 VSUBS 0.40171f
C5733 B11.n871 VSUBS 0.40171f
C5734 B11.n872 VSUBS 0.40171f
C5735 B11.n873 VSUBS 0.40171f
C5736 B11.n874 VSUBS 0.40171f
C5737 B11.n875 VSUBS 0.40171f
C5738 B11.n876 VSUBS 0.40171f
C5739 B11.n877 VSUBS 0.40171f
C5740 B11.n878 VSUBS 0.40171f
C5741 B11.n879 VSUBS 0.40171f
C5742 B11.n880 VSUBS 0.40171f
C5743 B11.n881 VSUBS 0.40171f
C5744 B11.n882 VSUBS 0.40171f
C5745 B11.n883 VSUBS 0.40171f
C5746 B11.n884 VSUBS 0.40171f
C5747 B11.n885 VSUBS 0.40171f
C5748 B11.n886 VSUBS 0.40171f
C5749 B11.n887 VSUBS 0.40171f
C5750 B11.n888 VSUBS 0.40171f
C5751 B11.n889 VSUBS 0.40171f
C5752 B11.n890 VSUBS 0.40171f
C5753 B11.n891 VSUBS 0.40171f
C5754 B11.n892 VSUBS 0.40171f
C5755 B11.n893 VSUBS 0.40171f
C5756 B11.n894 VSUBS 0.40171f
C5757 B11.n895 VSUBS 0.74614f
C5758 B11.n896 VSUBS 1.11165f
C5759 B11.n897 VSUBS 0.50287f
C5760 B11.n898 VSUBS 0.40171f
C5761 B11.n899 VSUBS 0.40171f
C5762 B11.n900 VSUBS 0.40171f
C5763 B11.n901 VSUBS 0.40171f
C5764 B11.n902 VSUBS 0.40171f
C5765 B11.n903 VSUBS 0.40171f
C5766 B11.n904 VSUBS 0.40171f
C5767 B11.n905 VSUBS 0.40171f
C5768 B11.n906 VSUBS 0.40171f
C5769 B11.n907 VSUBS 0.40171f
C5770 B11.n908 VSUBS 0.40171f
C5771 B11.n909 VSUBS 0.40171f
C5772 B11.n910 VSUBS 0.40171f
C5773 B11.n911 VSUBS 0.40171f
C5774 B11.n912 VSUBS 0.40171f
C5775 B11.n913 VSUBS 0.40171f
C5776 B11.n914 VSUBS 0.40171f
C5777 B11.n915 VSUBS 0.40171f
C5778 B11.n916 VSUBS 0.40171f
C5779 B11.n917 VSUBS 0.40171f
C5780 B11.n918 VSUBS 0.40171f
C5781 B11.n919 VSUBS 0.40171f
C5782 B11.n920 VSUBS 0.40171f
C5783 B11.n921 VSUBS 0.40171f
C5784 B11.n922 VSUBS 0.40171f
C5785 B11.n923 VSUBS 0.40171f
C5786 B11.n924 VSUBS 0.40171f
C5787 B11.n925 VSUBS 0.40171f
C5788 B11.n926 VSUBS 0.40171f
C5789 B11.n927 VSUBS 0.40171f
C5790 B11.n928 VSUBS 0.40171f
C5791 B11.n929 VSUBS 0.40171f
C5792 B11.n930 VSUBS 0.40171f
C5793 B11.n931 VSUBS 0.40171f
C5794 B11.n932 VSUBS 0.40171f
C5795 B11.n933 VSUBS 0.40171f
C5796 B11.n934 VSUBS 0.40171f
C5797 B11.n935 VSUBS 0.40171f
C5798 B11.n936 VSUBS 0.40171f
C5799 B11.n937 VSUBS 0.40171f
C5800 B11.n938 VSUBS 0.40171f
C5801 B11.n939 VSUBS 0.40171f
C5802 B11.n940 VSUBS 0.40171f
C5803 B11.n941 VSUBS 0.40171f
C5804 B11.n942 VSUBS 0.40171f
C5805 B11.n943 VSUBS 0.40171f
C5806 B11.n944 VSUBS 0.40171f
C5807 B11.n945 VSUBS 0.40171f
C5808 B11.n946 VSUBS 0.40171f
C5809 B11.n947 VSUBS 0.40171f
C5810 B11.n948 VSUBS 0.40171f
C5811 B11.n949 VSUBS 0.40171f
C5812 B11.n950 VSUBS 0.40171f
C5813 B11.n951 VSUBS 0.40171f
C5814 B11.n952 VSUBS 0.40171f
C5815 B11.n953 VSUBS 0.40171f
C5816 B11.n954 VSUBS 0.40171f
C5817 B11.n955 VSUBS 0.40171f
C5818 B11.n956 VSUBS 0.40171f
C5819 B11.n957 VSUBS 0.40171f
C5820 B11.n958 VSUBS 0.74614f
C5821 B11.n959 VSUBS 1.11165f
C5822 B11.n960 VSUBS 0.50287f
C5823 B11.n961 VSUBS 0.40171f
C5824 B11.n962 VSUBS 0.40171f
C5825 B11.n963 VSUBS 0.40171f
C5826 B11.n964 VSUBS 0.40171f
C5827 B11.n965 VSUBS 0.40171f
C5828 B11.n966 VSUBS 0.40171f
C5829 B11.n967 VSUBS 0.40171f
C5830 B11.n968 VSUBS 0.40171f
C5831 B11.n969 VSUBS 0.40171f
C5832 B11.n970 VSUBS 0.40171f
C5833 B11.n971 VSUBS 0.40171f
C5834 B11.n972 VSUBS 0.40171f
C5835 B11.n973 VSUBS 0.40171f
C5836 B11.n974 VSUBS 0.40171f
C5837 B11.n975 VSUBS 0.40171f
C5838 B11.n976 VSUBS 0.40171f
C5839 B11.n977 VSUBS 0.40171f
C5840 B11.n978 VSUBS 0.40171f
C5841 B11.n979 VSUBS 0.40171f
C5842 B11.n980 VSUBS 0.40171f
C5843 B11.n981 VSUBS 0.40171f
C5844 B11.n982 VSUBS 0.40171f
C5845 B11.n983 VSUBS 0.40171f
C5846 B11.n984 VSUBS 0.40171f
C5847 B11.n985 VSUBS 0.40171f
C5848 B11.n986 VSUBS 0.40171f
C5849 B11.n987 VSUBS 0.40171f
C5850 B11.n988 VSUBS 0.40171f
C5851 B11.n989 VSUBS 0.40171f
C5852 B11.n990 VSUBS 0.40171f
C5853 B11.n991 VSUBS 0.40171f
C5854 B11.n992 VSUBS 0.40171f
C5855 B11.n993 VSUBS 0.40171f
C5856 B11.n994 VSUBS 0.40171f
C5857 B11.n995 VSUBS 0.40171f
C5858 B11.n996 VSUBS 0.40171f
C5859 B11.n997 VSUBS 0.40171f
C5860 B11.n998 VSUBS 0.40171f
C5861 B11.n999 VSUBS 0.40171f
C5862 B11.n1000 VSUBS 0.40171f
C5863 B11.n1001 VSUBS 0.40171f
C5864 B11.n1002 VSUBS 0.40171f
C5865 B11.n1003 VSUBS 0.40171f
C5866 B11.n1004 VSUBS 0.40171f
C5867 B11.n1005 VSUBS 0.40171f
C5868 B11.n1006 VSUBS 0.40171f
C5869 B11.n1007 VSUBS 0.40171f
C5870 B11.n1008 VSUBS 0.40171f
C5871 B11.n1009 VSUBS 0.40171f
C5872 B11.n1010 VSUBS 0.40171f
C5873 B11.n1011 VSUBS 0.40171f
C5874 B11.n1012 VSUBS 0.40171f
C5875 B11.n1013 VSUBS 0.40171f
C5876 B11.n1014 VSUBS 0.40171f
C5877 B11.n1015 VSUBS 0.40171f
C5878 B11.n1016 VSUBS 0.40171f
C5879 B11.n1017 VSUBS 0.40171f
C5880 B11.n1018 VSUBS 0.40171f
C5881 B11.n1019 VSUBS 0.40171f
C5882 B11.n1020 VSUBS 0.40171f
C5883 B11.n1021 VSUBS 0.74614f
C5884 B11.n1022 VSUBS 4.64679f
C5885 B11.n1023 VSUBS 0.50287f
C5886 B11.n1024 VSUBS 0.40171f
C5887 B11.n1025 VSUBS 0.40171f
C5888 B11.n1026 VSUBS 0.40171f
C5889 B11.n1027 VSUBS 0.40171f
C5890 B11.n1028 VSUBS 0.40171f
C5891 B11.n1029 VSUBS 0.40171f
C5892 B11.n1030 VSUBS 0.40171f
C5893 B11.n1031 VSUBS 0.40171f
C5894 B11.n1032 VSUBS 0.40171f
C5895 B11.n1033 VSUBS 0.40171f
C5896 B11.n1034 VSUBS 0.40171f
C5897 B11.n1035 VSUBS 0.40171f
C5898 B11.n1036 VSUBS 0.40171f
C5899 B11.n1037 VSUBS 0.40171f
C5900 B11.n1038 VSUBS 0.40171f
C5901 B11.n1039 VSUBS 0.40171f
C5902 B11.n1040 VSUBS 0.40171f
C5903 B11.n1041 VSUBS 0.40171f
C5904 B11.n1042 VSUBS 0.40171f
C5905 B11.n1043 VSUBS 0.40171f
C5906 B11.n1044 VSUBS 0.40171f
C5907 B11.n1045 VSUBS 0.40171f
C5908 B11.n1046 VSUBS 0.40171f
C5909 B11.n1047 VSUBS 0.40171f
C5910 B11.n1048 VSUBS 0.40171f
C5911 B11.n1049 VSUBS 0.40171f
C5912 B11.n1050 VSUBS 0.40171f
C5913 B11.n1051 VSUBS 0.40171f
C5914 B11.n1052 VSUBS 0.40171f
C5915 B11.n1053 VSUBS 0.40171f
C5916 B11.n1054 VSUBS 0.40171f
C5917 B11.n1055 VSUBS 0.40171f
C5918 B11.n1056 VSUBS 0.40171f
C5919 B11.n1057 VSUBS 0.40171f
C5920 B11.n1058 VSUBS 0.40171f
C5921 B11.n1059 VSUBS 0.40171f
C5922 B11.n1060 VSUBS 0.40171f
C5923 B11.n1061 VSUBS 0.40171f
C5924 B11.n1062 VSUBS 0.40171f
C5925 B11.n1063 VSUBS 0.40171f
C5926 B11.n1064 VSUBS 0.40171f
C5927 B11.n1065 VSUBS 0.40171f
C5928 B11.n1066 VSUBS 0.40171f
C5929 B11.n1067 VSUBS 0.40171f
C5930 B11.n1068 VSUBS 0.40171f
C5931 B11.n1069 VSUBS 0.40171f
C5932 B11.n1070 VSUBS 0.40171f
C5933 B11.n1071 VSUBS 0.40171f
C5934 B11.n1072 VSUBS 0.40171f
C5935 B11.n1073 VSUBS 0.40171f
C5936 B11.n1074 VSUBS 0.40171f
C5937 B11.n1075 VSUBS 0.40171f
C5938 B11.n1076 VSUBS 0.40171f
C5939 B11.n1077 VSUBS 0.40171f
C5940 B11.n1078 VSUBS 0.40171f
C5941 B11.n1079 VSUBS 0.40171f
C5942 B11.n1080 VSUBS 0.40171f
C5943 B11.n1081 VSUBS 0.40171f
C5944 B11.n1082 VSUBS 0.40171f
C5945 B11.n1083 VSUBS 0.40171f
C5946 B11.n1084 VSUBS 0.75211f
C5947 B11.n1085 VSUBS 0.50287f
C5948 B11.n1086 VSUBS 0.40171f
C5949 B11.n1087 VSUBS 0.40171f
C5950 B11.n1088 VSUBS 0.40171f
C5951 B11.n1089 VSUBS 0.40171f
C5952 B11.n1090 VSUBS 0.40171f
C5953 B11.n1091 VSUBS 0.40171f
C5954 B11.n1092 VSUBS 0.40171f
C5955 B11.n1093 VSUBS 0.40171f
C5956 B11.n1094 VSUBS 0.40171f
C5957 B11.n1095 VSUBS 0.40171f
C5958 B11.n1096 VSUBS 0.40171f
C5959 B11.n1097 VSUBS 0.40171f
C5960 B11.n1098 VSUBS 0.40171f
C5961 B11.n1099 VSUBS 0.40171f
C5962 B11.n1100 VSUBS 0.40171f
C5963 B11.n1101 VSUBS 0.40171f
C5964 B11.n1102 VSUBS 0.40171f
C5965 B11.n1103 VSUBS 0.40171f
C5966 B11.n1104 VSUBS 0.40171f
C5967 B11.n1105 VSUBS 0.40171f
C5968 B11.n1106 VSUBS 0.40171f
C5969 B11.n1107 VSUBS 0.40171f
C5970 B11.n1108 VSUBS 0.40171f
C5971 B11.n1109 VSUBS 0.40171f
C5972 B11.n1110 VSUBS 0.40171f
C5973 B11.n1111 VSUBS 0.40171f
C5974 B11.n1112 VSUBS 0.40171f
C5975 B11.n1113 VSUBS 0.40171f
C5976 B11.n1114 VSUBS 0.40171f
C5977 B11.n1115 VSUBS 0.40171f
C5978 B11.n1116 VSUBS 0.40171f
C5979 B11.n1117 VSUBS 0.40171f
C5980 B11.n1118 VSUBS 0.40171f
C5981 B11.n1119 VSUBS 0.40171f
C5982 B11.n1120 VSUBS 0.40171f
C5983 B11.n1121 VSUBS 0.40171f
C5984 B11.n1122 VSUBS 0.40171f
C5985 B11.n1123 VSUBS 0.40171f
C5986 B11.n1124 VSUBS 0.40171f
C5987 B11.n1125 VSUBS 0.40171f
C5988 B11.n1126 VSUBS 0.40171f
C5989 B11.n1127 VSUBS 0.40171f
C5990 B11.n1128 VSUBS 0.40171f
C5991 B11.n1129 VSUBS 0.40171f
C5992 B11.n1130 VSUBS 0.40171f
C5993 B11.n1131 VSUBS 0.40171f
C5994 B11.n1132 VSUBS 0.40171f
C5995 B11.n1133 VSUBS 0.40171f
C5996 B11.n1134 VSUBS 0.40171f
C5997 B11.n1135 VSUBS 0.40171f
C5998 B11.n1136 VSUBS 0.40171f
C5999 B11.n1137 VSUBS 0.40171f
C6000 B11.n1138 VSUBS 0.40171f
C6001 B11.n1139 VSUBS 0.40171f
C6002 B11.n1140 VSUBS 0.40171f
C6003 B11.n1141 VSUBS 0.40171f
C6004 B11.n1142 VSUBS 0.40171f
C6005 B11.n1143 VSUBS 0.40171f
C6006 B11.n1144 VSUBS 0.40171f
C6007 B11.n1145 VSUBS 0.40171f
C6008 B11.n1146 VSUBS 0.72542f
C6009 B11.n1147 VSUBS 1.90094f
C6010 B11.n1148 VSUBS 0.50287f
C6011 B11.n1149 VSUBS 0.40171f
C6012 B11.n1150 VSUBS 0.40171f
C6013 B11.n1151 VSUBS 0.40171f
C6014 B11.n1152 VSUBS 0.40171f
C6015 B11.n1153 VSUBS 0.40171f
C6016 B11.n1154 VSUBS 0.40171f
C6017 B11.n1155 VSUBS 0.40171f
C6018 B11.n1156 VSUBS 0.40171f
C6019 B11.n1157 VSUBS 0.40171f
C6020 B11.n1158 VSUBS 0.40171f
C6021 B11.n1159 VSUBS 0.40171f
C6022 B11.n1160 VSUBS 0.40171f
C6023 B11.n1161 VSUBS 0.40171f
C6024 B11.n1162 VSUBS 0.40171f
C6025 B11.n1163 VSUBS 0.40171f
C6026 B11.n1164 VSUBS 0.40171f
C6027 B11.n1165 VSUBS 0.40171f
C6028 B11.n1166 VSUBS 0.40171f
C6029 B11.n1167 VSUBS 0.40171f
C6030 B11.n1168 VSUBS 0.40171f
C6031 B11.n1169 VSUBS 0.40171f
C6032 B11.n1170 VSUBS 0.40171f
C6033 B11.n1171 VSUBS 0.40171f
C6034 B11.n1172 VSUBS 0.40171f
C6035 B11.n1173 VSUBS 0.40171f
C6036 B11.n1174 VSUBS 0.40171f
C6037 B11.n1175 VSUBS 0.40171f
C6038 B11.n1176 VSUBS 0.40171f
C6039 B11.n1177 VSUBS 0.40171f
C6040 B11.n1178 VSUBS 0.40171f
C6041 B11.n1179 VSUBS 0.40171f
C6042 B11.n1180 VSUBS 0.40171f
C6043 B11.n1181 VSUBS 0.40171f
C6044 B11.n1182 VSUBS 0.40171f
C6045 B11.n1183 VSUBS 0.40171f
C6046 B11.n1184 VSUBS 0.40171f
C6047 B11.n1185 VSUBS 0.40171f
C6048 B11.n1186 VSUBS 0.40171f
C6049 B11.n1187 VSUBS 0.40171f
C6050 B11.n1188 VSUBS 0.40171f
C6051 B11.n1189 VSUBS 0.40171f
C6052 B11.n1190 VSUBS 0.40171f
C6053 B11.n1191 VSUBS 0.40171f
C6054 B11.n1192 VSUBS 0.40171f
C6055 B11.n1193 VSUBS 0.40171f
C6056 B11.n1194 VSUBS 0.40171f
C6057 B11.n1195 VSUBS 0.40171f
C6058 B11.n1196 VSUBS 0.40171f
C6059 B11.n1197 VSUBS 0.40171f
C6060 B11.n1198 VSUBS 0.40171f
C6061 B11.n1199 VSUBS 0.40171f
C6062 B11.n1200 VSUBS 0.40171f
C6063 B11.n1201 VSUBS 0.40171f
C6064 B11.n1202 VSUBS 0.40171f
C6065 B11.n1203 VSUBS 0.40171f
C6066 B11.n1204 VSUBS 0.40171f
C6067 B11.n1205 VSUBS 0.40171f
C6068 B11.n1206 VSUBS 0.40171f
C6069 B11.n1207 VSUBS 0.40171f
C6070 B11.n1208 VSUBS 0.40171f
C6071 B11.n1209 VSUBS 0.72542f
C6072 B11.n1210 VSUBS 1.09037f
C6073 B11.n1211 VSUBS 0.50287f
C6074 B11.n1212 VSUBS 0.40171f
C6075 B11.n1213 VSUBS 0.40171f
C6076 B11.n1214 VSUBS 0.40171f
C6077 B11.n1215 VSUBS 0.40171f
C6078 B11.n1216 VSUBS 0.40171f
C6079 B11.n1217 VSUBS 0.40171f
C6080 B11.n1218 VSUBS 0.40171f
C6081 B11.n1219 VSUBS 0.40171f
C6082 B11.n1220 VSUBS 0.40171f
C6083 B11.n1221 VSUBS 0.40171f
C6084 B11.n1222 VSUBS 0.40171f
C6085 B11.n1223 VSUBS 0.40171f
C6086 B11.n1224 VSUBS 0.40171f
C6087 B11.n1225 VSUBS 0.40171f
C6088 B11.n1226 VSUBS 0.40171f
C6089 B11.n1227 VSUBS 0.40171f
C6090 B11.n1228 VSUBS 0.40171f
C6091 B11.n1229 VSUBS 0.40171f
C6092 B11.n1230 VSUBS 0.40171f
C6093 B11.n1231 VSUBS 0.40171f
C6094 B11.n1232 VSUBS 0.40171f
C6095 B11.n1233 VSUBS 0.40171f
C6096 B11.n1234 VSUBS 0.40171f
C6097 B11.n1235 VSUBS 0.40171f
C6098 B11.n1236 VSUBS 0.40171f
C6099 B11.n1237 VSUBS 0.40171f
C6100 B11.n1238 VSUBS 0.40171f
C6101 B11.n1239 VSUBS 0.40171f
C6102 B11.n1240 VSUBS 0.40171f
C6103 B11.n1241 VSUBS 0.40171f
C6104 B11.n1242 VSUBS 0.40171f
C6105 B11.n1243 VSUBS 0.40171f
C6106 B11.n1244 VSUBS 0.40171f
C6107 B11.n1245 VSUBS 0.40171f
C6108 B11.n1246 VSUBS 0.40171f
C6109 B11.n1247 VSUBS 0.40171f
C6110 B11.n1248 VSUBS 0.40171f
C6111 B11.n1249 VSUBS 0.40171f
C6112 B11.n1250 VSUBS 0.40171f
C6113 B11.n1251 VSUBS 0.40171f
C6114 B11.n1252 VSUBS 0.40171f
C6115 B11.n1253 VSUBS 0.40171f
C6116 B11.n1254 VSUBS 0.40171f
C6117 B11.n1255 VSUBS 0.40171f
C6118 B11.n1256 VSUBS 0.40171f
C6119 B11.n1257 VSUBS 0.40171f
C6120 B11.n1258 VSUBS 0.40171f
C6121 B11.n1259 VSUBS 0.40171f
C6122 B11.n1260 VSUBS 0.40171f
C6123 B11.n1261 VSUBS 0.40171f
C6124 B11.n1262 VSUBS 0.40171f
C6125 B11.n1263 VSUBS 0.40171f
C6126 B11.n1264 VSUBS 0.40171f
C6127 B11.n1265 VSUBS 0.40171f
C6128 B11.n1266 VSUBS 0.40171f
C6129 B11.n1267 VSUBS 0.40171f
C6130 B11.n1268 VSUBS 0.40171f
C6131 B11.n1269 VSUBS 0.40171f
C6132 B11.n1270 VSUBS 0.40171f
C6133 B11.n1271 VSUBS 0.40171f
C6134 B11.n1272 VSUBS 0.72542f
C6135 B11.n1273 VSUBS 1.09037f
C6136 B11.n1274 VSUBS 0.50287f
C6137 B11.n1275 VSUBS 0.40171f
C6138 B11.n1276 VSUBS 0.40171f
C6139 B11.n1277 VSUBS 0.40171f
C6140 B11.n1278 VSUBS 0.40171f
C6141 B11.n1279 VSUBS 0.40171f
C6142 B11.n1280 VSUBS 0.40171f
C6143 B11.n1281 VSUBS 0.40171f
C6144 B11.n1282 VSUBS 0.40171f
C6145 B11.n1283 VSUBS 0.40171f
C6146 B11.n1284 VSUBS 0.40171f
C6147 B11.n1285 VSUBS 0.40171f
C6148 B11.n1286 VSUBS 0.40171f
C6149 B11.n1287 VSUBS 0.40171f
C6150 B11.n1288 VSUBS 0.40171f
C6151 B11.n1289 VSUBS 0.40171f
C6152 B11.n1290 VSUBS 0.40171f
C6153 B11.n1291 VSUBS 0.40171f
C6154 B11.n1292 VSUBS 0.40171f
C6155 B11.n1293 VSUBS 0.40171f
C6156 B11.n1294 VSUBS 0.40171f
C6157 B11.n1295 VSUBS 0.40171f
C6158 B11.n1296 VSUBS 0.40171f
C6159 B11.n1297 VSUBS 0.40171f
C6160 B11.n1298 VSUBS 0.40171f
C6161 B11.n1299 VSUBS 0.40171f
C6162 B11.n1300 VSUBS 0.40171f
C6163 B11.n1301 VSUBS 0.40171f
C6164 B11.n1302 VSUBS 0.40171f
C6165 B11.n1303 VSUBS 0.40171f
C6166 B11.n1304 VSUBS 0.40171f
C6167 B11.n1305 VSUBS 0.40171f
C6168 B11.n1306 VSUBS 0.40171f
C6169 B11.n1307 VSUBS 0.40171f
C6170 B11.n1308 VSUBS 0.40171f
C6171 B11.n1309 VSUBS 0.40171f
C6172 B11.n1310 VSUBS 0.40171f
C6173 B11.n1311 VSUBS 0.40171f
C6174 B11.n1312 VSUBS 0.40171f
C6175 B11.n1313 VSUBS 0.40171f
C6176 B11.n1314 VSUBS 0.40171f
C6177 B11.n1315 VSUBS 0.40171f
C6178 B11.n1316 VSUBS 0.40171f
C6179 B11.n1317 VSUBS 0.40171f
C6180 B11.n1318 VSUBS 0.40171f
C6181 B11.n1319 VSUBS 0.40171f
C6182 B11.n1320 VSUBS 0.40171f
C6183 B11.n1321 VSUBS 0.40171f
C6184 B11.n1322 VSUBS 0.40171f
C6185 B11.n1323 VSUBS 0.40171f
C6186 B11.n1324 VSUBS 0.40171f
C6187 B11.n1325 VSUBS 0.40171f
C6188 B11.n1326 VSUBS 0.40171f
C6189 B11.n1327 VSUBS 0.40171f
C6190 B11.n1328 VSUBS 0.40171f
C6191 B11.n1329 VSUBS 0.40171f
C6192 B11.n1330 VSUBS 0.40171f
C6193 B11.n1331 VSUBS 0.40171f
C6194 B11.n1332 VSUBS 0.40171f
C6195 B11.n1333 VSUBS 0.40171f
C6196 B11.n1334 VSUBS 0.40171f
C6197 B11.n1335 VSUBS 0.72542f
C6198 B11.n1336 VSUBS 1.09037f
C6199 B11.n1337 VSUBS 0.50287f
C6200 B11.n1338 VSUBS 0.40171f
C6201 B11.n1339 VSUBS 0.40171f
C6202 B11.n1340 VSUBS 0.40171f
C6203 B11.n1341 VSUBS 0.40171f
C6204 B11.n1342 VSUBS 0.40171f
C6205 B11.n1343 VSUBS 0.40171f
C6206 B11.n1344 VSUBS 0.40171f
C6207 B11.n1345 VSUBS 0.40171f
C6208 B11.n1346 VSUBS 0.40171f
C6209 B11.n1347 VSUBS 0.40171f
C6210 B11.n1348 VSUBS 0.40171f
C6211 B11.n1349 VSUBS 0.40171f
C6212 B11.n1350 VSUBS 0.40171f
C6213 B11.n1351 VSUBS 0.40171f
C6214 B11.n1352 VSUBS 0.40171f
C6215 B11.n1353 VSUBS 0.40171f
C6216 B11.n1354 VSUBS 0.40171f
C6217 B11.n1355 VSUBS 0.40171f
C6218 B11.n1356 VSUBS 0.40171f
C6219 B11.n1357 VSUBS 0.40171f
C6220 B11.n1358 VSUBS 0.40171f
C6221 B11.n1359 VSUBS 0.40171f
C6222 B11.n1360 VSUBS 0.40171f
C6223 B11.n1361 VSUBS 0.40171f
C6224 B11.n1362 VSUBS 0.40171f
C6225 B11.n1363 VSUBS 0.40171f
C6226 B11.n1364 VSUBS 0.40171f
C6227 B11.n1365 VSUBS 0.40171f
C6228 B11.n1366 VSUBS 0.40171f
C6229 B11.n1367 VSUBS 0.40171f
C6230 B11.n1368 VSUBS 0.40171f
C6231 B11.n1369 VSUBS 0.40171f
C6232 B11.n1370 VSUBS 0.40171f
C6233 B11.n1371 VSUBS 0.40171f
C6234 B11.n1372 VSUBS 0.40171f
C6235 B11.n1373 VSUBS 0.40171f
C6236 B11.n1374 VSUBS 0.40171f
C6237 B11.n1375 VSUBS 0.40171f
C6238 B11.n1376 VSUBS 0.40171f
C6239 B11.n1377 VSUBS 0.40171f
C6240 B11.n1378 VSUBS 0.40171f
C6241 B11.n1379 VSUBS 0.40171f
C6242 B11.n1380 VSUBS 0.40171f
C6243 B11.n1381 VSUBS 0.40171f
C6244 B11.n1382 VSUBS 0.40171f
C6245 B11.n1383 VSUBS 0.40171f
C6246 B11.n1384 VSUBS 0.40171f
C6247 B11.n1385 VSUBS 0.40171f
C6248 B11.n1386 VSUBS 0.40171f
C6249 B11.n1387 VSUBS 0.40171f
C6250 B11.n1388 VSUBS 0.40171f
C6251 B11.n1389 VSUBS 0.40171f
C6252 B11.n1390 VSUBS 0.40171f
C6253 B11.n1391 VSUBS 0.40171f
C6254 B11.n1392 VSUBS 0.40171f
C6255 B11.n1393 VSUBS 0.40171f
C6256 B11.n1394 VSUBS 0.40171f
C6257 B11.n1395 VSUBS 0.40171f
C6258 B11.n1396 VSUBS 0.40171f
C6259 B11.n1397 VSUBS 0.40171f
C6260 B11.n1398 VSUBS 0.72542f
C6261 B11.n1399 VSUBS 1.09037f
C6262 B11.n1400 VSUBS 0.50287f
C6263 B11.n1401 VSUBS 0.40171f
C6264 B11.n1402 VSUBS 0.40171f
C6265 B11.n1403 VSUBS 0.40171f
C6266 B11.n1404 VSUBS 0.40171f
C6267 B11.n1405 VSUBS 0.40171f
C6268 B11.n1406 VSUBS 0.40171f
C6269 B11.n1407 VSUBS 0.40171f
C6270 B11.n1408 VSUBS 0.40171f
C6271 B11.n1409 VSUBS 0.40171f
C6272 B11.n1410 VSUBS 0.40171f
C6273 B11.n1411 VSUBS 0.40171f
C6274 B11.n1412 VSUBS 0.40171f
C6275 B11.n1413 VSUBS 0.40171f
C6276 B11.n1414 VSUBS 0.40171f
C6277 B11.n1415 VSUBS 0.40171f
C6278 B11.n1416 VSUBS 0.40171f
C6279 B11.n1417 VSUBS 0.40171f
C6280 B11.n1418 VSUBS 0.40171f
C6281 B11.n1419 VSUBS 0.40171f
C6282 B11.n1420 VSUBS 0.40171f
C6283 B11.n1421 VSUBS 0.40171f
C6284 B11.n1422 VSUBS 0.40171f
C6285 B11.n1423 VSUBS 0.40171f
C6286 B11.n1424 VSUBS 0.40171f
C6287 B11.n1425 VSUBS 0.40171f
C6288 B11.n1426 VSUBS 0.40171f
C6289 B11.n1427 VSUBS 0.40171f
C6290 B11.n1428 VSUBS 0.40171f
C6291 B11.n1429 VSUBS 0.40171f
C6292 B11.n1430 VSUBS 0.40171f
C6293 B11.n1431 VSUBS 0.40171f
C6294 B11.n1432 VSUBS 0.40171f
C6295 B11.n1433 VSUBS 0.40171f
C6296 B11.n1434 VSUBS 0.40171f
C6297 B11.n1435 VSUBS 0.40171f
C6298 B11.n1436 VSUBS 0.40171f
C6299 B11.n1437 VSUBS 0.40171f
C6300 B11.n1438 VSUBS 0.40171f
C6301 B11.n1439 VSUBS 0.40171f
C6302 B11.n1440 VSUBS 0.40171f
C6303 B11.n1441 VSUBS 0.40171f
C6304 B11.n1442 VSUBS 0.40171f
C6305 B11.n1443 VSUBS 0.40171f
C6306 B11.n1444 VSUBS 0.40171f
C6307 B11.n1445 VSUBS 0.40171f
C6308 B11.n1446 VSUBS 0.40171f
C6309 B11.n1447 VSUBS 0.40171f
C6310 B11.n1448 VSUBS 0.40171f
C6311 B11.n1449 VSUBS 0.40171f
C6312 B11.n1450 VSUBS 0.40171f
C6313 B11.n1451 VSUBS 0.40171f
C6314 B11.n1452 VSUBS 0.40171f
C6315 B11.n1453 VSUBS 0.40171f
C6316 B11.n1454 VSUBS 0.40171f
C6317 B11.n1455 VSUBS 0.40171f
C6318 B11.n1456 VSUBS 0.40171f
C6319 B11.n1457 VSUBS 0.40171f
C6320 B11.n1458 VSUBS 0.40171f
C6321 B11.n1459 VSUBS 0.40171f
C6322 B11.n1460 VSUBS 0.40171f
C6323 B11.n1461 VSUBS 0.72542f
C6324 B11.n1462 VSUBS 1.09037f
C6325 B11.n1463 VSUBS 0.50287f
C6326 B11.n1464 VSUBS 0.40171f
C6327 B11.n1465 VSUBS 0.40171f
C6328 B11.n1466 VSUBS 0.40171f
C6329 B11.n1467 VSUBS 0.40171f
C6330 B11.n1468 VSUBS 0.40171f
C6331 B11.n1469 VSUBS 0.40171f
C6332 B11.n1470 VSUBS 0.40171f
C6333 B11.n1471 VSUBS 0.40171f
C6334 B11.n1472 VSUBS 0.40171f
C6335 B11.n1473 VSUBS 0.40171f
C6336 B11.n1474 VSUBS 0.40171f
C6337 B11.n1475 VSUBS 0.40171f
C6338 B11.n1476 VSUBS 0.40171f
C6339 B11.n1477 VSUBS 0.40171f
C6340 B11.n1478 VSUBS 0.40171f
C6341 B11.n1479 VSUBS 0.40171f
C6342 B11.n1480 VSUBS 0.40171f
C6343 B11.n1481 VSUBS 0.40171f
C6344 B11.n1482 VSUBS 0.40171f
C6345 B11.n1483 VSUBS 0.40171f
C6346 B11.n1484 VSUBS 0.40171f
C6347 B11.n1485 VSUBS 0.40171f
C6348 B11.n1486 VSUBS 0.40171f
C6349 B11.n1487 VSUBS 0.40171f
C6350 B11.n1488 VSUBS 0.40171f
C6351 B11.n1489 VSUBS 0.40171f
C6352 B11.n1490 VSUBS 0.40171f
C6353 B11.n1491 VSUBS 0.40171f
C6354 B11.n1492 VSUBS 0.40171f
C6355 B11.n1493 VSUBS 0.40171f
C6356 B11.n1494 VSUBS 0.40171f
C6357 B11.n1495 VSUBS 0.40171f
C6358 B11.n1496 VSUBS 0.40171f
C6359 B11.n1497 VSUBS 0.40171f
C6360 B11.n1498 VSUBS 0.40171f
C6361 B11.n1499 VSUBS 0.40171f
C6362 B11.n1500 VSUBS 0.40171f
C6363 B11.n1501 VSUBS 0.40171f
C6364 B11.n1502 VSUBS 0.40171f
C6365 B11.n1503 VSUBS 0.40171f
C6366 B11.n1504 VSUBS 0.40171f
C6367 B11.n1505 VSUBS 0.40171f
C6368 B11.n1506 VSUBS 0.40171f
C6369 B11.n1507 VSUBS 0.40171f
C6370 B11.n1508 VSUBS 0.40171f
C6371 B11.n1509 VSUBS 0.40171f
C6372 B11.n1510 VSUBS 0.40171f
C6373 B11.n1511 VSUBS 0.40171f
C6374 B11.n1512 VSUBS 0.40171f
C6375 B11.n1513 VSUBS 0.40171f
C6376 B11.n1514 VSUBS 0.40171f
C6377 B11.n1515 VSUBS 0.40171f
C6378 B11.n1516 VSUBS 0.40171f
C6379 B11.n1517 VSUBS 0.40171f
C6380 B11.n1518 VSUBS 0.40171f
C6381 B11.n1519 VSUBS 0.40171f
C6382 B11.n1520 VSUBS 0.40171f
C6383 B11.n1521 VSUBS 0.40171f
C6384 B11.n1522 VSUBS 0.40171f
C6385 B11.n1523 VSUBS 0.40171f
C6386 B11.n1524 VSUBS 0.72542f
C6387 B11.n1525 VSUBS 1.09037f
C6388 B11.n1526 VSUBS 0.50287f
C6389 B11.n1527 VSUBS 0.40171f
C6390 B11.n1528 VSUBS 0.40171f
C6391 B11.n1529 VSUBS 0.40171f
C6392 B11.n1530 VSUBS 0.40171f
C6393 B11.n1531 VSUBS 0.40171f
C6394 B11.n1532 VSUBS 0.40171f
C6395 B11.n1533 VSUBS 0.40171f
C6396 B11.n1534 VSUBS 0.40171f
C6397 B11.n1535 VSUBS 0.40171f
C6398 B11.n1536 VSUBS 0.40171f
C6399 B11.n1537 VSUBS 0.40171f
C6400 B11.n1538 VSUBS 0.40171f
C6401 B11.n1539 VSUBS 0.40171f
C6402 B11.n1540 VSUBS 0.40171f
C6403 B11.n1541 VSUBS 0.40171f
C6404 B11.n1542 VSUBS 0.40171f
C6405 B11.n1543 VSUBS 0.40171f
C6406 B11.n1544 VSUBS 0.40171f
C6407 B11.n1545 VSUBS 0.40171f
C6408 B11.n1546 VSUBS 0.40171f
C6409 B11.n1547 VSUBS 0.40171f
C6410 B11.n1548 VSUBS 0.40171f
C6411 B11.n1549 VSUBS 0.40171f
C6412 B11.n1550 VSUBS 0.40171f
C6413 B11.n1551 VSUBS 0.40171f
C6414 B11.n1552 VSUBS 0.40171f
C6415 B11.n1553 VSUBS 0.40171f
C6416 B11.n1554 VSUBS 0.40171f
C6417 B11.n1555 VSUBS 0.40171f
C6418 B11.n1556 VSUBS 0.40171f
C6419 B11.n1557 VSUBS 0.40171f
C6420 B11.n1558 VSUBS 0.40171f
C6421 B11.n1559 VSUBS 0.40171f
C6422 B11.n1560 VSUBS 0.40171f
C6423 B11.n1561 VSUBS 0.40171f
C6424 B11.n1562 VSUBS 0.40171f
C6425 B11.n1563 VSUBS 0.40171f
C6426 B11.n1564 VSUBS 0.40171f
C6427 B11.n1565 VSUBS 0.40171f
C6428 B11.n1566 VSUBS 0.40171f
C6429 B11.n1567 VSUBS 0.40171f
C6430 B11.n1568 VSUBS 0.40171f
C6431 B11.n1569 VSUBS 0.40171f
C6432 B11.n1570 VSUBS 0.40171f
C6433 B11.n1571 VSUBS 0.40171f
C6434 B11.n1572 VSUBS 0.40171f
C6435 B11.n1573 VSUBS 0.40171f
C6436 B11.n1574 VSUBS 0.40171f
C6437 B11.n1575 VSUBS 0.40171f
C6438 B11.n1576 VSUBS 0.40171f
C6439 B11.n1577 VSUBS 0.40171f
C6440 B11.n1578 VSUBS 0.40171f
C6441 B11.n1579 VSUBS 0.40171f
C6442 B11.n1580 VSUBS 0.40171f
C6443 B11.n1581 VSUBS 0.40171f
C6444 B11.n1582 VSUBS 0.40171f
C6445 B11.n1583 VSUBS 0.40171f
C6446 B11.n1584 VSUBS 0.40171f
C6447 B11.n1585 VSUBS 0.40171f
C6448 B11.n1586 VSUBS 0.40171f
C6449 B11.n1587 VSUBS 0.72542f
C6450 B11.n1588 VSUBS 1.09037f
C6451 B11.n1589 VSUBS 0.50287f
C6452 B11.n1590 VSUBS 0.40171f
C6453 B11.n1591 VSUBS 0.40171f
C6454 B11.n1592 VSUBS 0.40171f
C6455 B11.n1593 VSUBS 0.40171f
C6456 B11.n1594 VSUBS 0.40171f
C6457 B11.n1595 VSUBS 0.40171f
C6458 B11.n1596 VSUBS 0.40171f
C6459 B11.n1597 VSUBS 0.40171f
C6460 B11.n1598 VSUBS 0.40171f
C6461 B11.n1599 VSUBS 0.40171f
C6462 B11.n1600 VSUBS 0.40171f
C6463 B11.n1601 VSUBS 0.40171f
C6464 B11.n1602 VSUBS 0.40171f
C6465 B11.n1603 VSUBS 0.40171f
C6466 B11.n1604 VSUBS 0.40171f
C6467 B11.n1605 VSUBS 0.40171f
C6468 B11.n1606 VSUBS 0.40171f
C6469 B11.n1607 VSUBS 0.40171f
C6470 B11.n1608 VSUBS 0.40171f
C6471 B11.n1609 VSUBS 0.40171f
C6472 B11.n1610 VSUBS 0.40171f
C6473 B11.n1611 VSUBS 0.40171f
C6474 B11.n1612 VSUBS 0.40171f
C6475 B11.n1613 VSUBS 0.40171f
C6476 B11.n1614 VSUBS 0.40171f
C6477 B11.n1615 VSUBS 0.40171f
C6478 B11.n1616 VSUBS 0.40171f
C6479 B11.n1617 VSUBS 0.40171f
C6480 B11.n1618 VSUBS 0.40171f
C6481 B11.n1619 VSUBS 0.40171f
C6482 B11.n1620 VSUBS 0.40171f
C6483 B11.n1621 VSUBS 0.40171f
C6484 B11.n1622 VSUBS 0.40171f
C6485 B11.n1623 VSUBS 0.40171f
C6486 B11.n1624 VSUBS 0.40171f
C6487 B11.n1625 VSUBS 0.40171f
C6488 B11.n1626 VSUBS 0.40171f
C6489 B11.n1627 VSUBS 0.40171f
C6490 B11.n1628 VSUBS 0.40171f
C6491 B11.n1629 VSUBS 0.40171f
C6492 B11.n1630 VSUBS 0.40171f
C6493 B11.n1631 VSUBS 0.40171f
C6494 B11.n1632 VSUBS 0.40171f
C6495 B11.n1633 VSUBS 0.40171f
C6496 B11.n1634 VSUBS 0.40171f
C6497 B11.n1635 VSUBS 0.40171f
C6498 B11.n1636 VSUBS 0.40171f
C6499 B11.n1637 VSUBS 0.40171f
C6500 B11.n1638 VSUBS 0.40171f
C6501 B11.n1639 VSUBS 0.40171f
C6502 B11.n1640 VSUBS 0.40171f
C6503 B11.n1641 VSUBS 0.40171f
C6504 B11.n1642 VSUBS 0.40171f
C6505 B11.n1643 VSUBS 0.40171f
C6506 B11.n1644 VSUBS 0.40171f
C6507 B11.n1645 VSUBS 0.40171f
C6508 B11.n1646 VSUBS 0.40171f
C6509 B11.n1647 VSUBS 0.40171f
C6510 B11.n1648 VSUBS 0.40171f
C6511 B11.n1649 VSUBS 0.40171f
C6512 B11.n1650 VSUBS 0.72542f
C6513 B11.n1651 VSUBS 1.09037f
C6514 B11.n1652 VSUBS 0.50287f
C6515 B11.n1653 VSUBS 0.40171f
C6516 B11.n1654 VSUBS 0.40171f
C6517 B11.n1655 VSUBS 0.40171f
C6518 B11.n1656 VSUBS 0.40171f
C6519 B11.n1657 VSUBS 0.40171f
C6520 B11.n1658 VSUBS 0.40171f
C6521 B11.n1659 VSUBS 0.40171f
C6522 B11.n1660 VSUBS 0.40171f
C6523 B11.n1661 VSUBS 0.40171f
C6524 B11.n1662 VSUBS 0.40171f
C6525 B11.n1663 VSUBS 0.40171f
C6526 B11.n1664 VSUBS 0.40171f
C6527 B11.n1665 VSUBS 0.40171f
C6528 B11.n1666 VSUBS 0.40171f
C6529 B11.n1667 VSUBS 0.40171f
C6530 B11.n1668 VSUBS 0.40171f
C6531 B11.n1669 VSUBS 0.40171f
C6532 B11.n1670 VSUBS 0.40171f
C6533 B11.n1671 VSUBS 0.40171f
C6534 B11.n1672 VSUBS 0.40171f
C6535 B11.n1673 VSUBS 0.40171f
C6536 B11.n1674 VSUBS 0.40171f
C6537 B11.n1675 VSUBS 0.40171f
C6538 B11.n1676 VSUBS 0.40171f
C6539 B11.n1677 VSUBS 0.40171f
C6540 B11.n1678 VSUBS 0.40171f
C6541 B11.n1679 VSUBS 0.40171f
C6542 B11.n1680 VSUBS 0.40171f
C6543 B11.n1681 VSUBS 0.40171f
C6544 B11.n1682 VSUBS 0.40171f
C6545 B11.n1683 VSUBS 0.40171f
C6546 B11.n1684 VSUBS 0.40171f
C6547 B11.n1685 VSUBS 0.40171f
C6548 B11.n1686 VSUBS 0.40171f
C6549 B11.n1687 VSUBS 0.40171f
C6550 B11.n1688 VSUBS 0.40171f
C6551 B11.n1689 VSUBS 0.40171f
C6552 B11.n1690 VSUBS 0.40171f
C6553 B11.n1691 VSUBS 0.40171f
C6554 B11.n1692 VSUBS 0.40171f
C6555 B11.n1693 VSUBS 0.40171f
C6556 B11.n1694 VSUBS 0.40171f
C6557 B11.n1695 VSUBS 0.40171f
C6558 B11.n1696 VSUBS 0.40171f
C6559 B11.n1697 VSUBS 0.40171f
C6560 B11.n1698 VSUBS 0.40171f
C6561 B11.n1699 VSUBS 0.40171f
C6562 B11.n1700 VSUBS 0.40171f
C6563 B11.n1701 VSUBS 0.40171f
C6564 B11.n1702 VSUBS 0.40171f
C6565 B11.n1703 VSUBS 0.40171f
C6566 B11.n1704 VSUBS 0.40171f
C6567 B11.n1705 VSUBS 0.40171f
C6568 B11.n1706 VSUBS 0.40171f
C6569 B11.n1707 VSUBS 0.40171f
C6570 B11.n1708 VSUBS 0.40171f
C6571 B11.n1709 VSUBS 0.40171f
C6572 B11.n1710 VSUBS 0.40171f
C6573 B11.n1711 VSUBS 0.40171f
C6574 B11.n1712 VSUBS 0.40171f
C6575 B11.n1713 VSUBS 0.72542f
C6576 B11.n1714 VSUBS 1.09037f
C6577 B11.n1715 VSUBS 0.50287f
C6578 B11.n1716 VSUBS 0.40171f
C6579 B11.n1717 VSUBS 0.40171f
C6580 B11.n1718 VSUBS 0.40171f
C6581 B11.n1719 VSUBS 0.40171f
C6582 B11.n1720 VSUBS 0.40171f
C6583 B11.n1721 VSUBS 0.40171f
C6584 B11.n1722 VSUBS 0.40171f
C6585 B11.n1723 VSUBS 0.40171f
C6586 B11.n1724 VSUBS 0.40171f
C6587 B11.n1725 VSUBS 0.40171f
C6588 B11.n1726 VSUBS 0.40171f
C6589 B11.n1727 VSUBS 0.40171f
C6590 B11.n1728 VSUBS 0.40171f
C6591 B11.n1729 VSUBS 0.40171f
C6592 B11.n1730 VSUBS 0.40171f
C6593 B11.n1731 VSUBS 0.40171f
C6594 B11.n1732 VSUBS 0.40171f
C6595 B11.n1733 VSUBS 0.40171f
C6596 B11.n1734 VSUBS 0.40171f
C6597 B11.n1735 VSUBS 0.40171f
C6598 B11.n1736 VSUBS 0.40171f
C6599 B11.n1737 VSUBS 0.40171f
C6600 B11.n1738 VSUBS 0.40171f
C6601 B11.n1739 VSUBS 0.40171f
C6602 B11.n1740 VSUBS 0.40171f
C6603 B11.n1741 VSUBS 0.40171f
C6604 B11.n1742 VSUBS 0.40171f
C6605 B11.n1743 VSUBS 0.40171f
C6606 B11.n1744 VSUBS 0.40171f
C6607 B11.n1745 VSUBS 0.40171f
C6608 B11.n1746 VSUBS 0.40171f
C6609 B11.n1747 VSUBS 0.40171f
C6610 B11.n1748 VSUBS 0.40171f
C6611 B11.n1749 VSUBS 0.40171f
C6612 B11.n1750 VSUBS 0.40171f
C6613 B11.n1751 VSUBS 0.40171f
C6614 B11.n1752 VSUBS 0.40171f
C6615 B11.n1753 VSUBS 0.40171f
C6616 B11.n1754 VSUBS 0.40171f
C6617 B11.n1755 VSUBS 0.40171f
C6618 B11.n1756 VSUBS 0.40171f
C6619 B11.n1757 VSUBS 0.40171f
C6620 B11.n1758 VSUBS 0.40171f
C6621 B11.n1759 VSUBS 0.40171f
C6622 B11.n1760 VSUBS 0.40171f
C6623 B11.n1761 VSUBS 0.40171f
C6624 B11.n1762 VSUBS 0.40171f
C6625 B11.n1763 VSUBS 0.40171f
C6626 B11.n1764 VSUBS 0.40171f
C6627 B11.n1765 VSUBS 0.40171f
C6628 B11.n1766 VSUBS 0.40171f
C6629 B11.n1767 VSUBS 0.40171f
C6630 B11.n1768 VSUBS 0.40171f
C6631 B11.n1769 VSUBS 0.40171f
C6632 B11.n1770 VSUBS 0.40171f
C6633 B11.n1771 VSUBS 0.40171f
C6634 B11.n1772 VSUBS 0.40171f
C6635 B11.n1773 VSUBS 0.40171f
C6636 B11.n1774 VSUBS 0.40171f
C6637 B11.n1775 VSUBS 0.40171f
C6638 B11.n1776 VSUBS 0.72542f
C6639 B11.n1777 VSUBS 1.09037f
C6640 B11.n1778 VSUBS 0.50287f
C6641 B11.n1779 VSUBS 0.40171f
C6642 B11.n1780 VSUBS 0.40171f
C6643 B11.n1781 VSUBS 0.40171f
C6644 B11.n1782 VSUBS 0.40171f
C6645 B11.n1783 VSUBS 0.40171f
C6646 B11.n1784 VSUBS 0.40171f
C6647 B11.n1785 VSUBS 0.40171f
C6648 B11.n1786 VSUBS 0.40171f
C6649 B11.n1787 VSUBS 0.40171f
C6650 B11.n1788 VSUBS 0.40171f
C6651 B11.n1789 VSUBS 0.40171f
C6652 B11.n1790 VSUBS 0.40171f
C6653 B11.n1791 VSUBS 0.40171f
C6654 B11.n1792 VSUBS 0.40171f
C6655 B11.n1793 VSUBS 0.40171f
C6656 B11.n1794 VSUBS 0.40171f
C6657 B11.n1795 VSUBS 0.40171f
C6658 B11.n1796 VSUBS 0.40171f
C6659 B11.n1797 VSUBS 0.40171f
C6660 B11.n1798 VSUBS 0.40171f
C6661 B11.n1799 VSUBS 0.40171f
C6662 B11.n1800 VSUBS 0.40171f
C6663 B11.n1801 VSUBS 0.40171f
C6664 B11.n1802 VSUBS 0.40171f
C6665 B11.n1803 VSUBS 0.40171f
C6666 B11.n1804 VSUBS 0.40171f
C6667 B11.n1805 VSUBS 0.40171f
C6668 B11.n1806 VSUBS 0.40171f
C6669 B11.n1807 VSUBS 0.40171f
C6670 B11.n1808 VSUBS 0.40171f
C6671 B11.n1809 VSUBS 0.40171f
C6672 B11.n1810 VSUBS 0.40171f
C6673 B11.n1811 VSUBS 0.40171f
C6674 B11.n1812 VSUBS 0.40171f
C6675 B11.n1813 VSUBS 0.40171f
C6676 B11.n1814 VSUBS 0.40171f
C6677 B11.n1815 VSUBS 0.40171f
C6678 B11.n1816 VSUBS 0.40171f
C6679 B11.n1817 VSUBS 0.40171f
C6680 B11.n1818 VSUBS 0.40171f
C6681 B11.n1819 VSUBS 0.40171f
C6682 B11.n1820 VSUBS 0.40171f
C6683 B11.n1821 VSUBS 0.40171f
C6684 B11.n1822 VSUBS 0.40171f
C6685 B11.n1823 VSUBS 0.40171f
C6686 B11.n1824 VSUBS 0.40171f
C6687 B11.n1825 VSUBS 0.40171f
C6688 B11.n1826 VSUBS 0.40171f
C6689 B11.n1827 VSUBS 0.40171f
C6690 B11.n1828 VSUBS 0.40171f
C6691 B11.n1829 VSUBS 0.40171f
C6692 B11.n1830 VSUBS 0.40171f
C6693 B11.n1831 VSUBS 0.40171f
C6694 B11.n1832 VSUBS 0.40171f
C6695 B11.n1833 VSUBS 0.40171f
C6696 B11.n1834 VSUBS 0.40171f
C6697 B11.n1835 VSUBS 0.40171f
C6698 B11.n1836 VSUBS 0.40171f
C6699 B11.n1837 VSUBS 0.40171f
C6700 B11.n1838 VSUBS 0.40171f
C6701 B11.n1839 VSUBS 0.72542f
C6702 B11.n1840 VSUBS 1.09037f
C6703 B11.n1841 VSUBS 0.50287f
C6704 B11.n1842 VSUBS 0.40171f
C6705 B11.n1843 VSUBS 0.40171f
C6706 B11.n1844 VSUBS 0.40171f
C6707 B11.n1845 VSUBS 0.40171f
C6708 B11.n1846 VSUBS 0.40171f
C6709 B11.n1847 VSUBS 0.40171f
C6710 B11.n1848 VSUBS 0.40171f
C6711 B11.n1849 VSUBS 0.40171f
C6712 B11.n1850 VSUBS 0.40171f
C6713 B11.n1851 VSUBS 0.40171f
C6714 B11.n1852 VSUBS 0.40171f
C6715 B11.n1853 VSUBS 0.40171f
C6716 B11.n1854 VSUBS 0.40171f
C6717 B11.n1855 VSUBS 0.40171f
C6718 B11.n1856 VSUBS 0.40171f
C6719 B11.n1857 VSUBS 0.40171f
C6720 B11.n1858 VSUBS 0.40171f
C6721 B11.n1859 VSUBS 0.40171f
C6722 B11.n1860 VSUBS 0.40171f
C6723 B11.n1861 VSUBS 0.40171f
C6724 B11.n1862 VSUBS 0.40171f
C6725 B11.n1863 VSUBS 0.40171f
C6726 B11.n1864 VSUBS 0.40171f
C6727 B11.n1865 VSUBS 0.40171f
C6728 B11.n1866 VSUBS 0.40171f
C6729 B11.n1867 VSUBS 0.40171f
C6730 B11.n1868 VSUBS 0.40171f
C6731 B11.n1869 VSUBS 0.40171f
C6732 B11.n1870 VSUBS 0.40171f
C6733 B11.n1871 VSUBS 0.40171f
C6734 B11.n1872 VSUBS 0.40171f
C6735 B11.n1873 VSUBS 0.40171f
C6736 B11.n1874 VSUBS 0.40171f
C6737 B11.n1875 VSUBS 0.40171f
C6738 B11.n1876 VSUBS 0.40171f
C6739 B11.n1877 VSUBS 0.40171f
C6740 B11.n1878 VSUBS 0.40171f
C6741 B11.n1879 VSUBS 0.40171f
C6742 B11.n1880 VSUBS 0.40171f
C6743 B11.n1881 VSUBS 0.40171f
C6744 B11.n1882 VSUBS 0.40171f
C6745 B11.n1883 VSUBS 0.40171f
C6746 B11.n1884 VSUBS 0.40171f
C6747 B11.n1885 VSUBS 0.40171f
C6748 B11.n1886 VSUBS 0.40171f
C6749 B11.n1887 VSUBS 0.40171f
C6750 B11.n1888 VSUBS 0.40171f
C6751 B11.n1889 VSUBS 0.40171f
C6752 B11.n1890 VSUBS 0.40171f
C6753 B11.n1891 VSUBS 0.40171f
C6754 B11.n1892 VSUBS 0.40171f
C6755 B11.n1893 VSUBS 0.40171f
C6756 B11.n1894 VSUBS 0.40171f
C6757 B11.n1895 VSUBS 0.40171f
C6758 B11.n1896 VSUBS 0.40171f
C6759 B11.n1897 VSUBS 0.40171f
C6760 B11.n1898 VSUBS 0.40171f
C6761 B11.n1899 VSUBS 0.40171f
C6762 B11.n1900 VSUBS 0.40171f
C6763 B11.n1901 VSUBS 0.40171f
C6764 B11.n1902 VSUBS 0.72542f
C6765 B11.n1903 VSUBS 1.09037f
C6766 B11.n1904 VSUBS 0.50287f
C6767 B11.n1905 VSUBS 0.40171f
C6768 B11.n1906 VSUBS 0.40171f
C6769 B11.n1907 VSUBS 0.40171f
C6770 B11.n1908 VSUBS 0.40171f
C6771 B11.n1909 VSUBS 0.40171f
C6772 B11.n1910 VSUBS 0.40171f
C6773 B11.n1911 VSUBS 0.40171f
C6774 B11.n1912 VSUBS 0.40171f
C6775 B11.n1913 VSUBS 0.40171f
C6776 B11.n1914 VSUBS 0.40171f
C6777 B11.n1915 VSUBS 0.40171f
C6778 B11.n1916 VSUBS 0.40171f
C6779 B11.n1917 VSUBS 0.40171f
C6780 B11.n1918 VSUBS 0.40171f
C6781 B11.n1919 VSUBS 0.40171f
C6782 B11.n1920 VSUBS 0.40171f
C6783 B11.n1921 VSUBS 0.40171f
C6784 B11.n1922 VSUBS 0.40171f
C6785 B11.n1923 VSUBS 0.40171f
C6786 B11.n1924 VSUBS 0.40171f
C6787 B11.n1925 VSUBS 0.40171f
C6788 B11.n1926 VSUBS 0.40171f
C6789 B11.n1927 VSUBS 0.40171f
C6790 B11.n1928 VSUBS 0.40171f
C6791 B11.n1929 VSUBS 0.40171f
C6792 B11.n1930 VSUBS 0.40171f
C6793 B11.n1931 VSUBS 0.40171f
C6794 B11.n1932 VSUBS 0.40171f
C6795 B11.n1933 VSUBS 0.40171f
C6796 B11.n1934 VSUBS 0.40171f
C6797 B11.n1935 VSUBS 0.40171f
C6798 B11.n1936 VSUBS 0.40171f
C6799 B11.n1937 VSUBS 0.40171f
C6800 B11.n1938 VSUBS 0.40171f
C6801 B11.n1939 VSUBS 0.40171f
C6802 B11.n1940 VSUBS 0.40171f
C6803 B11.n1941 VSUBS 0.40171f
C6804 B11.n1942 VSUBS 0.40171f
C6805 B11.n1943 VSUBS 0.40171f
C6806 B11.n1944 VSUBS 0.40171f
C6807 B11.n1945 VSUBS 0.40171f
C6808 B11.n1946 VSUBS 0.40171f
C6809 B11.n1947 VSUBS 0.40171f
C6810 B11.n1948 VSUBS 0.40171f
C6811 B11.n1949 VSUBS 0.40171f
C6812 B11.n1950 VSUBS 0.40171f
C6813 B11.n1951 VSUBS 0.40171f
C6814 B11.n1952 VSUBS 0.40171f
C6815 B11.n1953 VSUBS 0.40171f
C6816 B11.n1954 VSUBS 0.40171f
C6817 B11.n1955 VSUBS 0.40171f
C6818 B11.n1956 VSUBS 0.40171f
C6819 B11.n1957 VSUBS 0.40171f
C6820 B11.n1958 VSUBS 0.40171f
C6821 B11.n1959 VSUBS 0.40171f
C6822 B11.n1960 VSUBS 0.40171f
C6823 B11.n1961 VSUBS 0.40171f
C6824 B11.n1962 VSUBS 0.40171f
C6825 B11.n1963 VSUBS 0.40171f
C6826 B11.n1964 VSUBS 0.40171f
C6827 B11.n1965 VSUBS 0.72542f
C6828 B11.n1966 VSUBS 1.09037f
C6829 B11.n1967 VSUBS 0.50287f
C6830 B11.n1968 VSUBS 0.40171f
C6831 B11.n1969 VSUBS 0.40171f
C6832 B11.n1970 VSUBS 0.40171f
C6833 B11.n1971 VSUBS 0.40171f
C6834 B11.n1972 VSUBS 0.40171f
C6835 B11.n1973 VSUBS 0.40171f
C6836 B11.n1974 VSUBS 0.40171f
C6837 B11.n1975 VSUBS 0.40171f
C6838 B11.n1976 VSUBS 0.40171f
C6839 B11.n1977 VSUBS 0.40171f
C6840 B11.n1978 VSUBS 0.40171f
C6841 B11.n1979 VSUBS 0.40171f
C6842 B11.n1980 VSUBS 0.40171f
C6843 B11.n1981 VSUBS 0.40171f
C6844 B11.n1982 VSUBS 0.40171f
C6845 B11.n1983 VSUBS 0.40171f
C6846 B11.n1984 VSUBS 0.40171f
C6847 B11.n1985 VSUBS 0.40171f
C6848 B11.n1986 VSUBS 0.40171f
C6849 B11.n1987 VSUBS 0.40171f
C6850 B11.n1988 VSUBS 0.40171f
C6851 B11.n1989 VSUBS 0.40171f
C6852 B11.n1990 VSUBS 0.40171f
C6853 B11.n1991 VSUBS 0.40171f
C6854 B11.n1992 VSUBS 0.40171f
C6855 B11.n1993 VSUBS 0.40171f
C6856 B11.n1994 VSUBS 0.40171f
C6857 B11.n1995 VSUBS 0.40171f
C6858 B11.n1996 VSUBS 0.40171f
C6859 B11.n1997 VSUBS 0.40171f
C6860 B11.n1998 VSUBS 0.40171f
C6861 B11.n1999 VSUBS 0.40171f
C6862 B11.n2000 VSUBS 0.40171f
C6863 B11.n2001 VSUBS 0.40171f
C6864 B11.n2002 VSUBS 0.40171f
C6865 B11.n2003 VSUBS 0.40171f
C6866 B11.n2004 VSUBS 0.40171f
C6867 B11.n2005 VSUBS 0.40171f
C6868 B11.n2006 VSUBS 0.40171f
C6869 B11.n2007 VSUBS 0.40171f
C6870 B11.n2008 VSUBS 0.40171f
C6871 B11.n2009 VSUBS 0.40171f
C6872 B11.n2010 VSUBS 0.40171f
C6873 B11.n2011 VSUBS 0.40171f
C6874 B11.n2012 VSUBS 0.40171f
C6875 B11.n2013 VSUBS 0.40171f
C6876 B11.n2014 VSUBS 0.40171f
C6877 B11.n2015 VSUBS 0.40171f
C6878 B11.n2016 VSUBS 0.40171f
C6879 B11.n2017 VSUBS 0.40171f
C6880 B11.n2018 VSUBS 0.40171f
C6881 B11.n2019 VSUBS 0.40171f
C6882 B11.n2020 VSUBS 0.40171f
C6883 B11.n2021 VSUBS 0.40171f
C6884 B11.n2022 VSUBS 0.40171f
C6885 B11.n2023 VSUBS 0.40171f
C6886 B11.n2024 VSUBS 0.40171f
C6887 B11.n2025 VSUBS 0.40171f
C6888 B11.n2026 VSUBS 0.40171f
C6889 B11.n2027 VSUBS 0.40171f
C6890 B11.n2028 VSUBS 0.72542f
C6891 B11.n2029 VSUBS 6.61314f
C6892 B11.n2030 VSUBS 6.67077f
C6893 B11.n2031 VSUBS 1.148f
C6894 B11.n2032 VSUBS 1.148f
C6895 B11.n2033 VSUBS 1.148f
C6896 B11.n2034 VSUBS 1.148f
C6897 B11.n2035 VSUBS 1.148f
C6898 B11.n2036 VSUBS 1.148f
C6899 B11.n2037 VSUBS 1.148f
C6900 B11.n2038 VSUBS 1.148f
C6901 B11.n2039 VSUBS 1.148f
C6902 B11.n2040 VSUBS 1.148f
C6903 B11.n2041 VSUBS 1.148f
C6904 B11.n2042 VSUBS 1.148f
C6905 B11.n2043 VSUBS 1.148f
C6906 B11.n2044 VSUBS 1.148f
C6907 B11.n2045 VSUBS 15.8642f
C6908 B7.n0 VSUBS 0.55894f
C6909 B7.n1 VSUBS 0.4465f
C6910 B7.n2 VSUBS 0.4465f
C6911 B7.n3 VSUBS 0.4465f
C6912 B7.n4 VSUBS 0.4465f
C6913 B7.n5 VSUBS 0.4465f
C6914 B7.n6 VSUBS 0.4465f
C6915 B7.n7 VSUBS 0.4465f
C6916 B7.n8 VSUBS 0.4465f
C6917 B7.n9 VSUBS 0.4465f
C6918 B7.n10 VSUBS 0.4465f
C6919 B7.n11 VSUBS 0.4465f
C6920 B7.n12 VSUBS 0.4465f
C6921 B7.n13 VSUBS 0.4465f
C6922 B7.n14 VSUBS 0.4465f
C6923 B7.n15 VSUBS 0.4465f
C6924 B7.n16 VSUBS 0.4465f
C6925 B7.n17 VSUBS 0.4465f
C6926 B7.n18 VSUBS 0.4465f
C6927 B7.n19 VSUBS 0.4465f
C6928 B7.n20 VSUBS 0.4465f
C6929 B7.n21 VSUBS 0.4465f
C6930 B7.n22 VSUBS 0.4465f
C6931 B7.n23 VSUBS 0.4465f
C6932 B7.n24 VSUBS 0.4465f
C6933 B7.n25 VSUBS 0.4465f
C6934 B7.n26 VSUBS 0.4465f
C6935 B7.n27 VSUBS 0.4465f
C6936 B7.n28 VSUBS 0.4465f
C6937 B7.n29 VSUBS 0.4465f
C6938 B7.n30 VSUBS 0.4465f
C6939 B7.n31 VSUBS 0.4465f
C6940 B7.n32 VSUBS 0.4465f
C6941 B7.n33 VSUBS 0.4465f
C6942 B7.n34 VSUBS 0.4465f
C6943 B7.n35 VSUBS 0.4465f
C6944 B7.n36 VSUBS 0.4465f
C6945 B7.n37 VSUBS 0.4465f
C6946 B7.n38 VSUBS 0.4465f
C6947 B7.n39 VSUBS 0.4465f
C6948 B7.n40 VSUBS 0.4465f
C6949 B7.n41 VSUBS 0.4465f
C6950 B7.n42 VSUBS 0.4465f
C6951 B7.n43 VSUBS 0.4465f
C6952 B7.n44 VSUBS 0.4465f
C6953 B7.n45 VSUBS 0.4465f
C6954 B7.n46 VSUBS 0.4465f
C6955 B7.n47 VSUBS 0.4465f
C6956 B7.n48 VSUBS 0.4465f
C6957 B7.n49 VSUBS 0.4465f
C6958 B7.n50 VSUBS 0.4465f
C6959 B7.n51 VSUBS 0.4465f
C6960 B7.n52 VSUBS 0.4465f
C6961 B7.n53 VSUBS 0.4465f
C6962 B7.n54 VSUBS 0.4465f
C6963 B7.n55 VSUBS 0.4465f
C6964 B7.n56 VSUBS 0.4465f
C6965 B7.n57 VSUBS 0.4465f
C6966 B7.n58 VSUBS 0.4465f
C6967 B7.n59 VSUBS 0.4465f
C6968 B7.n60 VSUBS 0.4465f
C6969 B7.n61 VSUBS 0.62928f
C6970 B7.n62 VSUBS 43.519f
C6971 B7.n63 VSUBS 0.55894f
C6972 B7.n64 VSUBS 0.4465f
C6973 B7.n65 VSUBS 0.4465f
C6974 B7.n66 VSUBS 0.4465f
C6975 B7.n67 VSUBS 0.4465f
C6976 B7.n68 VSUBS 0.4465f
C6977 B7.n69 VSUBS 0.4465f
C6978 B7.n70 VSUBS 0.4465f
C6979 B7.n71 VSUBS 0.4465f
C6980 B7.n72 VSUBS 0.4465f
C6981 B7.n73 VSUBS 0.4465f
C6982 B7.n74 VSUBS 0.4465f
C6983 B7.n75 VSUBS 0.4465f
C6984 B7.n76 VSUBS 0.4465f
C6985 B7.n77 VSUBS 0.4465f
C6986 B7.n78 VSUBS 0.4465f
C6987 B7.n79 VSUBS 0.4465f
C6988 B7.n80 VSUBS 0.4465f
C6989 B7.n81 VSUBS 0.4465f
C6990 B7.n82 VSUBS 0.4465f
C6991 B7.n83 VSUBS 0.4465f
C6992 B7.n84 VSUBS 0.4465f
C6993 B7.n85 VSUBS 0.4465f
C6994 B7.n86 VSUBS 0.4465f
C6995 B7.n87 VSUBS 0.4465f
C6996 B7.n88 VSUBS 0.4465f
C6997 B7.n89 VSUBS 0.4465f
C6998 B7.n90 VSUBS 0.4465f
C6999 B7.n91 VSUBS 0.4465f
C7000 B7.n92 VSUBS 0.4465f
C7001 B7.n93 VSUBS 0.4465f
C7002 B7.n94 VSUBS 0.4465f
C7003 B7.n95 VSUBS 0.4465f
C7004 B7.n96 VSUBS 0.4465f
C7005 B7.n97 VSUBS 0.4465f
C7006 B7.n98 VSUBS 0.4465f
C7007 B7.n99 VSUBS 0.4465f
C7008 B7.n100 VSUBS 0.4465f
C7009 B7.n101 VSUBS 0.4465f
C7010 B7.n102 VSUBS 0.4465f
C7011 B7.n103 VSUBS 0.4465f
C7012 B7.n104 VSUBS 0.4465f
C7013 B7.n105 VSUBS 0.4465f
C7014 B7.n106 VSUBS 0.4465f
C7015 B7.n107 VSUBS 0.4465f
C7016 B7.n108 VSUBS 0.4465f
C7017 B7.n109 VSUBS 0.4465f
C7018 B7.n110 VSUBS 0.4465f
C7019 B7.n111 VSUBS 0.4465f
C7020 B7.n112 VSUBS 0.4465f
C7021 B7.n113 VSUBS 0.4465f
C7022 B7.n114 VSUBS 0.4465f
C7023 B7.n115 VSUBS 0.4465f
C7024 B7.n116 VSUBS 0.4465f
C7025 B7.n117 VSUBS 0.4465f
C7026 B7.n118 VSUBS 0.4465f
C7027 B7.n119 VSUBS 0.4465f
C7028 B7.n120 VSUBS 0.4465f
C7029 B7.n121 VSUBS 0.4465f
C7030 B7.n122 VSUBS 0.4465f
C7031 B7.n123 VSUBS 0.4465f
C7032 B7.n124 VSUBS 8.92175f
C7033 B7.n125 VSUBS 23.529f
C7034 B8.n0 VSUBS 12.9173f
C7035 B8.n1 VSUBS 0.53498f
C7036 B8.n2 VSUBS 0.42736f
C7037 B8.n3 VSUBS 0.42736f
C7038 B8.n4 VSUBS 0.42736f
C7039 B8.n5 VSUBS 0.42736f
C7040 B8.n6 VSUBS 0.42736f
C7041 B8.n7 VSUBS 0.42736f
C7042 B8.n8 VSUBS 0.42736f
C7043 B8.n9 VSUBS 0.42736f
C7044 B8.n10 VSUBS 0.42736f
C7045 B8.n11 VSUBS 0.42736f
C7046 B8.n12 VSUBS 0.42736f
C7047 B8.n13 VSUBS 0.42736f
C7048 B8.n14 VSUBS 0.42736f
C7049 B8.n15 VSUBS 0.42736f
C7050 B8.n16 VSUBS 0.42736f
C7051 B8.n17 VSUBS 0.42736f
C7052 B8.n18 VSUBS 0.42736f
C7053 B8.n19 VSUBS 0.42736f
C7054 B8.n20 VSUBS 0.42736f
C7055 B8.n21 VSUBS 0.42736f
C7056 B8.n22 VSUBS 0.42736f
C7057 B8.n23 VSUBS 0.42736f
C7058 B8.n24 VSUBS 0.42736f
C7059 B8.n25 VSUBS 0.42736f
C7060 B8.n26 VSUBS 0.42736f
C7061 B8.n27 VSUBS 0.42736f
C7062 B8.n28 VSUBS 0.42736f
C7063 B8.n29 VSUBS 0.42736f
C7064 B8.n30 VSUBS 0.42736f
C7065 B8.n31 VSUBS 0.42736f
C7066 B8.n32 VSUBS 0.42736f
C7067 B8.n33 VSUBS 0.42736f
C7068 B8.n34 VSUBS 0.42736f
C7069 B8.n35 VSUBS 0.42736f
C7070 B8.n36 VSUBS 0.42736f
C7071 B8.n37 VSUBS 0.42736f
C7072 B8.n38 VSUBS 0.42736f
C7073 B8.n39 VSUBS 0.42736f
C7074 B8.n40 VSUBS 0.42736f
C7075 B8.n41 VSUBS 0.42736f
C7076 B8.n42 VSUBS 0.42736f
C7077 B8.n43 VSUBS 0.42736f
C7078 B8.n44 VSUBS 0.42736f
C7079 B8.n45 VSUBS 0.42736f
C7080 B8.n46 VSUBS 0.42736f
C7081 B8.n47 VSUBS 0.42736f
C7082 B8.n48 VSUBS 0.42736f
C7083 B8.n49 VSUBS 0.42736f
C7084 B8.n50 VSUBS 0.42736f
C7085 B8.n51 VSUBS 0.42736f
C7086 B8.n52 VSUBS 0.42736f
C7087 B8.n53 VSUBS 0.42736f
C7088 B8.n54 VSUBS 0.42736f
C7089 B8.n55 VSUBS 0.42736f
C7090 B8.n56 VSUBS 0.42736f
C7091 B8.n57 VSUBS 0.42736f
C7092 B8.n58 VSUBS 0.42736f
C7093 B8.n59 VSUBS 0.42736f
C7094 B8.n60 VSUBS 0.42736f
C7095 B8.n61 VSUBS 0.42736f
C7096 B8.n62 VSUBS 0.64965f
C7097 B8.n63 VSUBS 12.0493f
C7098 B8.n64 VSUBS 0.53498f
C7099 B8.n65 VSUBS 0.42736f
C7100 B8.n66 VSUBS 0.42736f
C7101 B8.n67 VSUBS 0.42736f
C7102 B8.n68 VSUBS 0.42736f
C7103 B8.n69 VSUBS 0.42736f
C7104 B8.n70 VSUBS 0.42736f
C7105 B8.n71 VSUBS 0.42736f
C7106 B8.n72 VSUBS 0.42736f
C7107 B8.n73 VSUBS 0.42736f
C7108 B8.n74 VSUBS 0.42736f
C7109 B8.n75 VSUBS 0.42736f
C7110 B8.n76 VSUBS 0.42736f
C7111 B8.n77 VSUBS 0.42736f
C7112 B8.n78 VSUBS 0.42736f
C7113 B8.n79 VSUBS 0.42736f
C7114 B8.n80 VSUBS 0.42736f
C7115 B8.n81 VSUBS 0.42736f
C7116 B8.n82 VSUBS 0.42736f
C7117 B8.n83 VSUBS 0.42736f
C7118 B8.n84 VSUBS 0.42736f
C7119 B8.n85 VSUBS 0.42736f
C7120 B8.n86 VSUBS 0.42736f
C7121 B8.n87 VSUBS 0.42736f
C7122 B8.n88 VSUBS 0.42736f
C7123 B8.n89 VSUBS 0.42736f
C7124 B8.n90 VSUBS 0.42736f
C7125 B8.n91 VSUBS 0.42736f
C7126 B8.n92 VSUBS 0.42736f
C7127 B8.n93 VSUBS 0.42736f
C7128 B8.n94 VSUBS 0.42736f
C7129 B8.n95 VSUBS 0.42736f
C7130 B8.n96 VSUBS 0.42736f
C7131 B8.n97 VSUBS 0.42736f
C7132 B8.n98 VSUBS 0.42736f
C7133 B8.n99 VSUBS 0.42736f
C7134 B8.n100 VSUBS 0.42736f
C7135 B8.n101 VSUBS 0.42736f
C7136 B8.n102 VSUBS 0.42736f
C7137 B8.n103 VSUBS 0.42736f
C7138 B8.n104 VSUBS 0.42736f
C7139 B8.n105 VSUBS 0.42736f
C7140 B8.n106 VSUBS 0.42736f
C7141 B8.n107 VSUBS 0.42736f
C7142 B8.n108 VSUBS 0.42736f
C7143 B8.n109 VSUBS 0.42736f
C7144 B8.n110 VSUBS 0.42736f
C7145 B8.n111 VSUBS 0.42736f
C7146 B8.n112 VSUBS 0.42736f
C7147 B8.n113 VSUBS 0.42736f
C7148 B8.n114 VSUBS 0.42736f
C7149 B8.n115 VSUBS 0.42736f
C7150 B8.n116 VSUBS 0.42736f
C7151 B8.n117 VSUBS 0.42736f
C7152 B8.n118 VSUBS 0.42736f
C7153 B8.n119 VSUBS 0.42736f
C7154 B8.n120 VSUBS 0.42736f
C7155 B8.n121 VSUBS 0.42736f
C7156 B8.n122 VSUBS 0.42736f
C7157 B8.n123 VSUBS 0.42736f
C7158 B8.n124 VSUBS 0.42736f
C7159 B8.n125 VSUBS 0.64965f
C7160 B8.n126 VSUBS 24.0897f
C7161 B8.n127 VSUBS 0.53498f
C7162 B8.n128 VSUBS 0.42736f
C7163 B8.n129 VSUBS 0.42736f
C7164 B8.n130 VSUBS 0.42736f
C7165 B8.n131 VSUBS 0.42736f
C7166 B8.n132 VSUBS 0.42736f
C7167 B8.n133 VSUBS 0.42736f
C7168 B8.n134 VSUBS 0.42736f
C7169 B8.n135 VSUBS 0.42736f
C7170 B8.n136 VSUBS 0.42736f
C7171 B8.n137 VSUBS 0.42736f
C7172 B8.n138 VSUBS 0.42736f
C7173 B8.n139 VSUBS 0.42736f
C7174 B8.n140 VSUBS 0.42736f
C7175 B8.n141 VSUBS 0.42736f
C7176 B8.n142 VSUBS 0.42736f
C7177 B8.n143 VSUBS 0.42736f
C7178 B8.n144 VSUBS 0.42736f
C7179 B8.n145 VSUBS 0.42736f
C7180 B8.n146 VSUBS 0.42736f
C7181 B8.n147 VSUBS 0.42736f
C7182 B8.n148 VSUBS 0.42736f
C7183 B8.n149 VSUBS 0.42736f
C7184 B8.n150 VSUBS 0.42736f
C7185 B8.n151 VSUBS 0.42736f
C7186 B8.n152 VSUBS 0.42736f
C7187 B8.n153 VSUBS 0.42736f
C7188 B8.n154 VSUBS 0.42736f
C7189 B8.n155 VSUBS 0.42736f
C7190 B8.n156 VSUBS 0.42736f
C7191 B8.n157 VSUBS 0.42736f
C7192 B8.n158 VSUBS 0.42736f
C7193 B8.n159 VSUBS 0.42736f
C7194 B8.n160 VSUBS 0.42736f
C7195 B8.n161 VSUBS 0.42736f
C7196 B8.n162 VSUBS 0.42736f
C7197 B8.n163 VSUBS 0.42736f
C7198 B8.n164 VSUBS 0.42736f
C7199 B8.n165 VSUBS 0.42736f
C7200 B8.n166 VSUBS 0.42736f
C7201 B8.n167 VSUBS 0.42736f
C7202 B8.n168 VSUBS 0.42736f
C7203 B8.n169 VSUBS 0.42736f
C7204 B8.n170 VSUBS 0.42736f
C7205 B8.n171 VSUBS 0.42736f
C7206 B8.n172 VSUBS 0.42736f
C7207 B8.n173 VSUBS 0.42736f
C7208 B8.n174 VSUBS 0.42736f
C7209 B8.n175 VSUBS 0.42736f
C7210 B8.n176 VSUBS 0.42736f
C7211 B8.n177 VSUBS 0.42736f
C7212 B8.n178 VSUBS 0.42736f
C7213 B8.n179 VSUBS 0.42736f
C7214 B8.n180 VSUBS 0.42736f
C7215 B8.n181 VSUBS 0.42736f
C7216 B8.n182 VSUBS 0.42736f
C7217 B8.n183 VSUBS 0.42736f
C7218 B8.n184 VSUBS 0.42736f
C7219 B8.n185 VSUBS 0.42736f
C7220 B8.n186 VSUBS 0.42736f
C7221 B8.n187 VSUBS 0.42736f
C7222 B8.n188 VSUBS 0.66324f
C7223 B8.n189 VSUBS 0.53498f
C7224 B8.n190 VSUBS 0.42736f
C7225 B8.n191 VSUBS 0.42736f
C7226 B8.n192 VSUBS 0.42736f
C7227 B8.n193 VSUBS 0.42736f
C7228 B8.n194 VSUBS 0.42736f
C7229 B8.n195 VSUBS 0.42736f
C7230 B8.n196 VSUBS 0.42736f
C7231 B8.n197 VSUBS 0.42736f
C7232 B8.n198 VSUBS 0.42736f
C7233 B8.n199 VSUBS 0.42736f
C7234 B8.n200 VSUBS 0.42736f
C7235 B8.n201 VSUBS 0.42736f
C7236 B8.n202 VSUBS 0.42736f
C7237 B8.n203 VSUBS 0.42736f
C7238 B8.n204 VSUBS 0.42736f
C7239 B8.n205 VSUBS 0.42736f
C7240 B8.n206 VSUBS 0.42736f
C7241 B8.n207 VSUBS 0.42736f
C7242 B8.n208 VSUBS 0.42736f
C7243 B8.n209 VSUBS 0.42736f
C7244 B8.n210 VSUBS 0.42736f
C7245 B8.n211 VSUBS 0.42736f
C7246 B8.n212 VSUBS 0.42736f
C7247 B8.n213 VSUBS 0.42736f
C7248 B8.n214 VSUBS 0.42736f
C7249 B8.n215 VSUBS 0.42736f
C7250 B8.n216 VSUBS 0.42736f
C7251 B8.n217 VSUBS 0.42736f
C7252 B8.n218 VSUBS 0.42736f
C7253 B8.n219 VSUBS 0.42736f
C7254 B8.n220 VSUBS 0.42736f
C7255 B8.n221 VSUBS 0.42736f
C7256 B8.n222 VSUBS 0.42736f
C7257 B8.n223 VSUBS 0.42736f
C7258 B8.n224 VSUBS 0.42736f
C7259 B8.n225 VSUBS 0.42736f
C7260 B8.n226 VSUBS 0.42736f
C7261 B8.n227 VSUBS 0.42736f
C7262 B8.n228 VSUBS 0.42736f
C7263 B8.n229 VSUBS 0.42736f
C7264 B8.n230 VSUBS 0.42736f
C7265 B8.n231 VSUBS 0.42736f
C7266 B8.n232 VSUBS 0.42736f
C7267 B8.n233 VSUBS 0.42736f
C7268 B8.n234 VSUBS 0.42736f
C7269 B8.n235 VSUBS 0.42736f
C7270 B8.n236 VSUBS 0.42736f
C7271 B8.n237 VSUBS 0.42736f
C7272 B8.n238 VSUBS 0.42736f
C7273 B8.n239 VSUBS 0.42736f
C7274 B8.n240 VSUBS 0.42736f
C7275 B8.n241 VSUBS 0.42736f
C7276 B8.n242 VSUBS 0.42736f
C7277 B8.n243 VSUBS 0.42736f
C7278 B8.n244 VSUBS 0.42736f
C7279 B8.n245 VSUBS 0.42736f
C7280 B8.n246 VSUBS 0.42736f
C7281 B8.n247 VSUBS 0.42736f
C7282 B8.n248 VSUBS 0.42736f
C7283 B8.n249 VSUBS 0.42736f
C7284 B8.n250 VSUBS 0.62798f
C7285 B8.n251 VSUBS 12.7317f
C7286 B8.n252 VSUBS 12.0966f
C7287 B8.n253 VSUBS 7.58893f
C7288 B9.n0 VSUBS 1.94231f
C7289 B9.n1 VSUBS 1.11685f
C7290 B9.n2 VSUBS 11.118f
C7291 B9.n3 VSUBS 0.52037f
C7292 B9.n4 VSUBS 0.41569f
C7293 B9.n5 VSUBS 0.41569f
C7294 B9.n6 VSUBS 0.41569f
C7295 B9.n7 VSUBS 0.41569f
C7296 B9.n8 VSUBS 0.41569f
C7297 B9.n9 VSUBS 0.41569f
C7298 B9.n10 VSUBS 0.41569f
C7299 B9.n11 VSUBS 0.41569f
C7300 B9.n12 VSUBS 0.41569f
C7301 B9.n13 VSUBS 0.41569f
C7302 B9.n14 VSUBS 0.41569f
C7303 B9.n15 VSUBS 0.41569f
C7304 B9.n16 VSUBS 0.41569f
C7305 B9.n17 VSUBS 0.41569f
C7306 B9.n18 VSUBS 0.41569f
C7307 B9.n19 VSUBS 0.41569f
C7308 B9.n20 VSUBS 0.41569f
C7309 B9.n21 VSUBS 0.41569f
C7310 B9.n22 VSUBS 0.41569f
C7311 B9.n23 VSUBS 0.41569f
C7312 B9.n24 VSUBS 0.41569f
C7313 B9.n25 VSUBS 0.41569f
C7314 B9.n26 VSUBS 0.41569f
C7315 B9.n27 VSUBS 0.41569f
C7316 B9.n28 VSUBS 0.41569f
C7317 B9.n29 VSUBS 0.41569f
C7318 B9.n30 VSUBS 0.41569f
C7319 B9.n31 VSUBS 0.41569f
C7320 B9.n32 VSUBS 0.41569f
C7321 B9.n33 VSUBS 0.41569f
C7322 B9.n34 VSUBS 0.41569f
C7323 B9.n35 VSUBS 0.41569f
C7324 B9.n36 VSUBS 0.41569f
C7325 B9.n37 VSUBS 0.41569f
C7326 B9.n38 VSUBS 0.41569f
C7327 B9.n39 VSUBS 0.41569f
C7328 B9.n40 VSUBS 0.41569f
C7329 B9.n41 VSUBS 0.41569f
C7330 B9.n42 VSUBS 0.41569f
C7331 B9.n43 VSUBS 0.41569f
C7332 B9.n44 VSUBS 0.41569f
C7333 B9.n45 VSUBS 0.41569f
C7334 B9.n46 VSUBS 0.41569f
C7335 B9.n47 VSUBS 0.41569f
C7336 B9.n48 VSUBS 0.41569f
C7337 B9.n49 VSUBS 0.41569f
C7338 B9.n50 VSUBS 0.41569f
C7339 B9.n51 VSUBS 0.41569f
C7340 B9.n52 VSUBS 0.41569f
C7341 B9.n53 VSUBS 0.41569f
C7342 B9.n54 VSUBS 0.41569f
C7343 B9.n55 VSUBS 0.41569f
C7344 B9.n56 VSUBS 0.41569f
C7345 B9.n57 VSUBS 0.41569f
C7346 B9.n58 VSUBS 0.41569f
C7347 B9.n59 VSUBS 0.41569f
C7348 B9.n60 VSUBS 0.41569f
C7349 B9.n61 VSUBS 0.41569f
C7350 B9.n62 VSUBS 0.41569f
C7351 B9.n63 VSUBS 0.41569f
C7352 B9.n64 VSUBS 0.6784f
C7353 B9.n65 VSUBS 11.0547f
C7354 B9.n66 VSUBS 0.52037f
C7355 B9.n67 VSUBS 0.41569f
C7356 B9.n68 VSUBS 0.41569f
C7357 B9.n69 VSUBS 0.41569f
C7358 B9.n70 VSUBS 0.41569f
C7359 B9.n71 VSUBS 0.41569f
C7360 B9.n72 VSUBS 0.41569f
C7361 B9.n73 VSUBS 0.41569f
C7362 B9.n74 VSUBS 0.41569f
C7363 B9.n75 VSUBS 0.41569f
C7364 B9.n76 VSUBS 0.41569f
C7365 B9.n77 VSUBS 0.41569f
C7366 B9.n78 VSUBS 0.41569f
C7367 B9.n79 VSUBS 0.41569f
C7368 B9.n80 VSUBS 0.41569f
C7369 B9.n81 VSUBS 0.41569f
C7370 B9.n82 VSUBS 0.41569f
C7371 B9.n83 VSUBS 0.41569f
C7372 B9.n84 VSUBS 0.41569f
C7373 B9.n85 VSUBS 0.41569f
C7374 B9.n86 VSUBS 0.41569f
C7375 B9.n87 VSUBS 0.41569f
C7376 B9.n88 VSUBS 0.41569f
C7377 B9.n89 VSUBS 0.41569f
C7378 B9.n90 VSUBS 0.41569f
C7379 B9.n91 VSUBS 0.41569f
C7380 B9.n92 VSUBS 0.41569f
C7381 B9.n93 VSUBS 0.41569f
C7382 B9.n94 VSUBS 0.41569f
C7383 B9.n95 VSUBS 0.41569f
C7384 B9.n96 VSUBS 0.41569f
C7385 B9.n97 VSUBS 0.41569f
C7386 B9.n98 VSUBS 0.41569f
C7387 B9.n99 VSUBS 0.41569f
C7388 B9.n100 VSUBS 0.41569f
C7389 B9.n101 VSUBS 0.41569f
C7390 B9.n102 VSUBS 0.41569f
C7391 B9.n103 VSUBS 0.41569f
C7392 B9.n104 VSUBS 0.41569f
C7393 B9.n105 VSUBS 0.41569f
C7394 B9.n106 VSUBS 0.41569f
C7395 B9.n107 VSUBS 0.41569f
C7396 B9.n108 VSUBS 0.41569f
C7397 B9.n109 VSUBS 0.41569f
C7398 B9.n110 VSUBS 0.41569f
C7399 B9.n111 VSUBS 0.41569f
C7400 B9.n112 VSUBS 0.41569f
C7401 B9.n113 VSUBS 0.41569f
C7402 B9.n114 VSUBS 0.41569f
C7403 B9.n115 VSUBS 0.41569f
C7404 B9.n116 VSUBS 0.41569f
C7405 B9.n117 VSUBS 0.41569f
C7406 B9.n118 VSUBS 0.41569f
C7407 B9.n119 VSUBS 0.41569f
C7408 B9.n120 VSUBS 0.41569f
C7409 B9.n121 VSUBS 0.41569f
C7410 B9.n122 VSUBS 0.41569f
C7411 B9.n123 VSUBS 0.41569f
C7412 B9.n124 VSUBS 0.41569f
C7413 B9.n125 VSUBS 0.41569f
C7414 B9.n126 VSUBS 0.41569f
C7415 B9.n127 VSUBS 0.6784f
C7416 B9.n128 VSUBS 1.05355f
C7417 B9.n129 VSUBS 0.52037f
C7418 B9.n130 VSUBS 0.41569f
C7419 B9.n131 VSUBS 0.41569f
C7420 B9.n132 VSUBS 0.41569f
C7421 B9.n133 VSUBS 0.41569f
C7422 B9.n134 VSUBS 0.41569f
C7423 B9.n135 VSUBS 0.41569f
C7424 B9.n136 VSUBS 0.41569f
C7425 B9.n137 VSUBS 0.41569f
C7426 B9.n138 VSUBS 0.41569f
C7427 B9.n139 VSUBS 0.41569f
C7428 B9.n140 VSUBS 0.41569f
C7429 B9.n141 VSUBS 0.41569f
C7430 B9.n142 VSUBS 0.41569f
C7431 B9.n143 VSUBS 0.41569f
C7432 B9.n144 VSUBS 0.41569f
C7433 B9.n145 VSUBS 0.41569f
C7434 B9.n146 VSUBS 0.41569f
C7435 B9.n147 VSUBS 0.41569f
C7436 B9.n148 VSUBS 0.41569f
C7437 B9.n149 VSUBS 0.41569f
C7438 B9.n150 VSUBS 0.41569f
C7439 B9.n151 VSUBS 0.41569f
C7440 B9.n152 VSUBS 0.41569f
C7441 B9.n153 VSUBS 0.41569f
C7442 B9.n154 VSUBS 0.41569f
C7443 B9.n155 VSUBS 0.41569f
C7444 B9.n156 VSUBS 0.41569f
C7445 B9.n157 VSUBS 0.41569f
C7446 B9.n158 VSUBS 0.41569f
C7447 B9.n159 VSUBS 0.41569f
C7448 B9.n160 VSUBS 0.41569f
C7449 B9.n161 VSUBS 0.41569f
C7450 B9.n162 VSUBS 0.41569f
C7451 B9.n163 VSUBS 0.41569f
C7452 B9.n164 VSUBS 0.41569f
C7453 B9.n165 VSUBS 0.41569f
C7454 B9.n166 VSUBS 0.41569f
C7455 B9.n167 VSUBS 0.41569f
C7456 B9.n168 VSUBS 0.41569f
C7457 B9.n169 VSUBS 0.41569f
C7458 B9.n170 VSUBS 0.41569f
C7459 B9.n171 VSUBS 0.41569f
C7460 B9.n172 VSUBS 0.41569f
C7461 B9.n173 VSUBS 0.41569f
C7462 B9.n174 VSUBS 0.41569f
C7463 B9.n175 VSUBS 0.41569f
C7464 B9.n176 VSUBS 0.41569f
C7465 B9.n177 VSUBS 0.41569f
C7466 B9.n178 VSUBS 0.41569f
C7467 B9.n179 VSUBS 0.41569f
C7468 B9.n180 VSUBS 0.41569f
C7469 B9.n181 VSUBS 0.41569f
C7470 B9.n182 VSUBS 0.41569f
C7471 B9.n183 VSUBS 0.41569f
C7472 B9.n184 VSUBS 0.41569f
C7473 B9.n185 VSUBS 0.41569f
C7474 B9.n186 VSUBS 0.41569f
C7475 B9.n187 VSUBS 0.41569f
C7476 B9.n188 VSUBS 0.41569f
C7477 B9.n189 VSUBS 0.41569f
C7478 B9.n190 VSUBS 0.6784f
C7479 B9.n191 VSUBS 1.05355f
C7480 B9.n192 VSUBS 0.52037f
C7481 B9.n193 VSUBS 0.41569f
C7482 B9.n194 VSUBS 0.41569f
C7483 B9.n195 VSUBS 0.41569f
C7484 B9.n196 VSUBS 0.41569f
C7485 B9.n197 VSUBS 0.41569f
C7486 B9.n198 VSUBS 0.41569f
C7487 B9.n199 VSUBS 0.41569f
C7488 B9.n200 VSUBS 0.41569f
C7489 B9.n201 VSUBS 0.41569f
C7490 B9.n202 VSUBS 0.41569f
C7491 B9.n203 VSUBS 0.41569f
C7492 B9.n204 VSUBS 0.41569f
C7493 B9.n205 VSUBS 0.41569f
C7494 B9.n206 VSUBS 0.41569f
C7495 B9.n207 VSUBS 0.41569f
C7496 B9.n208 VSUBS 0.41569f
C7497 B9.n209 VSUBS 0.41569f
C7498 B9.n210 VSUBS 0.41569f
C7499 B9.n211 VSUBS 0.41569f
C7500 B9.n212 VSUBS 0.41569f
C7501 B9.n213 VSUBS 0.41569f
C7502 B9.n214 VSUBS 0.41569f
C7503 B9.n215 VSUBS 0.41569f
C7504 B9.n216 VSUBS 0.41569f
C7505 B9.n217 VSUBS 0.41569f
C7506 B9.n218 VSUBS 0.41569f
C7507 B9.n219 VSUBS 0.41569f
C7508 B9.n220 VSUBS 0.41569f
C7509 B9.n221 VSUBS 0.41569f
C7510 B9.n222 VSUBS 0.41569f
C7511 B9.n223 VSUBS 0.41569f
C7512 B9.n224 VSUBS 0.41569f
C7513 B9.n225 VSUBS 0.41569f
C7514 B9.n226 VSUBS 0.41569f
C7515 B9.n227 VSUBS 0.41569f
C7516 B9.n228 VSUBS 0.41569f
C7517 B9.n229 VSUBS 0.41569f
C7518 B9.n230 VSUBS 0.41569f
C7519 B9.n231 VSUBS 0.41569f
C7520 B9.n232 VSUBS 0.41569f
C7521 B9.n233 VSUBS 0.41569f
C7522 B9.n234 VSUBS 0.41569f
C7523 B9.n235 VSUBS 0.41569f
C7524 B9.n236 VSUBS 0.41569f
C7525 B9.n237 VSUBS 0.41569f
C7526 B9.n238 VSUBS 0.41569f
C7527 B9.n239 VSUBS 0.41569f
C7528 B9.n240 VSUBS 0.41569f
C7529 B9.n241 VSUBS 0.41569f
C7530 B9.n242 VSUBS 0.41569f
C7531 B9.n243 VSUBS 0.41569f
C7532 B9.n244 VSUBS 0.41569f
C7533 B9.n245 VSUBS 0.41569f
C7534 B9.n246 VSUBS 0.41569f
C7535 B9.n247 VSUBS 0.41569f
C7536 B9.n248 VSUBS 0.41569f
C7537 B9.n249 VSUBS 0.41569f
C7538 B9.n250 VSUBS 0.41569f
C7539 B9.n251 VSUBS 0.41569f
C7540 B9.n252 VSUBS 0.41569f
C7541 B9.n253 VSUBS 0.6784f
C7542 B9.n254 VSUBS 20.8591f
C7543 B9.n255 VSUBS 0.52037f
C7544 B9.n256 VSUBS 0.41569f
C7545 B9.n257 VSUBS 0.41569f
C7546 B9.n258 VSUBS 0.41569f
C7547 B9.n259 VSUBS 0.41569f
C7548 B9.n260 VSUBS 0.41569f
C7549 B9.n261 VSUBS 0.41569f
C7550 B9.n262 VSUBS 0.41569f
C7551 B9.n263 VSUBS 0.41569f
C7552 B9.n264 VSUBS 0.41569f
C7553 B9.n265 VSUBS 0.41569f
C7554 B9.n266 VSUBS 0.41569f
C7555 B9.n267 VSUBS 0.41569f
C7556 B9.n268 VSUBS 0.41569f
C7557 B9.n269 VSUBS 0.41569f
C7558 B9.n270 VSUBS 0.41569f
C7559 B9.n271 VSUBS 0.41569f
C7560 B9.n272 VSUBS 0.41569f
C7561 B9.n273 VSUBS 0.41569f
C7562 B9.n274 VSUBS 0.41569f
C7563 B9.n275 VSUBS 0.41569f
C7564 B9.n276 VSUBS 0.41569f
C7565 B9.n277 VSUBS 0.41569f
C7566 B9.n278 VSUBS 0.41569f
C7567 B9.n279 VSUBS 0.41569f
C7568 B9.n280 VSUBS 0.41569f
C7569 B9.n281 VSUBS 0.41569f
C7570 B9.n282 VSUBS 0.41569f
C7571 B9.n283 VSUBS 0.41569f
C7572 B9.n284 VSUBS 0.41569f
C7573 B9.n285 VSUBS 0.41569f
C7574 B9.n286 VSUBS 0.41569f
C7575 B9.n287 VSUBS 0.41569f
C7576 B9.n288 VSUBS 0.41569f
C7577 B9.n289 VSUBS 0.41569f
C7578 B9.n290 VSUBS 0.41569f
C7579 B9.n291 VSUBS 0.41569f
C7580 B9.n292 VSUBS 0.41569f
C7581 B9.n293 VSUBS 0.41569f
C7582 B9.n294 VSUBS 0.41569f
C7583 B9.n295 VSUBS 0.41569f
C7584 B9.n296 VSUBS 0.41569f
C7585 B9.n297 VSUBS 0.41569f
C7586 B9.n298 VSUBS 0.41569f
C7587 B9.n299 VSUBS 0.41569f
C7588 B9.n300 VSUBS 0.41569f
C7589 B9.n301 VSUBS 0.41569f
C7590 B9.n302 VSUBS 0.41569f
C7591 B9.n303 VSUBS 0.41569f
C7592 B9.n304 VSUBS 0.41569f
C7593 B9.n305 VSUBS 0.41569f
C7594 B9.n306 VSUBS 0.41569f
C7595 B9.n307 VSUBS 0.41569f
C7596 B9.n308 VSUBS 0.41569f
C7597 B9.n309 VSUBS 0.41569f
C7598 B9.n310 VSUBS 0.41569f
C7599 B9.n311 VSUBS 0.41569f
C7600 B9.n312 VSUBS 0.41569f
C7601 B9.n313 VSUBS 0.41569f
C7602 B9.n314 VSUBS 0.41569f
C7603 B9.n315 VSUBS 0.41569f
C7604 B9.n316 VSUBS 0.6886f
C7605 B9.n317 VSUBS 0.52037f
C7606 B9.n318 VSUBS 0.41569f
C7607 B9.n319 VSUBS 0.41569f
C7608 B9.n320 VSUBS 0.41569f
C7609 B9.n321 VSUBS 0.41569f
C7610 B9.n322 VSUBS 0.41569f
C7611 B9.n323 VSUBS 0.41569f
C7612 B9.n324 VSUBS 0.41569f
C7613 B9.n325 VSUBS 0.41569f
C7614 B9.n326 VSUBS 0.41569f
C7615 B9.n327 VSUBS 0.41569f
C7616 B9.n328 VSUBS 0.41569f
C7617 B9.n329 VSUBS 0.41569f
C7618 B9.n330 VSUBS 0.41569f
C7619 B9.n331 VSUBS 0.41569f
C7620 B9.n332 VSUBS 0.41569f
C7621 B9.n333 VSUBS 0.41569f
C7622 B9.n334 VSUBS 0.41569f
C7623 B9.n335 VSUBS 0.41569f
C7624 B9.n336 VSUBS 0.41569f
C7625 B9.n337 VSUBS 0.41569f
C7626 B9.n338 VSUBS 0.41569f
C7627 B9.n339 VSUBS 0.41569f
C7628 B9.n340 VSUBS 0.41569f
C7629 B9.n341 VSUBS 0.41569f
C7630 B9.n342 VSUBS 0.41569f
C7631 B9.n343 VSUBS 0.41569f
C7632 B9.n344 VSUBS 0.41569f
C7633 B9.n345 VSUBS 0.41569f
C7634 B9.n346 VSUBS 0.41569f
C7635 B9.n347 VSUBS 0.41569f
C7636 B9.n348 VSUBS 0.41569f
C7637 B9.n349 VSUBS 0.41569f
C7638 B9.n350 VSUBS 0.41569f
C7639 B9.n351 VSUBS 0.41569f
C7640 B9.n352 VSUBS 0.41569f
C7641 B9.n353 VSUBS 0.41569f
C7642 B9.n354 VSUBS 0.41569f
C7643 B9.n355 VSUBS 0.41569f
C7644 B9.n356 VSUBS 0.41569f
C7645 B9.n357 VSUBS 0.41569f
C7646 B9.n358 VSUBS 0.41569f
C7647 B9.n359 VSUBS 0.41569f
C7648 B9.n360 VSUBS 0.41569f
C7649 B9.n361 VSUBS 0.41569f
C7650 B9.n362 VSUBS 0.41569f
C7651 B9.n363 VSUBS 0.41569f
C7652 B9.n364 VSUBS 0.41569f
C7653 B9.n365 VSUBS 0.41569f
C7654 B9.n366 VSUBS 0.41569f
C7655 B9.n367 VSUBS 0.41569f
C7656 B9.n368 VSUBS 0.41569f
C7657 B9.n369 VSUBS 0.41569f
C7658 B9.n370 VSUBS 0.41569f
C7659 B9.n371 VSUBS 0.41569f
C7660 B9.n372 VSUBS 0.41569f
C7661 B9.n373 VSUBS 0.41569f
C7662 B9.n374 VSUBS 0.41569f
C7663 B9.n375 VSUBS 0.41569f
C7664 B9.n376 VSUBS 0.41569f
C7665 B9.n377 VSUBS 0.41569f
C7666 B9.n378 VSUBS 0.65715f
C7667 B9.n379 VSUBS 1.76929f
C7668 B9.n380 VSUBS 0.52037f
C7669 B9.n381 VSUBS 0.41569f
C7670 B9.n382 VSUBS 0.41569f
C7671 B9.n383 VSUBS 0.41569f
C7672 B9.n384 VSUBS 0.41569f
C7673 B9.n385 VSUBS 0.41569f
C7674 B9.n386 VSUBS 0.41569f
C7675 B9.n387 VSUBS 0.41569f
C7676 B9.n388 VSUBS 0.41569f
C7677 B9.n389 VSUBS 0.41569f
C7678 B9.n390 VSUBS 0.41569f
C7679 B9.n391 VSUBS 0.41569f
C7680 B9.n392 VSUBS 0.41569f
C7681 B9.n393 VSUBS 0.41569f
C7682 B9.n394 VSUBS 0.41569f
C7683 B9.n395 VSUBS 0.41569f
C7684 B9.n396 VSUBS 0.41569f
C7685 B9.n397 VSUBS 0.41569f
C7686 B9.n398 VSUBS 0.41569f
C7687 B9.n399 VSUBS 0.41569f
C7688 B9.n400 VSUBS 0.41569f
C7689 B9.n401 VSUBS 0.41569f
C7690 B9.n402 VSUBS 0.41569f
C7691 B9.n403 VSUBS 0.41569f
C7692 B9.n404 VSUBS 0.41569f
C7693 B9.n405 VSUBS 0.41569f
C7694 B9.n406 VSUBS 0.41569f
C7695 B9.n407 VSUBS 0.41569f
C7696 B9.n408 VSUBS 0.41569f
C7697 B9.n409 VSUBS 0.41569f
C7698 B9.n410 VSUBS 0.41569f
C7699 B9.n411 VSUBS 0.41569f
C7700 B9.n412 VSUBS 0.41569f
C7701 B9.n413 VSUBS 0.41569f
C7702 B9.n414 VSUBS 0.41569f
C7703 B9.n415 VSUBS 0.41569f
C7704 B9.n416 VSUBS 0.41569f
C7705 B9.n417 VSUBS 0.41569f
C7706 B9.n418 VSUBS 0.41569f
C7707 B9.n419 VSUBS 0.41569f
C7708 B9.n420 VSUBS 0.41569f
C7709 B9.n421 VSUBS 0.41569f
C7710 B9.n422 VSUBS 0.41569f
C7711 B9.n423 VSUBS 0.41569f
C7712 B9.n424 VSUBS 0.41569f
C7713 B9.n425 VSUBS 0.41569f
C7714 B9.n426 VSUBS 0.41569f
C7715 B9.n427 VSUBS 0.41569f
C7716 B9.n428 VSUBS 0.41569f
C7717 B9.n429 VSUBS 0.41569f
C7718 B9.n430 VSUBS 0.41569f
C7719 B9.n431 VSUBS 0.41569f
C7720 B9.n432 VSUBS 0.41569f
C7721 B9.n433 VSUBS 0.41569f
C7722 B9.n434 VSUBS 0.41569f
C7723 B9.n435 VSUBS 0.41569f
C7724 B9.n436 VSUBS 0.41569f
C7725 B9.n437 VSUBS 0.41569f
C7726 B9.n438 VSUBS 0.41569f
C7727 B9.n439 VSUBS 0.41569f
C7728 B9.n440 VSUBS 0.41569f
C7729 B9.n441 VSUBS 0.65715f
C7730 B9.n442 VSUBS 1.03134f
C7731 B9.n443 VSUBS 0.52037f
C7732 B9.n444 VSUBS 0.41569f
C7733 B9.n445 VSUBS 0.41569f
C7734 B9.n446 VSUBS 0.41569f
C7735 B9.n447 VSUBS 0.41569f
C7736 B9.n448 VSUBS 0.41569f
C7737 B9.n449 VSUBS 0.41569f
C7738 B9.n450 VSUBS 0.41569f
C7739 B9.n451 VSUBS 0.41569f
C7740 B9.n452 VSUBS 0.41569f
C7741 B9.n453 VSUBS 0.41569f
C7742 B9.n454 VSUBS 0.41569f
C7743 B9.n455 VSUBS 0.41569f
C7744 B9.n456 VSUBS 0.41569f
C7745 B9.n457 VSUBS 0.41569f
C7746 B9.n458 VSUBS 0.41569f
C7747 B9.n459 VSUBS 0.41569f
C7748 B9.n460 VSUBS 0.41569f
C7749 B9.n461 VSUBS 0.41569f
C7750 B9.n462 VSUBS 0.41569f
C7751 B9.n463 VSUBS 0.41569f
C7752 B9.n464 VSUBS 0.41569f
C7753 B9.n465 VSUBS 0.41569f
C7754 B9.n466 VSUBS 0.41569f
C7755 B9.n467 VSUBS 0.41569f
C7756 B9.n468 VSUBS 0.41569f
C7757 B9.n469 VSUBS 0.41569f
C7758 B9.n470 VSUBS 0.41569f
C7759 B9.n471 VSUBS 0.41569f
C7760 B9.n472 VSUBS 0.41569f
C7761 B9.n473 VSUBS 0.41569f
C7762 B9.n474 VSUBS 0.41569f
C7763 B9.n475 VSUBS 0.41569f
C7764 B9.n476 VSUBS 0.41569f
C7765 B9.n477 VSUBS 0.41569f
C7766 B9.n478 VSUBS 0.41569f
C7767 B9.n479 VSUBS 0.41569f
C7768 B9.n480 VSUBS 0.41569f
C7769 B9.n481 VSUBS 0.41569f
C7770 B9.n482 VSUBS 0.41569f
C7771 B9.n483 VSUBS 0.41569f
C7772 B9.n484 VSUBS 0.41569f
C7773 B9.n485 VSUBS 0.41569f
C7774 B9.n486 VSUBS 0.41569f
C7775 B9.n487 VSUBS 0.41569f
C7776 B9.n488 VSUBS 0.41569f
C7777 B9.n489 VSUBS 0.41569f
C7778 B9.n490 VSUBS 0.41569f
C7779 B9.n491 VSUBS 0.41569f
C7780 B9.n492 VSUBS 0.41569f
C7781 B9.n493 VSUBS 0.41569f
C7782 B9.n494 VSUBS 0.41569f
C7783 B9.n495 VSUBS 0.41569f
C7784 B9.n496 VSUBS 0.41569f
C7785 B9.n497 VSUBS 0.41569f
C7786 B9.n498 VSUBS 0.41569f
C7787 B9.n499 VSUBS 0.41569f
C7788 B9.n500 VSUBS 0.41569f
C7789 B9.n501 VSUBS 0.41569f
C7790 B9.n502 VSUBS 0.41569f
C7791 B9.n503 VSUBS 0.41569f
C7792 B9.n504 VSUBS 0.65715f
C7793 B9.n505 VSUBS 11.0325f
C7794 B9.n506 VSUBS 11.0972f
C7795 B9.n507 VSUBS 1.09603f
C7796 B9.n508 VSUBS 1.09603f
C7797 B9.n509 VSUBS 8.61885f
C7798 B10.n0 VSUBS 2.00474f
C7799 B10.n1 VSUBS 1.14499f
C7800 B10.n2 VSUBS 1.14499f
C7801 B10.n3 VSUBS 1.14499f
C7802 B10.n4 VSUBS 1.14499f
C7803 B10.n5 VSUBS 1.14499f
C7804 B10.n6 VSUBS 9.58598f
C7805 B10.n7 VSUBS 0.5124f
C7806 B10.n8 VSUBS 0.40932f
C7807 B10.n9 VSUBS 0.40932f
C7808 B10.n10 VSUBS 0.40932f
C7809 B10.n11 VSUBS 0.40932f
C7810 B10.n12 VSUBS 0.40932f
C7811 B10.n13 VSUBS 0.40932f
C7812 B10.n14 VSUBS 0.40932f
C7813 B10.n15 VSUBS 0.40932f
C7814 B10.n16 VSUBS 0.40932f
C7815 B10.n17 VSUBS 0.40932f
C7816 B10.n18 VSUBS 0.40932f
C7817 B10.n19 VSUBS 0.40932f
C7818 B10.n20 VSUBS 0.40932f
C7819 B10.n21 VSUBS 0.40932f
C7820 B10.n22 VSUBS 0.40932f
C7821 B10.n23 VSUBS 0.40932f
C7822 B10.n24 VSUBS 0.40932f
C7823 B10.n25 VSUBS 0.40932f
C7824 B10.n26 VSUBS 0.40932f
C7825 B10.n27 VSUBS 0.40932f
C7826 B10.n28 VSUBS 0.40932f
C7827 B10.n29 VSUBS 0.40932f
C7828 B10.n30 VSUBS 0.40932f
C7829 B10.n31 VSUBS 0.40932f
C7830 B10.n32 VSUBS 0.40932f
C7831 B10.n33 VSUBS 0.40932f
C7832 B10.n34 VSUBS 0.40932f
C7833 B10.n35 VSUBS 0.40932f
C7834 B10.n36 VSUBS 0.40932f
C7835 B10.n37 VSUBS 0.40932f
C7836 B10.n38 VSUBS 0.40932f
C7837 B10.n39 VSUBS 0.40932f
C7838 B10.n40 VSUBS 0.40932f
C7839 B10.n41 VSUBS 0.40932f
C7840 B10.n42 VSUBS 0.40932f
C7841 B10.n43 VSUBS 0.40932f
C7842 B10.n44 VSUBS 0.40932f
C7843 B10.n45 VSUBS 0.40932f
C7844 B10.n46 VSUBS 0.40932f
C7845 B10.n47 VSUBS 0.40932f
C7846 B10.n48 VSUBS 0.40932f
C7847 B10.n49 VSUBS 0.40932f
C7848 B10.n50 VSUBS 0.40932f
C7849 B10.n51 VSUBS 0.40932f
C7850 B10.n52 VSUBS 0.40932f
C7851 B10.n53 VSUBS 0.40932f
C7852 B10.n54 VSUBS 0.40932f
C7853 B10.n55 VSUBS 0.40932f
C7854 B10.n56 VSUBS 0.40932f
C7855 B10.n57 VSUBS 0.40932f
C7856 B10.n58 VSUBS 0.40932f
C7857 B10.n59 VSUBS 0.40932f
C7858 B10.n60 VSUBS 0.40932f
C7859 B10.n61 VSUBS 0.40932f
C7860 B10.n62 VSUBS 0.40932f
C7861 B10.n63 VSUBS 0.40932f
C7862 B10.n64 VSUBS 0.40932f
C7863 B10.n65 VSUBS 0.40932f
C7864 B10.n66 VSUBS 0.40932f
C7865 B10.n67 VSUBS 0.40932f
C7866 B10.n68 VSUBS 0.71404f
C7867 B10.n69 VSUBS 9.52613f
C7868 B10.n70 VSUBS 0.5124f
C7869 B10.n71 VSUBS 0.40932f
C7870 B10.n72 VSUBS 0.40932f
C7871 B10.n73 VSUBS 0.40932f
C7872 B10.n74 VSUBS 0.40932f
C7873 B10.n75 VSUBS 0.40932f
C7874 B10.n76 VSUBS 0.40932f
C7875 B10.n77 VSUBS 0.40932f
C7876 B10.n78 VSUBS 0.40932f
C7877 B10.n79 VSUBS 0.40932f
C7878 B10.n80 VSUBS 0.40932f
C7879 B10.n81 VSUBS 0.40932f
C7880 B10.n82 VSUBS 0.40932f
C7881 B10.n83 VSUBS 0.40932f
C7882 B10.n84 VSUBS 0.40932f
C7883 B10.n85 VSUBS 0.40932f
C7884 B10.n86 VSUBS 0.40932f
C7885 B10.n87 VSUBS 0.40932f
C7886 B10.n88 VSUBS 0.40932f
C7887 B10.n89 VSUBS 0.40932f
C7888 B10.n90 VSUBS 0.40932f
C7889 B10.n91 VSUBS 0.40932f
C7890 B10.n92 VSUBS 0.40932f
C7891 B10.n93 VSUBS 0.40932f
C7892 B10.n94 VSUBS 0.40932f
C7893 B10.n95 VSUBS 0.40932f
C7894 B10.n96 VSUBS 0.40932f
C7895 B10.n97 VSUBS 0.40932f
C7896 B10.n98 VSUBS 0.40932f
C7897 B10.n99 VSUBS 0.40932f
C7898 B10.n100 VSUBS 0.40932f
C7899 B10.n101 VSUBS 0.40932f
C7900 B10.n102 VSUBS 0.40932f
C7901 B10.n103 VSUBS 0.40932f
C7902 B10.n104 VSUBS 0.40932f
C7903 B10.n105 VSUBS 0.40932f
C7904 B10.n106 VSUBS 0.40932f
C7905 B10.n107 VSUBS 0.40932f
C7906 B10.n108 VSUBS 0.40932f
C7907 B10.n109 VSUBS 0.40932f
C7908 B10.n110 VSUBS 0.40932f
C7909 B10.n111 VSUBS 0.40932f
C7910 B10.n112 VSUBS 0.40932f
C7911 B10.n113 VSUBS 0.40932f
C7912 B10.n114 VSUBS 0.40932f
C7913 B10.n115 VSUBS 0.40932f
C7914 B10.n116 VSUBS 0.40932f
C7915 B10.n117 VSUBS 0.40932f
C7916 B10.n118 VSUBS 0.40932f
C7917 B10.n119 VSUBS 0.40932f
C7918 B10.n120 VSUBS 0.40932f
C7919 B10.n121 VSUBS 0.40932f
C7920 B10.n122 VSUBS 0.40932f
C7921 B10.n123 VSUBS 0.40932f
C7922 B10.n124 VSUBS 0.40932f
C7923 B10.n125 VSUBS 0.40932f
C7924 B10.n126 VSUBS 0.40932f
C7925 B10.n127 VSUBS 0.40932f
C7926 B10.n128 VSUBS 0.40932f
C7927 B10.n129 VSUBS 0.40932f
C7928 B10.n130 VSUBS 0.40932f
C7929 B10.n131 VSUBS 0.71404f
C7930 B10.n132 VSUBS 1.08514f
C7931 B10.n133 VSUBS 0.5124f
C7932 B10.n134 VSUBS 0.40932f
C7933 B10.n135 VSUBS 0.40932f
C7934 B10.n136 VSUBS 0.40932f
C7935 B10.n137 VSUBS 0.40932f
C7936 B10.n138 VSUBS 0.40932f
C7937 B10.n139 VSUBS 0.40932f
C7938 B10.n140 VSUBS 0.40932f
C7939 B10.n141 VSUBS 0.40932f
C7940 B10.n142 VSUBS 0.40932f
C7941 B10.n143 VSUBS 0.40932f
C7942 B10.n144 VSUBS 0.40932f
C7943 B10.n145 VSUBS 0.40932f
C7944 B10.n146 VSUBS 0.40932f
C7945 B10.n147 VSUBS 0.40932f
C7946 B10.n148 VSUBS 0.40932f
C7947 B10.n149 VSUBS 0.40932f
C7948 B10.n150 VSUBS 0.40932f
C7949 B10.n151 VSUBS 0.40932f
C7950 B10.n152 VSUBS 0.40932f
C7951 B10.n153 VSUBS 0.40932f
C7952 B10.n154 VSUBS 0.40932f
C7953 B10.n155 VSUBS 0.40932f
C7954 B10.n156 VSUBS 0.40932f
C7955 B10.n157 VSUBS 0.40932f
C7956 B10.n158 VSUBS 0.40932f
C7957 B10.n159 VSUBS 0.40932f
C7958 B10.n160 VSUBS 0.40932f
C7959 B10.n161 VSUBS 0.40932f
C7960 B10.n162 VSUBS 0.40932f
C7961 B10.n163 VSUBS 0.40932f
C7962 B10.n164 VSUBS 0.40932f
C7963 B10.n165 VSUBS 0.40932f
C7964 B10.n166 VSUBS 0.40932f
C7965 B10.n167 VSUBS 0.40932f
C7966 B10.n168 VSUBS 0.40932f
C7967 B10.n169 VSUBS 0.40932f
C7968 B10.n170 VSUBS 0.40932f
C7969 B10.n171 VSUBS 0.40932f
C7970 B10.n172 VSUBS 0.40932f
C7971 B10.n173 VSUBS 0.40932f
C7972 B10.n174 VSUBS 0.40932f
C7973 B10.n175 VSUBS 0.40932f
C7974 B10.n176 VSUBS 0.40932f
C7975 B10.n177 VSUBS 0.40932f
C7976 B10.n178 VSUBS 0.40932f
C7977 B10.n179 VSUBS 0.40932f
C7978 B10.n180 VSUBS 0.40932f
C7979 B10.n181 VSUBS 0.40932f
C7980 B10.n182 VSUBS 0.40932f
C7981 B10.n183 VSUBS 0.40932f
C7982 B10.n184 VSUBS 0.40932f
C7983 B10.n185 VSUBS 0.40932f
C7984 B10.n186 VSUBS 0.40932f
C7985 B10.n187 VSUBS 0.40932f
C7986 B10.n188 VSUBS 0.40932f
C7987 B10.n189 VSUBS 0.40932f
C7988 B10.n190 VSUBS 0.40932f
C7989 B10.n191 VSUBS 0.40932f
C7990 B10.n192 VSUBS 0.40932f
C7991 B10.n193 VSUBS 0.40932f
C7992 B10.n194 VSUBS 0.71404f
C7993 B10.n195 VSUBS 1.08514f
C7994 B10.n196 VSUBS 0.5124f
C7995 B10.n197 VSUBS 0.40932f
C7996 B10.n198 VSUBS 0.40932f
C7997 B10.n199 VSUBS 0.40932f
C7998 B10.n200 VSUBS 0.40932f
C7999 B10.n201 VSUBS 0.40932f
C8000 B10.n202 VSUBS 0.40932f
C8001 B10.n203 VSUBS 0.40932f
C8002 B10.n204 VSUBS 0.40932f
C8003 B10.n205 VSUBS 0.40932f
C8004 B10.n206 VSUBS 0.40932f
C8005 B10.n207 VSUBS 0.40932f
C8006 B10.n208 VSUBS 0.40932f
C8007 B10.n209 VSUBS 0.40932f
C8008 B10.n210 VSUBS 0.40932f
C8009 B10.n211 VSUBS 0.40932f
C8010 B10.n212 VSUBS 0.40932f
C8011 B10.n213 VSUBS 0.40932f
C8012 B10.n214 VSUBS 0.40932f
C8013 B10.n215 VSUBS 0.40932f
C8014 B10.n216 VSUBS 0.40932f
C8015 B10.n217 VSUBS 0.40932f
C8016 B10.n218 VSUBS 0.40932f
C8017 B10.n219 VSUBS 0.40932f
C8018 B10.n220 VSUBS 0.40932f
C8019 B10.n221 VSUBS 0.40932f
C8020 B10.n222 VSUBS 0.40932f
C8021 B10.n223 VSUBS 0.40932f
C8022 B10.n224 VSUBS 0.40932f
C8023 B10.n225 VSUBS 0.40932f
C8024 B10.n226 VSUBS 0.40932f
C8025 B10.n227 VSUBS 0.40932f
C8026 B10.n228 VSUBS 0.40932f
C8027 B10.n229 VSUBS 0.40932f
C8028 B10.n230 VSUBS 0.40932f
C8029 B10.n231 VSUBS 0.40932f
C8030 B10.n232 VSUBS 0.40932f
C8031 B10.n233 VSUBS 0.40932f
C8032 B10.n234 VSUBS 0.40932f
C8033 B10.n235 VSUBS 0.40932f
C8034 B10.n236 VSUBS 0.40932f
C8035 B10.n237 VSUBS 0.40932f
C8036 B10.n238 VSUBS 0.40932f
C8037 B10.n239 VSUBS 0.40932f
C8038 B10.n240 VSUBS 0.40932f
C8039 B10.n241 VSUBS 0.40932f
C8040 B10.n242 VSUBS 0.40932f
C8041 B10.n243 VSUBS 0.40932f
C8042 B10.n244 VSUBS 0.40932f
C8043 B10.n245 VSUBS 0.40932f
C8044 B10.n246 VSUBS 0.40932f
C8045 B10.n247 VSUBS 0.40932f
C8046 B10.n248 VSUBS 0.40932f
C8047 B10.n249 VSUBS 0.40932f
C8048 B10.n250 VSUBS 0.40932f
C8049 B10.n251 VSUBS 0.40932f
C8050 B10.n252 VSUBS 0.40932f
C8051 B10.n253 VSUBS 0.40932f
C8052 B10.n254 VSUBS 0.40932f
C8053 B10.n255 VSUBS 0.40932f
C8054 B10.n256 VSUBS 0.40932f
C8055 B10.n257 VSUBS 0.71404f
C8056 B10.n258 VSUBS 1.08514f
C8057 B10.n259 VSUBS 0.5124f
C8058 B10.n260 VSUBS 0.40932f
C8059 B10.n261 VSUBS 0.40932f
C8060 B10.n262 VSUBS 0.40932f
C8061 B10.n263 VSUBS 0.40932f
C8062 B10.n264 VSUBS 0.40932f
C8063 B10.n265 VSUBS 0.40932f
C8064 B10.n266 VSUBS 0.40932f
C8065 B10.n267 VSUBS 0.40932f
C8066 B10.n268 VSUBS 0.40932f
C8067 B10.n269 VSUBS 0.40932f
C8068 B10.n270 VSUBS 0.40932f
C8069 B10.n271 VSUBS 0.40932f
C8070 B10.n272 VSUBS 0.40932f
C8071 B10.n273 VSUBS 0.40932f
C8072 B10.n274 VSUBS 0.40932f
C8073 B10.n275 VSUBS 0.40932f
C8074 B10.n276 VSUBS 0.40932f
C8075 B10.n277 VSUBS 0.40932f
C8076 B10.n278 VSUBS 0.40932f
C8077 B10.n279 VSUBS 0.40932f
C8078 B10.n280 VSUBS 0.40932f
C8079 B10.n281 VSUBS 0.40932f
C8080 B10.n282 VSUBS 0.40932f
C8081 B10.n283 VSUBS 0.40932f
C8082 B10.n284 VSUBS 0.40932f
C8083 B10.n285 VSUBS 0.40932f
C8084 B10.n286 VSUBS 0.40932f
C8085 B10.n287 VSUBS 0.40932f
C8086 B10.n288 VSUBS 0.40932f
C8087 B10.n289 VSUBS 0.40932f
C8088 B10.n290 VSUBS 0.40932f
C8089 B10.n291 VSUBS 0.40932f
C8090 B10.n292 VSUBS 0.40932f
C8091 B10.n293 VSUBS 0.40932f
C8092 B10.n294 VSUBS 0.40932f
C8093 B10.n295 VSUBS 0.40932f
C8094 B10.n296 VSUBS 0.40932f
C8095 B10.n297 VSUBS 0.40932f
C8096 B10.n298 VSUBS 0.40932f
C8097 B10.n299 VSUBS 0.40932f
C8098 B10.n300 VSUBS 0.40932f
C8099 B10.n301 VSUBS 0.40932f
C8100 B10.n302 VSUBS 0.40932f
C8101 B10.n303 VSUBS 0.40932f
C8102 B10.n304 VSUBS 0.40932f
C8103 B10.n305 VSUBS 0.40932f
C8104 B10.n306 VSUBS 0.40932f
C8105 B10.n307 VSUBS 0.40932f
C8106 B10.n308 VSUBS 0.40932f
C8107 B10.n309 VSUBS 0.40932f
C8108 B10.n310 VSUBS 0.40932f
C8109 B10.n311 VSUBS 0.40932f
C8110 B10.n312 VSUBS 0.40932f
C8111 B10.n313 VSUBS 0.40932f
C8112 B10.n314 VSUBS 0.40932f
C8113 B10.n315 VSUBS 0.40932f
C8114 B10.n316 VSUBS 0.40932f
C8115 B10.n317 VSUBS 0.40932f
C8116 B10.n318 VSUBS 0.40932f
C8117 B10.n319 VSUBS 0.40932f
C8118 B10.n320 VSUBS 0.71404f
C8119 B10.n321 VSUBS 1.08514f
C8120 B10.n322 VSUBS 0.5124f
C8121 B10.n323 VSUBS 0.40932f
C8122 B10.n324 VSUBS 0.40932f
C8123 B10.n325 VSUBS 0.40932f
C8124 B10.n326 VSUBS 0.40932f
C8125 B10.n327 VSUBS 0.40932f
C8126 B10.n328 VSUBS 0.40932f
C8127 B10.n329 VSUBS 0.40932f
C8128 B10.n330 VSUBS 0.40932f
C8129 B10.n331 VSUBS 0.40932f
C8130 B10.n332 VSUBS 0.40932f
C8131 B10.n333 VSUBS 0.40932f
C8132 B10.n334 VSUBS 0.40932f
C8133 B10.n335 VSUBS 0.40932f
C8134 B10.n336 VSUBS 0.40932f
C8135 B10.n337 VSUBS 0.40932f
C8136 B10.n338 VSUBS 0.40932f
C8137 B10.n339 VSUBS 0.40932f
C8138 B10.n340 VSUBS 0.40932f
C8139 B10.n341 VSUBS 0.40932f
C8140 B10.n342 VSUBS 0.40932f
C8141 B10.n343 VSUBS 0.40932f
C8142 B10.n344 VSUBS 0.40932f
C8143 B10.n345 VSUBS 0.40932f
C8144 B10.n346 VSUBS 0.40932f
C8145 B10.n347 VSUBS 0.40932f
C8146 B10.n348 VSUBS 0.40932f
C8147 B10.n349 VSUBS 0.40932f
C8148 B10.n350 VSUBS 0.40932f
C8149 B10.n351 VSUBS 0.40932f
C8150 B10.n352 VSUBS 0.40932f
C8151 B10.n353 VSUBS 0.40932f
C8152 B10.n354 VSUBS 0.40932f
C8153 B10.n355 VSUBS 0.40932f
C8154 B10.n356 VSUBS 0.40932f
C8155 B10.n357 VSUBS 0.40932f
C8156 B10.n358 VSUBS 0.40932f
C8157 B10.n359 VSUBS 0.40932f
C8158 B10.n360 VSUBS 0.40932f
C8159 B10.n361 VSUBS 0.40932f
C8160 B10.n362 VSUBS 0.40932f
C8161 B10.n363 VSUBS 0.40932f
C8162 B10.n364 VSUBS 0.40932f
C8163 B10.n365 VSUBS 0.40932f
C8164 B10.n366 VSUBS 0.40932f
C8165 B10.n367 VSUBS 0.40932f
C8166 B10.n368 VSUBS 0.40932f
C8167 B10.n369 VSUBS 0.40932f
C8168 B10.n370 VSUBS 0.40932f
C8169 B10.n371 VSUBS 0.40932f
C8170 B10.n372 VSUBS 0.40932f
C8171 B10.n373 VSUBS 0.40932f
C8172 B10.n374 VSUBS 0.40932f
C8173 B10.n375 VSUBS 0.40932f
C8174 B10.n376 VSUBS 0.40932f
C8175 B10.n377 VSUBS 0.40932f
C8176 B10.n378 VSUBS 0.40932f
C8177 B10.n379 VSUBS 0.40932f
C8178 B10.n380 VSUBS 0.40932f
C8179 B10.n381 VSUBS 0.40932f
C8180 B10.n382 VSUBS 0.40932f
C8181 B10.n383 VSUBS 0.71404f
C8182 B10.n384 VSUBS 1.08514f
C8183 B10.n385 VSUBS 0.5124f
C8184 B10.n386 VSUBS 0.40932f
C8185 B10.n387 VSUBS 0.40932f
C8186 B10.n388 VSUBS 0.40932f
C8187 B10.n389 VSUBS 0.40932f
C8188 B10.n390 VSUBS 0.40932f
C8189 B10.n391 VSUBS 0.40932f
C8190 B10.n392 VSUBS 0.40932f
C8191 B10.n393 VSUBS 0.40932f
C8192 B10.n394 VSUBS 0.40932f
C8193 B10.n395 VSUBS 0.40932f
C8194 B10.n396 VSUBS 0.40932f
C8195 B10.n397 VSUBS 0.40932f
C8196 B10.n398 VSUBS 0.40932f
C8197 B10.n399 VSUBS 0.40932f
C8198 B10.n400 VSUBS 0.40932f
C8199 B10.n401 VSUBS 0.40932f
C8200 B10.n402 VSUBS 0.40932f
C8201 B10.n403 VSUBS 0.40932f
C8202 B10.n404 VSUBS 0.40932f
C8203 B10.n405 VSUBS 0.40932f
C8204 B10.n406 VSUBS 0.40932f
C8205 B10.n407 VSUBS 0.40932f
C8206 B10.n408 VSUBS 0.40932f
C8207 B10.n409 VSUBS 0.40932f
C8208 B10.n410 VSUBS 0.40932f
C8209 B10.n411 VSUBS 0.40932f
C8210 B10.n412 VSUBS 0.40932f
C8211 B10.n413 VSUBS 0.40932f
C8212 B10.n414 VSUBS 0.40932f
C8213 B10.n415 VSUBS 0.40932f
C8214 B10.n416 VSUBS 0.40932f
C8215 B10.n417 VSUBS 0.40932f
C8216 B10.n418 VSUBS 0.40932f
C8217 B10.n419 VSUBS 0.40932f
C8218 B10.n420 VSUBS 0.40932f
C8219 B10.n421 VSUBS 0.40932f
C8220 B10.n422 VSUBS 0.40932f
C8221 B10.n423 VSUBS 0.40932f
C8222 B10.n424 VSUBS 0.40932f
C8223 B10.n425 VSUBS 0.40932f
C8224 B10.n426 VSUBS 0.40932f
C8225 B10.n427 VSUBS 0.40932f
C8226 B10.n428 VSUBS 0.40932f
C8227 B10.n429 VSUBS 0.40932f
C8228 B10.n430 VSUBS 0.40932f
C8229 B10.n431 VSUBS 0.40932f
C8230 B10.n432 VSUBS 0.40932f
C8231 B10.n433 VSUBS 0.40932f
C8232 B10.n434 VSUBS 0.40932f
C8233 B10.n435 VSUBS 0.40932f
C8234 B10.n436 VSUBS 0.40932f
C8235 B10.n437 VSUBS 0.40932f
C8236 B10.n438 VSUBS 0.40932f
C8237 B10.n439 VSUBS 0.40932f
C8238 B10.n440 VSUBS 0.40932f
C8239 B10.n441 VSUBS 0.40932f
C8240 B10.n442 VSUBS 0.40932f
C8241 B10.n443 VSUBS 0.40932f
C8242 B10.n444 VSUBS 0.40932f
C8243 B10.n445 VSUBS 0.40932f
C8244 B10.n446 VSUBS 0.71404f
C8245 B10.n447 VSUBS 1.08514f
C8246 B10.n448 VSUBS 0.5124f
C8247 B10.n449 VSUBS 0.40932f
C8248 B10.n450 VSUBS 0.40932f
C8249 B10.n451 VSUBS 0.40932f
C8250 B10.n452 VSUBS 0.40932f
C8251 B10.n453 VSUBS 0.40932f
C8252 B10.n454 VSUBS 0.40932f
C8253 B10.n455 VSUBS 0.40932f
C8254 B10.n456 VSUBS 0.40932f
C8255 B10.n457 VSUBS 0.40932f
C8256 B10.n458 VSUBS 0.40932f
C8257 B10.n459 VSUBS 0.40932f
C8258 B10.n460 VSUBS 0.40932f
C8259 B10.n461 VSUBS 0.40932f
C8260 B10.n462 VSUBS 0.40932f
C8261 B10.n463 VSUBS 0.40932f
C8262 B10.n464 VSUBS 0.40932f
C8263 B10.n465 VSUBS 0.40932f
C8264 B10.n466 VSUBS 0.40932f
C8265 B10.n467 VSUBS 0.40932f
C8266 B10.n468 VSUBS 0.40932f
C8267 B10.n469 VSUBS 0.40932f
C8268 B10.n470 VSUBS 0.40932f
C8269 B10.n471 VSUBS 0.40932f
C8270 B10.n472 VSUBS 0.40932f
C8271 B10.n473 VSUBS 0.40932f
C8272 B10.n474 VSUBS 0.40932f
C8273 B10.n475 VSUBS 0.40932f
C8274 B10.n476 VSUBS 0.40932f
C8275 B10.n477 VSUBS 0.40932f
C8276 B10.n478 VSUBS 0.40932f
C8277 B10.n479 VSUBS 0.40932f
C8278 B10.n480 VSUBS 0.40932f
C8279 B10.n481 VSUBS 0.40932f
C8280 B10.n482 VSUBS 0.40932f
C8281 B10.n483 VSUBS 0.40932f
C8282 B10.n484 VSUBS 0.40932f
C8283 B10.n485 VSUBS 0.40932f
C8284 B10.n486 VSUBS 0.40932f
C8285 B10.n487 VSUBS 0.40932f
C8286 B10.n488 VSUBS 0.40932f
C8287 B10.n489 VSUBS 0.40932f
C8288 B10.n490 VSUBS 0.40932f
C8289 B10.n491 VSUBS 0.40932f
C8290 B10.n492 VSUBS 0.40932f
C8291 B10.n493 VSUBS 0.40932f
C8292 B10.n494 VSUBS 0.40932f
C8293 B10.n495 VSUBS 0.40932f
C8294 B10.n496 VSUBS 0.40932f
C8295 B10.n497 VSUBS 0.40932f
C8296 B10.n498 VSUBS 0.40932f
C8297 B10.n499 VSUBS 0.40932f
C8298 B10.n500 VSUBS 0.40932f
C8299 B10.n501 VSUBS 0.40932f
C8300 B10.n502 VSUBS 0.40932f
C8301 B10.n503 VSUBS 0.40932f
C8302 B10.n504 VSUBS 0.40932f
C8303 B10.n505 VSUBS 0.40932f
C8304 B10.n506 VSUBS 0.40932f
C8305 B10.n507 VSUBS 0.40932f
C8306 B10.n508 VSUBS 0.40932f
C8307 B10.n509 VSUBS 0.71404f
C8308 B10.n510 VSUBS 15.4223f
C8309 B10.n511 VSUBS 0.5124f
C8310 B10.n512 VSUBS 0.40932f
C8311 B10.n513 VSUBS 0.40932f
C8312 B10.n514 VSUBS 0.40932f
C8313 B10.n515 VSUBS 0.40932f
C8314 B10.n516 VSUBS 0.40932f
C8315 B10.n517 VSUBS 0.40932f
C8316 B10.n518 VSUBS 0.40932f
C8317 B10.n519 VSUBS 0.40932f
C8318 B10.n520 VSUBS 0.40932f
C8319 B10.n521 VSUBS 0.40932f
C8320 B10.n522 VSUBS 0.40932f
C8321 B10.n523 VSUBS 0.40932f
C8322 B10.n524 VSUBS 0.40932f
C8323 B10.n525 VSUBS 0.40932f
C8324 B10.n526 VSUBS 0.40932f
C8325 B10.n527 VSUBS 0.40932f
C8326 B10.n528 VSUBS 0.40932f
C8327 B10.n529 VSUBS 0.40932f
C8328 B10.n530 VSUBS 0.40932f
C8329 B10.n531 VSUBS 0.40932f
C8330 B10.n532 VSUBS 0.40932f
C8331 B10.n533 VSUBS 0.40932f
C8332 B10.n534 VSUBS 0.40932f
C8333 B10.n535 VSUBS 0.40932f
C8334 B10.n536 VSUBS 0.40932f
C8335 B10.n537 VSUBS 0.40932f
C8336 B10.n538 VSUBS 0.40932f
C8337 B10.n539 VSUBS 0.40932f
C8338 B10.n540 VSUBS 0.40932f
C8339 B10.n541 VSUBS 0.40932f
C8340 B10.n542 VSUBS 0.40932f
C8341 B10.n543 VSUBS 0.40932f
C8342 B10.n544 VSUBS 0.40932f
C8343 B10.n545 VSUBS 0.40932f
C8344 B10.n546 VSUBS 0.40932f
C8345 B10.n547 VSUBS 0.40932f
C8346 B10.n548 VSUBS 0.40932f
C8347 B10.n549 VSUBS 0.40932f
C8348 B10.n550 VSUBS 0.40932f
C8349 B10.n551 VSUBS 0.40932f
C8350 B10.n552 VSUBS 0.40932f
C8351 B10.n553 VSUBS 0.40932f
C8352 B10.n554 VSUBS 0.40932f
C8353 B10.n555 VSUBS 0.40932f
C8354 B10.n556 VSUBS 0.40932f
C8355 B10.n557 VSUBS 0.40932f
C8356 B10.n558 VSUBS 0.40932f
C8357 B10.n559 VSUBS 0.40932f
C8358 B10.n560 VSUBS 0.40932f
C8359 B10.n561 VSUBS 0.40932f
C8360 B10.n562 VSUBS 0.40932f
C8361 B10.n563 VSUBS 0.40932f
C8362 B10.n564 VSUBS 0.40932f
C8363 B10.n565 VSUBS 0.40932f
C8364 B10.n566 VSUBS 0.40932f
C8365 B10.n567 VSUBS 0.40932f
C8366 B10.n568 VSUBS 0.40932f
C8367 B10.n569 VSUBS 0.40932f
C8368 B10.n570 VSUBS 0.40932f
C8369 B10.n571 VSUBS 0.40932f
C8370 B10.n572 VSUBS 0.72186f
C8371 B10.n573 VSUBS 0.5124f
C8372 B10.n574 VSUBS 0.40932f
C8373 B10.n575 VSUBS 0.40932f
C8374 B10.n576 VSUBS 0.40932f
C8375 B10.n577 VSUBS 0.40932f
C8376 B10.n578 VSUBS 0.40932f
C8377 B10.n579 VSUBS 0.40932f
C8378 B10.n580 VSUBS 0.40932f
C8379 B10.n581 VSUBS 0.40932f
C8380 B10.n582 VSUBS 0.40932f
C8381 B10.n583 VSUBS 0.40932f
C8382 B10.n584 VSUBS 0.40932f
C8383 B10.n585 VSUBS 0.40932f
C8384 B10.n586 VSUBS 0.40932f
C8385 B10.n587 VSUBS 0.40932f
C8386 B10.n588 VSUBS 0.40932f
C8387 B10.n589 VSUBS 0.40932f
C8388 B10.n590 VSUBS 0.40932f
C8389 B10.n591 VSUBS 0.40932f
C8390 B10.n592 VSUBS 0.40932f
C8391 B10.n593 VSUBS 0.40932f
C8392 B10.n594 VSUBS 0.40932f
C8393 B10.n595 VSUBS 0.40932f
C8394 B10.n596 VSUBS 0.40932f
C8395 B10.n597 VSUBS 0.40932f
C8396 B10.n598 VSUBS 0.40932f
C8397 B10.n599 VSUBS 0.40932f
C8398 B10.n600 VSUBS 0.40932f
C8399 B10.n601 VSUBS 0.40932f
C8400 B10.n602 VSUBS 0.40932f
C8401 B10.n603 VSUBS 0.40932f
C8402 B10.n604 VSUBS 0.40932f
C8403 B10.n605 VSUBS 0.40932f
C8404 B10.n606 VSUBS 0.40932f
C8405 B10.n607 VSUBS 0.40932f
C8406 B10.n608 VSUBS 0.40932f
C8407 B10.n609 VSUBS 0.40932f
C8408 B10.n610 VSUBS 0.40932f
C8409 B10.n611 VSUBS 0.40932f
C8410 B10.n612 VSUBS 0.40932f
C8411 B10.n613 VSUBS 0.40932f
C8412 B10.n614 VSUBS 0.40932f
C8413 B10.n615 VSUBS 0.40932f
C8414 B10.n616 VSUBS 0.40932f
C8415 B10.n617 VSUBS 0.40932f
C8416 B10.n618 VSUBS 0.40932f
C8417 B10.n619 VSUBS 0.40932f
C8418 B10.n620 VSUBS 0.40932f
C8419 B10.n621 VSUBS 0.40932f
C8420 B10.n622 VSUBS 0.40932f
C8421 B10.n623 VSUBS 0.40932f
C8422 B10.n624 VSUBS 0.40932f
C8423 B10.n625 VSUBS 0.40932f
C8424 B10.n626 VSUBS 0.40932f
C8425 B10.n627 VSUBS 0.40932f
C8426 B10.n628 VSUBS 0.40932f
C8427 B10.n629 VSUBS 0.40932f
C8428 B10.n630 VSUBS 0.40932f
C8429 B10.n631 VSUBS 0.40932f
C8430 B10.n632 VSUBS 0.40932f
C8431 B10.n633 VSUBS 0.40932f
C8432 B10.n634 VSUBS 0.69301f
C8433 B10.n635 VSUBS 1.84f
C8434 B10.n636 VSUBS 0.5124f
C8435 B10.n637 VSUBS 0.40932f
C8436 B10.n638 VSUBS 0.40932f
C8437 B10.n639 VSUBS 0.40932f
C8438 B10.n640 VSUBS 0.40932f
C8439 B10.n641 VSUBS 0.40932f
C8440 B10.n642 VSUBS 0.40932f
C8441 B10.n643 VSUBS 0.40932f
C8442 B10.n644 VSUBS 0.40932f
C8443 B10.n645 VSUBS 0.40932f
C8444 B10.n646 VSUBS 0.40932f
C8445 B10.n647 VSUBS 0.40932f
C8446 B10.n648 VSUBS 0.40932f
C8447 B10.n649 VSUBS 0.40932f
C8448 B10.n650 VSUBS 0.40932f
C8449 B10.n651 VSUBS 0.40932f
C8450 B10.n652 VSUBS 0.40932f
C8451 B10.n653 VSUBS 0.40932f
C8452 B10.n654 VSUBS 0.40932f
C8453 B10.n655 VSUBS 0.40932f
C8454 B10.n656 VSUBS 0.40932f
C8455 B10.n657 VSUBS 0.40932f
C8456 B10.n658 VSUBS 0.40932f
C8457 B10.n659 VSUBS 0.40932f
C8458 B10.n660 VSUBS 0.40932f
C8459 B10.n661 VSUBS 0.40932f
C8460 B10.n662 VSUBS 0.40932f
C8461 B10.n663 VSUBS 0.40932f
C8462 B10.n664 VSUBS 0.40932f
C8463 B10.n665 VSUBS 0.40932f
C8464 B10.n666 VSUBS 0.40932f
C8465 B10.n667 VSUBS 0.40932f
C8466 B10.n668 VSUBS 0.40932f
C8467 B10.n669 VSUBS 0.40932f
C8468 B10.n670 VSUBS 0.40932f
C8469 B10.n671 VSUBS 0.40932f
C8470 B10.n672 VSUBS 0.40932f
C8471 B10.n673 VSUBS 0.40932f
C8472 B10.n674 VSUBS 0.40932f
C8473 B10.n675 VSUBS 0.40932f
C8474 B10.n676 VSUBS 0.40932f
C8475 B10.n677 VSUBS 0.40932f
C8476 B10.n678 VSUBS 0.40932f
C8477 B10.n679 VSUBS 0.40932f
C8478 B10.n680 VSUBS 0.40932f
C8479 B10.n681 VSUBS 0.40932f
C8480 B10.n682 VSUBS 0.40932f
C8481 B10.n683 VSUBS 0.40932f
C8482 B10.n684 VSUBS 0.40932f
C8483 B10.n685 VSUBS 0.40932f
C8484 B10.n686 VSUBS 0.40932f
C8485 B10.n687 VSUBS 0.40932f
C8486 B10.n688 VSUBS 0.40932f
C8487 B10.n689 VSUBS 0.40932f
C8488 B10.n690 VSUBS 0.40932f
C8489 B10.n691 VSUBS 0.40932f
C8490 B10.n692 VSUBS 0.40932f
C8491 B10.n693 VSUBS 0.40932f
C8492 B10.n694 VSUBS 0.40932f
C8493 B10.n695 VSUBS 0.40932f
C8494 B10.n696 VSUBS 0.40932f
C8495 B10.n697 VSUBS 0.69301f
C8496 B10.n698 VSUBS 1.06338f
C8497 B10.n699 VSUBS 0.5124f
C8498 B10.n700 VSUBS 0.40932f
C8499 B10.n701 VSUBS 0.40932f
C8500 B10.n702 VSUBS 0.40932f
C8501 B10.n703 VSUBS 0.40932f
C8502 B10.n704 VSUBS 0.40932f
C8503 B10.n705 VSUBS 0.40932f
C8504 B10.n706 VSUBS 0.40932f
C8505 B10.n707 VSUBS 0.40932f
C8506 B10.n708 VSUBS 0.40932f
C8507 B10.n709 VSUBS 0.40932f
C8508 B10.n710 VSUBS 0.40932f
C8509 B10.n711 VSUBS 0.40932f
C8510 B10.n712 VSUBS 0.40932f
C8511 B10.n713 VSUBS 0.40932f
C8512 B10.n714 VSUBS 0.40932f
C8513 B10.n715 VSUBS 0.40932f
C8514 B10.n716 VSUBS 0.40932f
C8515 B10.n717 VSUBS 0.40932f
C8516 B10.n718 VSUBS 0.40932f
C8517 B10.n719 VSUBS 0.40932f
C8518 B10.n720 VSUBS 0.40932f
C8519 B10.n721 VSUBS 0.40932f
C8520 B10.n722 VSUBS 0.40932f
C8521 B10.n723 VSUBS 0.40932f
C8522 B10.n724 VSUBS 0.40932f
C8523 B10.n725 VSUBS 0.40932f
C8524 B10.n726 VSUBS 0.40932f
C8525 B10.n727 VSUBS 0.40932f
C8526 B10.n728 VSUBS 0.40932f
C8527 B10.n729 VSUBS 0.40932f
C8528 B10.n730 VSUBS 0.40932f
C8529 B10.n731 VSUBS 0.40932f
C8530 B10.n732 VSUBS 0.40932f
C8531 B10.n733 VSUBS 0.40932f
C8532 B10.n734 VSUBS 0.40932f
C8533 B10.n735 VSUBS 0.40932f
C8534 B10.n736 VSUBS 0.40932f
C8535 B10.n737 VSUBS 0.40932f
C8536 B10.n738 VSUBS 0.40932f
C8537 B10.n739 VSUBS 0.40932f
C8538 B10.n740 VSUBS 0.40932f
C8539 B10.n741 VSUBS 0.40932f
C8540 B10.n742 VSUBS 0.40932f
C8541 B10.n743 VSUBS 0.40932f
C8542 B10.n744 VSUBS 0.40932f
C8543 B10.n745 VSUBS 0.40932f
C8544 B10.n746 VSUBS 0.40932f
C8545 B10.n747 VSUBS 0.40932f
C8546 B10.n748 VSUBS 0.40932f
C8547 B10.n749 VSUBS 0.40932f
C8548 B10.n750 VSUBS 0.40932f
C8549 B10.n751 VSUBS 0.40932f
C8550 B10.n752 VSUBS 0.40932f
C8551 B10.n753 VSUBS 0.40932f
C8552 B10.n754 VSUBS 0.40932f
C8553 B10.n755 VSUBS 0.40932f
C8554 B10.n756 VSUBS 0.40932f
C8555 B10.n757 VSUBS 0.40932f
C8556 B10.n758 VSUBS 0.40932f
C8557 B10.n759 VSUBS 0.40932f
C8558 B10.n760 VSUBS 0.69301f
C8559 B10.n761 VSUBS 1.06338f
C8560 B10.n762 VSUBS 0.5124f
C8561 B10.n763 VSUBS 0.40932f
C8562 B10.n764 VSUBS 0.40932f
C8563 B10.n765 VSUBS 0.40932f
C8564 B10.n766 VSUBS 0.40932f
C8565 B10.n767 VSUBS 0.40932f
C8566 B10.n768 VSUBS 0.40932f
C8567 B10.n769 VSUBS 0.40932f
C8568 B10.n770 VSUBS 0.40932f
C8569 B10.n771 VSUBS 0.40932f
C8570 B10.n772 VSUBS 0.40932f
C8571 B10.n773 VSUBS 0.40932f
C8572 B10.n774 VSUBS 0.40932f
C8573 B10.n775 VSUBS 0.40932f
C8574 B10.n776 VSUBS 0.40932f
C8575 B10.n777 VSUBS 0.40932f
C8576 B10.n778 VSUBS 0.40932f
C8577 B10.n779 VSUBS 0.40932f
C8578 B10.n780 VSUBS 0.40932f
C8579 B10.n781 VSUBS 0.40932f
C8580 B10.n782 VSUBS 0.40932f
C8581 B10.n783 VSUBS 0.40932f
C8582 B10.n784 VSUBS 0.40932f
C8583 B10.n785 VSUBS 0.40932f
C8584 B10.n786 VSUBS 0.40932f
C8585 B10.n787 VSUBS 0.40932f
C8586 B10.n788 VSUBS 0.40932f
C8587 B10.n789 VSUBS 0.40932f
C8588 B10.n790 VSUBS 0.40932f
C8589 B10.n791 VSUBS 0.40932f
C8590 B10.n792 VSUBS 0.40932f
C8591 B10.n793 VSUBS 0.40932f
C8592 B10.n794 VSUBS 0.40932f
C8593 B10.n795 VSUBS 0.40932f
C8594 B10.n796 VSUBS 0.40932f
C8595 B10.n797 VSUBS 0.40932f
C8596 B10.n798 VSUBS 0.40932f
C8597 B10.n799 VSUBS 0.40932f
C8598 B10.n800 VSUBS 0.40932f
C8599 B10.n801 VSUBS 0.40932f
C8600 B10.n802 VSUBS 0.40932f
C8601 B10.n803 VSUBS 0.40932f
C8602 B10.n804 VSUBS 0.40932f
C8603 B10.n805 VSUBS 0.40932f
C8604 B10.n806 VSUBS 0.40932f
C8605 B10.n807 VSUBS 0.40932f
C8606 B10.n808 VSUBS 0.40932f
C8607 B10.n809 VSUBS 0.40932f
C8608 B10.n810 VSUBS 0.40932f
C8609 B10.n811 VSUBS 0.40932f
C8610 B10.n812 VSUBS 0.40932f
C8611 B10.n813 VSUBS 0.40932f
C8612 B10.n814 VSUBS 0.40932f
C8613 B10.n815 VSUBS 0.40932f
C8614 B10.n816 VSUBS 0.40932f
C8615 B10.n817 VSUBS 0.40932f
C8616 B10.n818 VSUBS 0.40932f
C8617 B10.n819 VSUBS 0.40932f
C8618 B10.n820 VSUBS 0.40932f
C8619 B10.n821 VSUBS 0.40932f
C8620 B10.n822 VSUBS 0.40932f
C8621 B10.n823 VSUBS 0.69301f
C8622 B10.n824 VSUBS 1.06338f
C8623 B10.n825 VSUBS 0.5124f
C8624 B10.n826 VSUBS 0.40932f
C8625 B10.n827 VSUBS 0.40932f
C8626 B10.n828 VSUBS 0.40932f
C8627 B10.n829 VSUBS 0.40932f
C8628 B10.n830 VSUBS 0.40932f
C8629 B10.n831 VSUBS 0.40932f
C8630 B10.n832 VSUBS 0.40932f
C8631 B10.n833 VSUBS 0.40932f
C8632 B10.n834 VSUBS 0.40932f
C8633 B10.n835 VSUBS 0.40932f
C8634 B10.n836 VSUBS 0.40932f
C8635 B10.n837 VSUBS 0.40932f
C8636 B10.n838 VSUBS 0.40932f
C8637 B10.n839 VSUBS 0.40932f
C8638 B10.n840 VSUBS 0.40932f
C8639 B10.n841 VSUBS 0.40932f
C8640 B10.n842 VSUBS 0.40932f
C8641 B10.n843 VSUBS 0.40932f
C8642 B10.n844 VSUBS 0.40932f
C8643 B10.n845 VSUBS 0.40932f
C8644 B10.n846 VSUBS 0.40932f
C8645 B10.n847 VSUBS 0.40932f
C8646 B10.n848 VSUBS 0.40932f
C8647 B10.n849 VSUBS 0.40932f
C8648 B10.n850 VSUBS 0.40932f
C8649 B10.n851 VSUBS 0.40932f
C8650 B10.n852 VSUBS 0.40932f
C8651 B10.n853 VSUBS 0.40932f
C8652 B10.n854 VSUBS 0.40932f
C8653 B10.n855 VSUBS 0.40932f
C8654 B10.n856 VSUBS 0.40932f
C8655 B10.n857 VSUBS 0.40932f
C8656 B10.n858 VSUBS 0.40932f
C8657 B10.n859 VSUBS 0.40932f
C8658 B10.n860 VSUBS 0.40932f
C8659 B10.n861 VSUBS 0.40932f
C8660 B10.n862 VSUBS 0.40932f
C8661 B10.n863 VSUBS 0.40932f
C8662 B10.n864 VSUBS 0.40932f
C8663 B10.n865 VSUBS 0.40932f
C8664 B10.n866 VSUBS 0.40932f
C8665 B10.n867 VSUBS 0.40932f
C8666 B10.n868 VSUBS 0.40932f
C8667 B10.n869 VSUBS 0.40932f
C8668 B10.n870 VSUBS 0.40932f
C8669 B10.n871 VSUBS 0.40932f
C8670 B10.n872 VSUBS 0.40932f
C8671 B10.n873 VSUBS 0.40932f
C8672 B10.n874 VSUBS 0.40932f
C8673 B10.n875 VSUBS 0.40932f
C8674 B10.n876 VSUBS 0.40932f
C8675 B10.n877 VSUBS 0.40932f
C8676 B10.n878 VSUBS 0.40932f
C8677 B10.n879 VSUBS 0.40932f
C8678 B10.n880 VSUBS 0.40932f
C8679 B10.n881 VSUBS 0.40932f
C8680 B10.n882 VSUBS 0.40932f
C8681 B10.n883 VSUBS 0.40932f
C8682 B10.n884 VSUBS 0.40932f
C8683 B10.n885 VSUBS 0.40932f
C8684 B10.n886 VSUBS 0.69301f
C8685 B10.n887 VSUBS 1.06338f
C8686 B10.n888 VSUBS 0.5124f
C8687 B10.n889 VSUBS 0.40932f
C8688 B10.n890 VSUBS 0.40932f
C8689 B10.n891 VSUBS 0.40932f
C8690 B10.n892 VSUBS 0.40932f
C8691 B10.n893 VSUBS 0.40932f
C8692 B10.n894 VSUBS 0.40932f
C8693 B10.n895 VSUBS 0.40932f
C8694 B10.n896 VSUBS 0.40932f
C8695 B10.n897 VSUBS 0.40932f
C8696 B10.n898 VSUBS 0.40932f
C8697 B10.n899 VSUBS 0.40932f
C8698 B10.n900 VSUBS 0.40932f
C8699 B10.n901 VSUBS 0.40932f
C8700 B10.n902 VSUBS 0.40932f
C8701 B10.n903 VSUBS 0.40932f
C8702 B10.n904 VSUBS 0.40932f
C8703 B10.n905 VSUBS 0.40932f
C8704 B10.n906 VSUBS 0.40932f
C8705 B10.n907 VSUBS 0.40932f
C8706 B10.n908 VSUBS 0.40932f
C8707 B10.n909 VSUBS 0.40932f
C8708 B10.n910 VSUBS 0.40932f
C8709 B10.n911 VSUBS 0.40932f
C8710 B10.n912 VSUBS 0.40932f
C8711 B10.n913 VSUBS 0.40932f
C8712 B10.n914 VSUBS 0.40932f
C8713 B10.n915 VSUBS 0.40932f
C8714 B10.n916 VSUBS 0.40932f
C8715 B10.n917 VSUBS 0.40932f
C8716 B10.n918 VSUBS 0.40932f
C8717 B10.n919 VSUBS 0.40932f
C8718 B10.n920 VSUBS 0.40932f
C8719 B10.n921 VSUBS 0.40932f
C8720 B10.n922 VSUBS 0.40932f
C8721 B10.n923 VSUBS 0.40932f
C8722 B10.n924 VSUBS 0.40932f
C8723 B10.n925 VSUBS 0.40932f
C8724 B10.n926 VSUBS 0.40932f
C8725 B10.n927 VSUBS 0.40932f
C8726 B10.n928 VSUBS 0.40932f
C8727 B10.n929 VSUBS 0.40932f
C8728 B10.n930 VSUBS 0.40932f
C8729 B10.n931 VSUBS 0.40932f
C8730 B10.n932 VSUBS 0.40932f
C8731 B10.n933 VSUBS 0.40932f
C8732 B10.n934 VSUBS 0.40932f
C8733 B10.n935 VSUBS 0.40932f
C8734 B10.n936 VSUBS 0.40932f
C8735 B10.n937 VSUBS 0.40932f
C8736 B10.n938 VSUBS 0.40932f
C8737 B10.n939 VSUBS 0.40932f
C8738 B10.n940 VSUBS 0.40932f
C8739 B10.n941 VSUBS 0.40932f
C8740 B10.n942 VSUBS 0.40932f
C8741 B10.n943 VSUBS 0.40932f
C8742 B10.n944 VSUBS 0.40932f
C8743 B10.n945 VSUBS 0.40932f
C8744 B10.n946 VSUBS 0.40932f
C8745 B10.n947 VSUBS 0.40932f
C8746 B10.n948 VSUBS 0.40932f
C8747 B10.n949 VSUBS 0.69301f
C8748 B10.n950 VSUBS 1.06338f
C8749 B10.n951 VSUBS 0.5124f
C8750 B10.n952 VSUBS 0.40932f
C8751 B10.n953 VSUBS 0.40932f
C8752 B10.n954 VSUBS 0.40932f
C8753 B10.n955 VSUBS 0.40932f
C8754 B10.n956 VSUBS 0.40932f
C8755 B10.n957 VSUBS 0.40932f
C8756 B10.n958 VSUBS 0.40932f
C8757 B10.n959 VSUBS 0.40932f
C8758 B10.n960 VSUBS 0.40932f
C8759 B10.n961 VSUBS 0.40932f
C8760 B10.n962 VSUBS 0.40932f
C8761 B10.n963 VSUBS 0.40932f
C8762 B10.n964 VSUBS 0.40932f
C8763 B10.n965 VSUBS 0.40932f
C8764 B10.n966 VSUBS 0.40932f
C8765 B10.n967 VSUBS 0.40932f
C8766 B10.n968 VSUBS 0.40932f
C8767 B10.n969 VSUBS 0.40932f
C8768 B10.n970 VSUBS 0.40932f
C8769 B10.n971 VSUBS 0.40932f
C8770 B10.n972 VSUBS 0.40932f
C8771 B10.n973 VSUBS 0.40932f
C8772 B10.n974 VSUBS 0.40932f
C8773 B10.n975 VSUBS 0.40932f
C8774 B10.n976 VSUBS 0.40932f
C8775 B10.n977 VSUBS 0.40932f
C8776 B10.n978 VSUBS 0.40932f
C8777 B10.n979 VSUBS 0.40932f
C8778 B10.n980 VSUBS 0.40932f
C8779 B10.n981 VSUBS 0.40932f
C8780 B10.n982 VSUBS 0.40932f
C8781 B10.n983 VSUBS 0.40932f
C8782 B10.n984 VSUBS 0.40932f
C8783 B10.n985 VSUBS 0.40932f
C8784 B10.n986 VSUBS 0.40932f
C8785 B10.n987 VSUBS 0.40932f
C8786 B10.n988 VSUBS 0.40932f
C8787 B10.n989 VSUBS 0.40932f
C8788 B10.n990 VSUBS 0.40932f
C8789 B10.n991 VSUBS 0.40932f
C8790 B10.n992 VSUBS 0.40932f
C8791 B10.n993 VSUBS 0.40932f
C8792 B10.n994 VSUBS 0.40932f
C8793 B10.n995 VSUBS 0.40932f
C8794 B10.n996 VSUBS 0.40932f
C8795 B10.n997 VSUBS 0.40932f
C8796 B10.n998 VSUBS 0.40932f
C8797 B10.n999 VSUBS 0.40932f
C8798 B10.n1000 VSUBS 0.40932f
C8799 B10.n1001 VSUBS 0.40932f
C8800 B10.n1002 VSUBS 0.40932f
C8801 B10.n1003 VSUBS 0.40932f
C8802 B10.n1004 VSUBS 0.40932f
C8803 B10.n1005 VSUBS 0.40932f
C8804 B10.n1006 VSUBS 0.40932f
C8805 B10.n1007 VSUBS 0.40932f
C8806 B10.n1008 VSUBS 0.40932f
C8807 B10.n1009 VSUBS 0.40932f
C8808 B10.n1010 VSUBS 0.40932f
C8809 B10.n1011 VSUBS 0.40932f
C8810 B10.n1012 VSUBS 0.69301f
C8811 B10.n1013 VSUBS 9.50438f
C8812 B10.n1014 VSUBS 9.56528f
C8813 B10.n1015 VSUBS 1.12429f
C8814 B10.n1016 VSUBS 1.12429f
C8815 B10.n1017 VSUBS 1.12429f
C8816 B10.n1018 VSUBS 1.12429f
C8817 B10.n1019 VSUBS 1.12429f
C8818 B10.n1020 VSUBS 1.12429f
C8819 B10.n1021 VSUBS 11.0343f
C8820 B2.n0 VSUBS 36.7469f
C8821 B2.n1 VSUBS 38.0189f
C8822 B3.n0 VSUBS 0.70084f
C8823 B3.n1 VSUBS 34.073f
C8824 B3.n2 VSUBS 0.70084f
C8825 B3.n3 VSUBS 35.4512f
C8826 B4.n0 VSUBS 0.68301f
C8827 B4.n1 VSUBS 0.54561f
C8828 B4.n2 VSUBS 0.53907f
C8829 B4.n3 VSUBS 0.68301f
C8830 B4.n4 VSUBS 0.53907f
C8831 B4.n5 VSUBS 30.7294f
C8832 B4.n6 VSUBS 0.68301f
C8833 B4.n7 VSUBS 0.54561f
C8834 B4.n8 VSUBS 0.53907f
C8835 B4.n9 VSUBS 0.68301f
C8836 B4.n10 VSUBS 0.53907f
C8837 B4.n11 VSUBS 32.5813f
C8838 B5.n0 VSUBS 0.66034f
C8839 B5.n1 VSUBS 0.5275f
C8840 B5.n2 VSUBS 0.5275f
C8841 B5.n3 VSUBS 0.5275f
C8842 B5.n4 VSUBS 0.5275f
C8843 B5.n5 VSUBS 0.5275f
C8844 B5.n6 VSUBS 0.52117f
C8845 B5.n7 VSUBS 0.66034f
C8846 B5.n8 VSUBS 0.5275f
C8847 B5.n9 VSUBS 0.5275f
C8848 B5.n10 VSUBS 0.5275f
C8849 B5.n11 VSUBS 0.5275f
C8850 B5.n12 VSUBS 0.52117f
C8851 B5.n13 VSUBS 22.3262f
C8852 B5.n14 VSUBS 0.66034f
C8853 B5.n15 VSUBS 0.5275f
C8854 B5.n16 VSUBS 0.5275f
C8855 B5.n17 VSUBS 0.5275f
C8856 B5.n18 VSUBS 0.5275f
C8857 B5.n19 VSUBS 0.5275f
C8858 B5.n20 VSUBS 0.52117f
C8859 B5.n21 VSUBS 0.66034f
C8860 B5.n22 VSUBS 0.5275f
C8861 B5.n23 VSUBS 0.5275f
C8862 B5.n24 VSUBS 0.5275f
C8863 B5.n25 VSUBS 0.5275f
C8864 B5.n26 VSUBS 0.52117f
C8865 B5.n27 VSUBS 27.9322f
.ends
