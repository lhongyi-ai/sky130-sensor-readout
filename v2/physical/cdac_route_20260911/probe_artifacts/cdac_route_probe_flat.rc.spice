* NGSPICE file created from cdac_route_probe_flat.ext - technology: sky130A

.subckt cdac_route_probe_flat TOP B0 B1
X0 B1.t1 TOP.t4 sky130_fd_pr__cap_mim_m3_1 l=3 w=3
X1 B1.t0 TOP.t6 sky130_fd_pr__cap_mim_m3_1 l=3 w=3
X2 B0.t1 TOP.t0 sky130_fd_pr__cap_mim_m3_1 l=3 w=3
X3 B0.t0 TOP.t2 sky130_fd_pr__cap_mim_m3_1 l=3 w=3
R0 B0 B0.t0 5.60941
R1 B0 B0.t1 2.11136
R2 B1 B1.t1 4.37266
R3 B1 B1.t0 1.91661
R4 TOP.t2 TOP.t6 0.626982
R5 TOP.t4 TOP.t0 0.626982
R6 TOP TOP.n0 0.243333
R7 TOP.n0 TOP.t2 0.17334
R8 TOP.n0 TOP.t4 0.17334
C0 B1 B0 1.80016f
C1 B0 TOP 2.54279f
C2 B1 TOP 2.41734f
C3 B0 VSUBS 5.42258f
C4 B1 VSUBS 5.86331f
C5 TOP VSUBS 5.13526f
C6 TOP.t0 VSUBS 2.14618f
C7 TOP.t4 VSUBS 2.70079f
C8 TOP.t6 VSUBS 2.14907f
C9 TOP.t2 VSUBS 3.21607f
C10 TOP.n0 VSUBS 0.18189f
.ends
