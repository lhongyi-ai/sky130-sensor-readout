* NGSPICE file created from probe_x_5p160.ext - technology: sky130A

.subckt mim_unit C2 C1
X0 C1 C2 sky130_fd_pr__cap_mim_m3_1 l=3 w=3
.ends

* Top level circuit probe_x_5p160

XX0 X0/C2 X0/C1 mim_unit
XX1 X1/C2 X1/C1 mim_unit
.end
