; New isolated MIM structure. Tested APIs from installed IC618 docs.
procedure(p2c4Layout(name rects pins)
 let((cv fig net term pin pt half result)
  when(ddGetObj("project1" name) error("Refuse existing target: %s" name))
  cv=dbOpenCellViewByType("project1" name "layout" "maskLayout" "w")
  unless(cv error("Cannot create %s" name))
  dbReplaceProp(cv "p1maOwner" "string" "cdac4_access_preparation_r1")
  dbReplaceProp(cv "p1maStatus" "string" "EXPERIMENT_NOT_QUALIFIED")
  foreach(row rects
   unless(dbCreateRect(cv list(car(row) cadr(row)) list(caddr(row) cadddr(row)))
    dbSave(cv) error("Failed rectangle")))
  foreach(row pins
   net=dbMakeNet(cv car(row))
   term=dbCreateTerm(net car(row) "inputOutput")
   pt=caddr(row)
   half=0.01
   fig=dbCreateRect(cv list(cadr(row) "pin")
    list(list(xCoord(pt)-half yCoord(pt)-half) list(xCoord(pt)+half yCoord(pt)+half)))
   pin=dbCreatePin(net fig)
   unless(pin dbSave(cv) error("Failed pin"))
   dbCreateLabel(cv list(cadr(row) "label") pt car(row) "centerCenter" "R0" "stick" 0.1))
  dbSave(cv)
  result=list(cv~>cellName length(cv~>shapes) cv~>bBox cv~>terminals~>name)
  dbClose(cv)
  result))

; All targets isolated. Refuses existing cells. No schematic/model mutation.
p2c4Layout("p2c4_access_pair_r1" list(list("met3" "drawing" list(-0.400000 -0.400000) list(4.400000 4.400000)) list("capm" "drawing" list(0.000000 0.000000) list(4.000000 4.000000)) list("met4" "drawing" list(0.100000 0.100000) list(3.900000 3.900000)) list("via3" "drawing" list(0.300000 0.300000) list(0.500000 0.500000)) list("via3" "drawing" list(0.300000 0.700000) list(0.500000 0.900000)) list("via3" "drawing" list(0.300000 1.100000) list(0.500000 1.300000)) list("via3" "drawing" list(0.300000 1.500000) list(0.500000 1.700000)) list("via3" "drawing" list(0.300000 1.900000) list(0.500000 2.100000)) list("via3" "drawing" list(0.300000 2.300000) list(0.500000 2.500000)) list("via3" "drawing" list(0.300000 2.700000) list(0.500000 2.900000)) list("via3" "drawing" list(0.300000 3.100000) list(0.500000 3.300000)) list("via3" "drawing" list(0.300000 3.500000) list(0.500000 3.700000)) list("via3" "drawing" list(0.700000 0.300000) list(0.900000 0.500000)) list("via3" "drawing" list(0.700000 0.700000) list(0.900000 0.900000)) list("via3" "drawing" list(0.700000 1.100000) list(0.900000 1.300000)) list("via3" "drawing" list(0.700000 1.500000) list(0.900000 1.700000)) list("via3" "drawing" list(0.700000 1.900000) list(0.900000 2.100000)) list("via3" "drawing" list(0.700000 2.300000) list(0.900000 2.500000)) list("via3" "drawing" list(0.700000 2.700000) list(0.900000 2.900000)) list("via3" "drawing" list(0.700000 3.100000) list(0.900000 3.300000)) list("via3" "drawing" list(0.700000 3.500000) list(0.900000 3.700000)) list("via3" "drawing" list(1.100000 0.300000) list(1.300000 0.500000)) list("via3" "drawing" list(1.100000 0.700000) list(1.300000 0.900000)) list("via3" "drawing" list(1.100000 1.100000) list(1.300000 1.300000)) list("via3" "drawing" list(1.100000 1.500000) list(1.300000 1.700000)) list("via3" "drawing" list(1.100000 1.900000) list(1.300000 2.100000)) list("via3" "drawing" list(1.100000 2.300000) list(1.300000 2.500000)) list("via3" "drawing" list(1.100000 2.700000) list(1.300000 2.900000)) list("via3" "drawing" list(1.100000 3.100000) list(1.300000 3.300000)) list("via3" "drawing" list(1.100000 3.500000) list(1.300000 3.700000)) list("via3" "drawing" list(1.500000 0.300000) list(1.700000 0.500000)) list("via3" "drawing" list(1.500000 0.700000) list(1.700000 0.900000)) list("via3" "drawing" list(1.500000 1.100000) list(1.700000 1.300000)) list("via3" "drawing" list(1.500000 1.500000) list(1.700000 1.700000)) list("via3" "drawing" list(1.500000 1.900000) list(1.700000 2.100000)) list("via3" "drawing" list(1.500000 2.300000) list(1.700000 2.500000)) list("via3" "drawing" list(1.500000 2.700000) list(1.700000 2.900000)) list("via3" "drawing" list(1.500000 3.100000) list(1.700000 3.300000)) list("via3" "drawing" list(1.500000 3.500000) list(1.700000 3.700000)) list("via3" "drawing" list(1.900000 0.300000) list(2.100000 0.500000)) list("via3" "drawing" list(1.900000 0.700000) list(2.100000 0.900000)) list("via3" "drawing" list(1.900000 1.100000) list(2.100000 1.300000)) list("via3" "drawing" list(1.900000 1.500000) list(2.100000 1.700000)) list("via3" "drawing" list(1.900000 1.900000) list(2.100000 2.100000)) list("via3" "drawing" list(1.900000 2.300000) list(2.100000 2.500000)) list("via3" "drawing" list(1.900000 2.700000) list(2.100000 2.900000)) list("via3" "drawing" list(1.900000 3.100000) list(2.100000 3.300000)) list("via3" "drawing" list(1.900000 3.500000) list(2.100000 3.700000)) list("via3" "drawing" list(2.300000 0.300000) list(2.500000 0.500000)) list("via3" "drawing" list(2.300000 0.700000) list(2.500000 0.900000)) list("via3" "drawing" list(2.300000 1.100000) list(2.500000 1.300000)) list("via3" "drawing" list(2.300000 1.500000) list(2.500000 1.700000)) list("via3" "drawing" list(2.300000 1.900000) list(2.500000 2.100000)) list("via3" "drawing" list(2.300000 2.300000) list(2.500000 2.500000)) list("via3" "drawing" list(2.300000 2.700000) list(2.500000 2.900000)) list("via3" "drawing" list(2.300000 3.100000) list(2.500000 3.300000)) list("via3" "drawing" list(2.300000 3.500000) list(2.500000 3.700000)) list("via3" "drawing" list(2.700000 0.300000) list(2.900000 0.500000)) list("via3" "drawing" list(2.700000 0.700000) list(2.900000 0.900000)) list("via3" "drawing" list(2.700000 1.100000) list(2.900000 1.300000)) list("via3" "drawing" list(2.700000 1.500000) list(2.900000 1.700000)) list("via3" "drawing" list(2.700000 1.900000) list(2.900000 2.100000)) list("via3" "drawing" list(2.700000 2.300000) list(2.900000 2.500000)) list("via3" "drawing" list(2.700000 2.700000) list(2.900000 2.900000)) list("via3" "drawing" list(2.700000 3.100000) list(2.900000 3.300000)) list("via3" "drawing" list(2.700000 3.500000) list(2.900000 3.700000)) list("via3" "drawing" list(3.100000 0.300000) list(3.300000 0.500000)) list("via3" "drawing" list(3.100000 0.700000) list(3.300000 0.900000)) list("via3" "drawing" list(3.100000 1.100000) list(3.300000 1.300000)) list("via3" "drawing" list(3.100000 1.500000) list(3.300000 1.700000)) list("via3" "drawing" list(3.100000 1.900000) list(3.300000 2.100000)) list("via3" "drawing" list(3.100000 2.300000) list(3.300000 2.500000)) list("via3" "drawing" list(3.100000 2.700000) list(3.300000 2.900000)) list("via3" "drawing" list(3.100000 3.100000) list(3.300000 3.300000)) list("via3" "drawing" list(3.100000 3.500000) list(3.300000 3.700000)) list("via3" "drawing" list(3.500000 0.300000) list(3.700000 0.500000)) list("via3" "drawing" list(3.500000 0.700000) list(3.700000 0.900000)) list("via3" "drawing" list(3.500000 1.100000) list(3.700000 1.300000)) list("via3" "drawing" list(3.500000 1.500000) list(3.700000 1.700000)) list("via3" "drawing" list(3.500000 1.900000) list(3.700000 2.100000)) list("via3" "drawing" list(3.500000 2.300000) list(3.700000 2.500000)) list("via3" "drawing" list(3.500000 2.700000) list(3.700000 2.900000)) list("via3" "drawing" list(3.500000 3.100000) list(3.700000 3.300000)) list("via3" "drawing" list(3.500000 3.500000) list(3.700000 3.700000)) list("met3" "drawing" list(11.600000 -0.400000) list(16.400000 4.400000)) list("capm" "drawing" list(12.000000 0.000000) list(16.000000 4.000000)) list("met4" "drawing" list(12.100000 0.100000) list(15.900000 3.900000)) list("via3" "drawing" list(12.300000 0.300000) list(12.500000 0.500000)) list("via3" "drawing" list(12.300000 0.700000) list(12.500000 0.900000)) list("via3" "drawing" list(12.300000 1.100000) list(12.500000 1.300000)) list("via3" "drawing" list(12.300000 1.500000) list(12.500000 1.700000)) list("via3" "drawing" list(12.300000 1.900000) list(12.500000 2.100000)) list("via3" "drawing" list(12.300000 2.300000) list(12.500000 2.500000)) list("via3" "drawing" list(12.300000 2.700000) list(12.500000 2.900000)) list("via3" "drawing" list(12.300000 3.100000) list(12.500000 3.300000)) list("via3" "drawing" list(12.300000 3.500000) list(12.500000 3.700000)) list("via3" "drawing" list(12.700000 0.300000) list(12.900000 0.500000)) list("via3" "drawing" list(12.700000 0.700000) list(12.900000 0.900000)) list("via3" "drawing" list(12.700000 1.100000) list(12.900000 1.300000)) list("via3" "drawing" list(12.700000 1.500000) list(12.900000 1.700000)) list("via3" "drawing" list(12.700000 1.900000) list(12.900000 2.100000)) list("via3" "drawing" list(12.700000 2.300000) list(12.900000 2.500000)) list("via3" "drawing" list(12.700000 2.700000) list(12.900000 2.900000)) list("via3" "drawing" list(12.700000 3.100000) list(12.900000 3.300000)) list("via3" "drawing" list(12.700000 3.500000) list(12.900000 3.700000)) list("via3" "drawing" list(13.100000 0.300000) list(13.300000 0.500000)) list("via3" "drawing" list(13.100000 0.700000) list(13.300000 0.900000)) list("via3" "drawing" list(13.100000 1.100000) list(13.300000 1.300000)) list("via3" "drawing" list(13.100000 1.500000) list(13.300000 1.700000)) list("via3" "drawing" list(13.100000 1.900000) list(13.300000 2.100000)) list("via3" "drawing" list(13.100000 2.300000) list(13.300000 2.500000)) list("via3" "drawing" list(13.100000 2.700000) list(13.300000 2.900000)) list("via3" "drawing" list(13.100000 3.100000) list(13.300000 3.300000)) list("via3" "drawing" list(13.100000 3.500000) list(13.300000 3.700000)) list("via3" "drawing" list(13.500000 0.300000) list(13.700000 0.500000)) list("via3" "drawing" list(13.500000 0.700000) list(13.700000 0.900000)) list("via3" "drawing" list(13.500000 1.100000) list(13.700000 1.300000)) list("via3" "drawing" list(13.500000 1.500000) list(13.700000 1.700000)) list("via3" "drawing" list(13.500000 1.900000) list(13.700000 2.100000)) list("via3" "drawing" list(13.500000 2.300000) list(13.700000 2.500000)) list("via3" "drawing" list(13.500000 2.700000) list(13.700000 2.900000)) list("via3" "drawing" list(13.500000 3.100000) list(13.700000 3.300000)) list("via3" "drawing" list(13.500000 3.500000) list(13.700000 3.700000)) list("via3" "drawing" list(13.900000 0.300000) list(14.100000 0.500000)) list("via3" "drawing" list(13.900000 0.700000) list(14.100000 0.900000)) list("via3" "drawing" list(13.900000 1.100000) list(14.100000 1.300000)) list("via3" "drawing" list(13.900000 1.500000) list(14.100000 1.700000)) list("via3" "drawing" list(13.900000 1.900000) list(14.100000 2.100000)) list("via3" "drawing" list(13.900000 2.300000) list(14.100000 2.500000)) list("via3" "drawing" list(13.900000 2.700000) list(14.100000 2.900000)) list("via3" "drawing" list(13.900000 3.100000) list(14.100000 3.300000)) list("via3" "drawing" list(13.900000 3.500000) list(14.100000 3.700000)) list("via3" "drawing" list(14.300000 0.300000) list(14.500000 0.500000)) list("via3" "drawing" list(14.300000 0.700000) list(14.500000 0.900000)) list("via3" "drawing" list(14.300000 1.100000) list(14.500000 1.300000)) list("via3" "drawing" list(14.300000 1.500000) list(14.500000 1.700000)) list("via3" "drawing" list(14.300000 1.900000) list(14.500000 2.100000)) list("via3" "drawing" list(14.300000 2.300000) list(14.500000 2.500000)) list("via3" "drawing" list(14.300000 2.700000) list(14.500000 2.900000)) list("via3" "drawing" list(14.300000 3.100000) list(14.500000 3.300000)) list("via3" "drawing" list(14.300000 3.500000) list(14.500000 3.700000)) list("via3" "drawing" list(14.700000 0.300000) list(14.900000 0.500000)) list("via3" "drawing" list(14.700000 0.700000) list(14.900000 0.900000)) list("via3" "drawing" list(14.700000 1.100000) list(14.900000 1.300000)) list("via3" "drawing" list(14.700000 1.500000) list(14.900000 1.700000)) list("via3" "drawing" list(14.700000 1.900000) list(14.900000 2.100000)) list("via3" "drawing" list(14.700000 2.300000) list(14.900000 2.500000)) list("via3" "drawing" list(14.700000 2.700000) list(14.900000 2.900000)) list("via3" "drawing" list(14.700000 3.100000) list(14.900000 3.300000)) list("via3" "drawing" list(14.700000 3.500000) list(14.900000 3.700000)) list("via3" "drawing" list(15.100000 0.300000) list(15.300000 0.500000)) list("via3" "drawing" list(15.100000 0.700000) list(15.300000 0.900000)) list("via3" "drawing" list(15.100000 1.100000) list(15.300000 1.300000)) list("via3" "drawing" list(15.100000 1.500000) list(15.300000 1.700000)) list("via3" "drawing" list(15.100000 1.900000) list(15.300000 2.100000)) list("via3" "drawing" list(15.100000 2.300000) list(15.300000 2.500000)) list("via3" "drawing" list(15.100000 2.700000) list(15.300000 2.900000)) list("via3" "drawing" list(15.100000 3.100000) list(15.300000 3.300000)) list("via3" "drawing" list(15.100000 3.500000) list(15.300000 3.700000)) list("via3" "drawing" list(15.500000 0.300000) list(15.700000 0.500000)) list("via3" "drawing" list(15.500000 0.700000) list(15.700000 0.900000)) list("via3" "drawing" list(15.500000 1.100000) list(15.700000 1.300000)) list("via3" "drawing" list(15.500000 1.500000) list(15.700000 1.700000)) list("via3" "drawing" list(15.500000 1.900000) list(15.700000 2.100000)) list("via3" "drawing" list(15.500000 2.300000) list(15.700000 2.500000)) list("via3" "drawing" list(15.500000 2.700000) list(15.700000 2.900000)) list("via3" "drawing" list(15.500000 3.100000) list(15.700000 3.300000)) list("via3" "drawing" list(15.500000 3.500000) list(15.700000 3.700000)) list("met4" "drawing" list(3.700000 1.700000) list(12.300000 2.300000)) list("met4" "drawing" list(1.700000 3.700000) list(2.300000 6.300000)) list("met3" "drawing" list(-4.300000 1.700000) list(-0.200000 2.300000)) list("met3" "drawing" list(16.200000 1.700000) list(20.300000 2.300000)) list("met3" "drawing" list(-4.200000 1.800000) list(-3.800000 2.200000)) list("via3" "drawing" list(-4.100000 1.900000) list(-3.900000 2.100000)) list("met4" "drawing" list(-4.600000 1.400000) list(-3.400000 2.600000)) list("via4" "drawing" list(-4.400000 1.600000) list(-3.600000 2.400000)) list("met5" "drawing" list(-4.800000 -4.800000) list(-3.200000 2.800000)) list("met3" "drawing" list(19.800000 1.800000) list(20.200000 2.200000)) list("via3" "drawing" list(19.900000 1.900000) list(20.100000 2.100000)) list("met4" "drawing" list(19.400000 1.400000) list(20.600000 2.600000)) list("via4" "drawing" list(19.600000 1.600000) list(20.400000 2.400000)) list("met5" "drawing" list(19.200000 -4.800000) list(20.800000 2.800000)) list("met5" "drawing" list(-10.800000 -4.800000) list(-3.200000 -3.200000)) list("met5" "drawing" list(19.200000 -4.800000) list(26.800000 -3.200000))) list(list("TOP" "met4" list(2.000000 6.000000)) list("BITA" "met5" list(-10.000000 -4.000000)) list("BITB" "met5" list(26.000000 -4.000000))))
p2c4Layout("p2c4_access_open_r1" list(list("met3" "drawing" list(-0.400000 -0.400000) list(4.400000 4.400000)) list("capm" "drawing" list(0.000000 0.000000) list(4.000000 4.000000)) list("met4" "drawing" list(0.100000 0.100000) list(3.900000 3.900000)) list("via3" "drawing" list(0.300000 0.300000) list(0.500000 0.500000)) list("via3" "drawing" list(0.300000 0.700000) list(0.500000 0.900000)) list("via3" "drawing" list(0.300000 1.100000) list(0.500000 1.300000)) list("via3" "drawing" list(0.300000 1.500000) list(0.500000 1.700000)) list("via3" "drawing" list(0.300000 1.900000) list(0.500000 2.100000)) list("via3" "drawing" list(0.300000 2.300000) list(0.500000 2.500000)) list("via3" "drawing" list(0.300000 2.700000) list(0.500000 2.900000)) list("via3" "drawing" list(0.300000 3.100000) list(0.500000 3.300000)) list("via3" "drawing" list(0.300000 3.500000) list(0.500000 3.700000)) list("via3" "drawing" list(0.700000 0.300000) list(0.900000 0.500000)) list("via3" "drawing" list(0.700000 0.700000) list(0.900000 0.900000)) list("via3" "drawing" list(0.700000 1.100000) list(0.900000 1.300000)) list("via3" "drawing" list(0.700000 1.500000) list(0.900000 1.700000)) list("via3" "drawing" list(0.700000 1.900000) list(0.900000 2.100000)) list("via3" "drawing" list(0.700000 2.300000) list(0.900000 2.500000)) list("via3" "drawing" list(0.700000 2.700000) list(0.900000 2.900000)) list("via3" "drawing" list(0.700000 3.100000) list(0.900000 3.300000)) list("via3" "drawing" list(0.700000 3.500000) list(0.900000 3.700000)) list("via3" "drawing" list(1.100000 0.300000) list(1.300000 0.500000)) list("via3" "drawing" list(1.100000 0.700000) list(1.300000 0.900000)) list("via3" "drawing" list(1.100000 1.100000) list(1.300000 1.300000)) list("via3" "drawing" list(1.100000 1.500000) list(1.300000 1.700000)) list("via3" "drawing" list(1.100000 1.900000) list(1.300000 2.100000)) list("via3" "drawing" list(1.100000 2.300000) list(1.300000 2.500000)) list("via3" "drawing" list(1.100000 2.700000) list(1.300000 2.900000)) list("via3" "drawing" list(1.100000 3.100000) list(1.300000 3.300000)) list("via3" "drawing" list(1.100000 3.500000) list(1.300000 3.700000)) list("via3" "drawing" list(1.500000 0.300000) list(1.700000 0.500000)) list("via3" "drawing" list(1.500000 0.700000) list(1.700000 0.900000)) list("via3" "drawing" list(1.500000 1.100000) list(1.700000 1.300000)) list("via3" "drawing" list(1.500000 1.500000) list(1.700000 1.700000)) list("via3" "drawing" list(1.500000 1.900000) list(1.700000 2.100000)) list("via3" "drawing" list(1.500000 2.300000) list(1.700000 2.500000)) list("via3" "drawing" list(1.500000 2.700000) list(1.700000 2.900000)) list("via3" "drawing" list(1.500000 3.100000) list(1.700000 3.300000)) list("via3" "drawing" list(1.500000 3.500000) list(1.700000 3.700000)) list("via3" "drawing" list(1.900000 0.300000) list(2.100000 0.500000)) list("via3" "drawing" list(1.900000 0.700000) list(2.100000 0.900000)) list("via3" "drawing" list(1.900000 1.100000) list(2.100000 1.300000)) list("via3" "drawing" list(1.900000 1.500000) list(2.100000 1.700000)) list("via3" "drawing" list(1.900000 1.900000) list(2.100000 2.100000)) list("via3" "drawing" list(1.900000 2.300000) list(2.100000 2.500000)) list("via3" "drawing" list(1.900000 2.700000) list(2.100000 2.900000)) list("via3" "drawing" list(1.900000 3.100000) list(2.100000 3.300000)) list("via3" "drawing" list(1.900000 3.500000) list(2.100000 3.700000)) list("via3" "drawing" list(2.300000 0.300000) list(2.500000 0.500000)) list("via3" "drawing" list(2.300000 0.700000) list(2.500000 0.900000)) list("via3" "drawing" list(2.300000 1.100000) list(2.500000 1.300000)) list("via3" "drawing" list(2.300000 1.500000) list(2.500000 1.700000)) list("via3" "drawing" list(2.300000 1.900000) list(2.500000 2.100000)) list("via3" "drawing" list(2.300000 2.300000) list(2.500000 2.500000)) list("via3" "drawing" list(2.300000 2.700000) list(2.500000 2.900000)) list("via3" "drawing" list(2.300000 3.100000) list(2.500000 3.300000)) list("via3" "drawing" list(2.300000 3.500000) list(2.500000 3.700000)) list("via3" "drawing" list(2.700000 0.300000) list(2.900000 0.500000)) list("via3" "drawing" list(2.700000 0.700000) list(2.900000 0.900000)) list("via3" "drawing" list(2.700000 1.100000) list(2.900000 1.300000)) list("via3" "drawing" list(2.700000 1.500000) list(2.900000 1.700000)) list("via3" "drawing" list(2.700000 1.900000) list(2.900000 2.100000)) list("via3" "drawing" list(2.700000 2.300000) list(2.900000 2.500000)) list("via3" "drawing" list(2.700000 2.700000) list(2.900000 2.900000)) list("via3" "drawing" list(2.700000 3.100000) list(2.900000 3.300000)) list("via3" "drawing" list(2.700000 3.500000) list(2.900000 3.700000)) list("via3" "drawing" list(3.100000 0.300000) list(3.300000 0.500000)) list("via3" "drawing" list(3.100000 0.700000) list(3.300000 0.900000)) list("via3" "drawing" list(3.100000 1.100000) list(3.300000 1.300000)) list("via3" "drawing" list(3.100000 1.500000) list(3.300000 1.700000)) list("via3" "drawing" list(3.100000 1.900000) list(3.300000 2.100000)) list("via3" "drawing" list(3.100000 2.300000) list(3.300000 2.500000)) list("via3" "drawing" list(3.100000 2.700000) list(3.300000 2.900000)) list("via3" "drawing" list(3.100000 3.100000) list(3.300000 3.300000)) list("via3" "drawing" list(3.100000 3.500000) list(3.300000 3.700000)) list("via3" "drawing" list(3.500000 0.300000) list(3.700000 0.500000)) list("via3" "drawing" list(3.500000 0.700000) list(3.700000 0.900000)) list("via3" "drawing" list(3.500000 1.100000) list(3.700000 1.300000)) list("via3" "drawing" list(3.500000 1.500000) list(3.700000 1.700000)) list("via3" "drawing" list(3.500000 1.900000) list(3.700000 2.100000)) list("via3" "drawing" list(3.500000 2.300000) list(3.700000 2.500000)) list("via3" "drawing" list(3.500000 2.700000) list(3.700000 2.900000)) list("via3" "drawing" list(3.500000 3.100000) list(3.700000 3.300000)) list("via3" "drawing" list(3.500000 3.500000) list(3.700000 3.700000)) list("met3" "drawing" list(11.600000 -0.400000) list(16.400000 4.400000)) list("capm" "drawing" list(12.000000 0.000000) list(16.000000 4.000000)) list("met4" "drawing" list(12.100000 0.100000) list(15.900000 3.900000)) list("via3" "drawing" list(12.300000 0.300000) list(12.500000 0.500000)) list("via3" "drawing" list(12.300000 0.700000) list(12.500000 0.900000)) list("via3" "drawing" list(12.300000 1.100000) list(12.500000 1.300000)) list("via3" "drawing" list(12.300000 1.500000) list(12.500000 1.700000)) list("via3" "drawing" list(12.300000 1.900000) list(12.500000 2.100000)) list("via3" "drawing" list(12.300000 2.300000) list(12.500000 2.500000)) list("via3" "drawing" list(12.300000 2.700000) list(12.500000 2.900000)) list("via3" "drawing" list(12.300000 3.100000) list(12.500000 3.300000)) list("via3" "drawing" list(12.300000 3.500000) list(12.500000 3.700000)) list("via3" "drawing" list(12.700000 0.300000) list(12.900000 0.500000)) list("via3" "drawing" list(12.700000 0.700000) list(12.900000 0.900000)) list("via3" "drawing" list(12.700000 1.100000) list(12.900000 1.300000)) list("via3" "drawing" list(12.700000 1.500000) list(12.900000 1.700000)) list("via3" "drawing" list(12.700000 1.900000) list(12.900000 2.100000)) list("via3" "drawing" list(12.700000 2.300000) list(12.900000 2.500000)) list("via3" "drawing" list(12.700000 2.700000) list(12.900000 2.900000)) list("via3" "drawing" list(12.700000 3.100000) list(12.900000 3.300000)) list("via3" "drawing" list(12.700000 3.500000) list(12.900000 3.700000)) list("via3" "drawing" list(13.100000 0.300000) list(13.300000 0.500000)) list("via3" "drawing" list(13.100000 0.700000) list(13.300000 0.900000)) list("via3" "drawing" list(13.100000 1.100000) list(13.300000 1.300000)) list("via3" "drawing" list(13.100000 1.500000) list(13.300000 1.700000)) list("via3" "drawing" list(13.100000 1.900000) list(13.300000 2.100000)) list("via3" "drawing" list(13.100000 2.300000) list(13.300000 2.500000)) list("via3" "drawing" list(13.100000 2.700000) list(13.300000 2.900000)) list("via3" "drawing" list(13.100000 3.100000) list(13.300000 3.300000)) list("via3" "drawing" list(13.100000 3.500000) list(13.300000 3.700000)) list("via3" "drawing" list(13.500000 0.300000) list(13.700000 0.500000)) list("via3" "drawing" list(13.500000 0.700000) list(13.700000 0.900000)) list("via3" "drawing" list(13.500000 1.100000) list(13.700000 1.300000)) list("via3" "drawing" list(13.500000 1.500000) list(13.700000 1.700000)) list("via3" "drawing" list(13.500000 1.900000) list(13.700000 2.100000)) list("via3" "drawing" list(13.500000 2.300000) list(13.700000 2.500000)) list("via3" "drawing" list(13.500000 2.700000) list(13.700000 2.900000)) list("via3" "drawing" list(13.500000 3.100000) list(13.700000 3.300000)) list("via3" "drawing" list(13.500000 3.500000) list(13.700000 3.700000)) list("via3" "drawing" list(13.900000 0.300000) list(14.100000 0.500000)) list("via3" "drawing" list(13.900000 0.700000) list(14.100000 0.900000)) list("via3" "drawing" list(13.900000 1.100000) list(14.100000 1.300000)) list("via3" "drawing" list(13.900000 1.500000) list(14.100000 1.700000)) list("via3" "drawing" list(13.900000 1.900000) list(14.100000 2.100000)) list("via3" "drawing" list(13.900000 2.300000) list(14.100000 2.500000)) list("via3" "drawing" list(13.900000 2.700000) list(14.100000 2.900000)) list("via3" "drawing" list(13.900000 3.100000) list(14.100000 3.300000)) list("via3" "drawing" list(13.900000 3.500000) list(14.100000 3.700000)) list("via3" "drawing" list(14.300000 0.300000) list(14.500000 0.500000)) list("via3" "drawing" list(14.300000 0.700000) list(14.500000 0.900000)) list("via3" "drawing" list(14.300000 1.100000) list(14.500000 1.300000)) list("via3" "drawing" list(14.300000 1.500000) list(14.500000 1.700000)) list("via3" "drawing" list(14.300000 1.900000) list(14.500000 2.100000)) list("via3" "drawing" list(14.300000 2.300000) list(14.500000 2.500000)) list("via3" "drawing" list(14.300000 2.700000) list(14.500000 2.900000)) list("via3" "drawing" list(14.300000 3.100000) list(14.500000 3.300000)) list("via3" "drawing" list(14.300000 3.500000) list(14.500000 3.700000)) list("via3" "drawing" list(14.700000 0.300000) list(14.900000 0.500000)) list("via3" "drawing" list(14.700000 0.700000) list(14.900000 0.900000)) list("via3" "drawing" list(14.700000 1.100000) list(14.900000 1.300000)) list("via3" "drawing" list(14.700000 1.500000) list(14.900000 1.700000)) list("via3" "drawing" list(14.700000 1.900000) list(14.900000 2.100000)) list("via3" "drawing" list(14.700000 2.300000) list(14.900000 2.500000)) list("via3" "drawing" list(14.700000 2.700000) list(14.900000 2.900000)) list("via3" "drawing" list(14.700000 3.100000) list(14.900000 3.300000)) list("via3" "drawing" list(14.700000 3.500000) list(14.900000 3.700000)) list("via3" "drawing" list(15.100000 0.300000) list(15.300000 0.500000)) list("via3" "drawing" list(15.100000 0.700000) list(15.300000 0.900000)) list("via3" "drawing" list(15.100000 1.100000) list(15.300000 1.300000)) list("via3" "drawing" list(15.100000 1.500000) list(15.300000 1.700000)) list("via3" "drawing" list(15.100000 1.900000) list(15.300000 2.100000)) list("via3" "drawing" list(15.100000 2.300000) list(15.300000 2.500000)) list("via3" "drawing" list(15.100000 2.700000) list(15.300000 2.900000)) list("via3" "drawing" list(15.100000 3.100000) list(15.300000 3.300000)) list("via3" "drawing" list(15.100000 3.500000) list(15.300000 3.700000)) list("via3" "drawing" list(15.500000 0.300000) list(15.700000 0.500000)) list("via3" "drawing" list(15.500000 0.700000) list(15.700000 0.900000)) list("via3" "drawing" list(15.500000 1.100000) list(15.700000 1.300000)) list("via3" "drawing" list(15.500000 1.500000) list(15.700000 1.700000)) list("via3" "drawing" list(15.500000 1.900000) list(15.700000 2.100000)) list("via3" "drawing" list(15.500000 2.300000) list(15.700000 2.500000)) list("via3" "drawing" list(15.500000 2.700000) list(15.700000 2.900000)) list("via3" "drawing" list(15.500000 3.100000) list(15.700000 3.300000)) list("via3" "drawing" list(15.500000 3.500000) list(15.700000 3.700000)) list("met4" "drawing" list(3.700000 1.700000) list(12.300000 2.300000)) list("met4" "drawing" list(1.700000 3.700000) list(2.300000 6.300000)) list("met3" "drawing" list(-4.300000 1.700000) list(-0.200000 2.300000)) list("met3" "drawing" list(16.200000 1.700000) list(20.300000 2.300000)) list("met3" "drawing" list(-4.200000 1.800000) list(-3.800000 2.200000)) list("via3" "drawing" list(-4.100000 1.900000) list(-3.900000 2.100000)) list("met4" "drawing" list(-4.600000 1.400000) list(-3.400000 2.600000)) list("via4" "drawing" list(-4.400000 1.600000) list(-3.600000 2.400000)) list("met5" "drawing" list(-4.800000 -4.800000) list(-3.200000 2.800000)) list("met3" "drawing" list(19.800000 1.800000) list(20.200000 2.200000)) list("via3" "drawing" list(19.900000 1.900000) list(20.100000 2.100000)) list("met4" "drawing" list(19.400000 1.400000) list(20.600000 2.600000)) list("met5" "drawing" list(19.200000 -4.800000) list(20.800000 2.800000)) list("met5" "drawing" list(-10.800000 -4.800000) list(-3.200000 -3.200000)) list("met5" "drawing" list(19.200000 -4.800000) list(26.800000 -3.200000))) list(list("TOP" "met4" list(2.000000 6.000000)) list("BITA" "met5" list(-10.000000 -4.000000)) list("BITB" "met5" list(26.000000 -4.000000))))
p2c4Layout("p2c4_access_short_r1" list(list("met3" "drawing" list(-0.400000 -0.400000) list(4.400000 4.400000)) list("capm" "drawing" list(0.000000 0.000000) list(4.000000 4.000000)) list("met4" "drawing" list(0.100000 0.100000) list(3.900000 3.900000)) list("via3" "drawing" list(0.300000 0.300000) list(0.500000 0.500000)) list("via3" "drawing" list(0.300000 0.700000) list(0.500000 0.900000)) list("via3" "drawing" list(0.300000 1.100000) list(0.500000 1.300000)) list("via3" "drawing" list(0.300000 1.500000) list(0.500000 1.700000)) list("via3" "drawing" list(0.300000 1.900000) list(0.500000 2.100000)) list("via3" "drawing" list(0.300000 2.300000) list(0.500000 2.500000)) list("via3" "drawing" list(0.300000 2.700000) list(0.500000 2.900000)) list("via3" "drawing" list(0.300000 3.100000) list(0.500000 3.300000)) list("via3" "drawing" list(0.300000 3.500000) list(0.500000 3.700000)) list("via3" "drawing" list(0.700000 0.300000) list(0.900000 0.500000)) list("via3" "drawing" list(0.700000 0.700000) list(0.900000 0.900000)) list("via3" "drawing" list(0.700000 1.100000) list(0.900000 1.300000)) list("via3" "drawing" list(0.700000 1.500000) list(0.900000 1.700000)) list("via3" "drawing" list(0.700000 1.900000) list(0.900000 2.100000)) list("via3" "drawing" list(0.700000 2.300000) list(0.900000 2.500000)) list("via3" "drawing" list(0.700000 2.700000) list(0.900000 2.900000)) list("via3" "drawing" list(0.700000 3.100000) list(0.900000 3.300000)) list("via3" "drawing" list(0.700000 3.500000) list(0.900000 3.700000)) list("via3" "drawing" list(1.100000 0.300000) list(1.300000 0.500000)) list("via3" "drawing" list(1.100000 0.700000) list(1.300000 0.900000)) list("via3" "drawing" list(1.100000 1.100000) list(1.300000 1.300000)) list("via3" "drawing" list(1.100000 1.500000) list(1.300000 1.700000)) list("via3" "drawing" list(1.100000 1.900000) list(1.300000 2.100000)) list("via3" "drawing" list(1.100000 2.300000) list(1.300000 2.500000)) list("via3" "drawing" list(1.100000 2.700000) list(1.300000 2.900000)) list("via3" "drawing" list(1.100000 3.100000) list(1.300000 3.300000)) list("via3" "drawing" list(1.100000 3.500000) list(1.300000 3.700000)) list("via3" "drawing" list(1.500000 0.300000) list(1.700000 0.500000)) list("via3" "drawing" list(1.500000 0.700000) list(1.700000 0.900000)) list("via3" "drawing" list(1.500000 1.100000) list(1.700000 1.300000)) list("via3" "drawing" list(1.500000 1.500000) list(1.700000 1.700000)) list("via3" "drawing" list(1.500000 1.900000) list(1.700000 2.100000)) list("via3" "drawing" list(1.500000 2.300000) list(1.700000 2.500000)) list("via3" "drawing" list(1.500000 2.700000) list(1.700000 2.900000)) list("via3" "drawing" list(1.500000 3.100000) list(1.700000 3.300000)) list("via3" "drawing" list(1.500000 3.500000) list(1.700000 3.700000)) list("via3" "drawing" list(1.900000 0.300000) list(2.100000 0.500000)) list("via3" "drawing" list(1.900000 0.700000) list(2.100000 0.900000)) list("via3" "drawing" list(1.900000 1.100000) list(2.100000 1.300000)) list("via3" "drawing" list(1.900000 1.500000) list(2.100000 1.700000)) list("via3" "drawing" list(1.900000 1.900000) list(2.100000 2.100000)) list("via3" "drawing" list(1.900000 2.300000) list(2.100000 2.500000)) list("via3" "drawing" list(1.900000 2.700000) list(2.100000 2.900000)) list("via3" "drawing" list(1.900000 3.100000) list(2.100000 3.300000)) list("via3" "drawing" list(1.900000 3.500000) list(2.100000 3.700000)) list("via3" "drawing" list(2.300000 0.300000) list(2.500000 0.500000)) list("via3" "drawing" list(2.300000 0.700000) list(2.500000 0.900000)) list("via3" "drawing" list(2.300000 1.100000) list(2.500000 1.300000)) list("via3" "drawing" list(2.300000 1.500000) list(2.500000 1.700000)) list("via3" "drawing" list(2.300000 1.900000) list(2.500000 2.100000)) list("via3" "drawing" list(2.300000 2.300000) list(2.500000 2.500000)) list("via3" "drawing" list(2.300000 2.700000) list(2.500000 2.900000)) list("via3" "drawing" list(2.300000 3.100000) list(2.500000 3.300000)) list("via3" "drawing" list(2.300000 3.500000) list(2.500000 3.700000)) list("via3" "drawing" list(2.700000 0.300000) list(2.900000 0.500000)) list("via3" "drawing" list(2.700000 0.700000) list(2.900000 0.900000)) list("via3" "drawing" list(2.700000 1.100000) list(2.900000 1.300000)) list("via3" "drawing" list(2.700000 1.500000) list(2.900000 1.700000)) list("via3" "drawing" list(2.700000 1.900000) list(2.900000 2.100000)) list("via3" "drawing" list(2.700000 2.300000) list(2.900000 2.500000)) list("via3" "drawing" list(2.700000 2.700000) list(2.900000 2.900000)) list("via3" "drawing" list(2.700000 3.100000) list(2.900000 3.300000)) list("via3" "drawing" list(2.700000 3.500000) list(2.900000 3.700000)) list("via3" "drawing" list(3.100000 0.300000) list(3.300000 0.500000)) list("via3" "drawing" list(3.100000 0.700000) list(3.300000 0.900000)) list("via3" "drawing" list(3.100000 1.100000) list(3.300000 1.300000)) list("via3" "drawing" list(3.100000 1.500000) list(3.300000 1.700000)) list("via3" "drawing" list(3.100000 1.900000) list(3.300000 2.100000)) list("via3" "drawing" list(3.100000 2.300000) list(3.300000 2.500000)) list("via3" "drawing" list(3.100000 2.700000) list(3.300000 2.900000)) list("via3" "drawing" list(3.100000 3.100000) list(3.300000 3.300000)) list("via3" "drawing" list(3.100000 3.500000) list(3.300000 3.700000)) list("via3" "drawing" list(3.500000 0.300000) list(3.700000 0.500000)) list("via3" "drawing" list(3.500000 0.700000) list(3.700000 0.900000)) list("via3" "drawing" list(3.500000 1.100000) list(3.700000 1.300000)) list("via3" "drawing" list(3.500000 1.500000) list(3.700000 1.700000)) list("via3" "drawing" list(3.500000 1.900000) list(3.700000 2.100000)) list("via3" "drawing" list(3.500000 2.300000) list(3.700000 2.500000)) list("via3" "drawing" list(3.500000 2.700000) list(3.700000 2.900000)) list("via3" "drawing" list(3.500000 3.100000) list(3.700000 3.300000)) list("via3" "drawing" list(3.500000 3.500000) list(3.700000 3.700000)) list("met3" "drawing" list(11.600000 -0.400000) list(16.400000 4.400000)) list("capm" "drawing" list(12.000000 0.000000) list(16.000000 4.000000)) list("met4" "drawing" list(12.100000 0.100000) list(15.900000 3.900000)) list("via3" "drawing" list(12.300000 0.300000) list(12.500000 0.500000)) list("via3" "drawing" list(12.300000 0.700000) list(12.500000 0.900000)) list("via3" "drawing" list(12.300000 1.100000) list(12.500000 1.300000)) list("via3" "drawing" list(12.300000 1.500000) list(12.500000 1.700000)) list("via3" "drawing" list(12.300000 1.900000) list(12.500000 2.100000)) list("via3" "drawing" list(12.300000 2.300000) list(12.500000 2.500000)) list("via3" "drawing" list(12.300000 2.700000) list(12.500000 2.900000)) list("via3" "drawing" list(12.300000 3.100000) list(12.500000 3.300000)) list("via3" "drawing" list(12.300000 3.500000) list(12.500000 3.700000)) list("via3" "drawing" list(12.700000 0.300000) list(12.900000 0.500000)) list("via3" "drawing" list(12.700000 0.700000) list(12.900000 0.900000)) list("via3" "drawing" list(12.700000 1.100000) list(12.900000 1.300000)) list("via3" "drawing" list(12.700000 1.500000) list(12.900000 1.700000)) list("via3" "drawing" list(12.700000 1.900000) list(12.900000 2.100000)) list("via3" "drawing" list(12.700000 2.300000) list(12.900000 2.500000)) list("via3" "drawing" list(12.700000 2.700000) list(12.900000 2.900000)) list("via3" "drawing" list(12.700000 3.100000) list(12.900000 3.300000)) list("via3" "drawing" list(12.700000 3.500000) list(12.900000 3.700000)) list("via3" "drawing" list(13.100000 0.300000) list(13.300000 0.500000)) list("via3" "drawing" list(13.100000 0.700000) list(13.300000 0.900000)) list("via3" "drawing" list(13.100000 1.100000) list(13.300000 1.300000)) list("via3" "drawing" list(13.100000 1.500000) list(13.300000 1.700000)) list("via3" "drawing" list(13.100000 1.900000) list(13.300000 2.100000)) list("via3" "drawing" list(13.100000 2.300000) list(13.300000 2.500000)) list("via3" "drawing" list(13.100000 2.700000) list(13.300000 2.900000)) list("via3" "drawing" list(13.100000 3.100000) list(13.300000 3.300000)) list("via3" "drawing" list(13.100000 3.500000) list(13.300000 3.700000)) list("via3" "drawing" list(13.500000 0.300000) list(13.700000 0.500000)) list("via3" "drawing" list(13.500000 0.700000) list(13.700000 0.900000)) list("via3" "drawing" list(13.500000 1.100000) list(13.700000 1.300000)) list("via3" "drawing" list(13.500000 1.500000) list(13.700000 1.700000)) list("via3" "drawing" list(13.500000 1.900000) list(13.700000 2.100000)) list("via3" "drawing" list(13.500000 2.300000) list(13.700000 2.500000)) list("via3" "drawing" list(13.500000 2.700000) list(13.700000 2.900000)) list("via3" "drawing" list(13.500000 3.100000) list(13.700000 3.300000)) list("via3" "drawing" list(13.500000 3.500000) list(13.700000 3.700000)) list("via3" "drawing" list(13.900000 0.300000) list(14.100000 0.500000)) list("via3" "drawing" list(13.900000 0.700000) list(14.100000 0.900000)) list("via3" "drawing" list(13.900000 1.100000) list(14.100000 1.300000)) list("via3" "drawing" list(13.900000 1.500000) list(14.100000 1.700000)) list("via3" "drawing" list(13.900000 1.900000) list(14.100000 2.100000)) list("via3" "drawing" list(13.900000 2.300000) list(14.100000 2.500000)) list("via3" "drawing" list(13.900000 2.700000) list(14.100000 2.900000)) list("via3" "drawing" list(13.900000 3.100000) list(14.100000 3.300000)) list("via3" "drawing" list(13.900000 3.500000) list(14.100000 3.700000)) list("via3" "drawing" list(14.300000 0.300000) list(14.500000 0.500000)) list("via3" "drawing" list(14.300000 0.700000) list(14.500000 0.900000)) list("via3" "drawing" list(14.300000 1.100000) list(14.500000 1.300000)) list("via3" "drawing" list(14.300000 1.500000) list(14.500000 1.700000)) list("via3" "drawing" list(14.300000 1.900000) list(14.500000 2.100000)) list("via3" "drawing" list(14.300000 2.300000) list(14.500000 2.500000)) list("via3" "drawing" list(14.300000 2.700000) list(14.500000 2.900000)) list("via3" "drawing" list(14.300000 3.100000) list(14.500000 3.300000)) list("via3" "drawing" list(14.300000 3.500000) list(14.500000 3.700000)) list("via3" "drawing" list(14.700000 0.300000) list(14.900000 0.500000)) list("via3" "drawing" list(14.700000 0.700000) list(14.900000 0.900000)) list("via3" "drawing" list(14.700000 1.100000) list(14.900000 1.300000)) list("via3" "drawing" list(14.700000 1.500000) list(14.900000 1.700000)) list("via3" "drawing" list(14.700000 1.900000) list(14.900000 2.100000)) list("via3" "drawing" list(14.700000 2.300000) list(14.900000 2.500000)) list("via3" "drawing" list(14.700000 2.700000) list(14.900000 2.900000)) list("via3" "drawing" list(14.700000 3.100000) list(14.900000 3.300000)) list("via3" "drawing" list(14.700000 3.500000) list(14.900000 3.700000)) list("via3" "drawing" list(15.100000 0.300000) list(15.300000 0.500000)) list("via3" "drawing" list(15.100000 0.700000) list(15.300000 0.900000)) list("via3" "drawing" list(15.100000 1.100000) list(15.300000 1.300000)) list("via3" "drawing" list(15.100000 1.500000) list(15.300000 1.700000)) list("via3" "drawing" list(15.100000 1.900000) list(15.300000 2.100000)) list("via3" "drawing" list(15.100000 2.300000) list(15.300000 2.500000)) list("via3" "drawing" list(15.100000 2.700000) list(15.300000 2.900000)) list("via3" "drawing" list(15.100000 3.100000) list(15.300000 3.300000)) list("via3" "drawing" list(15.100000 3.500000) list(15.300000 3.700000)) list("via3" "drawing" list(15.500000 0.300000) list(15.700000 0.500000)) list("via3" "drawing" list(15.500000 0.700000) list(15.700000 0.900000)) list("via3" "drawing" list(15.500000 1.100000) list(15.700000 1.300000)) list("via3" "drawing" list(15.500000 1.500000) list(15.700000 1.700000)) list("via3" "drawing" list(15.500000 1.900000) list(15.700000 2.100000)) list("via3" "drawing" list(15.500000 2.300000) list(15.700000 2.500000)) list("via3" "drawing" list(15.500000 2.700000) list(15.700000 2.900000)) list("via3" "drawing" list(15.500000 3.100000) list(15.700000 3.300000)) list("via3" "drawing" list(15.500000 3.500000) list(15.700000 3.700000)) list("met4" "drawing" list(3.700000 1.700000) list(12.300000 2.300000)) list("met4" "drawing" list(1.700000 3.700000) list(2.300000 6.300000)) list("met3" "drawing" list(-4.300000 1.700000) list(-0.200000 2.300000)) list("met3" "drawing" list(16.200000 1.700000) list(20.300000 2.300000)) list("met3" "drawing" list(-4.200000 1.800000) list(-3.800000 2.200000)) list("via3" "drawing" list(-4.100000 1.900000) list(-3.900000 2.100000)) list("met4" "drawing" list(-4.600000 1.400000) list(-3.400000 2.600000)) list("via4" "drawing" list(-4.400000 1.600000) list(-3.600000 2.400000)) list("met5" "drawing" list(-4.800000 -4.800000) list(-3.200000 2.800000)) list("met3" "drawing" list(19.800000 1.800000) list(20.200000 2.200000)) list("via3" "drawing" list(19.900000 1.900000) list(20.100000 2.100000)) list("met4" "drawing" list(19.400000 1.400000) list(20.600000 2.600000)) list("via4" "drawing" list(19.600000 1.600000) list(20.400000 2.400000)) list("met5" "drawing" list(19.200000 -4.800000) list(20.800000 2.800000)) list("met5" "drawing" list(-10.800000 -4.800000) list(-3.200000 -3.200000)) list("met5" "drawing" list(19.200000 -4.800000) list(26.800000 -3.200000)) list("met3" "drawing" list(4.200000 -0.300000) list(11.800000 0.300000))) list(list("TOP" "met4" list(2.000000 6.000000)) list("BITA" "met5" list(-10.000000 -4.000000)) list("BITB" "met5" list(26.000000 -4.000000))))
printf("P2C4_ACCESS_CREATED_NOT_VERIFIED\n")
