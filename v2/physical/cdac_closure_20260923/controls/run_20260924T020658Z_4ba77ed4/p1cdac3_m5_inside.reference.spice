.subckt p1cdac3_m5_inside_flat TOP BIT AGG
X0 BIT TOP sky130_fd_pr__cap_mim_m3_1 w=3 l=3
X1 BIT TOP sky130_fd_pr__cap_mim_m3_1 w=3 l=3
X2 BIT TOP sky130_fd_pr__cap_mim_m3_1 w=3 l=3
X3 BIT TOP sky130_fd_pr__cap_mim_m3_1 w=3 l=3
X4 BIT TOP sky130_fd_pr__cap_mim_m3_1 w=3 l=3
X5 BIT TOP sky130_fd_pr__cap_mim_m3_1 w=3 l=3
X6 BIT TOP sky130_fd_pr__cap_mim_m3_1 w=3 l=3
X7 BIT TOP sky130_fd_pr__cap_mim_m3_1 w=3 l=3
X8 BIT TOP sky130_fd_pr__cap_mim_m3_1 w=3 l=3
X9 BIT TOP sky130_fd_pr__cap_mim_m3_1 w=3 l=3
X10 BIT TOP sky130_fd_pr__cap_mim_m3_1 w=3 l=3
X11 BIT TOP sky130_fd_pr__cap_mim_m3_1 w=3 l=3
X12 BIT TOP sky130_fd_pr__cap_mim_m3_1 w=3 l=3
X13 BIT TOP sky130_fd_pr__cap_mim_m3_1 w=3 l=3
X14 BIT TOP sky130_fd_pr__cap_mim_m3_1 w=3 l=3
X15 BIT TOP sky130_fd_pr__cap_mim_m3_1 w=3 l=3
X16 BIT TOP sky130_fd_pr__cap_mim_m3_1 w=3 l=3
X17 BIT TOP sky130_fd_pr__cap_mim_m3_1 w=3 l=3
X18 BIT TOP sky130_fd_pr__cap_mim_m3_1 w=3 l=3
X19 BIT TOP sky130_fd_pr__cap_mim_m3_1 w=3 l=3
X20 BIT TOP sky130_fd_pr__cap_mim_m3_1 w=3 l=3
X21 BIT TOP sky130_fd_pr__cap_mim_m3_1 w=3 l=3
X22 BIT TOP sky130_fd_pr__cap_mim_m3_1 w=3 l=3
X23 BIT TOP sky130_fd_pr__cap_mim_m3_1 w=3 l=3
X24 BIT TOP sky130_fd_pr__cap_mim_m3_1 w=3 l=3
X25 BIT TOP sky130_fd_pr__cap_mim_m3_1 w=3 l=3
X26 BIT TOP sky130_fd_pr__cap_mim_m3_1 w=3 l=3
X27 BIT TOP sky130_fd_pr__cap_mim_m3_1 w=3 l=3
X28 BIT TOP sky130_fd_pr__cap_mim_m3_1 w=3 l=3
X29 BIT TOP sky130_fd_pr__cap_mim_m3_1 w=3 l=3
X30 BIT TOP sky130_fd_pr__cap_mim_m3_1 w=3 l=3
X31 BIT TOP sky130_fd_pr__cap_mim_m3_1 w=3 l=3
X32 BIT TOP sky130_fd_pr__cap_mim_m3_1 w=3 l=3
X33 BIT TOP sky130_fd_pr__cap_mim_m3_1 w=3 l=3
X34 BIT TOP sky130_fd_pr__cap_mim_m3_1 w=3 l=3
X35 BIT TOP sky130_fd_pr__cap_mim_m3_1 w=3 l=3
X36 BIT TOP sky130_fd_pr__cap_mim_m3_1 w=3 l=3
X37 BIT TOP sky130_fd_pr__cap_mim_m3_1 w=3 l=3
X38 BIT TOP sky130_fd_pr__cap_mim_m3_1 w=3 l=3
X39 BIT TOP sky130_fd_pr__cap_mim_m3_1 w=3 l=3
X40 BIT TOP sky130_fd_pr__cap_mim_m3_1 w=3 l=3
X41 BIT TOP sky130_fd_pr__cap_mim_m3_1 w=3 l=3
X42 BIT TOP sky130_fd_pr__cap_mim_m3_1 w=3 l=3
X43 BIT TOP sky130_fd_pr__cap_mim_m3_1 w=3 l=3
X44 BIT TOP sky130_fd_pr__cap_mim_m3_1 w=3 l=3
X45 BIT TOP sky130_fd_pr__cap_mim_m3_1 w=3 l=3
X46 BIT TOP sky130_fd_pr__cap_mim_m3_1 w=3 l=3
X47 BIT TOP sky130_fd_pr__cap_mim_m3_1 w=3 l=3
X48 BIT TOP sky130_fd_pr__cap_mim_m3_1 w=3 l=3
X49 BIT TOP sky130_fd_pr__cap_mim_m3_1 w=3 l=3
X50 BIT TOP sky130_fd_pr__cap_mim_m3_1 w=3 l=3
X51 BIT TOP sky130_fd_pr__cap_mim_m3_1 w=3 l=3
X52 BIT TOP sky130_fd_pr__cap_mim_m3_1 w=3 l=3
X53 BIT TOP sky130_fd_pr__cap_mim_m3_1 w=3 l=3
X54 BIT TOP sky130_fd_pr__cap_mim_m3_1 w=3 l=3
X55 BIT TOP sky130_fd_pr__cap_mim_m3_1 w=3 l=3
X56 BIT TOP sky130_fd_pr__cap_mim_m3_1 w=3 l=3
X57 BIT TOP sky130_fd_pr__cap_mim_m3_1 w=3 l=3
X58 BIT TOP sky130_fd_pr__cap_mim_m3_1 w=3 l=3
X59 BIT TOP sky130_fd_pr__cap_mim_m3_1 w=3 l=3
X60 BIT TOP sky130_fd_pr__cap_mim_m3_1 w=3 l=3
X61 BIT TOP sky130_fd_pr__cap_mim_m3_1 w=3 l=3
X62 BIT TOP sky130_fd_pr__cap_mim_m3_1 w=3 l=3
X63 BIT TOP sky130_fd_pr__cap_mim_m3_1 w=3 l=3
X64 BIT TOP sky130_fd_pr__cap_mim_m3_1 w=3 l=3
X65 BIT TOP sky130_fd_pr__cap_mim_m3_1 w=3 l=3
X66 BIT TOP sky130_fd_pr__cap_mim_m3_1 w=3 l=3
X67 BIT TOP sky130_fd_pr__cap_mim_m3_1 w=3 l=3
X68 BIT TOP sky130_fd_pr__cap_mim_m3_1 w=3 l=3
X69 BIT TOP sky130_fd_pr__cap_mim_m3_1 w=3 l=3
X70 BIT TOP sky130_fd_pr__cap_mim_m3_1 w=3 l=3
X71 BIT TOP sky130_fd_pr__cap_mim_m3_1 w=3 l=3
X72 BIT TOP sky130_fd_pr__cap_mim_m3_1 w=3 l=3
X73 BIT TOP sky130_fd_pr__cap_mim_m3_1 w=3 l=3
X74 BIT TOP sky130_fd_pr__cap_mim_m3_1 w=3 l=3
X75 BIT TOP sky130_fd_pr__cap_mim_m3_1 w=3 l=3
X76 BIT TOP sky130_fd_pr__cap_mim_m3_1 w=3 l=3
X77 BIT TOP sky130_fd_pr__cap_mim_m3_1 w=3 l=3
X78 BIT TOP sky130_fd_pr__cap_mim_m3_1 w=3 l=3
X79 BIT TOP sky130_fd_pr__cap_mim_m3_1 w=3 l=3
X80 BIT TOP sky130_fd_pr__cap_mim_m3_1 w=3 l=3
X81 BIT TOP sky130_fd_pr__cap_mim_m3_1 w=3 l=3
X82 BIT TOP sky130_fd_pr__cap_mim_m3_1 w=3 l=3
X83 BIT TOP sky130_fd_pr__cap_mim_m3_1 w=3 l=3
X84 BIT TOP sky130_fd_pr__cap_mim_m3_1 w=3 l=3
X85 BIT TOP sky130_fd_pr__cap_mim_m3_1 w=3 l=3
X86 BIT TOP sky130_fd_pr__cap_mim_m3_1 w=3 l=3
X87 BIT TOP sky130_fd_pr__cap_mim_m3_1 w=3 l=3
X88 BIT TOP sky130_fd_pr__cap_mim_m3_1 w=3 l=3
X89 BIT TOP sky130_fd_pr__cap_mim_m3_1 w=3 l=3
X90 BIT TOP sky130_fd_pr__cap_mim_m3_1 w=3 l=3
X91 BIT TOP sky130_fd_pr__cap_mim_m3_1 w=3 l=3
X92 BIT TOP sky130_fd_pr__cap_mim_m3_1 w=3 l=3
X93 BIT TOP sky130_fd_pr__cap_mim_m3_1 w=3 l=3
X94 BIT TOP sky130_fd_pr__cap_mim_m3_1 w=3 l=3
X95 BIT TOP sky130_fd_pr__cap_mim_m3_1 w=3 l=3
X96 BIT TOP sky130_fd_pr__cap_mim_m3_1 w=3 l=3
X97 BIT TOP sky130_fd_pr__cap_mim_m3_1 w=3 l=3
X98 BIT TOP sky130_fd_pr__cap_mim_m3_1 w=3 l=3
X99 BIT TOP sky130_fd_pr__cap_mim_m3_1 w=3 l=3
X100 BIT TOP sky130_fd_pr__cap_mim_m3_1 w=3 l=3
X101 BIT TOP sky130_fd_pr__cap_mim_m3_1 w=3 l=3
X102 BIT TOP sky130_fd_pr__cap_mim_m3_1 w=3 l=3
X103 BIT TOP sky130_fd_pr__cap_mim_m3_1 w=3 l=3
X104 BIT TOP sky130_fd_pr__cap_mim_m3_1 w=3 l=3
X105 BIT TOP sky130_fd_pr__cap_mim_m3_1 w=3 l=3
X106 BIT TOP sky130_fd_pr__cap_mim_m3_1 w=3 l=3
X107 BIT TOP sky130_fd_pr__cap_mim_m3_1 w=3 l=3
X108 BIT TOP sky130_fd_pr__cap_mim_m3_1 w=3 l=3
X109 BIT TOP sky130_fd_pr__cap_mim_m3_1 w=3 l=3
X110 BIT TOP sky130_fd_pr__cap_mim_m3_1 w=3 l=3
X111 BIT TOP sky130_fd_pr__cap_mim_m3_1 w=3 l=3
X112 BIT TOP sky130_fd_pr__cap_mim_m3_1 w=3 l=3
X113 BIT TOP sky130_fd_pr__cap_mim_m3_1 w=3 l=3
X114 BIT TOP sky130_fd_pr__cap_mim_m3_1 w=3 l=3
X115 BIT TOP sky130_fd_pr__cap_mim_m3_1 w=3 l=3
X116 BIT TOP sky130_fd_pr__cap_mim_m3_1 w=3 l=3
X117 BIT TOP sky130_fd_pr__cap_mim_m3_1 w=3 l=3
X118 BIT TOP sky130_fd_pr__cap_mim_m3_1 w=3 l=3
X119 BIT TOP sky130_fd_pr__cap_mim_m3_1 w=3 l=3
X120 BIT TOP sky130_fd_pr__cap_mim_m3_1 w=3 l=3
X121 BIT TOP sky130_fd_pr__cap_mim_m3_1 w=3 l=3
X122 BIT TOP sky130_fd_pr__cap_mim_m3_1 w=3 l=3
X123 BIT TOP sky130_fd_pr__cap_mim_m3_1 w=3 l=3
X124 BIT TOP sky130_fd_pr__cap_mim_m3_1 w=3 l=3
X125 BIT TOP sky130_fd_pr__cap_mim_m3_1 w=3 l=3
X126 BIT TOP sky130_fd_pr__cap_mim_m3_1 w=3 l=3
X127 BIT TOP sky130_fd_pr__cap_mim_m3_1 w=3 l=3
.ends
