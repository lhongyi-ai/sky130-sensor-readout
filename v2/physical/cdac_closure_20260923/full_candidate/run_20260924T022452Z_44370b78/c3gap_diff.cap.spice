* NGSPICE file created from c3gap_diff_flat.ext - technology: sky130A

.subckt c3gap_diff_flat P_TOP P_B11 P_B10 P_B9 P_B8 P_B7 P_B6 P_B5 P_B4 P_B3 P_B2
+ P_B1 P_B0 P_DUMMY P_EDGE_BIAS N_TOP N_B11 N_B10 N_B9 N_B8 N_B7 N_B6 N_B5 N_B4 N_B3
+ N_B2 N_B1 N_B0 N_DUMMY N_EDGE_BIAS
X0 N_B7 N_TOP sky130_fd_pr__cap_mim_m3_1 l=3 w=3
X1 P_EDGE_BIAS P_EDGE_BIAS sky130_fd_pr__cap_mim_m3_1 l=3 w=3
X2 P_B7 P_TOP sky130_fd_pr__cap_mim_m3_1 l=3 w=3
X3 N_B11 N_TOP sky130_fd_pr__cap_mim_m3_1 l=3 w=3
X4 N_B11 N_TOP sky130_fd_pr__cap_mim_m3_1 l=3 w=3
X5 P_B11 P_TOP sky130_fd_pr__cap_mim_m3_1 l=3 w=3
X6 N_B11 N_TOP sky130_fd_pr__cap_mim_m3_1 l=3 w=3
X7 N_B11 N_TOP sky130_fd_pr__cap_mim_m3_1 l=3 w=3
X8 N_B9 N_TOP sky130_fd_pr__cap_mim_m3_1 l=3 w=3
X9 P_B11 P_TOP sky130_fd_pr__cap_mim_m3_1 l=3 w=3
X10 P_B10 P_TOP sky130_fd_pr__cap_mim_m3_1 l=3 w=3
X11 P_B10 P_TOP sky130_fd_pr__cap_mim_m3_1 l=3 w=3
X12 N_B10 N_TOP sky130_fd_pr__cap_mim_m3_1 l=3 w=3
X13 N_B11 N_TOP sky130_fd_pr__cap_mim_m3_1 l=3 w=3
X14 N_B10 N_TOP sky130_fd_pr__cap_mim_m3_1 l=3 w=3
X15 N_B11 N_TOP sky130_fd_pr__cap_mim_m3_1 l=3 w=3
X16 N_B6 N_TOP sky130_fd_pr__cap_mim_m3_1 l=3 w=3
X17 P_B3 P_TOP sky130_fd_pr__cap_mim_m3_1 l=3 w=3
X18 N_B8 N_TOP sky130_fd_pr__cap_mim_m3_1 l=3 w=3
X19 P_B11 P_TOP sky130_fd_pr__cap_mim_m3_1 l=3 w=3
X20 N_B10 N_TOP sky130_fd_pr__cap_mim_m3_1 l=3 w=3
X21 N_EDGE_BIAS N_EDGE_BIAS sky130_fd_pr__cap_mim_m3_1 l=3 w=3
X22 N_B9 N_TOP sky130_fd_pr__cap_mim_m3_1 l=3 w=3
X23 P_B11 P_TOP sky130_fd_pr__cap_mim_m3_1 l=3 w=3
X24 P_EDGE_BIAS P_EDGE_BIAS sky130_fd_pr__cap_mim_m3_1 l=3 w=3
X25 P_B11 P_TOP sky130_fd_pr__cap_mim_m3_1 l=3 w=3
X26 N_B10 N_TOP sky130_fd_pr__cap_mim_m3_1 l=3 w=3
X27 N_B11 N_TOP sky130_fd_pr__cap_mim_m3_1 l=3 w=3
X28 N_B9 N_TOP sky130_fd_pr__cap_mim_m3_1 l=3 w=3
X29 N_B10 N_TOP sky130_fd_pr__cap_mim_m3_1 l=3 w=3
X30 P_EDGE_BIAS P_EDGE_BIAS sky130_fd_pr__cap_mim_m3_1 l=3 w=3
X31 P_EDGE_BIAS P_EDGE_BIAS sky130_fd_pr__cap_mim_m3_1 l=3 w=3
X32 N_B10 N_TOP sky130_fd_pr__cap_mim_m3_1 l=3 w=3
X33 N_EDGE_BIAS N_EDGE_BIAS sky130_fd_pr__cap_mim_m3_1 l=3 w=3
X34 P_B11 P_TOP sky130_fd_pr__cap_mim_m3_1 l=3 w=3
X35 N_B11 N_TOP sky130_fd_pr__cap_mim_m3_1 l=3 w=3
X36 P_B11 P_TOP sky130_fd_pr__cap_mim_m3_1 l=3 w=3
X37 P_B11 P_TOP sky130_fd_pr__cap_mim_m3_1 l=3 w=3
X38 N_B10 N_TOP sky130_fd_pr__cap_mim_m3_1 l=3 w=3
X39 P_B11 P_TOP sky130_fd_pr__cap_mim_m3_1 l=3 w=3
X40 P_B9 P_TOP sky130_fd_pr__cap_mim_m3_1 l=3 w=3
X41 P_B11 P_TOP sky130_fd_pr__cap_mim_m3_1 l=3 w=3
X42 N_EDGE_BIAS N_EDGE_BIAS sky130_fd_pr__cap_mim_m3_1 l=3 w=3
X43 N_B11 N_TOP sky130_fd_pr__cap_mim_m3_1 l=3 w=3
X44 P_B9 P_TOP sky130_fd_pr__cap_mim_m3_1 l=3 w=3
X45 N_B11 N_TOP sky130_fd_pr__cap_mim_m3_1 l=3 w=3
X46 N_B11 N_TOP sky130_fd_pr__cap_mim_m3_1 l=3 w=3
X47 P_B10 P_TOP sky130_fd_pr__cap_mim_m3_1 l=3 w=3
X48 P_B11 P_TOP sky130_fd_pr__cap_mim_m3_1 l=3 w=3
X49 N_B11 N_TOP sky130_fd_pr__cap_mim_m3_1 l=3 w=3
X50 N_B10 N_TOP sky130_fd_pr__cap_mim_m3_1 l=3 w=3
X51 N_EDGE_BIAS N_EDGE_BIAS sky130_fd_pr__cap_mim_m3_1 l=3 w=3
X52 N_B11 N_TOP sky130_fd_pr__cap_mim_m3_1 l=3 w=3
X53 P_B11 P_TOP sky130_fd_pr__cap_mim_m3_1 l=3 w=3
X54 P_B11 P_TOP sky130_fd_pr__cap_mim_m3_1 l=3 w=3
X55 P_B11 P_TOP sky130_fd_pr__cap_mim_m3_1 l=3 w=3
X56 N_B9 N_TOP sky130_fd_pr__cap_mim_m3_1 l=3 w=3
X57 P_B9 P_TOP sky130_fd_pr__cap_mim_m3_1 l=3 w=3
X58 N_B11 N_TOP sky130_fd_pr__cap_mim_m3_1 l=3 w=3
X59 P_B10 P_TOP sky130_fd_pr__cap_mim_m3_1 l=3 w=3
X60 P_B11 P_TOP sky130_fd_pr__cap_mim_m3_1 l=3 w=3
X61 P_B10 P_TOP sky130_fd_pr__cap_mim_m3_1 l=3 w=3
X62 P_B11 P_TOP sky130_fd_pr__cap_mim_m3_1 l=3 w=3
X63 N_B7 N_TOP sky130_fd_pr__cap_mim_m3_1 l=3 w=3
X64 P_B7 P_TOP sky130_fd_pr__cap_mim_m3_1 l=3 w=3
X65 N_B11 N_TOP sky130_fd_pr__cap_mim_m3_1 l=3 w=3
X66 P_B10 P_TOP sky130_fd_pr__cap_mim_m3_1 l=3 w=3
X67 P_B11 P_TOP sky130_fd_pr__cap_mim_m3_1 l=3 w=3
X68 P_EDGE_BIAS P_EDGE_BIAS sky130_fd_pr__cap_mim_m3_1 l=3 w=3
X69 P_B11 P_TOP sky130_fd_pr__cap_mim_m3_1 l=3 w=3
X70 P_B11 P_TOP sky130_fd_pr__cap_mim_m3_1 l=3 w=3
X71 N_B9 N_TOP sky130_fd_pr__cap_mim_m3_1 l=3 w=3
X72 N_B9 N_TOP sky130_fd_pr__cap_mim_m3_1 l=3 w=3
X73 N_B11 N_TOP sky130_fd_pr__cap_mim_m3_1 l=3 w=3
X74 P_B9 P_TOP sky130_fd_pr__cap_mim_m3_1 l=3 w=3
X75 N_B9 N_TOP sky130_fd_pr__cap_mim_m3_1 l=3 w=3
X76 N_B8 N_TOP sky130_fd_pr__cap_mim_m3_1 l=3 w=3
X77 P_B11 P_TOP sky130_fd_pr__cap_mim_m3_1 l=3 w=3
X78 N_B8 N_TOP sky130_fd_pr__cap_mim_m3_1 l=3 w=3
X79 P_B8 P_TOP sky130_fd_pr__cap_mim_m3_1 l=3 w=3
X80 N_B10 N_TOP sky130_fd_pr__cap_mim_m3_1 l=3 w=3
X81 P_B10 P_TOP sky130_fd_pr__cap_mim_m3_1 l=3 w=3
X82 P_B11 P_TOP sky130_fd_pr__cap_mim_m3_1 l=3 w=3
X83 N_B9 N_TOP sky130_fd_pr__cap_mim_m3_1 l=3 w=3
X84 P_EDGE_BIAS P_EDGE_BIAS sky130_fd_pr__cap_mim_m3_1 l=3 w=3
X85 N_B11 N_TOP sky130_fd_pr__cap_mim_m3_1 l=3 w=3
X86 N_B11 N_TOP sky130_fd_pr__cap_mim_m3_1 l=3 w=3
X87 N_B7 N_TOP sky130_fd_pr__cap_mim_m3_1 l=3 w=3
X88 N_B11 N_TOP sky130_fd_pr__cap_mim_m3_1 l=3 w=3
X89 P_B9 P_TOP sky130_fd_pr__cap_mim_m3_1 l=3 w=3
X90 N_B8 N_TOP sky130_fd_pr__cap_mim_m3_1 l=3 w=3
X91 P_EDGE_BIAS P_EDGE_BIAS sky130_fd_pr__cap_mim_m3_1 l=3 w=3
X92 N_B10 N_TOP sky130_fd_pr__cap_mim_m3_1 l=3 w=3
X93 N_B11 N_TOP sky130_fd_pr__cap_mim_m3_1 l=3 w=3
X94 N_B8 N_TOP sky130_fd_pr__cap_mim_m3_1 l=3 w=3
X95 P_B11 P_TOP sky130_fd_pr__cap_mim_m3_1 l=3 w=3
X96 N_B10 N_TOP sky130_fd_pr__cap_mim_m3_1 l=3 w=3
X97 P_B10 P_TOP sky130_fd_pr__cap_mim_m3_1 l=3 w=3
X98 P_B11 P_TOP sky130_fd_pr__cap_mim_m3_1 l=3 w=3
X99 P_B11 P_TOP sky130_fd_pr__cap_mim_m3_1 l=3 w=3
X100 N_B11 N_TOP sky130_fd_pr__cap_mim_m3_1 l=3 w=3
X101 N_B11 N_TOP sky130_fd_pr__cap_mim_m3_1 l=3 w=3
X102 P_B11 P_TOP sky130_fd_pr__cap_mim_m3_1 l=3 w=3
X103 N_EDGE_BIAS N_EDGE_BIAS sky130_fd_pr__cap_mim_m3_1 l=3 w=3
X104 N_B11 N_TOP sky130_fd_pr__cap_mim_m3_1 l=3 w=3
X105 N_B9 N_TOP sky130_fd_pr__cap_mim_m3_1 l=3 w=3
X106 N_B11 N_TOP sky130_fd_pr__cap_mim_m3_1 l=3 w=3
X107 P_B9 P_TOP sky130_fd_pr__cap_mim_m3_1 l=3 w=3
X108 P_B8 P_TOP sky130_fd_pr__cap_mim_m3_1 l=3 w=3
X109 N_B11 N_TOP sky130_fd_pr__cap_mim_m3_1 l=3 w=3
X110 N_B9 N_TOP sky130_fd_pr__cap_mim_m3_1 l=3 w=3
X111 P_B11 P_TOP sky130_fd_pr__cap_mim_m3_1 l=3 w=3
X112 N_B11 N_TOP sky130_fd_pr__cap_mim_m3_1 l=3 w=3
X113 N_B5 N_TOP sky130_fd_pr__cap_mim_m3_1 l=3 w=3
X114 N_B11 N_TOP sky130_fd_pr__cap_mim_m3_1 l=3 w=3
X115 P_B10 P_TOP sky130_fd_pr__cap_mim_m3_1 l=3 w=3
X116 N_B11 N_TOP sky130_fd_pr__cap_mim_m3_1 l=3 w=3
X117 P_B11 P_TOP sky130_fd_pr__cap_mim_m3_1 l=3 w=3
X118 P_B7 P_TOP sky130_fd_pr__cap_mim_m3_1 l=3 w=3
X119 P_B9 P_TOP sky130_fd_pr__cap_mim_m3_1 l=3 w=3
X120 N_B11 N_TOP sky130_fd_pr__cap_mim_m3_1 l=3 w=3
X121 P_B7 P_TOP sky130_fd_pr__cap_mim_m3_1 l=3 w=3
X122 N_B11 N_TOP sky130_fd_pr__cap_mim_m3_1 l=3 w=3
X123 N_B11 N_TOP sky130_fd_pr__cap_mim_m3_1 l=3 w=3
X124 N_B9 N_TOP sky130_fd_pr__cap_mim_m3_1 l=3 w=3
X125 N_B11 N_TOP sky130_fd_pr__cap_mim_m3_1 l=3 w=3
X126 P_B10 P_TOP sky130_fd_pr__cap_mim_m3_1 l=3 w=3
X127 N_B10 N_TOP sky130_fd_pr__cap_mim_m3_1 l=3 w=3
X128 N_B10 N_TOP sky130_fd_pr__cap_mim_m3_1 l=3 w=3
X129 N_EDGE_BIAS N_EDGE_BIAS sky130_fd_pr__cap_mim_m3_1 l=3 w=3
X130 P_B8 P_TOP sky130_fd_pr__cap_mim_m3_1 l=3 w=3
X131 N_B10 N_TOP sky130_fd_pr__cap_mim_m3_1 l=3 w=3
X132 N_B10 N_TOP sky130_fd_pr__cap_mim_m3_1 l=3 w=3
X133 P_B10 P_TOP sky130_fd_pr__cap_mim_m3_1 l=3 w=3
X134 N_B5 N_TOP sky130_fd_pr__cap_mim_m3_1 l=3 w=3
X135 P_B5 P_TOP sky130_fd_pr__cap_mim_m3_1 l=3 w=3
X136 N_B11 N_TOP sky130_fd_pr__cap_mim_m3_1 l=3 w=3
X137 P_B11 P_TOP sky130_fd_pr__cap_mim_m3_1 l=3 w=3
X138 P_B9 P_TOP sky130_fd_pr__cap_mim_m3_1 l=3 w=3
X139 N_B10 N_TOP sky130_fd_pr__cap_mim_m3_1 l=3 w=3
X140 N_B11 N_TOP sky130_fd_pr__cap_mim_m3_1 l=3 w=3
X141 N_B7 N_TOP sky130_fd_pr__cap_mim_m3_1 l=3 w=3
X142 P_B11 P_TOP sky130_fd_pr__cap_mim_m3_1 l=3 w=3
X143 N_B10 N_TOP sky130_fd_pr__cap_mim_m3_1 l=3 w=3
X144 N_B10 N_TOP sky130_fd_pr__cap_mim_m3_1 l=3 w=3
X145 P_EDGE_BIAS P_EDGE_BIAS sky130_fd_pr__cap_mim_m3_1 l=3 w=3
X146 N_B10 N_TOP sky130_fd_pr__cap_mim_m3_1 l=3 w=3
X147 P_B11 P_TOP sky130_fd_pr__cap_mim_m3_1 l=3 w=3
X148 P_B11 P_TOP sky130_fd_pr__cap_mim_m3_1 l=3 w=3
X149 P_B11 P_TOP sky130_fd_pr__cap_mim_m3_1 l=3 w=3
X150 N_B10 N_TOP sky130_fd_pr__cap_mim_m3_1 l=3 w=3
X151 P_B11 P_TOP sky130_fd_pr__cap_mim_m3_1 l=3 w=3
X152 N_B10 N_TOP sky130_fd_pr__cap_mim_m3_1 l=3 w=3
X153 P_B10 P_TOP sky130_fd_pr__cap_mim_m3_1 l=3 w=3
X154 P_B9 P_TOP sky130_fd_pr__cap_mim_m3_1 l=3 w=3
X155 P_B11 P_TOP sky130_fd_pr__cap_mim_m3_1 l=3 w=3
X156 P_EDGE_BIAS P_EDGE_BIAS sky130_fd_pr__cap_mim_m3_1 l=3 w=3
X157 P_B11 P_TOP sky130_fd_pr__cap_mim_m3_1 l=3 w=3
X158 N_B10 N_TOP sky130_fd_pr__cap_mim_m3_1 l=3 w=3
X159 N_B11 N_TOP sky130_fd_pr__cap_mim_m3_1 l=3 w=3
X160 N_B11 N_TOP sky130_fd_pr__cap_mim_m3_1 l=3 w=3
X161 P_B10 P_TOP sky130_fd_pr__cap_mim_m3_1 l=3 w=3
X162 P_B11 P_TOP sky130_fd_pr__cap_mim_m3_1 l=3 w=3
X163 N_B11 N_TOP sky130_fd_pr__cap_mim_m3_1 l=3 w=3
X164 N_B10 N_TOP sky130_fd_pr__cap_mim_m3_1 l=3 w=3
X165 N_B11 N_TOP sky130_fd_pr__cap_mim_m3_1 l=3 w=3
X166 N_B11 N_TOP sky130_fd_pr__cap_mim_m3_1 l=3 w=3
X167 P_B9 P_TOP sky130_fd_pr__cap_mim_m3_1 l=3 w=3
X168 P_B11 P_TOP sky130_fd_pr__cap_mim_m3_1 l=3 w=3
X169 N_B10 N_TOP sky130_fd_pr__cap_mim_m3_1 l=3 w=3
X170 N_B11 N_TOP sky130_fd_pr__cap_mim_m3_1 l=3 w=3
X171 P_B7 P_TOP sky130_fd_pr__cap_mim_m3_1 l=3 w=3
X172 N_B11 N_TOP sky130_fd_pr__cap_mim_m3_1 l=3 w=3
X173 P_B10 P_TOP sky130_fd_pr__cap_mim_m3_1 l=3 w=3
X174 N_B11 N_TOP sky130_fd_pr__cap_mim_m3_1 l=3 w=3
X175 P_B7 P_TOP sky130_fd_pr__cap_mim_m3_1 l=3 w=3
X176 N_B11 N_TOP sky130_fd_pr__cap_mim_m3_1 l=3 w=3
X177 N_B11 N_TOP sky130_fd_pr__cap_mim_m3_1 l=3 w=3
X178 P_B11 P_TOP sky130_fd_pr__cap_mim_m3_1 l=3 w=3
X179 N_B11 N_TOP sky130_fd_pr__cap_mim_m3_1 l=3 w=3
X180 N_B9 N_TOP sky130_fd_pr__cap_mim_m3_1 l=3 w=3
X181 P_B9 P_TOP sky130_fd_pr__cap_mim_m3_1 l=3 w=3
X182 N_B8 N_TOP sky130_fd_pr__cap_mim_m3_1 l=3 w=3
X183 N_B9 N_TOP sky130_fd_pr__cap_mim_m3_1 l=3 w=3
X184 N_B11 N_TOP sky130_fd_pr__cap_mim_m3_1 l=3 w=3
X185 N_B8 N_TOP sky130_fd_pr__cap_mim_m3_1 l=3 w=3
X186 P_B11 P_TOP sky130_fd_pr__cap_mim_m3_1 l=3 w=3
X187 N_B8 N_TOP sky130_fd_pr__cap_mim_m3_1 l=3 w=3
X188 P_B8 P_TOP sky130_fd_pr__cap_mim_m3_1 l=3 w=3
X189 N_B10 N_TOP sky130_fd_pr__cap_mim_m3_1 l=3 w=3
X190 P_B11 P_TOP sky130_fd_pr__cap_mim_m3_1 l=3 w=3
X191 N_EDGE_BIAS N_EDGE_BIAS sky130_fd_pr__cap_mim_m3_1 l=3 w=3
X192 P_B11 P_TOP sky130_fd_pr__cap_mim_m3_1 l=3 w=3
X193 N_B11 N_TOP sky130_fd_pr__cap_mim_m3_1 l=3 w=3
X194 N_B10 N_TOP sky130_fd_pr__cap_mim_m3_1 l=3 w=3
X195 N_B9 N_TOP sky130_fd_pr__cap_mim_m3_1 l=3 w=3
X196 N_B7 N_TOP sky130_fd_pr__cap_mim_m3_1 l=3 w=3
X197 N_B11 N_TOP sky130_fd_pr__cap_mim_m3_1 l=3 w=3
X198 N_B11 N_TOP sky130_fd_pr__cap_mim_m3_1 l=3 w=3
X199 N_B8 N_TOP sky130_fd_pr__cap_mim_m3_1 l=3 w=3
X200 N_B10 N_TOP sky130_fd_pr__cap_mim_m3_1 l=3 w=3
X201 N_B11 N_TOP sky130_fd_pr__cap_mim_m3_1 l=3 w=3
X202 P_B11 P_TOP sky130_fd_pr__cap_mim_m3_1 l=3 w=3
X203 P_B10 P_TOP sky130_fd_pr__cap_mim_m3_1 l=3 w=3
X204 P_B11 P_TOP sky130_fd_pr__cap_mim_m3_1 l=3 w=3
X205 P_B11 P_TOP sky130_fd_pr__cap_mim_m3_1 l=3 w=3
X206 N_EDGE_BIAS N_EDGE_BIAS sky130_fd_pr__cap_mim_m3_1 l=3 w=3
X207 P_B10 P_TOP sky130_fd_pr__cap_mim_m3_1 l=3 w=3
X208 N_B11 N_TOP sky130_fd_pr__cap_mim_m3_1 l=3 w=3
X209 N_B6 N_TOP sky130_fd_pr__cap_mim_m3_1 l=3 w=3
X210 N_B11 N_TOP sky130_fd_pr__cap_mim_m3_1 l=3 w=3
X211 P_B11 P_TOP sky130_fd_pr__cap_mim_m3_1 l=3 w=3
X212 P_B11 P_TOP sky130_fd_pr__cap_mim_m3_1 l=3 w=3
X213 P_B11 P_TOP sky130_fd_pr__cap_mim_m3_1 l=3 w=3
X214 P_B11 P_TOP sky130_fd_pr__cap_mim_m3_1 l=3 w=3
X215 N_B11 N_TOP sky130_fd_pr__cap_mim_m3_1 l=3 w=3
X216 N_B11 N_TOP sky130_fd_pr__cap_mim_m3_1 l=3 w=3
X217 P_B8 P_TOP sky130_fd_pr__cap_mim_m3_1 l=3 w=3
X218 P_B11 P_TOP sky130_fd_pr__cap_mim_m3_1 l=3 w=3
X219 N_B11 N_TOP sky130_fd_pr__cap_mim_m3_1 l=3 w=3
X220 P_B11 P_TOP sky130_fd_pr__cap_mim_m3_1 l=3 w=3
X221 N_B11 N_TOP sky130_fd_pr__cap_mim_m3_1 l=3 w=3
X222 N_B9 N_TOP sky130_fd_pr__cap_mim_m3_1 l=3 w=3
X223 P_B10 P_TOP sky130_fd_pr__cap_mim_m3_1 l=3 w=3
X224 N_B10 N_TOP sky130_fd_pr__cap_mim_m3_1 l=3 w=3
X225 N_B11 N_TOP sky130_fd_pr__cap_mim_m3_1 l=3 w=3
X226 P_B7 P_TOP sky130_fd_pr__cap_mim_m3_1 l=3 w=3
X227 P_B11 P_TOP sky130_fd_pr__cap_mim_m3_1 l=3 w=3
X228 N_B11 N_TOP sky130_fd_pr__cap_mim_m3_1 l=3 w=3
X229 P_B11 P_TOP sky130_fd_pr__cap_mim_m3_1 l=3 w=3
X230 P_B11 P_TOP sky130_fd_pr__cap_mim_m3_1 l=3 w=3
X231 N_B10 N_TOP sky130_fd_pr__cap_mim_m3_1 l=3 w=3
X232 N_B9 N_TOP sky130_fd_pr__cap_mim_m3_1 l=3 w=3
X233 N_B11 N_TOP sky130_fd_pr__cap_mim_m3_1 l=3 w=3
X234 P_B10 P_TOP sky130_fd_pr__cap_mim_m3_1 l=3 w=3
X235 N_B10 N_TOP sky130_fd_pr__cap_mim_m3_1 l=3 w=3
X236 P_B10 P_TOP sky130_fd_pr__cap_mim_m3_1 l=3 w=3
X237 P_B5 P_TOP sky130_fd_pr__cap_mim_m3_1 l=3 w=3
X238 N_B10 N_TOP sky130_fd_pr__cap_mim_m3_1 l=3 w=3
X239 N_B11 N_TOP sky130_fd_pr__cap_mim_m3_1 l=3 w=3
X240 P_B10 P_TOP sky130_fd_pr__cap_mim_m3_1 l=3 w=3
X241 P_EDGE_BIAS P_EDGE_BIAS sky130_fd_pr__cap_mim_m3_1 l=3 w=3
X242 P_B11 P_TOP sky130_fd_pr__cap_mim_m3_1 l=3 w=3
X243 N_B10 N_TOP sky130_fd_pr__cap_mim_m3_1 l=3 w=3
X244 P_B10 P_TOP sky130_fd_pr__cap_mim_m3_1 l=3 w=3
X245 N_B3 N_TOP sky130_fd_pr__cap_mim_m3_1 l=3 w=3
X246 N_B11 N_TOP sky130_fd_pr__cap_mim_m3_1 l=3 w=3
X247 N_B11 N_TOP sky130_fd_pr__cap_mim_m3_1 l=3 w=3
X248 P_B11 P_TOP sky130_fd_pr__cap_mim_m3_1 l=3 w=3
X249 P_B11 P_TOP sky130_fd_pr__cap_mim_m3_1 l=3 w=3
X250 N_B10 N_TOP sky130_fd_pr__cap_mim_m3_1 l=3 w=3
X251 P_B11 P_TOP sky130_fd_pr__cap_mim_m3_1 l=3 w=3
X252 P_B9 P_TOP sky130_fd_pr__cap_mim_m3_1 l=3 w=3
X253 N_B10 N_TOP sky130_fd_pr__cap_mim_m3_1 l=3 w=3
X254 N_B11 N_TOP sky130_fd_pr__cap_mim_m3_1 l=3 w=3
X255 N_B10 N_TOP sky130_fd_pr__cap_mim_m3_1 l=3 w=3
X256 N_B11 N_TOP sky130_fd_pr__cap_mim_m3_1 l=3 w=3
X257 P_B11 P_TOP sky130_fd_pr__cap_mim_m3_1 l=3 w=3
X258 N_B7 N_TOP sky130_fd_pr__cap_mim_m3_1 l=3 w=3
X259 N_B10 N_TOP sky130_fd_pr__cap_mim_m3_1 l=3 w=3
X260 N_B11 N_TOP sky130_fd_pr__cap_mim_m3_1 l=3 w=3
X261 N_B10 N_TOP sky130_fd_pr__cap_mim_m3_1 l=3 w=3
X262 N_EDGE_BIAS N_EDGE_BIAS sky130_fd_pr__cap_mim_m3_1 l=3 w=3
X263 P_EDGE_BIAS P_EDGE_BIAS sky130_fd_pr__cap_mim_m3_1 l=3 w=3
X264 P_B11 P_TOP sky130_fd_pr__cap_mim_m3_1 l=3 w=3
X265 P_B10 P_TOP sky130_fd_pr__cap_mim_m3_1 l=3 w=3
X266 P_B11 P_TOP sky130_fd_pr__cap_mim_m3_1 l=3 w=3
X267 N_B11 N_TOP sky130_fd_pr__cap_mim_m3_1 l=3 w=3
X268 N_B11 N_TOP sky130_fd_pr__cap_mim_m3_1 l=3 w=3
X269 P_B11 P_TOP sky130_fd_pr__cap_mim_m3_1 l=3 w=3
X270 N_B8 N_TOP sky130_fd_pr__cap_mim_m3_1 l=3 w=3
X271 N_B10 N_TOP sky130_fd_pr__cap_mim_m3_1 l=3 w=3
X272 N_B11 N_TOP sky130_fd_pr__cap_mim_m3_1 l=3 w=3
X273 P_B11 P_TOP sky130_fd_pr__cap_mim_m3_1 l=3 w=3
X274 P_B9 P_TOP sky130_fd_pr__cap_mim_m3_1 l=3 w=3
X275 N_B11 N_TOP sky130_fd_pr__cap_mim_m3_1 l=3 w=3
X276 P_B11 P_TOP sky130_fd_pr__cap_mim_m3_1 l=3 w=3
X277 N_B11 N_TOP sky130_fd_pr__cap_mim_m3_1 l=3 w=3
X278 N_B11 N_TOP sky130_fd_pr__cap_mim_m3_1 l=3 w=3
X279 P_B11 P_TOP sky130_fd_pr__cap_mim_m3_1 l=3 w=3
X280 P_B11 P_TOP sky130_fd_pr__cap_mim_m3_1 l=3 w=3
X281 P_B11 P_TOP sky130_fd_pr__cap_mim_m3_1 l=3 w=3
X282 N_B10 N_TOP sky130_fd_pr__cap_mim_m3_1 l=3 w=3
X283 P_B9 P_TOP sky130_fd_pr__cap_mim_m3_1 l=3 w=3
X284 N_B9 N_TOP sky130_fd_pr__cap_mim_m3_1 l=3 w=3
X285 P_B9 P_TOP sky130_fd_pr__cap_mim_m3_1 l=3 w=3
X286 N_B11 N_TOP sky130_fd_pr__cap_mim_m3_1 l=3 w=3
X287 P_B11 P_TOP sky130_fd_pr__cap_mim_m3_1 l=3 w=3
X288 P_B11 P_TOP sky130_fd_pr__cap_mim_m3_1 l=3 w=3
X289 N_B10 N_TOP sky130_fd_pr__cap_mim_m3_1 l=3 w=3
X290 N_B11 N_TOP sky130_fd_pr__cap_mim_m3_1 l=3 w=3
X291 P_B11 P_TOP sky130_fd_pr__cap_mim_m3_1 l=3 w=3
X292 P_B7 P_TOP sky130_fd_pr__cap_mim_m3_1 l=3 w=3
X293 P_B10 P_TOP sky130_fd_pr__cap_mim_m3_1 l=3 w=3
X294 P_B11 P_TOP sky130_fd_pr__cap_mim_m3_1 l=3 w=3
X295 N_B11 N_TOP sky130_fd_pr__cap_mim_m3_1 l=3 w=3
X296 N_B9 N_TOP sky130_fd_pr__cap_mim_m3_1 l=3 w=3
X297 P_B11 P_TOP sky130_fd_pr__cap_mim_m3_1 l=3 w=3
X298 N_B11 N_TOP sky130_fd_pr__cap_mim_m3_1 l=3 w=3
X299 P_B10 P_TOP sky130_fd_pr__cap_mim_m3_1 l=3 w=3
X300 P_B9 P_TOP sky130_fd_pr__cap_mim_m3_1 l=3 w=3
X301 N_B9 N_TOP sky130_fd_pr__cap_mim_m3_1 l=3 w=3
X302 N_B8 N_TOP sky130_fd_pr__cap_mim_m3_1 l=3 w=3
X303 P_B8 P_TOP sky130_fd_pr__cap_mim_m3_1 l=3 w=3
X304 P_EDGE_BIAS P_EDGE_BIAS sky130_fd_pr__cap_mim_m3_1 l=3 w=3
X305 P_B10 P_TOP sky130_fd_pr__cap_mim_m3_1 l=3 w=3
X306 N_B8 N_TOP sky130_fd_pr__cap_mim_m3_1 l=3 w=3
X307 N_B10 N_TOP sky130_fd_pr__cap_mim_m3_1 l=3 w=3
X308 N_B11 N_TOP sky130_fd_pr__cap_mim_m3_1 l=3 w=3
X309 N_B9 N_TOP sky130_fd_pr__cap_mim_m3_1 l=3 w=3
X310 P_EDGE_BIAS P_EDGE_BIAS sky130_fd_pr__cap_mim_m3_1 l=3 w=3
X311 P_B11 P_TOP sky130_fd_pr__cap_mim_m3_1 l=3 w=3
X312 P_B10 P_TOP sky130_fd_pr__cap_mim_m3_1 l=3 w=3
X313 N_B11 N_TOP sky130_fd_pr__cap_mim_m3_1 l=3 w=3
X314 N_B7 N_TOP sky130_fd_pr__cap_mim_m3_1 l=3 w=3
X315 N_B9 N_TOP sky130_fd_pr__cap_mim_m3_1 l=3 w=3
X316 P_B11 P_TOP sky130_fd_pr__cap_mim_m3_1 l=3 w=3
X317 P_B11 P_TOP sky130_fd_pr__cap_mim_m3_1 l=3 w=3
X318 N_B7 N_TOP sky130_fd_pr__cap_mim_m3_1 l=3 w=3
X319 N_B11 N_TOP sky130_fd_pr__cap_mim_m3_1 l=3 w=3
X320 P_B11 P_TOP sky130_fd_pr__cap_mim_m3_1 l=3 w=3
X321 N_B11 N_TOP sky130_fd_pr__cap_mim_m3_1 l=3 w=3
X322 N_B8 N_TOP sky130_fd_pr__cap_mim_m3_1 l=3 w=3
X323 N_B10 N_TOP sky130_fd_pr__cap_mim_m3_1 l=3 w=3
X324 P_B10 P_TOP sky130_fd_pr__cap_mim_m3_1 l=3 w=3
X325 P_B11 P_TOP sky130_fd_pr__cap_mim_m3_1 l=3 w=3
X326 P_B11 P_TOP sky130_fd_pr__cap_mim_m3_1 l=3 w=3
X327 P_B11 P_TOP sky130_fd_pr__cap_mim_m3_1 l=3 w=3
X328 P_B11 P_TOP sky130_fd_pr__cap_mim_m3_1 l=3 w=3
X329 N_B8 N_TOP sky130_fd_pr__cap_mim_m3_1 l=3 w=3
X330 P_B10 P_TOP sky130_fd_pr__cap_mim_m3_1 l=3 w=3
X331 N_B10 N_TOP sky130_fd_pr__cap_mim_m3_1 l=3 w=3
X332 P_B11 P_TOP sky130_fd_pr__cap_mim_m3_1 l=3 w=3
X333 P_B11 P_TOP sky130_fd_pr__cap_mim_m3_1 l=3 w=3
X334 N_B6 N_TOP sky130_fd_pr__cap_mim_m3_1 l=3 w=3
X335 P_B7 P_TOP sky130_fd_pr__cap_mim_m3_1 l=3 w=3
X336 N_B9 N_TOP sky130_fd_pr__cap_mim_m3_1 l=3 w=3
X337 P_B11 P_TOP sky130_fd_pr__cap_mim_m3_1 l=3 w=3
X338 N_B11 N_TOP sky130_fd_pr__cap_mim_m3_1 l=3 w=3
X339 N_B11 N_TOP sky130_fd_pr__cap_mim_m3_1 l=3 w=3
X340 N_B9 N_TOP sky130_fd_pr__cap_mim_m3_1 l=3 w=3
X341 P_B11 P_TOP sky130_fd_pr__cap_mim_m3_1 l=3 w=3
X342 N_B5 N_TOP sky130_fd_pr__cap_mim_m3_1 l=3 w=3
X343 N_B11 N_TOP sky130_fd_pr__cap_mim_m3_1 l=3 w=3
X344 P_B11 P_TOP sky130_fd_pr__cap_mim_m3_1 l=3 w=3
X345 P_B10 P_TOP sky130_fd_pr__cap_mim_m3_1 l=3 w=3
X346 P_B10 P_TOP sky130_fd_pr__cap_mim_m3_1 l=3 w=3
X347 P_B10 P_TOP sky130_fd_pr__cap_mim_m3_1 l=3 w=3
X348 N_B11 N_TOP sky130_fd_pr__cap_mim_m3_1 l=3 w=3
X349 N_B11 N_TOP sky130_fd_pr__cap_mim_m3_1 l=3 w=3
X350 N_EDGE_BIAS N_EDGE_BIAS sky130_fd_pr__cap_mim_m3_1 l=3 w=3
X351 P_B7 P_TOP sky130_fd_pr__cap_mim_m3_1 l=3 w=3
X352 N_B11 N_TOP sky130_fd_pr__cap_mim_m3_1 l=3 w=3
X353 N_B11 N_TOP sky130_fd_pr__cap_mim_m3_1 l=3 w=3
X354 P_B11 P_TOP sky130_fd_pr__cap_mim_m3_1 l=3 w=3
X355 N_B11 N_TOP sky130_fd_pr__cap_mim_m3_1 l=3 w=3
X356 N_B9 N_TOP sky130_fd_pr__cap_mim_m3_1 l=3 w=3
X357 N_B11 N_TOP sky130_fd_pr__cap_mim_m3_1 l=3 w=3
X358 P_B10 P_TOP sky130_fd_pr__cap_mim_m3_1 l=3 w=3
X359 P_B10 P_TOP sky130_fd_pr__cap_mim_m3_1 l=3 w=3
X360 N_B10 N_TOP sky130_fd_pr__cap_mim_m3_1 l=3 w=3
X361 P_B11 P_TOP sky130_fd_pr__cap_mim_m3_1 l=3 w=3
X362 N_B10 N_TOP sky130_fd_pr__cap_mim_m3_1 l=3 w=3
X363 P_B10 P_TOP sky130_fd_pr__cap_mim_m3_1 l=3 w=3
X364 P_B4 P_TOP sky130_fd_pr__cap_mim_m3_1 l=3 w=3
X365 P_EDGE_BIAS P_EDGE_BIAS sky130_fd_pr__cap_mim_m3_1 l=3 w=3
X366 P_B11 P_TOP sky130_fd_pr__cap_mim_m3_1 l=3 w=3
X367 N_B10 N_TOP sky130_fd_pr__cap_mim_m3_1 l=3 w=3
X368 N_B9 N_TOP sky130_fd_pr__cap_mim_m3_1 l=3 w=3
X369 N_B11 N_TOP sky130_fd_pr__cap_mim_m3_1 l=3 w=3
X370 P_EDGE_BIAS P_EDGE_BIAS sky130_fd_pr__cap_mim_m3_1 l=3 w=3
X371 N_B10 N_TOP sky130_fd_pr__cap_mim_m3_1 l=3 w=3
X372 P_B11 P_TOP sky130_fd_pr__cap_mim_m3_1 l=3 w=3
X373 P_B11 P_TOP sky130_fd_pr__cap_mim_m3_1 l=3 w=3
X374 N_B7 N_TOP sky130_fd_pr__cap_mim_m3_1 l=3 w=3
X375 N_B10 N_TOP sky130_fd_pr__cap_mim_m3_1 l=3 w=3
X376 P_B10 P_TOP sky130_fd_pr__cap_mim_m3_1 l=3 w=3
X377 N_B7 N_TOP sky130_fd_pr__cap_mim_m3_1 l=3 w=3
X378 P_EDGE_BIAS P_EDGE_BIAS sky130_fd_pr__cap_mim_m3_1 l=3 w=3
X379 N_B10 N_TOP sky130_fd_pr__cap_mim_m3_1 l=3 w=3
X380 N_B11 N_TOP sky130_fd_pr__cap_mim_m3_1 l=3 w=3
X381 P_B11 P_TOP sky130_fd_pr__cap_mim_m3_1 l=3 w=3
X382 P_B11 P_TOP sky130_fd_pr__cap_mim_m3_1 l=3 w=3
X383 N_B10 N_TOP sky130_fd_pr__cap_mim_m3_1 l=3 w=3
X384 P_B11 P_TOP sky130_fd_pr__cap_mim_m3_1 l=3 w=3
X385 N_B8 N_TOP sky130_fd_pr__cap_mim_m3_1 l=3 w=3
X386 P_B9 P_TOP sky130_fd_pr__cap_mim_m3_1 l=3 w=3
X387 P_EDGE_BIAS P_EDGE_BIAS sky130_fd_pr__cap_mim_m3_1 l=3 w=3
X388 N_B10 N_TOP sky130_fd_pr__cap_mim_m3_1 l=3 w=3
X389 N_B11 N_TOP sky130_fd_pr__cap_mim_m3_1 l=3 w=3
X390 N_B11 N_TOP sky130_fd_pr__cap_mim_m3_1 l=3 w=3
X391 P_B11 P_TOP sky130_fd_pr__cap_mim_m3_1 l=3 w=3
X392 N_B10 N_TOP sky130_fd_pr__cap_mim_m3_1 l=3 w=3
X393 N_B11 N_TOP sky130_fd_pr__cap_mim_m3_1 l=3 w=3
X394 P_B11 P_TOP sky130_fd_pr__cap_mim_m3_1 l=3 w=3
X395 P_B11 P_TOP sky130_fd_pr__cap_mim_m3_1 l=3 w=3
X396 P_B9 P_TOP sky130_fd_pr__cap_mim_m3_1 l=3 w=3
X397 P_B11 P_TOP sky130_fd_pr__cap_mim_m3_1 l=3 w=3
X398 P_EDGE_BIAS P_EDGE_BIAS sky130_fd_pr__cap_mim_m3_1 l=3 w=3
X399 P_B9 P_TOP sky130_fd_pr__cap_mim_m3_1 l=3 w=3
X400 N_B10 N_TOP sky130_fd_pr__cap_mim_m3_1 l=3 w=3
X401 N_B11 N_TOP sky130_fd_pr__cap_mim_m3_1 l=3 w=3
X402 P_B11 P_TOP sky130_fd_pr__cap_mim_m3_1 l=3 w=3
X403 P_B11 P_TOP sky130_fd_pr__cap_mim_m3_1 l=3 w=3
X404 P_B7 P_TOP sky130_fd_pr__cap_mim_m3_1 l=3 w=3
X405 N_B11 N_TOP sky130_fd_pr__cap_mim_m3_1 l=3 w=3
X406 P_B10 P_TOP sky130_fd_pr__cap_mim_m3_1 l=3 w=3
X407 N_B11 N_TOP sky130_fd_pr__cap_mim_m3_1 l=3 w=3
X408 N_EDGE_BIAS N_EDGE_BIAS sky130_fd_pr__cap_mim_m3_1 l=3 w=3
X409 N_B9 N_TOP sky130_fd_pr__cap_mim_m3_1 l=3 w=3
X410 P_B9 P_TOP sky130_fd_pr__cap_mim_m3_1 l=3 w=3
X411 N_B9 N_TOP sky130_fd_pr__cap_mim_m3_1 l=3 w=3
X412 N_B11 N_TOP sky130_fd_pr__cap_mim_m3_1 l=3 w=3
X413 P_B9 P_TOP sky130_fd_pr__cap_mim_m3_1 l=3 w=3
X414 N_EDGE_BIAS N_EDGE_BIAS sky130_fd_pr__cap_mim_m3_1 l=3 w=3
X415 N_B8 N_TOP sky130_fd_pr__cap_mim_m3_1 l=3 w=3
X416 P_B11 P_TOP sky130_fd_pr__cap_mim_m3_1 l=3 w=3
X417 P_B8 P_TOP sky130_fd_pr__cap_mim_m3_1 l=3 w=3
X418 P_B8 P_TOP sky130_fd_pr__cap_mim_m3_1 l=3 w=3
X419 P_B10 P_TOP sky130_fd_pr__cap_mim_m3_1 l=3 w=3
X420 N_B10 N_TOP sky130_fd_pr__cap_mim_m3_1 l=3 w=3
X421 P_EDGE_BIAS P_EDGE_BIAS sky130_fd_pr__cap_mim_m3_1 l=3 w=3
X422 N_B9 N_TOP sky130_fd_pr__cap_mim_m3_1 l=3 w=3
X423 N_B11 N_TOP sky130_fd_pr__cap_mim_m3_1 l=3 w=3
X424 N_B11 N_TOP sky130_fd_pr__cap_mim_m3_1 l=3 w=3
X425 P_B11 P_TOP sky130_fd_pr__cap_mim_m3_1 l=3 w=3
X426 N_B7 N_TOP sky130_fd_pr__cap_mim_m3_1 l=3 w=3
X427 N_B11 N_TOP sky130_fd_pr__cap_mim_m3_1 l=3 w=3
X428 P_B7 P_TOP sky130_fd_pr__cap_mim_m3_1 l=3 w=3
X429 P_B10 P_TOP sky130_fd_pr__cap_mim_m3_1 l=3 w=3
X430 N_B11 N_TOP sky130_fd_pr__cap_mim_m3_1 l=3 w=3
X431 N_B11 N_TOP sky130_fd_pr__cap_mim_m3_1 l=3 w=3
X432 N_B8 N_TOP sky130_fd_pr__cap_mim_m3_1 l=3 w=3
X433 N_B10 N_TOP sky130_fd_pr__cap_mim_m3_1 l=3 w=3
X434 P_B10 P_TOP sky130_fd_pr__cap_mim_m3_1 l=3 w=3
X435 P_B11 P_TOP sky130_fd_pr__cap_mim_m3_1 l=3 w=3
X436 P_B11 P_TOP sky130_fd_pr__cap_mim_m3_1 l=3 w=3
X437 P_B9 P_TOP sky130_fd_pr__cap_mim_m3_1 l=3 w=3
X438 N_B11 N_TOP sky130_fd_pr__cap_mim_m3_1 l=3 w=3
X439 P_B11 P_TOP sky130_fd_pr__cap_mim_m3_1 l=3 w=3
X440 N_B11 N_TOP sky130_fd_pr__cap_mim_m3_1 l=3 w=3
X441 N_B10 N_TOP sky130_fd_pr__cap_mim_m3_1 l=3 w=3
X442 P_B11 P_TOP sky130_fd_pr__cap_mim_m3_1 l=3 w=3
X443 N_B11 N_TOP sky130_fd_pr__cap_mim_m3_1 l=3 w=3
X444 N_B11 N_TOP sky130_fd_pr__cap_mim_m3_1 l=3 w=3
X445 N_B9 N_TOP sky130_fd_pr__cap_mim_m3_1 l=3 w=3
X446 N_B11 N_TOP sky130_fd_pr__cap_mim_m3_1 l=3 w=3
X447 N_B9 N_TOP sky130_fd_pr__cap_mim_m3_1 l=3 w=3
X448 P_B11 P_TOP sky130_fd_pr__cap_mim_m3_1 l=3 w=3
X449 N_B11 N_TOP sky130_fd_pr__cap_mim_m3_1 l=3 w=3
X450 N_B11 N_TOP sky130_fd_pr__cap_mim_m3_1 l=3 w=3
X451 N_B6 N_TOP sky130_fd_pr__cap_mim_m3_1 l=3 w=3
X452 N_B11 N_TOP sky130_fd_pr__cap_mim_m3_1 l=3 w=3
X453 P_B11 P_TOP sky130_fd_pr__cap_mim_m3_1 l=3 w=3
X454 P_B10 P_TOP sky130_fd_pr__cap_mim_m3_1 l=3 w=3
X455 N_B11 N_TOP sky130_fd_pr__cap_mim_m3_1 l=3 w=3
X456 N_B11 N_TOP sky130_fd_pr__cap_mim_m3_1 l=3 w=3
X457 N_B10 N_TOP sky130_fd_pr__cap_mim_m3_1 l=3 w=3
X458 P_B11 P_TOP sky130_fd_pr__cap_mim_m3_1 l=3 w=3
X459 N_B11 N_TOP sky130_fd_pr__cap_mim_m3_1 l=3 w=3
X460 P_B11 P_TOP sky130_fd_pr__cap_mim_m3_1 l=3 w=3
X461 P_B11 P_TOP sky130_fd_pr__cap_mim_m3_1 l=3 w=3
X462 P_B7 P_TOP sky130_fd_pr__cap_mim_m3_1 l=3 w=3
X463 N_B11 N_TOP sky130_fd_pr__cap_mim_m3_1 l=3 w=3
X464 N_B9 N_TOP sky130_fd_pr__cap_mim_m3_1 l=3 w=3
X465 P_B11 P_TOP sky130_fd_pr__cap_mim_m3_1 l=3 w=3
X466 P_B10 P_TOP sky130_fd_pr__cap_mim_m3_1 l=3 w=3
X467 N_B9 N_TOP sky130_fd_pr__cap_mim_m3_1 l=3 w=3
X468 N_B10 N_TOP sky130_fd_pr__cap_mim_m3_1 l=3 w=3
X469 N_B10 N_TOP sky130_fd_pr__cap_mim_m3_1 l=3 w=3
X470 P_B10 P_TOP sky130_fd_pr__cap_mim_m3_1 l=3 w=3
X471 N_EDGE_BIAS N_EDGE_BIAS sky130_fd_pr__cap_mim_m3_1 l=3 w=3
X472 P_B10 P_TOP sky130_fd_pr__cap_mim_m3_1 l=3 w=3
X473 N_B11 N_TOP sky130_fd_pr__cap_mim_m3_1 l=3 w=3
X474 P_B5 P_TOP sky130_fd_pr__cap_mim_m3_1 l=3 w=3
X475 N_B11 N_TOP sky130_fd_pr__cap_mim_m3_1 l=3 w=3
X476 N_B9 N_TOP sky130_fd_pr__cap_mim_m3_1 l=3 w=3
X477 N_B11 N_TOP sky130_fd_pr__cap_mim_m3_1 l=3 w=3
X478 P_B11 P_TOP sky130_fd_pr__cap_mim_m3_1 l=3 w=3
X479 N_B9 N_TOP sky130_fd_pr__cap_mim_m3_1 l=3 w=3
X480 P_B9 P_TOP sky130_fd_pr__cap_mim_m3_1 l=3 w=3
X481 N_B10 N_TOP sky130_fd_pr__cap_mim_m3_1 l=3 w=3
X482 N_B10 N_TOP sky130_fd_pr__cap_mim_m3_1 l=3 w=3
X483 N_B7 N_TOP sky130_fd_pr__cap_mim_m3_1 l=3 w=3
X484 N_B11 N_TOP sky130_fd_pr__cap_mim_m3_1 l=3 w=3
X485 P_B7 P_TOP sky130_fd_pr__cap_mim_m3_1 l=3 w=3
X486 N_B10 N_TOP sky130_fd_pr__cap_mim_m3_1 l=3 w=3
X487 P_EDGE_BIAS P_EDGE_BIAS sky130_fd_pr__cap_mim_m3_1 l=3 w=3
X488 N_B10 N_TOP sky130_fd_pr__cap_mim_m3_1 l=3 w=3
X489 N_B11 N_TOP sky130_fd_pr__cap_mim_m3_1 l=3 w=3
X490 N_B9 N_TOP sky130_fd_pr__cap_mim_m3_1 l=3 w=3
X491 P_B11 P_TOP sky130_fd_pr__cap_mim_m3_1 l=3 w=3
X492 P_B11 P_TOP sky130_fd_pr__cap_mim_m3_1 l=3 w=3
X493 P_B11 P_TOP sky130_fd_pr__cap_mim_m3_1 l=3 w=3
X494 N_B10 N_TOP sky130_fd_pr__cap_mim_m3_1 l=3 w=3
X495 N_B10 N_TOP sky130_fd_pr__cap_mim_m3_1 l=3 w=3
X496 P_B6 P_TOP sky130_fd_pr__cap_mim_m3_1 l=3 w=3
X497 P_B9 P_TOP sky130_fd_pr__cap_mim_m3_1 l=3 w=3
X498 N_B11 N_TOP sky130_fd_pr__cap_mim_m3_1 l=3 w=3
X499 P_B11 P_TOP sky130_fd_pr__cap_mim_m3_1 l=3 w=3
X500 N_B10 N_TOP sky130_fd_pr__cap_mim_m3_1 l=3 w=3
X501 P_B11 P_TOP sky130_fd_pr__cap_mim_m3_1 l=3 w=3
X502 N_B6 N_TOP sky130_fd_pr__cap_mim_m3_1 l=3 w=3
X503 N_B11 N_TOP sky130_fd_pr__cap_mim_m3_1 l=3 w=3
X504 P_B11 P_TOP sky130_fd_pr__cap_mim_m3_1 l=3 w=3
X505 N_B11 N_TOP sky130_fd_pr__cap_mim_m3_1 l=3 w=3
X506 N_B10 N_TOP sky130_fd_pr__cap_mim_m3_1 l=3 w=3
X507 P_B11 P_TOP sky130_fd_pr__cap_mim_m3_1 l=3 w=3
X508 N_B11 N_TOP sky130_fd_pr__cap_mim_m3_1 l=3 w=3
X509 P_B9 P_TOP sky130_fd_pr__cap_mim_m3_1 l=3 w=3
X510 P_B11 P_TOP sky130_fd_pr__cap_mim_m3_1 l=3 w=3
X511 N_B11 N_TOP sky130_fd_pr__cap_mim_m3_1 l=3 w=3
X512 N_B10 N_TOP sky130_fd_pr__cap_mim_m3_1 l=3 w=3
X513 N_B11 N_TOP sky130_fd_pr__cap_mim_m3_1 l=3 w=3
X514 N_B11 N_TOP sky130_fd_pr__cap_mim_m3_1 l=3 w=3
X515 N_B11 N_TOP sky130_fd_pr__cap_mim_m3_1 l=3 w=3
X516 N_B11 N_TOP sky130_fd_pr__cap_mim_m3_1 l=3 w=3
X517 N_B10 N_TOP sky130_fd_pr__cap_mim_m3_1 l=3 w=3
X518 P_B7 P_TOP sky130_fd_pr__cap_mim_m3_1 l=3 w=3
X519 P_B11 P_TOP sky130_fd_pr__cap_mim_m3_1 l=3 w=3
X520 N_B11 N_TOP sky130_fd_pr__cap_mim_m3_1 l=3 w=3
X521 P_B11 P_TOP sky130_fd_pr__cap_mim_m3_1 l=3 w=3
X522 N_B9 N_TOP sky130_fd_pr__cap_mim_m3_1 l=3 w=3
X523 P_B9 P_TOP sky130_fd_pr__cap_mim_m3_1 l=3 w=3
X524 N_B8 N_TOP sky130_fd_pr__cap_mim_m3_1 l=3 w=3
X525 P_B8 P_TOP sky130_fd_pr__cap_mim_m3_1 l=3 w=3
X526 N_B9 N_TOP sky130_fd_pr__cap_mim_m3_1 l=3 w=3
X527 N_B11 N_TOP sky130_fd_pr__cap_mim_m3_1 l=3 w=3
X528 N_EDGE_BIAS N_EDGE_BIAS sky130_fd_pr__cap_mim_m3_1 l=3 w=3
X529 P_B11 P_TOP sky130_fd_pr__cap_mim_m3_1 l=3 w=3
X530 P_B10 P_TOP sky130_fd_pr__cap_mim_m3_1 l=3 w=3
X531 P_B8 P_TOP sky130_fd_pr__cap_mim_m3_1 l=3 w=3
X532 N_B10 N_TOP sky130_fd_pr__cap_mim_m3_1 l=3 w=3
X533 N_B10 N_TOP sky130_fd_pr__cap_mim_m3_1 l=3 w=3
X534 P_B11 P_TOP sky130_fd_pr__cap_mim_m3_1 l=3 w=3
X535 P_B11 P_TOP sky130_fd_pr__cap_mim_m3_1 l=3 w=3
X536 N_B10 N_TOP sky130_fd_pr__cap_mim_m3_1 l=3 w=3
X537 P_B11 P_TOP sky130_fd_pr__cap_mim_m3_1 l=3 w=3
X538 P_B11 P_TOP sky130_fd_pr__cap_mim_m3_1 l=3 w=3
X539 N_B7 N_TOP sky130_fd_pr__cap_mim_m3_1 l=3 w=3
X540 N_B11 N_TOP sky130_fd_pr__cap_mim_m3_1 l=3 w=3
X541 N_B9 N_TOP sky130_fd_pr__cap_mim_m3_1 l=3 w=3
X542 N_B7 N_TOP sky130_fd_pr__cap_mim_m3_1 l=3 w=3
X543 N_B11 N_TOP sky130_fd_pr__cap_mim_m3_1 l=3 w=3
X544 P_B8 P_TOP sky130_fd_pr__cap_mim_m3_1 l=3 w=3
X545 N_B10 N_TOP sky130_fd_pr__cap_mim_m3_1 l=3 w=3
X546 N_B10 N_TOP sky130_fd_pr__cap_mim_m3_1 l=3 w=3
X547 N_B11 N_TOP sky130_fd_pr__cap_mim_m3_1 l=3 w=3
X548 P_B11 P_TOP sky130_fd_pr__cap_mim_m3_1 l=3 w=3
X549 N_B10 N_TOP sky130_fd_pr__cap_mim_m3_1 l=3 w=3
X550 N_B9 N_TOP sky130_fd_pr__cap_mim_m3_1 l=3 w=3
X551 P_B11 P_TOP sky130_fd_pr__cap_mim_m3_1 l=3 w=3
X552 P_B11 P_TOP sky130_fd_pr__cap_mim_m3_1 l=3 w=3
X553 N_B8 N_TOP sky130_fd_pr__cap_mim_m3_1 l=3 w=3
X554 P_B10 P_TOP sky130_fd_pr__cap_mim_m3_1 l=3 w=3
X555 N_B11 N_TOP sky130_fd_pr__cap_mim_m3_1 l=3 w=3
X556 N_B6 N_TOP sky130_fd_pr__cap_mim_m3_1 l=3 w=3
X557 N_B11 N_TOP sky130_fd_pr__cap_mim_m3_1 l=3 w=3
X558 P_B11 P_TOP sky130_fd_pr__cap_mim_m3_1 l=3 w=3
X559 N_B11 N_TOP sky130_fd_pr__cap_mim_m3_1 l=3 w=3
X560 N_B9 N_TOP sky130_fd_pr__cap_mim_m3_1 l=3 w=3
X561 N_B10 N_TOP sky130_fd_pr__cap_mim_m3_1 l=3 w=3
X562 P_B11 P_TOP sky130_fd_pr__cap_mim_m3_1 l=3 w=3
X563 P_B11 P_TOP sky130_fd_pr__cap_mim_m3_1 l=3 w=3
X564 P_B11 P_TOP sky130_fd_pr__cap_mim_m3_1 l=3 w=3
X565 N_B11 N_TOP sky130_fd_pr__cap_mim_m3_1 l=3 w=3
X566 N_EDGE_BIAS N_EDGE_BIAS sky130_fd_pr__cap_mim_m3_1 l=3 w=3
X567 P_B11 P_TOP sky130_fd_pr__cap_mim_m3_1 l=3 w=3
X568 P_B10 P_TOP sky130_fd_pr__cap_mim_m3_1 l=3 w=3
X569 N_B10 N_TOP sky130_fd_pr__cap_mim_m3_1 l=3 w=3
X570 N_B11 N_TOP sky130_fd_pr__cap_mim_m3_1 l=3 w=3
X571 P_EDGE_BIAS P_EDGE_BIAS sky130_fd_pr__cap_mim_m3_1 l=3 w=3
X572 N_B11 N_TOP sky130_fd_pr__cap_mim_m3_1 l=3 w=3
X573 P_B11 P_TOP sky130_fd_pr__cap_mim_m3_1 l=3 w=3
X574 P_B11 P_TOP sky130_fd_pr__cap_mim_m3_1 l=3 w=3
X575 N_B11 N_TOP sky130_fd_pr__cap_mim_m3_1 l=3 w=3
X576 P_B9 P_TOP sky130_fd_pr__cap_mim_m3_1 l=3 w=3
X577 N_B9 N_TOP sky130_fd_pr__cap_mim_m3_1 l=3 w=3
X578 P_B11 P_TOP sky130_fd_pr__cap_mim_m3_1 l=3 w=3
X579 N_B11 N_TOP sky130_fd_pr__cap_mim_m3_1 l=3 w=3
X580 N_B11 N_TOP sky130_fd_pr__cap_mim_m3_1 l=3 w=3
X581 P_B9 P_TOP sky130_fd_pr__cap_mim_m3_1 l=3 w=3
X582 P_B10 P_TOP sky130_fd_pr__cap_mim_m3_1 l=3 w=3
X583 P_B4 P_TOP sky130_fd_pr__cap_mim_m3_1 l=3 w=3
X584 N_B10 N_TOP sky130_fd_pr__cap_mim_m3_1 l=3 w=3
X585 N_B11 N_TOP sky130_fd_pr__cap_mim_m3_1 l=3 w=3
X586 P_B10 P_TOP sky130_fd_pr__cap_mim_m3_1 l=3 w=3
X587 P_B11 P_TOP sky130_fd_pr__cap_mim_m3_1 l=3 w=3
X588 P_B10 P_TOP sky130_fd_pr__cap_mim_m3_1 l=3 w=3
X589 P_B9 P_TOP sky130_fd_pr__cap_mim_m3_1 l=3 w=3
X590 N_B11 N_TOP sky130_fd_pr__cap_mim_m3_1 l=3 w=3
X591 N_EDGE_BIAS N_EDGE_BIAS sky130_fd_pr__cap_mim_m3_1 l=3 w=3
X592 N_B9 N_TOP sky130_fd_pr__cap_mim_m3_1 l=3 w=3
X593 P_B11 P_TOP sky130_fd_pr__cap_mim_m3_1 l=3 w=3
X594 N_B11 N_TOP sky130_fd_pr__cap_mim_m3_1 l=3 w=3
X595 N_B11 N_TOP sky130_fd_pr__cap_mim_m3_1 l=3 w=3
X596 P_B11 P_TOP sky130_fd_pr__cap_mim_m3_1 l=3 w=3
X597 N_B9 N_TOP sky130_fd_pr__cap_mim_m3_1 l=3 w=3
X598 P_B9 P_TOP sky130_fd_pr__cap_mim_m3_1 l=3 w=3
X599 N_B7 N_TOP sky130_fd_pr__cap_mim_m3_1 l=3 w=3
X600 N_B10 N_TOP sky130_fd_pr__cap_mim_m3_1 l=3 w=3
X601 N_B10 N_TOP sky130_fd_pr__cap_mim_m3_1 l=3 w=3
X602 N_B7 N_TOP sky130_fd_pr__cap_mim_m3_1 l=3 w=3
X603 N_B10 N_TOP sky130_fd_pr__cap_mim_m3_1 l=3 w=3
X604 P_B10 P_TOP sky130_fd_pr__cap_mim_m3_1 l=3 w=3
X605 P_EDGE_BIAS P_EDGE_BIAS sky130_fd_pr__cap_mim_m3_1 l=3 w=3
X606 N_B9 N_TOP sky130_fd_pr__cap_mim_m3_1 l=3 w=3
X607 P_B11 P_TOP sky130_fd_pr__cap_mim_m3_1 l=3 w=3
X608 N_B9 N_TOP sky130_fd_pr__cap_mim_m3_1 l=3 w=3
X609 P_B10 P_TOP sky130_fd_pr__cap_mim_m3_1 l=3 w=3
X610 N_B11 N_TOP sky130_fd_pr__cap_mim_m3_1 l=3 w=3
X611 N_B8 N_TOP sky130_fd_pr__cap_mim_m3_1 l=3 w=3
X612 N_B10 N_TOP sky130_fd_pr__cap_mim_m3_1 l=3 w=3
X613 N_B11 N_TOP sky130_fd_pr__cap_mim_m3_1 l=3 w=3
X614 P_B11 P_TOP sky130_fd_pr__cap_mim_m3_1 l=3 w=3
X615 N_B11 N_TOP sky130_fd_pr__cap_mim_m3_1 l=3 w=3
X616 P_B11 P_TOP sky130_fd_pr__cap_mim_m3_1 l=3 w=3
X617 P_B11 P_TOP sky130_fd_pr__cap_mim_m3_1 l=3 w=3
X618 P_B11 P_TOP sky130_fd_pr__cap_mim_m3_1 l=3 w=3
X619 P_B11 P_TOP sky130_fd_pr__cap_mim_m3_1 l=3 w=3
X620 P_B11 P_TOP sky130_fd_pr__cap_mim_m3_1 l=3 w=3
X621 N_B10 N_TOP sky130_fd_pr__cap_mim_m3_1 l=3 w=3
X622 N_B11 N_TOP sky130_fd_pr__cap_mim_m3_1 l=3 w=3
X623 P_B11 P_TOP sky130_fd_pr__cap_mim_m3_1 l=3 w=3
X624 P_B9 P_TOP sky130_fd_pr__cap_mim_m3_1 l=3 w=3
X625 P_B11 P_TOP sky130_fd_pr__cap_mim_m3_1 l=3 w=3
X626 N_B11 N_TOP sky130_fd_pr__cap_mim_m3_1 l=3 w=3
X627 N_B11 N_TOP sky130_fd_pr__cap_mim_m3_1 l=3 w=3
X628 N_B10 N_TOP sky130_fd_pr__cap_mim_m3_1 l=3 w=3
X629 P_B10 P_TOP sky130_fd_pr__cap_mim_m3_1 l=3 w=3
X630 P_B10 P_TOP sky130_fd_pr__cap_mim_m3_1 l=3 w=3
X631 N_B11 N_TOP sky130_fd_pr__cap_mim_m3_1 l=3 w=3
X632 P_B11 P_TOP sky130_fd_pr__cap_mim_m3_1 l=3 w=3
X633 P_B11 P_TOP sky130_fd_pr__cap_mim_m3_1 l=3 w=3
X634 P_B11 P_TOP sky130_fd_pr__cap_mim_m3_1 l=3 w=3
X635 P_B9 P_TOP sky130_fd_pr__cap_mim_m3_1 l=3 w=3
X636 P_B10 P_TOP sky130_fd_pr__cap_mim_m3_1 l=3 w=3
X637 N_B9 N_TOP sky130_fd_pr__cap_mim_m3_1 l=3 w=3
X638 N_B8 N_TOP sky130_fd_pr__cap_mim_m3_1 l=3 w=3
X639 P_B8 P_TOP sky130_fd_pr__cap_mim_m3_1 l=3 w=3
X640 N_B11 N_TOP sky130_fd_pr__cap_mim_m3_1 l=3 w=3
X641 N_B11 N_TOP sky130_fd_pr__cap_mim_m3_1 l=3 w=3
X642 P_B10 P_TOP sky130_fd_pr__cap_mim_m3_1 l=3 w=3
X643 P_B10 P_TOP sky130_fd_pr__cap_mim_m3_1 l=3 w=3
X644 N_B10 N_TOP sky130_fd_pr__cap_mim_m3_1 l=3 w=3
X645 P_B10 P_TOP sky130_fd_pr__cap_mim_m3_1 l=3 w=3
X646 N_B11 N_TOP sky130_fd_pr__cap_mim_m3_1 l=3 w=3
X647 N_B11 N_TOP sky130_fd_pr__cap_mim_m3_1 l=3 w=3
X648 P_B11 P_TOP sky130_fd_pr__cap_mim_m3_1 l=3 w=3
X649 N_B11 N_TOP sky130_fd_pr__cap_mim_m3_1 l=3 w=3
X650 P_B11 P_TOP sky130_fd_pr__cap_mim_m3_1 l=3 w=3
X651 P_B10 P_TOP sky130_fd_pr__cap_mim_m3_1 l=3 w=3
X652 N_B11 N_TOP sky130_fd_pr__cap_mim_m3_1 l=3 w=3
X653 N_B7 N_TOP sky130_fd_pr__cap_mim_m3_1 l=3 w=3
X654 N_B9 N_TOP sky130_fd_pr__cap_mim_m3_1 l=3 w=3
X655 N_B11 N_TOP sky130_fd_pr__cap_mim_m3_1 l=3 w=3
X656 P_B11 P_TOP sky130_fd_pr__cap_mim_m3_1 l=3 w=3
X657 N_B7 N_TOP sky130_fd_pr__cap_mim_m3_1 l=3 w=3
X658 P_B11 P_TOP sky130_fd_pr__cap_mim_m3_1 l=3 w=3
X659 N_B8 N_TOP sky130_fd_pr__cap_mim_m3_1 l=3 w=3
X660 N_B10 N_TOP sky130_fd_pr__cap_mim_m3_1 l=3 w=3
X661 P_B10 P_TOP sky130_fd_pr__cap_mim_m3_1 l=3 w=3
X662 P_B11 P_TOP sky130_fd_pr__cap_mim_m3_1 l=3 w=3
X663 N_B10 N_TOP sky130_fd_pr__cap_mim_m3_1 l=3 w=3
X664 P_B11 P_TOP sky130_fd_pr__cap_mim_m3_1 l=3 w=3
X665 N_B8 N_TOP sky130_fd_pr__cap_mim_m3_1 l=3 w=3
X666 P_B11 P_TOP sky130_fd_pr__cap_mim_m3_1 l=3 w=3
X667 N_B11 N_TOP sky130_fd_pr__cap_mim_m3_1 l=3 w=3
X668 N_B11 N_TOP sky130_fd_pr__cap_mim_m3_1 l=3 w=3
X669 N_B10 N_TOP sky130_fd_pr__cap_mim_m3_1 l=3 w=3
X670 N_B6 N_TOP sky130_fd_pr__cap_mim_m3_1 l=3 w=3
X671 N_B9 N_TOP sky130_fd_pr__cap_mim_m3_1 l=3 w=3
X672 P_B11 P_TOP sky130_fd_pr__cap_mim_m3_1 l=3 w=3
X673 N_B11 N_TOP sky130_fd_pr__cap_mim_m3_1 l=3 w=3
X674 N_B9 N_TOP sky130_fd_pr__cap_mim_m3_1 l=3 w=3
X675 P_B11 P_TOP sky130_fd_pr__cap_mim_m3_1 l=3 w=3
X676 P_B11 P_TOP sky130_fd_pr__cap_mim_m3_1 l=3 w=3
X677 N_B11 N_TOP sky130_fd_pr__cap_mim_m3_1 l=3 w=3
X678 P_B11 P_TOP sky130_fd_pr__cap_mim_m3_1 l=3 w=3
X679 N_B11 N_TOP sky130_fd_pr__cap_mim_m3_1 l=3 w=3
X680 N_B11 N_TOP sky130_fd_pr__cap_mim_m3_1 l=3 w=3
X681 P_B10 P_TOP sky130_fd_pr__cap_mim_m3_1 l=3 w=3
X682 N_EDGE_BIAS N_EDGE_BIAS sky130_fd_pr__cap_mim_m3_1 l=3 w=3
X683 N_B11 N_TOP sky130_fd_pr__cap_mim_m3_1 l=3 w=3
X684 P_B7 P_TOP sky130_fd_pr__cap_mim_m3_1 l=3 w=3
X685 N_B11 N_TOP sky130_fd_pr__cap_mim_m3_1 l=3 w=3
X686 N_B11 N_TOP sky130_fd_pr__cap_mim_m3_1 l=3 w=3
X687 P_B11 P_TOP sky130_fd_pr__cap_mim_m3_1 l=3 w=3
X688 P_B11 P_TOP sky130_fd_pr__cap_mim_m3_1 l=3 w=3
X689 N_B9 N_TOP sky130_fd_pr__cap_mim_m3_1 l=3 w=3
X690 N_EDGE_BIAS N_EDGE_BIAS sky130_fd_pr__cap_mim_m3_1 l=3 w=3
X691 P_B10 P_TOP sky130_fd_pr__cap_mim_m3_1 l=3 w=3
X692 P_B9 P_TOP sky130_fd_pr__cap_mim_m3_1 l=3 w=3
X693 P_B10 P_TOP sky130_fd_pr__cap_mim_m3_1 l=3 w=3
X694 P_B11 P_TOP sky130_fd_pr__cap_mim_m3_1 l=3 w=3
X695 N_B10 N_TOP sky130_fd_pr__cap_mim_m3_1 l=3 w=3
X696 P_B10 P_TOP sky130_fd_pr__cap_mim_m3_1 l=3 w=3
X697 N_B11 N_TOP sky130_fd_pr__cap_mim_m3_1 l=3 w=3
X698 P_B5 P_TOP sky130_fd_pr__cap_mim_m3_1 l=3 w=3
X699 N_B11 N_TOP sky130_fd_pr__cap_mim_m3_1 l=3 w=3
X700 P_B11 P_TOP sky130_fd_pr__cap_mim_m3_1 l=3 w=3
X701 P_B11 P_TOP sky130_fd_pr__cap_mim_m3_1 l=3 w=3
X702 P_B11 P_TOP sky130_fd_pr__cap_mim_m3_1 l=3 w=3
X703 P_B11 P_TOP sky130_fd_pr__cap_mim_m3_1 l=3 w=3
X704 N_B9 N_TOP sky130_fd_pr__cap_mim_m3_1 l=3 w=3
X705 N_B11 N_TOP sky130_fd_pr__cap_mim_m3_1 l=3 w=3
X706 P_B9 P_TOP sky130_fd_pr__cap_mim_m3_1 l=3 w=3
X707 P_B10 P_TOP sky130_fd_pr__cap_mim_m3_1 l=3 w=3
X708 P_B11 P_TOP sky130_fd_pr__cap_mim_m3_1 l=3 w=3
X709 P_B11 P_TOP sky130_fd_pr__cap_mim_m3_1 l=3 w=3
X710 N_B7 N_TOP sky130_fd_pr__cap_mim_m3_1 l=3 w=3
X711 N_B10 N_TOP sky130_fd_pr__cap_mim_m3_1 l=3 w=3
X712 P_B10 P_TOP sky130_fd_pr__cap_mim_m3_1 l=3 w=3
X713 N_B7 N_TOP sky130_fd_pr__cap_mim_m3_1 l=3 w=3
X714 P_EDGE_BIAS P_EDGE_BIAS sky130_fd_pr__cap_mim_m3_1 l=3 w=3
X715 P_B8 P_TOP sky130_fd_pr__cap_mim_m3_1 l=3 w=3
X716 N_B10 N_TOP sky130_fd_pr__cap_mim_m3_1 l=3 w=3
X717 P_EDGE_BIAS P_EDGE_BIAS sky130_fd_pr__cap_mim_m3_1 l=3 w=3
X718 N_B11 N_TOP sky130_fd_pr__cap_mim_m3_1 l=3 w=3
X719 P_B11 P_TOP sky130_fd_pr__cap_mim_m3_1 l=3 w=3
X720 N_B11 N_TOP sky130_fd_pr__cap_mim_m3_1 l=3 w=3
X721 N_B9 N_TOP sky130_fd_pr__cap_mim_m3_1 l=3 w=3
X722 N_B8 N_TOP sky130_fd_pr__cap_mim_m3_1 l=3 w=3
X723 P_B11 P_TOP sky130_fd_pr__cap_mim_m3_1 l=3 w=3
X724 P_B11 P_TOP sky130_fd_pr__cap_mim_m3_1 l=3 w=3
X725 N_B11 N_TOP sky130_fd_pr__cap_mim_m3_1 l=3 w=3
X726 N_B10 N_TOP sky130_fd_pr__cap_mim_m3_1 l=3 w=3
X727 N_B11 N_TOP sky130_fd_pr__cap_mim_m3_1 l=3 w=3
X728 N_B8 N_TOP sky130_fd_pr__cap_mim_m3_1 l=3 w=3
X729 N_B10 N_TOP sky130_fd_pr__cap_mim_m3_1 l=3 w=3
X730 P_B11 P_TOP sky130_fd_pr__cap_mim_m3_1 l=3 w=3
X731 N_B11 N_TOP sky130_fd_pr__cap_mim_m3_1 l=3 w=3
X732 N_B11 N_TOP sky130_fd_pr__cap_mim_m3_1 l=3 w=3
X733 P_B11 P_TOP sky130_fd_pr__cap_mim_m3_1 l=3 w=3
X734 N_B11 N_TOP sky130_fd_pr__cap_mim_m3_1 l=3 w=3
X735 P_B11 P_TOP sky130_fd_pr__cap_mim_m3_1 l=3 w=3
X736 N_B11 N_TOP sky130_fd_pr__cap_mim_m3_1 l=3 w=3
X737 N_B8 N_TOP sky130_fd_pr__cap_mim_m3_1 l=3 w=3
X738 P_B9 P_TOP sky130_fd_pr__cap_mim_m3_1 l=3 w=3
X739 N_B10 N_TOP sky130_fd_pr__cap_mim_m3_1 l=3 w=3
X740 P_B11 P_TOP sky130_fd_pr__cap_mim_m3_1 l=3 w=3
X741 N_B11 N_TOP sky130_fd_pr__cap_mim_m3_1 l=3 w=3
X742 P_B11 P_TOP sky130_fd_pr__cap_mim_m3_1 l=3 w=3
X743 N_EDGE_BIAS N_EDGE_BIAS sky130_fd_pr__cap_mim_m3_1 l=3 w=3
X744 N_EDGE_BIAS N_EDGE_BIAS sky130_fd_pr__cap_mim_m3_1 l=3 w=3
X745 N_B11 N_TOP sky130_fd_pr__cap_mim_m3_1 l=3 w=3
X746 N_B10 N_TOP sky130_fd_pr__cap_mim_m3_1 l=3 w=3
X747 N_B11 N_TOP sky130_fd_pr__cap_mim_m3_1 l=3 w=3
X748 P_B7 P_TOP sky130_fd_pr__cap_mim_m3_1 l=3 w=3
X749 P_B11 P_TOP sky130_fd_pr__cap_mim_m3_1 l=3 w=3
X750 N_EDGE_BIAS N_EDGE_BIAS sky130_fd_pr__cap_mim_m3_1 l=3 w=3
X751 P_B9 P_TOP sky130_fd_pr__cap_mim_m3_1 l=3 w=3
X752 P_B9 P_TOP sky130_fd_pr__cap_mim_m3_1 l=3 w=3
X753 N_B11 N_TOP sky130_fd_pr__cap_mim_m3_1 l=3 w=3
X754 N_B8 N_TOP sky130_fd_pr__cap_mim_m3_1 l=3 w=3
X755 N_B11 N_TOP sky130_fd_pr__cap_mim_m3_1 l=3 w=3
X756 P_B11 P_TOP sky130_fd_pr__cap_mim_m3_1 l=3 w=3
X757 P_B8 P_TOP sky130_fd_pr__cap_mim_m3_1 l=3 w=3
X758 N_B11 N_TOP sky130_fd_pr__cap_mim_m3_1 l=3 w=3
X759 N_B11 N_TOP sky130_fd_pr__cap_mim_m3_1 l=3 w=3
X760 P_B8 P_TOP sky130_fd_pr__cap_mim_m3_1 l=3 w=3
X761 P_B10 P_TOP sky130_fd_pr__cap_mim_m3_1 l=3 w=3
X762 N_B10 N_TOP sky130_fd_pr__cap_mim_m3_1 l=3 w=3
X763 N_B10 N_TOP sky130_fd_pr__cap_mim_m3_1 l=3 w=3
X764 P_B9 P_TOP sky130_fd_pr__cap_mim_m3_1 l=3 w=3
X765 N_B11 N_TOP sky130_fd_pr__cap_mim_m3_1 l=3 w=3
X766 P_B10 P_TOP sky130_fd_pr__cap_mim_m3_1 l=3 w=3
X767 N_B7 N_TOP sky130_fd_pr__cap_mim_m3_1 l=3 w=3
X768 N_B11 N_TOP sky130_fd_pr__cap_mim_m3_1 l=3 w=3
X769 P_B7 P_TOP sky130_fd_pr__cap_mim_m3_1 l=3 w=3
X770 N_B11 N_TOP sky130_fd_pr__cap_mim_m3_1 l=3 w=3
X771 P_B10 P_TOP sky130_fd_pr__cap_mim_m3_1 l=3 w=3
X772 P_B10 P_TOP sky130_fd_pr__cap_mim_m3_1 l=3 w=3
X773 N_B11 N_TOP sky130_fd_pr__cap_mim_m3_1 l=3 w=3
X774 N_B8 N_TOP sky130_fd_pr__cap_mim_m3_1 l=3 w=3
X775 N_B10 N_TOP sky130_fd_pr__cap_mim_m3_1 l=3 w=3
X776 P_B10 P_TOP sky130_fd_pr__cap_mim_m3_1 l=3 w=3
X777 P_B11 P_TOP sky130_fd_pr__cap_mim_m3_1 l=3 w=3
X778 N_B11 N_TOP sky130_fd_pr__cap_mim_m3_1 l=3 w=3
X779 N_B6 N_TOP sky130_fd_pr__cap_mim_m3_1 l=3 w=3
X780 N_B11 N_TOP sky130_fd_pr__cap_mim_m3_1 l=3 w=3
X781 N_B10 N_TOP sky130_fd_pr__cap_mim_m3_1 l=3 w=3
X782 N_B11 N_TOP sky130_fd_pr__cap_mim_m3_1 l=3 w=3
X783 N_B9 N_TOP sky130_fd_pr__cap_mim_m3_1 l=3 w=3
X784 N_B9 N_TOP sky130_fd_pr__cap_mim_m3_1 l=3 w=3
X785 N_B11 N_TOP sky130_fd_pr__cap_mim_m3_1 l=3 w=3
X786 P_B11 P_TOP sky130_fd_pr__cap_mim_m3_1 l=3 w=3
X787 N_B9 N_TOP sky130_fd_pr__cap_mim_m3_1 l=3 w=3
X788 P_B11 P_TOP sky130_fd_pr__cap_mim_m3_1 l=3 w=3
X789 P_B11 P_TOP sky130_fd_pr__cap_mim_m3_1 l=3 w=3
X790 P_B11 P_TOP sky130_fd_pr__cap_mim_m3_1 l=3 w=3
X791 N_B10 N_TOP sky130_fd_pr__cap_mim_m3_1 l=3 w=3
X792 P_B11 P_TOP sky130_fd_pr__cap_mim_m3_1 l=3 w=3
X793 N_B9 N_TOP sky130_fd_pr__cap_mim_m3_1 l=3 w=3
X794 P_B8 P_TOP sky130_fd_pr__cap_mim_m3_1 l=3 w=3
X795 N_B11 N_TOP sky130_fd_pr__cap_mim_m3_1 l=3 w=3
X796 P_B11 P_TOP sky130_fd_pr__cap_mim_m3_1 l=3 w=3
X797 N_B10 N_TOP sky130_fd_pr__cap_mim_m3_1 l=3 w=3
X798 P_B11 P_TOP sky130_fd_pr__cap_mim_m3_1 l=3 w=3
X799 N_B11 N_TOP sky130_fd_pr__cap_mim_m3_1 l=3 w=3
X800 N_B9 N_TOP sky130_fd_pr__cap_mim_m3_1 l=3 w=3
X801 P_B9 P_TOP sky130_fd_pr__cap_mim_m3_1 l=3 w=3
X802 P_B11 P_TOP sky130_fd_pr__cap_mim_m3_1 l=3 w=3
X803 P_B11 P_TOP sky130_fd_pr__cap_mim_m3_1 l=3 w=3
X804 N_EDGE_BIAS N_EDGE_BIAS sky130_fd_pr__cap_mim_m3_1 l=3 w=3
X805 P_B0 P_TOP sky130_fd_pr__cap_mim_m3_1 l=3 w=3
X806 N_B11 N_TOP sky130_fd_pr__cap_mim_m3_1 l=3 w=3
X807 P_B10 P_TOP sky130_fd_pr__cap_mim_m3_1 l=3 w=3
X808 N_B11 N_TOP sky130_fd_pr__cap_mim_m3_1 l=3 w=3
X809 N_B11 N_TOP sky130_fd_pr__cap_mim_m3_1 l=3 w=3
X810 P_EDGE_BIAS P_EDGE_BIAS sky130_fd_pr__cap_mim_m3_1 l=3 w=3
X811 P_B10 P_TOP sky130_fd_pr__cap_mim_m3_1 l=3 w=3
X812 N_B11 N_TOP sky130_fd_pr__cap_mim_m3_1 l=3 w=3
X813 P_B6 P_TOP sky130_fd_pr__cap_mim_m3_1 l=3 w=3
X814 N_B9 N_TOP sky130_fd_pr__cap_mim_m3_1 l=3 w=3
X815 N_B11 N_TOP sky130_fd_pr__cap_mim_m3_1 l=3 w=3
X816 N_B11 N_TOP sky130_fd_pr__cap_mim_m3_1 l=3 w=3
X817 N_B9 N_TOP sky130_fd_pr__cap_mim_m3_1 l=3 w=3
X818 N_B10 N_TOP sky130_fd_pr__cap_mim_m3_1 l=3 w=3
X819 P_B11 P_TOP sky130_fd_pr__cap_mim_m3_1 l=3 w=3
X820 N_B11 N_TOP sky130_fd_pr__cap_mim_m3_1 l=3 w=3
X821 N_B7 N_TOP sky130_fd_pr__cap_mim_m3_1 l=3 w=3
X822 P_B7 P_TOP sky130_fd_pr__cap_mim_m3_1 l=3 w=3
X823 N_B10 N_TOP sky130_fd_pr__cap_mim_m3_1 l=3 w=3
X824 P_B11 P_TOP sky130_fd_pr__cap_mim_m3_1 l=3 w=3
X825 P_EDGE_BIAS P_EDGE_BIAS sky130_fd_pr__cap_mim_m3_1 l=3 w=3
X826 N_B10 N_TOP sky130_fd_pr__cap_mim_m3_1 l=3 w=3
X827 N_EDGE_BIAS N_EDGE_BIAS sky130_fd_pr__cap_mim_m3_1 l=3 w=3
X828 N_B11 N_TOP sky130_fd_pr__cap_mim_m3_1 l=3 w=3
X829 N_B9 N_TOP sky130_fd_pr__cap_mim_m3_1 l=3 w=3
X830 P_B11 P_TOP sky130_fd_pr__cap_mim_m3_1 l=3 w=3
X831 N_B8 N_TOP sky130_fd_pr__cap_mim_m3_1 l=3 w=3
X832 N_B10 N_TOP sky130_fd_pr__cap_mim_m3_1 l=3 w=3
X833 P_B11 P_TOP sky130_fd_pr__cap_mim_m3_1 l=3 w=3
X834 N_B11 N_TOP sky130_fd_pr__cap_mim_m3_1 l=3 w=3
X835 N_B10 N_TOP sky130_fd_pr__cap_mim_m3_1 l=3 w=3
X836 P_B11 P_TOP sky130_fd_pr__cap_mim_m3_1 l=3 w=3
X837 N_B11 N_TOP sky130_fd_pr__cap_mim_m3_1 l=3 w=3
X838 P_B11 P_TOP sky130_fd_pr__cap_mim_m3_1 l=3 w=3
X839 P_B11 P_TOP sky130_fd_pr__cap_mim_m3_1 l=3 w=3
X840 P_B11 P_TOP sky130_fd_pr__cap_mim_m3_1 l=3 w=3
X841 N_EDGE_BIAS N_EDGE_BIAS sky130_fd_pr__cap_mim_m3_1 l=3 w=3
X842 N_B11 N_TOP sky130_fd_pr__cap_mim_m3_1 l=3 w=3
X843 P_B11 P_TOP sky130_fd_pr__cap_mim_m3_1 l=3 w=3
X844 P_B11 P_TOP sky130_fd_pr__cap_mim_m3_1 l=3 w=3
X845 N_B10 N_TOP sky130_fd_pr__cap_mim_m3_1 l=3 w=3
X846 N_B10 N_TOP sky130_fd_pr__cap_mim_m3_1 l=3 w=3
X847 N_B11 N_TOP sky130_fd_pr__cap_mim_m3_1 l=3 w=3
X848 P_B10 P_TOP sky130_fd_pr__cap_mim_m3_1 l=3 w=3
X849 P_B11 P_TOP sky130_fd_pr__cap_mim_m3_1 l=3 w=3
X850 N_B11 N_TOP sky130_fd_pr__cap_mim_m3_1 l=3 w=3
X851 N_B11 N_TOP sky130_fd_pr__cap_mim_m3_1 l=3 w=3
X852 N_B11 N_TOP sky130_fd_pr__cap_mim_m3_1 l=3 w=3
X853 P_B11 P_TOP sky130_fd_pr__cap_mim_m3_1 l=3 w=3
X854 N_B11 N_TOP sky130_fd_pr__cap_mim_m3_1 l=3 w=3
X855 P_B11 P_TOP sky130_fd_pr__cap_mim_m3_1 l=3 w=3
X856 P_B9 P_TOP sky130_fd_pr__cap_mim_m3_1 l=3 w=3
X857 P_B8 P_TOP sky130_fd_pr__cap_mim_m3_1 l=3 w=3
X858 N_B11 N_TOP sky130_fd_pr__cap_mim_m3_1 l=3 w=3
X859 P_B11 P_TOP sky130_fd_pr__cap_mim_m3_1 l=3 w=3
X860 P_B11 P_TOP sky130_fd_pr__cap_mim_m3_1 l=3 w=3
X861 P_B11 P_TOP sky130_fd_pr__cap_mim_m3_1 l=3 w=3
X862 N_B11 N_TOP sky130_fd_pr__cap_mim_m3_1 l=3 w=3
X863 P_B8 P_TOP sky130_fd_pr__cap_mim_m3_1 l=3 w=3
X864 N_B10 N_TOP sky130_fd_pr__cap_mim_m3_1 l=3 w=3
X865 P_B11 P_TOP sky130_fd_pr__cap_mim_m3_1 l=3 w=3
X866 N_B10 N_TOP sky130_fd_pr__cap_mim_m3_1 l=3 w=3
X867 N_B11 N_TOP sky130_fd_pr__cap_mim_m3_1 l=3 w=3
X868 N_B9 N_TOP sky130_fd_pr__cap_mim_m3_1 l=3 w=3
X869 P_B11 P_TOP sky130_fd_pr__cap_mim_m3_1 l=3 w=3
X870 P_B10 P_TOP sky130_fd_pr__cap_mim_m3_1 l=3 w=3
X871 N_B7 N_TOP sky130_fd_pr__cap_mim_m3_1 l=3 w=3
X872 N_B11 N_TOP sky130_fd_pr__cap_mim_m3_1 l=3 w=3
X873 N_B11 N_TOP sky130_fd_pr__cap_mim_m3_1 l=3 w=3
X874 N_B8 N_TOP sky130_fd_pr__cap_mim_m3_1 l=3 w=3
X875 P_B8 P_TOP sky130_fd_pr__cap_mim_m3_1 l=3 w=3
X876 N_B10 N_TOP sky130_fd_pr__cap_mim_m3_1 l=3 w=3
X877 N_B11 N_TOP sky130_fd_pr__cap_mim_m3_1 l=3 w=3
X878 P_B11 P_TOP sky130_fd_pr__cap_mim_m3_1 l=3 w=3
X879 N_B10 N_TOP sky130_fd_pr__cap_mim_m3_1 l=3 w=3
X880 P_B11 P_TOP sky130_fd_pr__cap_mim_m3_1 l=3 w=3
X881 N_B11 N_TOP sky130_fd_pr__cap_mim_m3_1 l=3 w=3
X882 N_B11 N_TOP sky130_fd_pr__cap_mim_m3_1 l=3 w=3
X883 N_B8 N_TOP sky130_fd_pr__cap_mim_m3_1 l=3 w=3
X884 N_B11 N_TOP sky130_fd_pr__cap_mim_m3_1 l=3 w=3
X885 N_B10 N_TOP sky130_fd_pr__cap_mim_m3_1 l=3 w=3
X886 N_B6 N_TOP sky130_fd_pr__cap_mim_m3_1 l=3 w=3
X887 N_B11 N_TOP sky130_fd_pr__cap_mim_m3_1 l=3 w=3
X888 P_B11 P_TOP sky130_fd_pr__cap_mim_m3_1 l=3 w=3
X889 N_B11 N_TOP sky130_fd_pr__cap_mim_m3_1 l=3 w=3
X890 N_B11 N_TOP sky130_fd_pr__cap_mim_m3_1 l=3 w=3
X891 N_B9 N_TOP sky130_fd_pr__cap_mim_m3_1 l=3 w=3
X892 P_B11 P_TOP sky130_fd_pr__cap_mim_m3_1 l=3 w=3
X893 N_B10 N_TOP sky130_fd_pr__cap_mim_m3_1 l=3 w=3
X894 P_B11 P_TOP sky130_fd_pr__cap_mim_m3_1 l=3 w=3
X895 P_B11 P_TOP sky130_fd_pr__cap_mim_m3_1 l=3 w=3
X896 N_EDGE_BIAS N_EDGE_BIAS sky130_fd_pr__cap_mim_m3_1 l=3 w=3
X897 P_B11 P_TOP sky130_fd_pr__cap_mim_m3_1 l=3 w=3
X898 P_B10 P_TOP sky130_fd_pr__cap_mim_m3_1 l=3 w=3
X899 P_B11 P_TOP sky130_fd_pr__cap_mim_m3_1 l=3 w=3
X900 N_B11 N_TOP sky130_fd_pr__cap_mim_m3_1 l=3 w=3
X901 N_B11 N_TOP sky130_fd_pr__cap_mim_m3_1 l=3 w=3
X902 N_B11 N_TOP sky130_fd_pr__cap_mim_m3_1 l=3 w=3
X903 P_B11 P_TOP sky130_fd_pr__cap_mim_m3_1 l=3 w=3
X904 P_B11 P_TOP sky130_fd_pr__cap_mim_m3_1 l=3 w=3
X905 P_B9 P_TOP sky130_fd_pr__cap_mim_m3_1 l=3 w=3
X906 N_B9 N_TOP sky130_fd_pr__cap_mim_m3_1 l=3 w=3
X907 P_B11 P_TOP sky130_fd_pr__cap_mim_m3_1 l=3 w=3
X908 N_B11 N_TOP sky130_fd_pr__cap_mim_m3_1 l=3 w=3
X909 P_B9 P_TOP sky130_fd_pr__cap_mim_m3_1 l=3 w=3
X910 P_B10 P_TOP sky130_fd_pr__cap_mim_m3_1 l=3 w=3
X911 P_B1 P_TOP sky130_fd_pr__cap_mim_m3_1 l=3 w=3
X912 N_B10 N_TOP sky130_fd_pr__cap_mim_m3_1 l=3 w=3
X913 N_B11 N_TOP sky130_fd_pr__cap_mim_m3_1 l=3 w=3
X914 P_B10 P_TOP sky130_fd_pr__cap_mim_m3_1 l=3 w=3
X915 P_B11 P_TOP sky130_fd_pr__cap_mim_m3_1 l=3 w=3
X916 N_B11 N_TOP sky130_fd_pr__cap_mim_m3_1 l=3 w=3
X917 N_B11 N_TOP sky130_fd_pr__cap_mim_m3_1 l=3 w=3
X918 P_B11 P_TOP sky130_fd_pr__cap_mim_m3_1 l=3 w=3
X919 N_B11 N_TOP sky130_fd_pr__cap_mim_m3_1 l=3 w=3
X920 P_B10 P_TOP sky130_fd_pr__cap_mim_m3_1 l=3 w=3
X921 P_B9 P_TOP sky130_fd_pr__cap_mim_m3_1 l=3 w=3
X922 N_B9 N_TOP sky130_fd_pr__cap_mim_m3_1 l=3 w=3
X923 P_B11 P_TOP sky130_fd_pr__cap_mim_m3_1 l=3 w=3
X924 N_B11 N_TOP sky130_fd_pr__cap_mim_m3_1 l=3 w=3
X925 N_B9 N_TOP sky130_fd_pr__cap_mim_m3_1 l=3 w=3
X926 N_B10 N_TOP sky130_fd_pr__cap_mim_m3_1 l=3 w=3
X927 P_B10 P_TOP sky130_fd_pr__cap_mim_m3_1 l=3 w=3
X928 N_B10 N_TOP sky130_fd_pr__cap_mim_m3_1 l=3 w=3
X929 P_B11 P_TOP sky130_fd_pr__cap_mim_m3_1 l=3 w=3
X930 N_B7 N_TOP sky130_fd_pr__cap_mim_m3_1 l=3 w=3
X931 N_B11 N_TOP sky130_fd_pr__cap_mim_m3_1 l=3 w=3
X932 P_B10 P_TOP sky130_fd_pr__cap_mim_m3_1 l=3 w=3
X933 P_EDGE_BIAS P_EDGE_BIAS sky130_fd_pr__cap_mim_m3_1 l=3 w=3
X934 P_EDGE_BIAS P_EDGE_BIAS sky130_fd_pr__cap_mim_m3_1 l=3 w=3
X935 N_B11 N_TOP sky130_fd_pr__cap_mim_m3_1 l=3 w=3
X936 P_B11 P_TOP sky130_fd_pr__cap_mim_m3_1 l=3 w=3
X937 N_B9 N_TOP sky130_fd_pr__cap_mim_m3_1 l=3 w=3
X938 N_B9 N_TOP sky130_fd_pr__cap_mim_m3_1 l=3 w=3
X939 N_B11 N_TOP sky130_fd_pr__cap_mim_m3_1 l=3 w=3
X940 N_B10 N_TOP sky130_fd_pr__cap_mim_m3_1 l=3 w=3
X941 P_B11 P_TOP sky130_fd_pr__cap_mim_m3_1 l=3 w=3
X942 N_B8 N_TOP sky130_fd_pr__cap_mim_m3_1 l=3 w=3
X943 N_B10 N_TOP sky130_fd_pr__cap_mim_m3_1 l=3 w=3
X944 N_B11 N_TOP sky130_fd_pr__cap_mim_m3_1 l=3 w=3
X945 P_B11 P_TOP sky130_fd_pr__cap_mim_m3_1 l=3 w=3
X946 N_B11 N_TOP sky130_fd_pr__cap_mim_m3_1 l=3 w=3
X947 P_B11 P_TOP sky130_fd_pr__cap_mim_m3_1 l=3 w=3
X948 N_B9 N_TOP sky130_fd_pr__cap_mim_m3_1 l=3 w=3
X949 P_B11 P_TOP sky130_fd_pr__cap_mim_m3_1 l=3 w=3
X950 P_B11 P_TOP sky130_fd_pr__cap_mim_m3_1 l=3 w=3
X951 P_B11 P_TOP sky130_fd_pr__cap_mim_m3_1 l=3 w=3
X952 N_EDGE_BIAS N_EDGE_BIAS sky130_fd_pr__cap_mim_m3_1 l=3 w=3
X953 P_B11 P_TOP sky130_fd_pr__cap_mim_m3_1 l=3 w=3
X954 N_B10 N_TOP sky130_fd_pr__cap_mim_m3_1 l=3 w=3
X955 N_B11 N_TOP sky130_fd_pr__cap_mim_m3_1 l=3 w=3
X956 P_B9 P_TOP sky130_fd_pr__cap_mim_m3_1 l=3 w=3
X957 P_B11 P_TOP sky130_fd_pr__cap_mim_m3_1 l=3 w=3
X958 N_EDGE_BIAS N_EDGE_BIAS sky130_fd_pr__cap_mim_m3_1 l=3 w=3
X959 N_B11 N_TOP sky130_fd_pr__cap_mim_m3_1 l=3 w=3
X960 P_B11 P_TOP sky130_fd_pr__cap_mim_m3_1 l=3 w=3
X961 N_B10 N_TOP sky130_fd_pr__cap_mim_m3_1 l=3 w=3
X962 P_B10 P_TOP sky130_fd_pr__cap_mim_m3_1 l=3 w=3
X963 P_B11 P_TOP sky130_fd_pr__cap_mim_m3_1 l=3 w=3
X964 P_B10 P_TOP sky130_fd_pr__cap_mim_m3_1 l=3 w=3
X965 N_B11 N_TOP sky130_fd_pr__cap_mim_m3_1 l=3 w=3
X966 P_B11 P_TOP sky130_fd_pr__cap_mim_m3_1 l=3 w=3
X967 P_B11 P_TOP sky130_fd_pr__cap_mim_m3_1 l=3 w=3
X968 P_B9 P_TOP sky130_fd_pr__cap_mim_m3_1 l=3 w=3
X969 N_B11 N_TOP sky130_fd_pr__cap_mim_m3_1 l=3 w=3
X970 P_B11 P_TOP sky130_fd_pr__cap_mim_m3_1 l=3 w=3
X971 P_B10 P_TOP sky130_fd_pr__cap_mim_m3_1 l=3 w=3
X972 N_EDGE_BIAS N_EDGE_BIAS sky130_fd_pr__cap_mim_m3_1 l=3 w=3
X973 N_B8 N_TOP sky130_fd_pr__cap_mim_m3_1 l=3 w=3
X974 P_B8 P_TOP sky130_fd_pr__cap_mim_m3_1 l=3 w=3
X975 N_B11 N_TOP sky130_fd_pr__cap_mim_m3_1 l=3 w=3
X976 N_B11 N_TOP sky130_fd_pr__cap_mim_m3_1 l=3 w=3
X977 N_B11 N_TOP sky130_fd_pr__cap_mim_m3_1 l=3 w=3
X978 N_B11 N_TOP sky130_fd_pr__cap_mim_m3_1 l=3 w=3
X979 P_B10 P_TOP sky130_fd_pr__cap_mim_m3_1 l=3 w=3
X980 N_B10 N_TOP sky130_fd_pr__cap_mim_m3_1 l=3 w=3
X981 P_B10 P_TOP sky130_fd_pr__cap_mim_m3_1 l=3 w=3
X982 P_EDGE_BIAS P_EDGE_BIAS sky130_fd_pr__cap_mim_m3_1 l=3 w=3
X983 P_B10 P_TOP sky130_fd_pr__cap_mim_m3_1 l=3 w=3
X984 N_B7 N_TOP sky130_fd_pr__cap_mim_m3_1 l=3 w=3
X985 P_B7 P_TOP sky130_fd_pr__cap_mim_m3_1 l=3 w=3
X986 N_B9 N_TOP sky130_fd_pr__cap_mim_m3_1 l=3 w=3
X987 N_B11 N_TOP sky130_fd_pr__cap_mim_m3_1 l=3 w=3
X988 P_B11 P_TOP sky130_fd_pr__cap_mim_m3_1 l=3 w=3
X989 N_B11 N_TOP sky130_fd_pr__cap_mim_m3_1 l=3 w=3
X990 N_B9 N_TOP sky130_fd_pr__cap_mim_m3_1 l=3 w=3
X991 P_B10 P_TOP sky130_fd_pr__cap_mim_m3_1 l=3 w=3
X992 P_B11 P_TOP sky130_fd_pr__cap_mim_m3_1 l=3 w=3
X993 P_EDGE_BIAS P_EDGE_BIAS sky130_fd_pr__cap_mim_m3_1 l=3 w=3
X994 N_B10 N_TOP sky130_fd_pr__cap_mim_m3_1 l=3 w=3
X995 N_B10 N_TOP sky130_fd_pr__cap_mim_m3_1 l=3 w=3
X996 N_B10 N_TOP sky130_fd_pr__cap_mim_m3_1 l=3 w=3
X997 N_EDGE_BIAS N_EDGE_BIAS sky130_fd_pr__cap_mim_m3_1 l=3 w=3
X998 N_B6 N_TOP sky130_fd_pr__cap_mim_m3_1 l=3 w=3
X999 N_B8 N_TOP sky130_fd_pr__cap_mim_m3_1 l=3 w=3
X1000 P_EDGE_BIAS P_EDGE_BIAS sky130_fd_pr__cap_mim_m3_1 l=3 w=3
X1001 N_B11 N_TOP sky130_fd_pr__cap_mim_m3_1 l=3 w=3
X1002 N_B10 N_TOP sky130_fd_pr__cap_mim_m3_1 l=3 w=3
X1003 N_B5 N_TOP sky130_fd_pr__cap_mim_m3_1 l=3 w=3
X1004 P_B11 P_TOP sky130_fd_pr__cap_mim_m3_1 l=3 w=3
X1005 N_B11 N_TOP sky130_fd_pr__cap_mim_m3_1 l=3 w=3
X1006 N_B9 N_TOP sky130_fd_pr__cap_mim_m3_1 l=3 w=3
X1007 P_B11 P_TOP sky130_fd_pr__cap_mim_m3_1 l=3 w=3
X1008 N_EDGE_BIAS N_EDGE_BIAS sky130_fd_pr__cap_mim_m3_1 l=3 w=3
X1009 N_EDGE_BIAS N_EDGE_BIAS sky130_fd_pr__cap_mim_m3_1 l=3 w=3
X1010 P_B11 P_TOP sky130_fd_pr__cap_mim_m3_1 l=3 w=3
X1011 N_B11 N_TOP sky130_fd_pr__cap_mim_m3_1 l=3 w=3
X1012 P_EDGE_BIAS P_EDGE_BIAS sky130_fd_pr__cap_mim_m3_1 l=3 w=3
X1013 N_B10 N_TOP sky130_fd_pr__cap_mim_m3_1 l=3 w=3
X1014 N_EDGE_BIAS N_EDGE_BIAS sky130_fd_pr__cap_mim_m3_1 l=3 w=3
X1015 P_B11 P_TOP sky130_fd_pr__cap_mim_m3_1 l=3 w=3
X1016 P_B11 P_TOP sky130_fd_pr__cap_mim_m3_1 l=3 w=3
X1017 N_B9 N_TOP sky130_fd_pr__cap_mim_m3_1 l=3 w=3
X1018 P_B10 P_TOP sky130_fd_pr__cap_mim_m3_1 l=3 w=3
X1019 P_B9 P_TOP sky130_fd_pr__cap_mim_m3_1 l=3 w=3
X1020 N_B11 N_TOP sky130_fd_pr__cap_mim_m3_1 l=3 w=3
X1021 P_B11 P_TOP sky130_fd_pr__cap_mim_m3_1 l=3 w=3
X1022 N_B11 N_TOP sky130_fd_pr__cap_mim_m3_1 l=3 w=3
X1023 P_B10 P_TOP sky130_fd_pr__cap_mim_m3_1 l=3 w=3
X1024 P_B11 P_TOP sky130_fd_pr__cap_mim_m3_1 l=3 w=3
X1025 P_B10 P_TOP sky130_fd_pr__cap_mim_m3_1 l=3 w=3
X1026 P_B10 P_TOP sky130_fd_pr__cap_mim_m3_1 l=3 w=3
X1027 N_B11 N_TOP sky130_fd_pr__cap_mim_m3_1 l=3 w=3
X1028 N_B11 N_TOP sky130_fd_pr__cap_mim_m3_1 l=3 w=3
X1029 P_B11 P_TOP sky130_fd_pr__cap_mim_m3_1 l=3 w=3
X1030 P_B11 P_TOP sky130_fd_pr__cap_mim_m3_1 l=3 w=3
X1031 P_B9 P_TOP sky130_fd_pr__cap_mim_m3_1 l=3 w=3
X1032 N_B9 N_TOP sky130_fd_pr__cap_mim_m3_1 l=3 w=3
X1033 N_B11 N_TOP sky130_fd_pr__cap_mim_m3_1 l=3 w=3
X1034 P_B9 P_TOP sky130_fd_pr__cap_mim_m3_1 l=3 w=3
X1035 P_B10 P_TOP sky130_fd_pr__cap_mim_m3_1 l=3 w=3
X1036 P_B11 P_TOP sky130_fd_pr__cap_mim_m3_1 l=3 w=3
X1037 N_B7 N_TOP sky130_fd_pr__cap_mim_m3_1 l=3 w=3
X1038 P_B7 P_TOP sky130_fd_pr__cap_mim_m3_1 l=3 w=3
X1039 N_B10 N_TOP sky130_fd_pr__cap_mim_m3_1 l=3 w=3
X1040 P_B10 P_TOP sky130_fd_pr__cap_mim_m3_1 l=3 w=3
X1041 P_EDGE_BIAS P_EDGE_BIAS sky130_fd_pr__cap_mim_m3_1 l=3 w=3
X1042 N_B11 N_TOP sky130_fd_pr__cap_mim_m3_1 l=3 w=3
X1043 N_B9 N_TOP sky130_fd_pr__cap_mim_m3_1 l=3 w=3
X1044 N_B11 N_TOP sky130_fd_pr__cap_mim_m3_1 l=3 w=3
X1045 N_B11 N_TOP sky130_fd_pr__cap_mim_m3_1 l=3 w=3
X1046 N_B9 N_TOP sky130_fd_pr__cap_mim_m3_1 l=3 w=3
X1047 N_B8 N_TOP sky130_fd_pr__cap_mim_m3_1 l=3 w=3
X1048 P_B9 P_TOP sky130_fd_pr__cap_mim_m3_1 l=3 w=3
X1049 P_B11 P_TOP sky130_fd_pr__cap_mim_m3_1 l=3 w=3
X1050 N_B8 N_TOP sky130_fd_pr__cap_mim_m3_1 l=3 w=3
X1051 N_B10 N_TOP sky130_fd_pr__cap_mim_m3_1 l=3 w=3
X1052 N_B8 N_TOP sky130_fd_pr__cap_mim_m3_1 l=3 w=3
X1053 P_B11 P_TOP sky130_fd_pr__cap_mim_m3_1 l=3 w=3
X1054 P_B11 P_TOP sky130_fd_pr__cap_mim_m3_1 l=3 w=3
X1055 N_B11 N_TOP sky130_fd_pr__cap_mim_m3_1 l=3 w=3
X1056 N_B11 N_TOP sky130_fd_pr__cap_mim_m3_1 l=3 w=3
X1057 P_B11 P_TOP sky130_fd_pr__cap_mim_m3_1 l=3 w=3
X1058 N_EDGE_BIAS N_EDGE_BIAS sky130_fd_pr__cap_mim_m3_1 l=3 w=3
X1059 N_B11 N_TOP sky130_fd_pr__cap_mim_m3_1 l=3 w=3
X1060 N_B8 N_TOP sky130_fd_pr__cap_mim_m3_1 l=3 w=3
X1061 N_B10 N_TOP sky130_fd_pr__cap_mim_m3_1 l=3 w=3
X1062 P_B11 P_TOP sky130_fd_pr__cap_mim_m3_1 l=3 w=3
X1063 N_B11 N_TOP sky130_fd_pr__cap_mim_m3_1 l=3 w=3
X1064 P_B10 P_TOP sky130_fd_pr__cap_mim_m3_1 l=3 w=3
X1065 N_B11 N_TOP sky130_fd_pr__cap_mim_m3_1 l=3 w=3
X1066 N_B11 N_TOP sky130_fd_pr__cap_mim_m3_1 l=3 w=3
X1067 N_EDGE_BIAS N_EDGE_BIAS sky130_fd_pr__cap_mim_m3_1 l=3 w=3
X1068 P_B11 P_TOP sky130_fd_pr__cap_mim_m3_1 l=3 w=3
X1069 N_B11 N_TOP sky130_fd_pr__cap_mim_m3_1 l=3 w=3
X1070 P_B9 P_TOP sky130_fd_pr__cap_mim_m3_1 l=3 w=3
X1071 P_B8 P_TOP sky130_fd_pr__cap_mim_m3_1 l=3 w=3
X1072 P_B9 P_TOP sky130_fd_pr__cap_mim_m3_1 l=3 w=3
X1073 N_B11 N_TOP sky130_fd_pr__cap_mim_m3_1 l=3 w=3
X1074 P_B11 P_TOP sky130_fd_pr__cap_mim_m3_1 l=3 w=3
X1075 N_B11 N_TOP sky130_fd_pr__cap_mim_m3_1 l=3 w=3
X1076 P_B8 P_TOP sky130_fd_pr__cap_mim_m3_1 l=3 w=3
X1077 N_B11 N_TOP sky130_fd_pr__cap_mim_m3_1 l=3 w=3
X1078 N_B11 N_TOP sky130_fd_pr__cap_mim_m3_1 l=3 w=3
X1079 N_B11 N_TOP sky130_fd_pr__cap_mim_m3_1 l=3 w=3
X1080 P_B11 P_TOP sky130_fd_pr__cap_mim_m3_1 l=3 w=3
X1081 P_B10 P_TOP sky130_fd_pr__cap_mim_m3_1 l=3 w=3
X1082 N_B10 N_TOP sky130_fd_pr__cap_mim_m3_1 l=3 w=3
X1083 P_B9 P_TOP sky130_fd_pr__cap_mim_m3_1 l=3 w=3
X1084 P_B10 P_TOP sky130_fd_pr__cap_mim_m3_1 l=3 w=3
X1085 N_B7 N_TOP sky130_fd_pr__cap_mim_m3_1 l=3 w=3
X1086 N_B11 N_TOP sky130_fd_pr__cap_mim_m3_1 l=3 w=3
X1087 P_B7 P_TOP sky130_fd_pr__cap_mim_m3_1 l=3 w=3
X1088 N_B11 N_TOP sky130_fd_pr__cap_mim_m3_1 l=3 w=3
X1089 P_B11 P_TOP sky130_fd_pr__cap_mim_m3_1 l=3 w=3
X1090 N_B11 N_TOP sky130_fd_pr__cap_mim_m3_1 l=3 w=3
X1091 P_B10 P_TOP sky130_fd_pr__cap_mim_m3_1 l=3 w=3
X1092 N_B10 N_TOP sky130_fd_pr__cap_mim_m3_1 l=3 w=3
X1093 N_B6 N_TOP sky130_fd_pr__cap_mim_m3_1 l=3 w=3
X1094 N_B11 N_TOP sky130_fd_pr__cap_mim_m3_1 l=3 w=3
X1095 N_B10 N_TOP sky130_fd_pr__cap_mim_m3_1 l=3 w=3
X1096 P_B11 P_TOP sky130_fd_pr__cap_mim_m3_1 l=3 w=3
X1097 N_B10 N_TOP sky130_fd_pr__cap_mim_m3_1 l=3 w=3
X1098 N_B6 N_TOP sky130_fd_pr__cap_mim_m3_1 l=3 w=3
X1099 N_B11 N_TOP sky130_fd_pr__cap_mim_m3_1 l=3 w=3
X1100 N_B10 N_TOP sky130_fd_pr__cap_mim_m3_1 l=3 w=3
X1101 P_B11 P_TOP sky130_fd_pr__cap_mim_m3_1 l=3 w=3
X1102 P_B11 P_TOP sky130_fd_pr__cap_mim_m3_1 l=3 w=3
X1103 P_B11 P_TOP sky130_fd_pr__cap_mim_m3_1 l=3 w=3
X1104 N_EDGE_BIAS N_EDGE_BIAS sky130_fd_pr__cap_mim_m3_1 l=3 w=3
X1105 N_B9 N_TOP sky130_fd_pr__cap_mim_m3_1 l=3 w=3
X1106 P_B11 P_TOP sky130_fd_pr__cap_mim_m3_1 l=3 w=3
X1107 N_B10 N_TOP sky130_fd_pr__cap_mim_m3_1 l=3 w=3
X1108 P_B11 P_TOP sky130_fd_pr__cap_mim_m3_1 l=3 w=3
X1109 N_B11 N_TOP sky130_fd_pr__cap_mim_m3_1 l=3 w=3
X1110 N_B10 N_TOP sky130_fd_pr__cap_mim_m3_1 l=3 w=3
X1111 P_B11 P_TOP sky130_fd_pr__cap_mim_m3_1 l=3 w=3
X1112 N_EDGE_BIAS N_EDGE_BIAS sky130_fd_pr__cap_mim_m3_1 l=3 w=3
X1113 P_B8 P_TOP sky130_fd_pr__cap_mim_m3_1 l=3 w=3
X1114 N_B11 N_TOP sky130_fd_pr__cap_mim_m3_1 l=3 w=3
X1115 P_B11 P_TOP sky130_fd_pr__cap_mim_m3_1 l=3 w=3
X1116 N_B11 N_TOP sky130_fd_pr__cap_mim_m3_1 l=3 w=3
X1117 N_B10 N_TOP sky130_fd_pr__cap_mim_m3_1 l=3 w=3
X1118 P_B11 P_TOP sky130_fd_pr__cap_mim_m3_1 l=3 w=3
X1119 P_B9 P_TOP sky130_fd_pr__cap_mim_m3_1 l=3 w=3
X1120 P_B11 P_TOP sky130_fd_pr__cap_mim_m3_1 l=3 w=3
X1121 N_B11 N_TOP sky130_fd_pr__cap_mim_m3_1 l=3 w=3
X1122 N_B11 N_TOP sky130_fd_pr__cap_mim_m3_1 l=3 w=3
X1123 N_B11 N_TOP sky130_fd_pr__cap_mim_m3_1 l=3 w=3
X1124 N_B11 N_TOP sky130_fd_pr__cap_mim_m3_1 l=3 w=3
X1125 P_B10 P_TOP sky130_fd_pr__cap_mim_m3_1 l=3 w=3
X1126 N_B11 N_TOP sky130_fd_pr__cap_mim_m3_1 l=3 w=3
X1127 N_B11 N_TOP sky130_fd_pr__cap_mim_m3_1 l=3 w=3
X1128 N_B11 N_TOP sky130_fd_pr__cap_mim_m3_1 l=3 w=3
X1129 P_B11 P_TOP sky130_fd_pr__cap_mim_m3_1 l=3 w=3
X1130 N_B11 N_TOP sky130_fd_pr__cap_mim_m3_1 l=3 w=3
X1131 P_B11 P_TOP sky130_fd_pr__cap_mim_m3_1 l=3 w=3
X1132 N_B11 N_TOP sky130_fd_pr__cap_mim_m3_1 l=3 w=3
X1133 P_B9 P_TOP sky130_fd_pr__cap_mim_m3_1 l=3 w=3
X1134 N_B9 N_TOP sky130_fd_pr__cap_mim_m3_1 l=3 w=3
X1135 N_B11 N_TOP sky130_fd_pr__cap_mim_m3_1 l=3 w=3
X1136 P_B11 P_TOP sky130_fd_pr__cap_mim_m3_1 l=3 w=3
X1137 N_B7 N_TOP sky130_fd_pr__cap_mim_m3_1 l=3 w=3
X1138 P_B7 P_TOP sky130_fd_pr__cap_mim_m3_1 l=3 w=3
X1139 N_B10 N_TOP sky130_fd_pr__cap_mim_m3_1 l=3 w=3
X1140 P_B11 P_TOP sky130_fd_pr__cap_mim_m3_1 l=3 w=3
X1141 P_EDGE_BIAS P_EDGE_BIAS sky130_fd_pr__cap_mim_m3_1 l=3 w=3
X1142 N_B11 N_TOP sky130_fd_pr__cap_mim_m3_1 l=3 w=3
X1143 N_B9 N_TOP sky130_fd_pr__cap_mim_m3_1 l=3 w=3
X1144 N_B11 N_TOP sky130_fd_pr__cap_mim_m3_1 l=3 w=3
X1145 N_B9 N_TOP sky130_fd_pr__cap_mim_m3_1 l=3 w=3
X1146 N_B10 N_TOP sky130_fd_pr__cap_mim_m3_1 l=3 w=3
X1147 P_B11 P_TOP sky130_fd_pr__cap_mim_m3_1 l=3 w=3
X1148 N_B8 N_TOP sky130_fd_pr__cap_mim_m3_1 l=3 w=3
X1149 N_B8 N_TOP sky130_fd_pr__cap_mim_m3_1 l=3 w=3
X1150 N_B10 N_TOP sky130_fd_pr__cap_mim_m3_1 l=3 w=3
X1151 P_B11 P_TOP sky130_fd_pr__cap_mim_m3_1 l=3 w=3
X1152 N_EDGE_BIAS N_EDGE_BIAS sky130_fd_pr__cap_mim_m3_1 l=3 w=3
X1153 P_B11 P_TOP sky130_fd_pr__cap_mim_m3_1 l=3 w=3
X1154 N_B11 N_TOP sky130_fd_pr__cap_mim_m3_1 l=3 w=3
X1155 N_B10 N_TOP sky130_fd_pr__cap_mim_m3_1 l=3 w=3
X1156 P_B11 P_TOP sky130_fd_pr__cap_mim_m3_1 l=3 w=3
X1157 N_B11 N_TOP sky130_fd_pr__cap_mim_m3_1 l=3 w=3
X1158 P_B11 P_TOP sky130_fd_pr__cap_mim_m3_1 l=3 w=3
X1159 N_B7 N_TOP sky130_fd_pr__cap_mim_m3_1 l=3 w=3
X1160 P_B11 P_TOP sky130_fd_pr__cap_mim_m3_1 l=3 w=3
X1161 N_B10 N_TOP sky130_fd_pr__cap_mim_m3_1 l=3 w=3
X1162 P_B11 P_TOP sky130_fd_pr__cap_mim_m3_1 l=3 w=3
X1163 N_B11 N_TOP sky130_fd_pr__cap_mim_m3_1 l=3 w=3
X1164 N_B10 N_TOP sky130_fd_pr__cap_mim_m3_1 l=3 w=3
X1165 N_B11 N_TOP sky130_fd_pr__cap_mim_m3_1 l=3 w=3
X1166 P_B10 P_TOP sky130_fd_pr__cap_mim_m3_1 l=3 w=3
X1167 P_B11 P_TOP sky130_fd_pr__cap_mim_m3_1 l=3 w=3
X1168 P_B11 P_TOP sky130_fd_pr__cap_mim_m3_1 l=3 w=3
X1169 N_B11 N_TOP sky130_fd_pr__cap_mim_m3_1 l=3 w=3
X1170 N_B9 N_TOP sky130_fd_pr__cap_mim_m3_1 l=3 w=3
X1171 P_B11 P_TOP sky130_fd_pr__cap_mim_m3_1 l=3 w=3
X1172 N_B11 N_TOP sky130_fd_pr__cap_mim_m3_1 l=3 w=3
X1173 N_B11 N_TOP sky130_fd_pr__cap_mim_m3_1 l=3 w=3
X1174 P_EDGE_BIAS P_EDGE_BIAS sky130_fd_pr__cap_mim_m3_1 l=3 w=3
X1175 P_B9 P_TOP sky130_fd_pr__cap_mim_m3_1 l=3 w=3
X1176 P_B8 P_TOP sky130_fd_pr__cap_mim_m3_1 l=3 w=3
X1177 N_B11 N_TOP sky130_fd_pr__cap_mim_m3_1 l=3 w=3
X1178 P_EDGE_BIAS P_EDGE_BIAS sky130_fd_pr__cap_mim_m3_1 l=3 w=3
X1179 P_B11 P_TOP sky130_fd_pr__cap_mim_m3_1 l=3 w=3
X1180 N_B10 N_TOP sky130_fd_pr__cap_mim_m3_1 l=3 w=3
X1181 P_B11 P_TOP sky130_fd_pr__cap_mim_m3_1 l=3 w=3
X1182 N_B11 N_TOP sky130_fd_pr__cap_mim_m3_1 l=3 w=3
X1183 N_B11 N_TOP sky130_fd_pr__cap_mim_m3_1 l=3 w=3
X1184 P_B10 P_TOP sky130_fd_pr__cap_mim_m3_1 l=3 w=3
X1185 N_B10 N_TOP sky130_fd_pr__cap_mim_m3_1 l=3 w=3
X1186 P_B10 P_TOP sky130_fd_pr__cap_mim_m3_1 l=3 w=3
X1187 N_B11 N_TOP sky130_fd_pr__cap_mim_m3_1 l=3 w=3
X1188 P_EDGE_BIAS P_EDGE_BIAS sky130_fd_pr__cap_mim_m3_1 l=3 w=3
X1189 N_B11 N_TOP sky130_fd_pr__cap_mim_m3_1 l=3 w=3
X1190 P_B11 P_TOP sky130_fd_pr__cap_mim_m3_1 l=3 w=3
X1191 N_EDGE_BIAS N_EDGE_BIAS sky130_fd_pr__cap_mim_m3_1 l=3 w=3
X1192 N_B7 N_TOP sky130_fd_pr__cap_mim_m3_1 l=3 w=3
X1193 N_B11 N_TOP sky130_fd_pr__cap_mim_m3_1 l=3 w=3
X1194 N_B10 N_TOP sky130_fd_pr__cap_mim_m3_1 l=3 w=3
X1195 N_B11 N_TOP sky130_fd_pr__cap_mim_m3_1 l=3 w=3
X1196 N_B10 N_TOP sky130_fd_pr__cap_mim_m3_1 l=3 w=3
X1197 P_B10 P_TOP sky130_fd_pr__cap_mim_m3_1 l=3 w=3
X1198 P_B6 P_TOP sky130_fd_pr__cap_mim_m3_1 l=3 w=3
X1199 N_B10 N_TOP sky130_fd_pr__cap_mim_m3_1 l=3 w=3
X1200 N_B11 N_TOP sky130_fd_pr__cap_mim_m3_1 l=3 w=3
X1201 N_B10 N_TOP sky130_fd_pr__cap_mim_m3_1 l=3 w=3
X1202 P_B11 P_TOP sky130_fd_pr__cap_mim_m3_1 l=3 w=3
X1203 N_B10 N_TOP sky130_fd_pr__cap_mim_m3_1 l=3 w=3
X1204 N_B11 N_TOP sky130_fd_pr__cap_mim_m3_1 l=3 w=3
X1205 N_B10 N_TOP sky130_fd_pr__cap_mim_m3_1 l=3 w=3
X1206 N_B11 N_TOP sky130_fd_pr__cap_mim_m3_1 l=3 w=3
X1207 N_B5 N_TOP sky130_fd_pr__cap_mim_m3_1 l=3 w=3
X1208 P_B11 P_TOP sky130_fd_pr__cap_mim_m3_1 l=3 w=3
X1209 P_B9 P_TOP sky130_fd_pr__cap_mim_m3_1 l=3 w=3
X1210 P_B11 P_TOP sky130_fd_pr__cap_mim_m3_1 l=3 w=3
X1211 N_B11 N_TOP sky130_fd_pr__cap_mim_m3_1 l=3 w=3
X1212 N_B10 N_TOP sky130_fd_pr__cap_mim_m3_1 l=3 w=3
X1213 P_B11 P_TOP sky130_fd_pr__cap_mim_m3_1 l=3 w=3
X1214 N_B7 N_TOP sky130_fd_pr__cap_mim_m3_1 l=3 w=3
X1215 N_B10 N_TOP sky130_fd_pr__cap_mim_m3_1 l=3 w=3
X1216 P_B11 P_TOP sky130_fd_pr__cap_mim_m3_1 l=3 w=3
X1217 P_EDGE_BIAS P_EDGE_BIAS sky130_fd_pr__cap_mim_m3_1 l=3 w=3
X1218 N_EDGE_BIAS N_EDGE_BIAS sky130_fd_pr__cap_mim_m3_1 l=3 w=3
X1219 N_B11 N_TOP sky130_fd_pr__cap_mim_m3_1 l=3 w=3
X1220 N_B11 N_TOP sky130_fd_pr__cap_mim_m3_1 l=3 w=3
X1221 P_B11 P_TOP sky130_fd_pr__cap_mim_m3_1 l=3 w=3
X1222 N_B11 N_TOP sky130_fd_pr__cap_mim_m3_1 l=3 w=3
X1223 P_B11 P_TOP sky130_fd_pr__cap_mim_m3_1 l=3 w=3
X1224 P_B11 P_TOP sky130_fd_pr__cap_mim_m3_1 l=3 w=3
X1225 P_B9 P_TOP sky130_fd_pr__cap_mim_m3_1 l=3 w=3
X1226 N_B9 N_TOP sky130_fd_pr__cap_mim_m3_1 l=3 w=3
X1227 P_B11 P_TOP sky130_fd_pr__cap_mim_m3_1 l=3 w=3
X1228 P_B9 P_TOP sky130_fd_pr__cap_mim_m3_1 l=3 w=3
X1229 N_B11 N_TOP sky130_fd_pr__cap_mim_m3_1 l=3 w=3
X1230 P_B11 P_TOP sky130_fd_pr__cap_mim_m3_1 l=3 w=3
X1231 N_B11 N_TOP sky130_fd_pr__cap_mim_m3_1 l=3 w=3
X1232 P_B10 P_TOP sky130_fd_pr__cap_mim_m3_1 l=3 w=3
X1233 P_B11 P_TOP sky130_fd_pr__cap_mim_m3_1 l=3 w=3
X1234 N_B11 N_TOP sky130_fd_pr__cap_mim_m3_1 l=3 w=3
X1235 P_B11 P_TOP sky130_fd_pr__cap_mim_m3_1 l=3 w=3
X1236 P_B9 P_TOP sky130_fd_pr__cap_mim_m3_1 l=3 w=3
X1237 N_B9 N_TOP sky130_fd_pr__cap_mim_m3_1 l=3 w=3
X1238 P_B11 P_TOP sky130_fd_pr__cap_mim_m3_1 l=3 w=3
X1239 N_B11 N_TOP sky130_fd_pr__cap_mim_m3_1 l=3 w=3
X1240 P_B11 P_TOP sky130_fd_pr__cap_mim_m3_1 l=3 w=3
X1241 P_B9 P_TOP sky130_fd_pr__cap_mim_m3_1 l=3 w=3
X1242 P_B10 P_TOP sky130_fd_pr__cap_mim_m3_1 l=3 w=3
X1243 N_B10 N_TOP sky130_fd_pr__cap_mim_m3_1 l=3 w=3
X1244 P_EDGE_BIAS P_EDGE_BIAS sky130_fd_pr__cap_mim_m3_1 l=3 w=3
X1245 P_B10 P_TOP sky130_fd_pr__cap_mim_m3_1 l=3 w=3
X1246 N_B7 N_TOP sky130_fd_pr__cap_mim_m3_1 l=3 w=3
X1247 N_B11 N_TOP sky130_fd_pr__cap_mim_m3_1 l=3 w=3
X1248 N_B9 N_TOP sky130_fd_pr__cap_mim_m3_1 l=3 w=3
X1249 P_EDGE_BIAS P_EDGE_BIAS sky130_fd_pr__cap_mim_m3_1 l=3 w=3
X1250 N_B11 N_TOP sky130_fd_pr__cap_mim_m3_1 l=3 w=3
X1251 N_B11 N_TOP sky130_fd_pr__cap_mim_m3_1 l=3 w=3
X1252 P_B11 P_TOP sky130_fd_pr__cap_mim_m3_1 l=3 w=3
X1253 P_B10 P_TOP sky130_fd_pr__cap_mim_m3_1 l=3 w=3
X1254 N_B9 N_TOP sky130_fd_pr__cap_mim_m3_1 l=3 w=3
X1255 N_B8 N_TOP sky130_fd_pr__cap_mim_m3_1 l=3 w=3
X1256 N_B9 N_TOP sky130_fd_pr__cap_mim_m3_1 l=3 w=3
X1257 N_B8 N_TOP sky130_fd_pr__cap_mim_m3_1 l=3 w=3
X1258 P_B11 P_TOP sky130_fd_pr__cap_mim_m3_1 l=3 w=3
X1259 N_B11 N_TOP sky130_fd_pr__cap_mim_m3_1 l=3 w=3
X1260 P_B11 P_TOP sky130_fd_pr__cap_mim_m3_1 l=3 w=3
X1261 N_B8 N_TOP sky130_fd_pr__cap_mim_m3_1 l=3 w=3
X1262 N_B10 N_TOP sky130_fd_pr__cap_mim_m3_1 l=3 w=3
X1263 P_B11 P_TOP sky130_fd_pr__cap_mim_m3_1 l=3 w=3
X1264 P_B11 P_TOP sky130_fd_pr__cap_mim_m3_1 l=3 w=3
X1265 N_B9 N_TOP sky130_fd_pr__cap_mim_m3_1 l=3 w=3
X1266 P_B11 P_TOP sky130_fd_pr__cap_mim_m3_1 l=3 w=3
X1267 P_B11 P_TOP sky130_fd_pr__cap_mim_m3_1 l=3 w=3
X1268 N_B7 N_TOP sky130_fd_pr__cap_mim_m3_1 l=3 w=3
X1269 N_B8 N_TOP sky130_fd_pr__cap_mim_m3_1 l=3 w=3
X1270 N_B10 N_TOP sky130_fd_pr__cap_mim_m3_1 l=3 w=3
X1271 N_B11 N_TOP sky130_fd_pr__cap_mim_m3_1 l=3 w=3
X1272 P_B11 P_TOP sky130_fd_pr__cap_mim_m3_1 l=3 w=3
X1273 N_B11 N_TOP sky130_fd_pr__cap_mim_m3_1 l=3 w=3
X1274 N_B10 N_TOP sky130_fd_pr__cap_mim_m3_1 l=3 w=3
X1275 P_B10 P_TOP sky130_fd_pr__cap_mim_m3_1 l=3 w=3
X1276 P_B11 P_TOP sky130_fd_pr__cap_mim_m3_1 l=3 w=3
X1277 P_B11 P_TOP sky130_fd_pr__cap_mim_m3_1 l=3 w=3
X1278 P_B10 P_TOP sky130_fd_pr__cap_mim_m3_1 l=3 w=3
X1279 N_B11 N_TOP sky130_fd_pr__cap_mim_m3_1 l=3 w=3
X1280 P_B11 P_TOP sky130_fd_pr__cap_mim_m3_1 l=3 w=3
X1281 N_B11 N_TOP sky130_fd_pr__cap_mim_m3_1 l=3 w=3
X1282 P_B8 P_TOP sky130_fd_pr__cap_mim_m3_1 l=3 w=3
X1283 N_B11 N_TOP sky130_fd_pr__cap_mim_m3_1 l=3 w=3
X1284 N_B11 N_TOP sky130_fd_pr__cap_mim_m3_1 l=3 w=3
X1285 N_B11 N_TOP sky130_fd_pr__cap_mim_m3_1 l=3 w=3
X1286 N_B11 N_TOP sky130_fd_pr__cap_mim_m3_1 l=3 w=3
X1287 P_B10 P_TOP sky130_fd_pr__cap_mim_m3_1 l=3 w=3
X1288 N_B10 N_TOP sky130_fd_pr__cap_mim_m3_1 l=3 w=3
X1289 P_B10 P_TOP sky130_fd_pr__cap_mim_m3_1 l=3 w=3
X1290 P_B11 P_TOP sky130_fd_pr__cap_mim_m3_1 l=3 w=3
X1291 P_B10 P_TOP sky130_fd_pr__cap_mim_m3_1 l=3 w=3
X1292 P_B11 P_TOP sky130_fd_pr__cap_mim_m3_1 l=3 w=3
X1293 P_B7 P_TOP sky130_fd_pr__cap_mim_m3_1 l=3 w=3
X1294 N_B11 N_TOP sky130_fd_pr__cap_mim_m3_1 l=3 w=3
X1295 P_B11 P_TOP sky130_fd_pr__cap_mim_m3_1 l=3 w=3
X1296 N_B11 N_TOP sky130_fd_pr__cap_mim_m3_1 l=3 w=3
X1297 P_B10 P_TOP sky130_fd_pr__cap_mim_m3_1 l=3 w=3
X1298 N_B9 N_TOP sky130_fd_pr__cap_mim_m3_1 l=3 w=3
X1299 N_B10 N_TOP sky130_fd_pr__cap_mim_m3_1 l=3 w=3
X1300 P_B11 P_TOP sky130_fd_pr__cap_mim_m3_1 l=3 w=3
X1301 P_B11 P_TOP sky130_fd_pr__cap_mim_m3_1 l=3 w=3
X1302 N_B10 N_TOP sky130_fd_pr__cap_mim_m3_1 l=3 w=3
X1303 P_B10 P_TOP sky130_fd_pr__cap_mim_m3_1 l=3 w=3
X1304 P_B11 P_TOP sky130_fd_pr__cap_mim_m3_1 l=3 w=3
X1305 N_B10 N_TOP sky130_fd_pr__cap_mim_m3_1 l=3 w=3
X1306 N_B4 N_TOP sky130_fd_pr__cap_mim_m3_1 l=3 w=3
X1307 N_B11 N_TOP sky130_fd_pr__cap_mim_m3_1 l=3 w=3
X1308 N_B11 N_TOP sky130_fd_pr__cap_mim_m3_1 l=3 w=3
X1309 P_B11 P_TOP sky130_fd_pr__cap_mim_m3_1 l=3 w=3
X1310 P_B11 P_TOP sky130_fd_pr__cap_mim_m3_1 l=3 w=3
X1311 N_B9 N_TOP sky130_fd_pr__cap_mim_m3_1 l=3 w=3
X1312 N_B7 N_TOP sky130_fd_pr__cap_mim_m3_1 l=3 w=3
X1313 P_B11 P_TOP sky130_fd_pr__cap_mim_m3_1 l=3 w=3
X1314 N_B11 N_TOP sky130_fd_pr__cap_mim_m3_1 l=3 w=3
X1315 P_EDGE_BIAS P_EDGE_BIAS sky130_fd_pr__cap_mim_m3_1 l=3 w=3
X1316 N_B10 N_TOP sky130_fd_pr__cap_mim_m3_1 l=3 w=3
X1317 N_EDGE_BIAS N_EDGE_BIAS sky130_fd_pr__cap_mim_m3_1 l=3 w=3
X1318 P_B11 P_TOP sky130_fd_pr__cap_mim_m3_1 l=3 w=3
X1319 N_B10 N_TOP sky130_fd_pr__cap_mim_m3_1 l=3 w=3
X1320 P_B9 P_TOP sky130_fd_pr__cap_mim_m3_1 l=3 w=3
X1321 P_B11 P_TOP sky130_fd_pr__cap_mim_m3_1 l=3 w=3
X1322 P_B11 P_TOP sky130_fd_pr__cap_mim_m3_1 l=3 w=3
X1323 P_B9 P_TOP sky130_fd_pr__cap_mim_m3_1 l=3 w=3
X1324 N_B11 N_TOP sky130_fd_pr__cap_mim_m3_1 l=3 w=3
X1325 P_B11 P_TOP sky130_fd_pr__cap_mim_m3_1 l=3 w=3
X1326 P_B11 P_TOP sky130_fd_pr__cap_mim_m3_1 l=3 w=3
X1327 P_B10 P_TOP sky130_fd_pr__cap_mim_m3_1 l=3 w=3
X1328 N_B11 N_TOP sky130_fd_pr__cap_mim_m3_1 l=3 w=3
X1329 N_B11 N_TOP sky130_fd_pr__cap_mim_m3_1 l=3 w=3
X1330 P_EDGE_BIAS P_EDGE_BIAS sky130_fd_pr__cap_mim_m3_1 l=3 w=3
X1331 N_B11 N_TOP sky130_fd_pr__cap_mim_m3_1 l=3 w=3
X1332 P_B11 P_TOP sky130_fd_pr__cap_mim_m3_1 l=3 w=3
X1333 P_B9 P_TOP sky130_fd_pr__cap_mim_m3_1 l=3 w=3
X1334 N_B11 N_TOP sky130_fd_pr__cap_mim_m3_1 l=3 w=3
X1335 N_B9 N_TOP sky130_fd_pr__cap_mim_m3_1 l=3 w=3
X1336 P_B9 P_TOP sky130_fd_pr__cap_mim_m3_1 l=3 w=3
X1337 N_B11 N_TOP sky130_fd_pr__cap_mim_m3_1 l=3 w=3
X1338 P_B11 P_TOP sky130_fd_pr__cap_mim_m3_1 l=3 w=3
X1339 P_B7 P_TOP sky130_fd_pr__cap_mim_m3_1 l=3 w=3
X1340 P_B10 P_TOP sky130_fd_pr__cap_mim_m3_1 l=3 w=3
X1341 N_B11 N_TOP sky130_fd_pr__cap_mim_m3_1 l=3 w=3
X1342 N_EDGE_BIAS N_EDGE_BIAS sky130_fd_pr__cap_mim_m3_1 l=3 w=3
X1343 N_B9 N_TOP sky130_fd_pr__cap_mim_m3_1 l=3 w=3
X1344 N_B11 N_TOP sky130_fd_pr__cap_mim_m3_1 l=3 w=3
X1345 N_B9 N_TOP sky130_fd_pr__cap_mim_m3_1 l=3 w=3
X1346 N_B9 N_TOP sky130_fd_pr__cap_mim_m3_1 l=3 w=3
X1347 N_B8 N_TOP sky130_fd_pr__cap_mim_m3_1 l=3 w=3
X1348 P_B11 P_TOP sky130_fd_pr__cap_mim_m3_1 l=3 w=3
X1349 P_B8 P_TOP sky130_fd_pr__cap_mim_m3_1 l=3 w=3
X1350 P_B11 P_TOP sky130_fd_pr__cap_mim_m3_1 l=3 w=3
X1351 P_B10 P_TOP sky130_fd_pr__cap_mim_m3_1 l=3 w=3
X1352 N_B8 N_TOP sky130_fd_pr__cap_mim_m3_1 l=3 w=3
X1353 N_B10 N_TOP sky130_fd_pr__cap_mim_m3_1 l=3 w=3
X1354 P_B11 P_TOP sky130_fd_pr__cap_mim_m3_1 l=3 w=3
X1355 P_B9 P_TOP sky130_fd_pr__cap_mim_m3_1 l=3 w=3
X1356 N_B11 N_TOP sky130_fd_pr__cap_mim_m3_1 l=3 w=3
X1357 N_B11 N_TOP sky130_fd_pr__cap_mim_m3_1 l=3 w=3
X1358 P_B11 P_TOP sky130_fd_pr__cap_mim_m3_1 l=3 w=3
X1359 N_B11 N_TOP sky130_fd_pr__cap_mim_m3_1 l=3 w=3
X1360 N_B8 N_TOP sky130_fd_pr__cap_mim_m3_1 l=3 w=3
X1361 P_B11 P_TOP sky130_fd_pr__cap_mim_m3_1 l=3 w=3
X1362 N_B11 N_TOP sky130_fd_pr__cap_mim_m3_1 l=3 w=3
X1363 P_B10 P_TOP sky130_fd_pr__cap_mim_m3_1 l=3 w=3
X1364 N_B11 N_TOP sky130_fd_pr__cap_mim_m3_1 l=3 w=3
X1365 P_B11 P_TOP sky130_fd_pr__cap_mim_m3_1 l=3 w=3
X1366 N_B11 N_TOP sky130_fd_pr__cap_mim_m3_1 l=3 w=3
X1367 P_B11 P_TOP sky130_fd_pr__cap_mim_m3_1 l=3 w=3
X1368 N_B11 N_TOP sky130_fd_pr__cap_mim_m3_1 l=3 w=3
X1369 N_B11 N_TOP sky130_fd_pr__cap_mim_m3_1 l=3 w=3
X1370 N_B9 N_TOP sky130_fd_pr__cap_mim_m3_1 l=3 w=3
X1371 N_B11 N_TOP sky130_fd_pr__cap_mim_m3_1 l=3 w=3
X1372 P_B11 P_TOP sky130_fd_pr__cap_mim_m3_1 l=3 w=3
X1373 P_B11 P_TOP sky130_fd_pr__cap_mim_m3_1 l=3 w=3
X1374 P_B10 P_TOP sky130_fd_pr__cap_mim_m3_1 l=3 w=3
X1375 N_B4 N_TOP sky130_fd_pr__cap_mim_m3_1 l=3 w=3
X1376 P_B8 P_TOP sky130_fd_pr__cap_mim_m3_1 l=3 w=3
X1377 P_B11 P_TOP sky130_fd_pr__cap_mim_m3_1 l=3 w=3
X1378 N_B11 N_TOP sky130_fd_pr__cap_mim_m3_1 l=3 w=3
X1379 P_B11 P_TOP sky130_fd_pr__cap_mim_m3_1 l=3 w=3
X1380 P_B10 P_TOP sky130_fd_pr__cap_mim_m3_1 l=3 w=3
X1381 N_B10 N_TOP sky130_fd_pr__cap_mim_m3_1 l=3 w=3
X1382 N_B11 N_TOP sky130_fd_pr__cap_mim_m3_1 l=3 w=3
X1383 P_B11 P_TOP sky130_fd_pr__cap_mim_m3_1 l=3 w=3
X1384 P_EDGE_BIAS P_EDGE_BIAS sky130_fd_pr__cap_mim_m3_1 l=3 w=3
X1385 P_B7 P_TOP sky130_fd_pr__cap_mim_m3_1 l=3 w=3
X1386 N_B11 N_TOP sky130_fd_pr__cap_mim_m3_1 l=3 w=3
X1387 N_B11 N_TOP sky130_fd_pr__cap_mim_m3_1 l=3 w=3
X1388 N_B9 N_TOP sky130_fd_pr__cap_mim_m3_1 l=3 w=3
X1389 N_B11 N_TOP sky130_fd_pr__cap_mim_m3_1 l=3 w=3
X1390 P_B11 P_TOP sky130_fd_pr__cap_mim_m3_1 l=3 w=3
X1391 N_B9 N_TOP sky130_fd_pr__cap_mim_m3_1 l=3 w=3
X1392 N_B11 N_TOP sky130_fd_pr__cap_mim_m3_1 l=3 w=3
X1393 P_B10 P_TOP sky130_fd_pr__cap_mim_m3_1 l=3 w=3
X1394 N_B10 N_TOP sky130_fd_pr__cap_mim_m3_1 l=3 w=3
X1395 N_B10 N_TOP sky130_fd_pr__cap_mim_m3_1 l=3 w=3
X1396 N_B11 N_TOP sky130_fd_pr__cap_mim_m3_1 l=3 w=3
X1397 N_B10 N_TOP sky130_fd_pr__cap_mim_m3_1 l=3 w=3
X1398 N_B11 N_TOP sky130_fd_pr__cap_mim_m3_1 l=3 w=3
X1399 P_B3 P_TOP sky130_fd_pr__cap_mim_m3_1 l=3 w=3
X1400 N_B10 N_TOP sky130_fd_pr__cap_mim_m3_1 l=3 w=3
X1401 N_B9 N_TOP sky130_fd_pr__cap_mim_m3_1 l=3 w=3
X1402 N_B9 N_TOP sky130_fd_pr__cap_mim_m3_1 l=3 w=3
X1403 N_B11 N_TOP sky130_fd_pr__cap_mim_m3_1 l=3 w=3
X1404 P_B10 P_TOP sky130_fd_pr__cap_mim_m3_1 l=3 w=3
X1405 P_B11 P_TOP sky130_fd_pr__cap_mim_m3_1 l=3 w=3
X1406 N_B10 N_TOP sky130_fd_pr__cap_mim_m3_1 l=3 w=3
X1407 N_B9 N_TOP sky130_fd_pr__cap_mim_m3_1 l=3 w=3
X1408 N_B10 N_TOP sky130_fd_pr__cap_mim_m3_1 l=3 w=3
X1409 N_B11 N_TOP sky130_fd_pr__cap_mim_m3_1 l=3 w=3
X1410 P_EDGE_BIAS P_EDGE_BIAS sky130_fd_pr__cap_mim_m3_1 l=3 w=3
X1411 N_B10 N_TOP sky130_fd_pr__cap_mim_m3_1 l=3 w=3
X1412 N_EDGE_BIAS N_EDGE_BIAS sky130_fd_pr__cap_mim_m3_1 l=3 w=3
X1413 P_B11 P_TOP sky130_fd_pr__cap_mim_m3_1 l=3 w=3
X1414 P_B8 P_TOP sky130_fd_pr__cap_mim_m3_1 l=3 w=3
X1415 N_B11 N_TOP sky130_fd_pr__cap_mim_m3_1 l=3 w=3
X1416 P_B11 P_TOP sky130_fd_pr__cap_mim_m3_1 l=3 w=3
X1417 N_B10 N_TOP sky130_fd_pr__cap_mim_m3_1 l=3 w=3
X1418 P_B9 P_TOP sky130_fd_pr__cap_mim_m3_1 l=3 w=3
X1419 P_B11 P_TOP sky130_fd_pr__cap_mim_m3_1 l=3 w=3
X1420 N_B11 N_TOP sky130_fd_pr__cap_mim_m3_1 l=3 w=3
X1421 N_B11 N_TOP sky130_fd_pr__cap_mim_m3_1 l=3 w=3
X1422 N_B11 N_TOP sky130_fd_pr__cap_mim_m3_1 l=3 w=3
X1423 N_B11 N_TOP sky130_fd_pr__cap_mim_m3_1 l=3 w=3
X1424 N_B11 N_TOP sky130_fd_pr__cap_mim_m3_1 l=3 w=3
X1425 P_B11 P_TOP sky130_fd_pr__cap_mim_m3_1 l=3 w=3
X1426 N_B11 N_TOP sky130_fd_pr__cap_mim_m3_1 l=3 w=3
X1427 N_B10 N_TOP sky130_fd_pr__cap_mim_m3_1 l=3 w=3
X1428 N_B11 N_TOP sky130_fd_pr__cap_mim_m3_1 l=3 w=3
X1429 P_B11 P_TOP sky130_fd_pr__cap_mim_m3_1 l=3 w=3
X1430 P_B11 P_TOP sky130_fd_pr__cap_mim_m3_1 l=3 w=3
X1431 P_B11 P_TOP sky130_fd_pr__cap_mim_m3_1 l=3 w=3
X1432 N_B9 N_TOP sky130_fd_pr__cap_mim_m3_1 l=3 w=3
X1433 N_B11 N_TOP sky130_fd_pr__cap_mim_m3_1 l=3 w=3
X1434 P_B11 P_TOP sky130_fd_pr__cap_mim_m3_1 l=3 w=3
X1435 P_B10 P_TOP sky130_fd_pr__cap_mim_m3_1 l=3 w=3
X1436 P_B7 P_TOP sky130_fd_pr__cap_mim_m3_1 l=3 w=3
X1437 N_B11 N_TOP sky130_fd_pr__cap_mim_m3_1 l=3 w=3
X1438 N_B10 N_TOP sky130_fd_pr__cap_mim_m3_1 l=3 w=3
X1439 P_B11 P_TOP sky130_fd_pr__cap_mim_m3_1 l=3 w=3
X1440 P_EDGE_BIAS P_EDGE_BIAS sky130_fd_pr__cap_mim_m3_1 l=3 w=3
X1441 N_B11 N_TOP sky130_fd_pr__cap_mim_m3_1 l=3 w=3
X1442 P_B11 P_TOP sky130_fd_pr__cap_mim_m3_1 l=3 w=3
X1443 P_B11 P_TOP sky130_fd_pr__cap_mim_m3_1 l=3 w=3
X1444 N_B9 N_TOP sky130_fd_pr__cap_mim_m3_1 l=3 w=3
X1445 N_B8 N_TOP sky130_fd_pr__cap_mim_m3_1 l=3 w=3
X1446 N_B9 N_TOP sky130_fd_pr__cap_mim_m3_1 l=3 w=3
X1447 N_B11 N_TOP sky130_fd_pr__cap_mim_m3_1 l=3 w=3
X1448 P_B11 P_TOP sky130_fd_pr__cap_mim_m3_1 l=3 w=3
X1449 N_B8 N_TOP sky130_fd_pr__cap_mim_m3_1 l=3 w=3
X1450 N_B11 N_TOP sky130_fd_pr__cap_mim_m3_1 l=3 w=3
X1451 P_B8 P_TOP sky130_fd_pr__cap_mim_m3_1 l=3 w=3
X1452 N_B10 N_TOP sky130_fd_pr__cap_mim_m3_1 l=3 w=3
X1453 N_B10 N_TOP sky130_fd_pr__cap_mim_m3_1 l=3 w=3
X1454 P_B11 P_TOP sky130_fd_pr__cap_mim_m3_1 l=3 w=3
X1455 N_B10 N_TOP sky130_fd_pr__cap_mim_m3_1 l=3 w=3
X1456 N_B9 N_TOP sky130_fd_pr__cap_mim_m3_1 l=3 w=3
X1457 N_B9 N_TOP sky130_fd_pr__cap_mim_m3_1 l=3 w=3
X1458 P_B11 P_TOP sky130_fd_pr__cap_mim_m3_1 l=3 w=3
X1459 N_B11 N_TOP sky130_fd_pr__cap_mim_m3_1 l=3 w=3
X1460 N_B10 N_TOP sky130_fd_pr__cap_mim_m3_1 l=3 w=3
X1461 N_B11 N_TOP sky130_fd_pr__cap_mim_m3_1 l=3 w=3
X1462 N_B11 N_TOP sky130_fd_pr__cap_mim_m3_1 l=3 w=3
X1463 N_B7 N_TOP sky130_fd_pr__cap_mim_m3_1 l=3 w=3
X1464 N_B10 N_TOP sky130_fd_pr__cap_mim_m3_1 l=3 w=3
X1465 N_B11 N_TOP sky130_fd_pr__cap_mim_m3_1 l=3 w=3
X1466 N_B11 N_TOP sky130_fd_pr__cap_mim_m3_1 l=3 w=3
X1467 N_B10 N_TOP sky130_fd_pr__cap_mim_m3_1 l=3 w=3
X1468 P_B11 P_TOP sky130_fd_pr__cap_mim_m3_1 l=3 w=3
X1469 N_B10 N_TOP sky130_fd_pr__cap_mim_m3_1 l=3 w=3
X1470 P_B10 P_TOP sky130_fd_pr__cap_mim_m3_1 l=3 w=3
X1471 P_B11 P_TOP sky130_fd_pr__cap_mim_m3_1 l=3 w=3
X1472 P_B11 P_TOP sky130_fd_pr__cap_mim_m3_1 l=3 w=3
X1473 N_B11 N_TOP sky130_fd_pr__cap_mim_m3_1 l=3 w=3
X1474 P_B11 P_TOP sky130_fd_pr__cap_mim_m3_1 l=3 w=3
X1475 N_B11 N_TOP sky130_fd_pr__cap_mim_m3_1 l=3 w=3
X1476 N_B11 N_TOP sky130_fd_pr__cap_mim_m3_1 l=3 w=3
X1477 P_B11 P_TOP sky130_fd_pr__cap_mim_m3_1 l=3 w=3
X1478 N_B10 N_TOP sky130_fd_pr__cap_mim_m3_1 l=3 w=3
X1479 N_B11 N_TOP sky130_fd_pr__cap_mim_m3_1 l=3 w=3
X1480 N_B11 N_TOP sky130_fd_pr__cap_mim_m3_1 l=3 w=3
X1481 P_B11 P_TOP sky130_fd_pr__cap_mim_m3_1 l=3 w=3
X1482 N_B11 N_TOP sky130_fd_pr__cap_mim_m3_1 l=3 w=3
X1483 P_B8 P_TOP sky130_fd_pr__cap_mim_m3_1 l=3 w=3
X1484 N_B11 N_TOP sky130_fd_pr__cap_mim_m3_1 l=3 w=3
X1485 P_B11 P_TOP sky130_fd_pr__cap_mim_m3_1 l=3 w=3
X1486 P_B10 P_TOP sky130_fd_pr__cap_mim_m3_1 l=3 w=3
X1487 N_B11 N_TOP sky130_fd_pr__cap_mim_m3_1 l=3 w=3
X1488 N_B11 N_TOP sky130_fd_pr__cap_mim_m3_1 l=3 w=3
X1489 P_B11 P_TOP sky130_fd_pr__cap_mim_m3_1 l=3 w=3
X1490 P_B9 P_TOP sky130_fd_pr__cap_mim_m3_1 l=3 w=3
X1491 N_B9 N_TOP sky130_fd_pr__cap_mim_m3_1 l=3 w=3
X1492 N_B11 N_TOP sky130_fd_pr__cap_mim_m3_1 l=3 w=3
X1493 N_B11 N_TOP sky130_fd_pr__cap_mim_m3_1 l=3 w=3
X1494 P_B11 P_TOP sky130_fd_pr__cap_mim_m3_1 l=3 w=3
X1495 N_B11 N_TOP sky130_fd_pr__cap_mim_m3_1 l=3 w=3
X1496 N_B9 N_TOP sky130_fd_pr__cap_mim_m3_1 l=3 w=3
X1497 P_B10 P_TOP sky130_fd_pr__cap_mim_m3_1 l=3 w=3
X1498 P_B11 P_TOP sky130_fd_pr__cap_mim_m3_1 l=3 w=3
X1499 P_B6 P_TOP sky130_fd_pr__cap_mim_m3_1 l=3 w=3
X1500 N_B10 N_TOP sky130_fd_pr__cap_mim_m3_1 l=3 w=3
X1501 N_B10 N_TOP sky130_fd_pr__cap_mim_m3_1 l=3 w=3
X1502 N_B10 N_TOP sky130_fd_pr__cap_mim_m3_1 l=3 w=3
X1503 N_B11 N_TOP sky130_fd_pr__cap_mim_m3_1 l=3 w=3
X1504 P_B10 P_TOP sky130_fd_pr__cap_mim_m3_1 l=3 w=3
X1505 N_B5 N_TOP sky130_fd_pr__cap_mim_m3_1 l=3 w=3
X1506 N_B11 N_TOP sky130_fd_pr__cap_mim_m3_1 l=3 w=3
X1507 P_B11 P_TOP sky130_fd_pr__cap_mim_m3_1 l=3 w=3
X1508 P_B11 P_TOP sky130_fd_pr__cap_mim_m3_1 l=3 w=3
X1509 N_B9 N_TOP sky130_fd_pr__cap_mim_m3_1 l=3 w=3
X1510 P_B9 P_TOP sky130_fd_pr__cap_mim_m3_1 l=3 w=3
X1511 N_B11 N_TOP sky130_fd_pr__cap_mim_m3_1 l=3 w=3
X1512 N_B10 N_TOP sky130_fd_pr__cap_mim_m3_1 l=3 w=3
X1513 P_B11 P_TOP sky130_fd_pr__cap_mim_m3_1 l=3 w=3
X1514 N_B7 N_TOP sky130_fd_pr__cap_mim_m3_1 l=3 w=3
X1515 N_B10 N_TOP sky130_fd_pr__cap_mim_m3_1 l=3 w=3
X1516 P_EDGE_BIAS P_EDGE_BIAS sky130_fd_pr__cap_mim_m3_1 l=3 w=3
X1517 N_EDGE_BIAS N_EDGE_BIAS sky130_fd_pr__cap_mim_m3_1 l=3 w=3
X1518 P_B11 P_TOP sky130_fd_pr__cap_mim_m3_1 l=3 w=3
X1519 P_B11 P_TOP sky130_fd_pr__cap_mim_m3_1 l=3 w=3
X1520 P_B11 P_TOP sky130_fd_pr__cap_mim_m3_1 l=3 w=3
X1521 N_B11 N_TOP sky130_fd_pr__cap_mim_m3_1 l=3 w=3
X1522 N_B10 N_TOP sky130_fd_pr__cap_mim_m3_1 l=3 w=3
X1523 P_B11 P_TOP sky130_fd_pr__cap_mim_m3_1 l=3 w=3
X1524 P_B9 P_TOP sky130_fd_pr__cap_mim_m3_1 l=3 w=3
X1525 N_B11 N_TOP sky130_fd_pr__cap_mim_m3_1 l=3 w=3
X1526 P_B11 P_TOP sky130_fd_pr__cap_mim_m3_1 l=3 w=3
X1527 N_B11 N_TOP sky130_fd_pr__cap_mim_m3_1 l=3 w=3
X1528 P_B10 P_TOP sky130_fd_pr__cap_mim_m3_1 l=3 w=3
X1529 P_B11 P_TOP sky130_fd_pr__cap_mim_m3_1 l=3 w=3
X1530 N_B11 N_TOP sky130_fd_pr__cap_mim_m3_1 l=3 w=3
X1531 P_B10 P_TOP sky130_fd_pr__cap_mim_m3_1 l=3 w=3
X1532 N_B11 N_TOP sky130_fd_pr__cap_mim_m3_1 l=3 w=3
X1533 P_B11 P_TOP sky130_fd_pr__cap_mim_m3_1 l=3 w=3
X1534 P_B9 P_TOP sky130_fd_pr__cap_mim_m3_1 l=3 w=3
X1535 P_B9 P_TOP sky130_fd_pr__cap_mim_m3_1 l=3 w=3
X1536 P_B11 P_TOP sky130_fd_pr__cap_mim_m3_1 l=3 w=3
X1537 P_B10 P_TOP sky130_fd_pr__cap_mim_m3_1 l=3 w=3
X1538 N_B10 N_TOP sky130_fd_pr__cap_mim_m3_1 l=3 w=3
X1539 N_B11 N_TOP sky130_fd_pr__cap_mim_m3_1 l=3 w=3
X1540 N_B11 N_TOP sky130_fd_pr__cap_mim_m3_1 l=3 w=3
X1541 P_B10 P_TOP sky130_fd_pr__cap_mim_m3_1 l=3 w=3
X1542 P_B10 P_TOP sky130_fd_pr__cap_mim_m3_1 l=3 w=3
X1543 N_B11 N_TOP sky130_fd_pr__cap_mim_m3_1 l=3 w=3
X1544 P_B11 P_TOP sky130_fd_pr__cap_mim_m3_1 l=3 w=3
X1545 P_B11 P_TOP sky130_fd_pr__cap_mim_m3_1 l=3 w=3
X1546 P_B11 P_TOP sky130_fd_pr__cap_mim_m3_1 l=3 w=3
X1547 N_B11 N_TOP sky130_fd_pr__cap_mim_m3_1 l=3 w=3
X1548 P_B10 P_TOP sky130_fd_pr__cap_mim_m3_1 l=3 w=3
X1549 N_B9 N_TOP sky130_fd_pr__cap_mim_m3_1 l=3 w=3
X1550 N_B8 N_TOP sky130_fd_pr__cap_mim_m3_1 l=3 w=3
X1551 N_B9 N_TOP sky130_fd_pr__cap_mim_m3_1 l=3 w=3
X1552 N_B11 N_TOP sky130_fd_pr__cap_mim_m3_1 l=3 w=3
X1553 N_B8 N_TOP sky130_fd_pr__cap_mim_m3_1 l=3 w=3
X1554 P_B11 P_TOP sky130_fd_pr__cap_mim_m3_1 l=3 w=3
X1555 N_B8 N_TOP sky130_fd_pr__cap_mim_m3_1 l=3 w=3
X1556 N_B10 N_TOP sky130_fd_pr__cap_mim_m3_1 l=3 w=3
X1557 P_B11 P_TOP sky130_fd_pr__cap_mim_m3_1 l=3 w=3
X1558 N_EDGE_BIAS N_EDGE_BIAS sky130_fd_pr__cap_mim_m3_1 l=3 w=3
X1559 P_B11 P_TOP sky130_fd_pr__cap_mim_m3_1 l=3 w=3
X1560 P_B10 P_TOP sky130_fd_pr__cap_mim_m3_1 l=3 w=3
X1561 N_B9 N_TOP sky130_fd_pr__cap_mim_m3_1 l=3 w=3
X1562 N_B11 N_TOP sky130_fd_pr__cap_mim_m3_1 l=3 w=3
X1563 N_B10 N_TOP sky130_fd_pr__cap_mim_m3_1 l=3 w=3
X1564 N_B11 N_TOP sky130_fd_pr__cap_mim_m3_1 l=3 w=3
X1565 N_B7 N_TOP sky130_fd_pr__cap_mim_m3_1 l=3 w=3
X1566 N_B8 N_TOP sky130_fd_pr__cap_mim_m3_1 l=3 w=3
X1567 N_B10 N_TOP sky130_fd_pr__cap_mim_m3_1 l=3 w=3
X1568 P_B11 P_TOP sky130_fd_pr__cap_mim_m3_1 l=3 w=3
X1569 P_B10 P_TOP sky130_fd_pr__cap_mim_m3_1 l=3 w=3
X1570 N_B11 N_TOP sky130_fd_pr__cap_mim_m3_1 l=3 w=3
X1571 N_B8 N_TOP sky130_fd_pr__cap_mim_m3_1 l=3 w=3
X1572 P_B10 P_TOP sky130_fd_pr__cap_mim_m3_1 l=3 w=3
X1573 P_B11 P_TOP sky130_fd_pr__cap_mim_m3_1 l=3 w=3
X1574 N_B6 N_TOP sky130_fd_pr__cap_mim_m3_1 l=3 w=3
X1575 N_B11 N_TOP sky130_fd_pr__cap_mim_m3_1 l=3 w=3
X1576 P_B11 P_TOP sky130_fd_pr__cap_mim_m3_1 l=3 w=3
X1577 N_EDGE_BIAS N_EDGE_BIAS sky130_fd_pr__cap_mim_m3_1 l=3 w=3
X1578 N_B11 N_TOP sky130_fd_pr__cap_mim_m3_1 l=3 w=3
X1579 N_B11 N_TOP sky130_fd_pr__cap_mim_m3_1 l=3 w=3
X1580 P_B8 P_TOP sky130_fd_pr__cap_mim_m3_1 l=3 w=3
X1581 N_B11 N_TOP sky130_fd_pr__cap_mim_m3_1 l=3 w=3
X1582 P_B11 P_TOP sky130_fd_pr__cap_mim_m3_1 l=3 w=3
X1583 P_B11 P_TOP sky130_fd_pr__cap_mim_m3_1 l=3 w=3
X1584 N_EDGE_BIAS N_EDGE_BIAS sky130_fd_pr__cap_mim_m3_1 l=3 w=3
X1585 P_B10 P_TOP sky130_fd_pr__cap_mim_m3_1 l=3 w=3
X1586 P_B10 P_TOP sky130_fd_pr__cap_mim_m3_1 l=3 w=3
X1587 P_B11 P_TOP sky130_fd_pr__cap_mim_m3_1 l=3 w=3
X1588 N_B11 N_TOP sky130_fd_pr__cap_mim_m3_1 l=3 w=3
X1589 N_B8 N_TOP sky130_fd_pr__cap_mim_m3_1 l=3 w=3
X1590 N_B11 N_TOP sky130_fd_pr__cap_mim_m3_1 l=3 w=3
X1591 P_B10 P_TOP sky130_fd_pr__cap_mim_m3_1 l=3 w=3
X1592 N_B11 N_TOP sky130_fd_pr__cap_mim_m3_1 l=3 w=3
X1593 P_B11 P_TOP sky130_fd_pr__cap_mim_m3_1 l=3 w=3
X1594 P_B7 P_TOP sky130_fd_pr__cap_mim_m3_1 l=3 w=3
X1595 N_B11 N_TOP sky130_fd_pr__cap_mim_m3_1 l=3 w=3
X1596 P_B11 P_TOP sky130_fd_pr__cap_mim_m3_1 l=3 w=3
X1597 P_B11 P_TOP sky130_fd_pr__cap_mim_m3_1 l=3 w=3
X1598 N_B11 N_TOP sky130_fd_pr__cap_mim_m3_1 l=3 w=3
X1599 N_B9 N_TOP sky130_fd_pr__cap_mim_m3_1 l=3 w=3
X1600 P_B9 P_TOP sky130_fd_pr__cap_mim_m3_1 l=3 w=3
X1601 P_B10 P_TOP sky130_fd_pr__cap_mim_m3_1 l=3 w=3
X1602 P_B10 P_TOP sky130_fd_pr__cap_mim_m3_1 l=3 w=3
X1603 P_B11 P_TOP sky130_fd_pr__cap_mim_m3_1 l=3 w=3
X1604 P_B10 P_TOP sky130_fd_pr__cap_mim_m3_1 l=3 w=3
X1605 P_B11 P_TOP sky130_fd_pr__cap_mim_m3_1 l=3 w=3
X1606 P_B5 P_TOP sky130_fd_pr__cap_mim_m3_1 l=3 w=3
X1607 N_B10 N_TOP sky130_fd_pr__cap_mim_m3_1 l=3 w=3
X1608 N_B11 N_TOP sky130_fd_pr__cap_mim_m3_1 l=3 w=3
X1609 P_B10 P_TOP sky130_fd_pr__cap_mim_m3_1 l=3 w=3
X1610 P_B7 P_TOP sky130_fd_pr__cap_mim_m3_1 l=3 w=3
X1611 P_B11 P_TOP sky130_fd_pr__cap_mim_m3_1 l=3 w=3
X1612 N_B10 N_TOP sky130_fd_pr__cap_mim_m3_1 l=3 w=3
X1613 N_B2 N_TOP sky130_fd_pr__cap_mim_m3_1 l=3 w=3
X1614 N_B11 N_TOP sky130_fd_pr__cap_mim_m3_1 l=3 w=3
X1615 P_B11 P_TOP sky130_fd_pr__cap_mim_m3_1 l=3 w=3
X1616 N_B11 N_TOP sky130_fd_pr__cap_mim_m3_1 l=3 w=3
X1617 P_B11 P_TOP sky130_fd_pr__cap_mim_m3_1 l=3 w=3
X1618 P_B11 P_TOP sky130_fd_pr__cap_mim_m3_1 l=3 w=3
X1619 N_B10 N_TOP sky130_fd_pr__cap_mim_m3_1 l=3 w=3
X1620 N_B11 N_TOP sky130_fd_pr__cap_mim_m3_1 l=3 w=3
X1621 N_B11 N_TOP sky130_fd_pr__cap_mim_m3_1 l=3 w=3
X1622 N_B7 N_TOP sky130_fd_pr__cap_mim_m3_1 l=3 w=3
X1623 N_B11 N_TOP sky130_fd_pr__cap_mim_m3_1 l=3 w=3
X1624 N_B10 N_TOP sky130_fd_pr__cap_mim_m3_1 l=3 w=3
X1625 N_EDGE_BIAS N_EDGE_BIAS sky130_fd_pr__cap_mim_m3_1 l=3 w=3
X1626 P_EDGE_BIAS P_EDGE_BIAS sky130_fd_pr__cap_mim_m3_1 l=3 w=3
X1627 P_B11 P_TOP sky130_fd_pr__cap_mim_m3_1 l=3 w=3
X1628 N_B11 N_TOP sky130_fd_pr__cap_mim_m3_1 l=3 w=3
X1629 N_B11 N_TOP sky130_fd_pr__cap_mim_m3_1 l=3 w=3
X1630 N_B8 N_TOP sky130_fd_pr__cap_mim_m3_1 l=3 w=3
X1631 P_B10 P_TOP sky130_fd_pr__cap_mim_m3_1 l=3 w=3
X1632 P_B9 P_TOP sky130_fd_pr__cap_mim_m3_1 l=3 w=3
X1633 N_B11 N_TOP sky130_fd_pr__cap_mim_m3_1 l=3 w=3
X1634 P_B11 P_TOP sky130_fd_pr__cap_mim_m3_1 l=3 w=3
X1635 N_EDGE_BIAS N_EDGE_BIAS sky130_fd_pr__cap_mim_m3_1 l=3 w=3
X1636 P_B11 P_TOP sky130_fd_pr__cap_mim_m3_1 l=3 w=3
X1637 N_EDGE_BIAS N_EDGE_BIAS sky130_fd_pr__cap_mim_m3_1 l=3 w=3
X1638 N_B11 N_TOP sky130_fd_pr__cap_mim_m3_1 l=3 w=3
X1639 P_B11 P_TOP sky130_fd_pr__cap_mim_m3_1 l=3 w=3
X1640 N_B11 N_TOP sky130_fd_pr__cap_mim_m3_1 l=3 w=3
X1641 P_B11 P_TOP sky130_fd_pr__cap_mim_m3_1 l=3 w=3
X1642 N_EDGE_BIAS N_EDGE_BIAS sky130_fd_pr__cap_mim_m3_1 l=3 w=3
X1643 P_B11 P_TOP sky130_fd_pr__cap_mim_m3_1 l=3 w=3
X1644 P_B11 P_TOP sky130_fd_pr__cap_mim_m3_1 l=3 w=3
X1645 P_B9 P_TOP sky130_fd_pr__cap_mim_m3_1 l=3 w=3
X1646 N_B11 N_TOP sky130_fd_pr__cap_mim_m3_1 l=3 w=3
X1647 P_B11 P_TOP sky130_fd_pr__cap_mim_m3_1 l=3 w=3
X1648 N_B10 N_TOP sky130_fd_pr__cap_mim_m3_1 l=3 w=3
X1649 N_B11 N_TOP sky130_fd_pr__cap_mim_m3_1 l=3 w=3
X1650 N_B11 N_TOP sky130_fd_pr__cap_mim_m3_1 l=3 w=3
X1651 P_B7 P_TOP sky130_fd_pr__cap_mim_m3_1 l=3 w=3
X1652 N_B11 N_TOP sky130_fd_pr__cap_mim_m3_1 l=3 w=3
X1653 N_B11 N_TOP sky130_fd_pr__cap_mim_m3_1 l=3 w=3
X1654 P_B10 P_TOP sky130_fd_pr__cap_mim_m3_1 l=3 w=3
X1655 P_B11 P_TOP sky130_fd_pr__cap_mim_m3_1 l=3 w=3
X1656 N_B11 N_TOP sky130_fd_pr__cap_mim_m3_1 l=3 w=3
X1657 N_B11 N_TOP sky130_fd_pr__cap_mim_m3_1 l=3 w=3
X1658 P_B9 P_TOP sky130_fd_pr__cap_mim_m3_1 l=3 w=3
X1659 N_B11 N_TOP sky130_fd_pr__cap_mim_m3_1 l=3 w=3
X1660 P_B10 P_TOP sky130_fd_pr__cap_mim_m3_1 l=3 w=3
X1661 N_B9 N_TOP sky130_fd_pr__cap_mim_m3_1 l=3 w=3
X1662 N_B8 N_TOP sky130_fd_pr__cap_mim_m3_1 l=3 w=3
X1663 P_B11 P_TOP sky130_fd_pr__cap_mim_m3_1 l=3 w=3
X1664 P_B8 P_TOP sky130_fd_pr__cap_mim_m3_1 l=3 w=3
X1665 N_B11 N_TOP sky130_fd_pr__cap_mim_m3_1 l=3 w=3
X1666 P_B10 P_TOP sky130_fd_pr__cap_mim_m3_1 l=3 w=3
X1667 P_B10 P_TOP sky130_fd_pr__cap_mim_m3_1 l=3 w=3
X1668 N_B8 N_TOP sky130_fd_pr__cap_mim_m3_1 l=3 w=3
X1669 N_B10 N_TOP sky130_fd_pr__cap_mim_m3_1 l=3 w=3
X1670 N_B11 N_TOP sky130_fd_pr__cap_mim_m3_1 l=3 w=3
X1671 P_B11 P_TOP sky130_fd_pr__cap_mim_m3_1 l=3 w=3
X1672 P_B10 P_TOP sky130_fd_pr__cap_mim_m3_1 l=3 w=3
X1673 N_B7 N_TOP sky130_fd_pr__cap_mim_m3_1 l=3 w=3
X1674 N_B11 N_TOP sky130_fd_pr__cap_mim_m3_1 l=3 w=3
X1675 N_B11 N_TOP sky130_fd_pr__cap_mim_m3_1 l=3 w=3
X1676 P_B11 P_TOP sky130_fd_pr__cap_mim_m3_1 l=3 w=3
X1677 N_B8 N_TOP sky130_fd_pr__cap_mim_m3_1 l=3 w=3
X1678 P_B11 P_TOP sky130_fd_pr__cap_mim_m3_1 l=3 w=3
X1679 P_B10 P_TOP sky130_fd_pr__cap_mim_m3_1 l=3 w=3
X1680 P_B11 P_TOP sky130_fd_pr__cap_mim_m3_1 l=3 w=3
X1681 P_B11 P_TOP sky130_fd_pr__cap_mim_m3_1 l=3 w=3
X1682 N_EDGE_BIAS N_EDGE_BIAS sky130_fd_pr__cap_mim_m3_1 l=3 w=3
X1683 N_EDGE_BIAS N_EDGE_BIAS sky130_fd_pr__cap_mim_m3_1 l=3 w=3
X1684 N_B10 N_TOP sky130_fd_pr__cap_mim_m3_1 l=3 w=3
X1685 P_B11 P_TOP sky130_fd_pr__cap_mim_m3_1 l=3 w=3
X1686 N_B9 N_TOP sky130_fd_pr__cap_mim_m3_1 l=3 w=3
X1687 P_B9 P_TOP sky130_fd_pr__cap_mim_m3_1 l=3 w=3
X1688 N_B11 N_TOP sky130_fd_pr__cap_mim_m3_1 l=3 w=3
X1689 P_B11 P_TOP sky130_fd_pr__cap_mim_m3_1 l=3 w=3
X1690 N_B11 N_TOP sky130_fd_pr__cap_mim_m3_1 l=3 w=3
X1691 N_B9 N_TOP sky130_fd_pr__cap_mim_m3_1 l=3 w=3
X1692 P_B11 P_TOP sky130_fd_pr__cap_mim_m3_1 l=3 w=3
X1693 P_B10 P_TOP sky130_fd_pr__cap_mim_m3_1 l=3 w=3
X1694 P_B11 P_TOP sky130_fd_pr__cap_mim_m3_1 l=3 w=3
X1695 N_B11 N_TOP sky130_fd_pr__cap_mim_m3_1 l=3 w=3
X1696 P_B11 P_TOP sky130_fd_pr__cap_mim_m3_1 l=3 w=3
X1697 P_B8 P_TOP sky130_fd_pr__cap_mim_m3_1 l=3 w=3
X1698 N_B11 N_TOP sky130_fd_pr__cap_mim_m3_1 l=3 w=3
X1699 N_B11 N_TOP sky130_fd_pr__cap_mim_m3_1 l=3 w=3
X1700 P_B7 P_TOP sky130_fd_pr__cap_mim_m3_1 l=3 w=3
X1701 N_B9 N_TOP sky130_fd_pr__cap_mim_m3_1 l=3 w=3
X1702 N_B11 N_TOP sky130_fd_pr__cap_mim_m3_1 l=3 w=3
X1703 N_B11 N_TOP sky130_fd_pr__cap_mim_m3_1 l=3 w=3
X1704 N_B11 N_TOP sky130_fd_pr__cap_mim_m3_1 l=3 w=3
X1705 N_B9 N_TOP sky130_fd_pr__cap_mim_m3_1 l=3 w=3
X1706 N_B11 N_TOP sky130_fd_pr__cap_mim_m3_1 l=3 w=3
X1707 P_B10 P_TOP sky130_fd_pr__cap_mim_m3_1 l=3 w=3
X1708 N_B10 N_TOP sky130_fd_pr__cap_mim_m3_1 l=3 w=3
X1709 P_B11 P_TOP sky130_fd_pr__cap_mim_m3_1 l=3 w=3
X1710 P_B3 P_TOP sky130_fd_pr__cap_mim_m3_1 l=3 w=3
X1711 N_B10 N_TOP sky130_fd_pr__cap_mim_m3_1 l=3 w=3
X1712 N_B11 N_TOP sky130_fd_pr__cap_mim_m3_1 l=3 w=3
X1713 P_B5 P_TOP sky130_fd_pr__cap_mim_m3_1 l=3 w=3
X1714 P_B11 P_TOP sky130_fd_pr__cap_mim_m3_1 l=3 w=3
X1715 N_B9 N_TOP sky130_fd_pr__cap_mim_m3_1 l=3 w=3
X1716 N_B10 N_TOP sky130_fd_pr__cap_mim_m3_1 l=3 w=3
X1717 N_B9 N_TOP sky130_fd_pr__cap_mim_m3_1 l=3 w=3
X1718 N_B11 N_TOP sky130_fd_pr__cap_mim_m3_1 l=3 w=3
X1719 N_B10 N_TOP sky130_fd_pr__cap_mim_m3_1 l=3 w=3
X1720 P_B11 P_TOP sky130_fd_pr__cap_mim_m3_1 l=3 w=3
X1721 N_B7 N_TOP sky130_fd_pr__cap_mim_m3_1 l=3 w=3
X1722 N_B10 N_TOP sky130_fd_pr__cap_mim_m3_1 l=3 w=3
X1723 N_EDGE_BIAS N_EDGE_BIAS sky130_fd_pr__cap_mim_m3_1 l=3 w=3
X1724 P_EDGE_BIAS P_EDGE_BIAS sky130_fd_pr__cap_mim_m3_1 l=3 w=3
X1725 N_B10 N_TOP sky130_fd_pr__cap_mim_m3_1 l=3 w=3
X1726 P_EDGE_BIAS P_EDGE_BIAS sky130_fd_pr__cap_mim_m3_1 l=3 w=3
X1727 N_B11 N_TOP sky130_fd_pr__cap_mim_m3_1 l=3 w=3
X1728 P_B11 P_TOP sky130_fd_pr__cap_mim_m3_1 l=3 w=3
X1729 N_B11 N_TOP sky130_fd_pr__cap_mim_m3_1 l=3 w=3
X1730 N_B11 N_TOP sky130_fd_pr__cap_mim_m3_1 l=3 w=3
X1731 N_EDGE_BIAS N_EDGE_BIAS sky130_fd_pr__cap_mim_m3_1 l=3 w=3
X1732 P_B11 P_TOP sky130_fd_pr__cap_mim_m3_1 l=3 w=3
X1733 N_B10 N_TOP sky130_fd_pr__cap_mim_m3_1 l=3 w=3
X1734 N_B11 N_TOP sky130_fd_pr__cap_mim_m3_1 l=3 w=3
X1735 P_B11 P_TOP sky130_fd_pr__cap_mim_m3_1 l=3 w=3
X1736 N_B11 N_TOP sky130_fd_pr__cap_mim_m3_1 l=3 w=3
X1737 P_B11 P_TOP sky130_fd_pr__cap_mim_m3_1 l=3 w=3
X1738 N_B11 N_TOP sky130_fd_pr__cap_mim_m3_1 l=3 w=3
X1739 P_B11 P_TOP sky130_fd_pr__cap_mim_m3_1 l=3 w=3
X1740 P_B11 P_TOP sky130_fd_pr__cap_mim_m3_1 l=3 w=3
X1741 P_B10 P_TOP sky130_fd_pr__cap_mim_m3_1 l=3 w=3
X1742 P_EDGE_BIAS P_EDGE_BIAS sky130_fd_pr__cap_mim_m3_1 l=3 w=3
X1743 N_B11 N_TOP sky130_fd_pr__cap_mim_m3_1 l=3 w=3
X1744 N_B10 N_TOP sky130_fd_pr__cap_mim_m3_1 l=3 w=3
X1745 P_B11 P_TOP sky130_fd_pr__cap_mim_m3_1 l=3 w=3
X1746 P_B11 P_TOP sky130_fd_pr__cap_mim_m3_1 l=3 w=3
X1747 N_B11 N_TOP sky130_fd_pr__cap_mim_m3_1 l=3 w=3
X1748 P_B11 P_TOP sky130_fd_pr__cap_mim_m3_1 l=3 w=3
X1749 N_B10 N_TOP sky130_fd_pr__cap_mim_m3_1 l=3 w=3
X1750 P_B7 P_TOP sky130_fd_pr__cap_mim_m3_1 l=3 w=3
X1751 N_B11 N_TOP sky130_fd_pr__cap_mim_m3_1 l=3 w=3
X1752 N_B11 N_TOP sky130_fd_pr__cap_mim_m3_1 l=3 w=3
X1753 P_B9 P_TOP sky130_fd_pr__cap_mim_m3_1 l=3 w=3
X1754 N_B9 N_TOP sky130_fd_pr__cap_mim_m3_1 l=3 w=3
X1755 N_B11 N_TOP sky130_fd_pr__cap_mim_m3_1 l=3 w=3
X1756 P_B10 P_TOP sky130_fd_pr__cap_mim_m3_1 l=3 w=3
X1757 N_B8 N_TOP sky130_fd_pr__cap_mim_m3_1 l=3 w=3
X1758 N_B11 N_TOP sky130_fd_pr__cap_mim_m3_1 l=3 w=3
X1759 P_B11 P_TOP sky130_fd_pr__cap_mim_m3_1 l=3 w=3
X1760 N_B8 N_TOP sky130_fd_pr__cap_mim_m3_1 l=3 w=3
X1761 P_B8 P_TOP sky130_fd_pr__cap_mim_m3_1 l=3 w=3
X1762 N_B10 N_TOP sky130_fd_pr__cap_mim_m3_1 l=3 w=3
X1763 N_B10 N_TOP sky130_fd_pr__cap_mim_m3_1 l=3 w=3
X1764 P_EDGE_BIAS P_EDGE_BIAS sky130_fd_pr__cap_mim_m3_1 l=3 w=3
X1765 N_B9 N_TOP sky130_fd_pr__cap_mim_m3_1 l=3 w=3
X1766 N_B11 N_TOP sky130_fd_pr__cap_mim_m3_1 l=3 w=3
X1767 N_B11 N_TOP sky130_fd_pr__cap_mim_m3_1 l=3 w=3
X1768 N_B10 N_TOP sky130_fd_pr__cap_mim_m3_1 l=3 w=3
X1769 P_B10 P_TOP sky130_fd_pr__cap_mim_m3_1 l=3 w=3
X1770 N_B11 N_TOP sky130_fd_pr__cap_mim_m3_1 l=3 w=3
X1771 N_B7 N_TOP sky130_fd_pr__cap_mim_m3_1 l=3 w=3
X1772 N_B11 N_TOP sky130_fd_pr__cap_mim_m3_1 l=3 w=3
X1773 N_B11 N_TOP sky130_fd_pr__cap_mim_m3_1 l=3 w=3
X1774 N_B10 N_TOP sky130_fd_pr__cap_mim_m3_1 l=3 w=3
X1775 N_B10 N_TOP sky130_fd_pr__cap_mim_m3_1 l=3 w=3
X1776 P_B10 P_TOP sky130_fd_pr__cap_mim_m3_1 l=3 w=3
X1777 P_B11 P_TOP sky130_fd_pr__cap_mim_m3_1 l=3 w=3
X1778 P_B11 P_TOP sky130_fd_pr__cap_mim_m3_1 l=3 w=3
X1779 N_EDGE_BIAS N_EDGE_BIAS sky130_fd_pr__cap_mim_m3_1 l=3 w=3
X1780 N_EDGE_BIAS N_EDGE_BIAS sky130_fd_pr__cap_mim_m3_1 l=3 w=3
X1781 P_B11 P_TOP sky130_fd_pr__cap_mim_m3_1 l=3 w=3
X1782 N_B11 N_TOP sky130_fd_pr__cap_mim_m3_1 l=3 w=3
X1783 P_B11 P_TOP sky130_fd_pr__cap_mim_m3_1 l=3 w=3
X1784 N_B11 N_TOP sky130_fd_pr__cap_mim_m3_1 l=3 w=3
X1785 N_B11 N_TOP sky130_fd_pr__cap_mim_m3_1 l=3 w=3
X1786 P_B11 P_TOP sky130_fd_pr__cap_mim_m3_1 l=3 w=3
X1787 N_B11 N_TOP sky130_fd_pr__cap_mim_m3_1 l=3 w=3
X1788 P_B11 P_TOP sky130_fd_pr__cap_mim_m3_1 l=3 w=3
X1789 P_B8 P_TOP sky130_fd_pr__cap_mim_m3_1 l=3 w=3
X1790 N_B11 N_TOP sky130_fd_pr__cap_mim_m3_1 l=3 w=3
X1791 P_B11 P_TOP sky130_fd_pr__cap_mim_m3_1 l=3 w=3
X1792 P_B10 P_TOP sky130_fd_pr__cap_mim_m3_1 l=3 w=3
X1793 P_B11 P_TOP sky130_fd_pr__cap_mim_m3_1 l=3 w=3
X1794 P_B11 P_TOP sky130_fd_pr__cap_mim_m3_1 l=3 w=3
X1795 N_B11 N_TOP sky130_fd_pr__cap_mim_m3_1 l=3 w=3
X1796 P_B11 P_TOP sky130_fd_pr__cap_mim_m3_1 l=3 w=3
X1797 P_B11 P_TOP sky130_fd_pr__cap_mim_m3_1 l=3 w=3
X1798 P_B11 P_TOP sky130_fd_pr__cap_mim_m3_1 l=3 w=3
X1799 P_B9 P_TOP sky130_fd_pr__cap_mim_m3_1 l=3 w=3
X1800 N_B9 N_TOP sky130_fd_pr__cap_mim_m3_1 l=3 w=3
X1801 N_B11 N_TOP sky130_fd_pr__cap_mim_m3_1 l=3 w=3
X1802 P_B11 P_TOP sky130_fd_pr__cap_mim_m3_1 l=3 w=3
X1803 N_B9 N_TOP sky130_fd_pr__cap_mim_m3_1 l=3 w=3
X1804 P_B10 P_TOP sky130_fd_pr__cap_mim_m3_1 l=3 w=3
X1805 P_B5 P_TOP sky130_fd_pr__cap_mim_m3_1 l=3 w=3
X1806 N_B10 N_TOP sky130_fd_pr__cap_mim_m3_1 l=3 w=3
X1807 N_B10 N_TOP sky130_fd_pr__cap_mim_m3_1 l=3 w=3
X1808 P_B10 P_TOP sky130_fd_pr__cap_mim_m3_1 l=3 w=3
X1809 P_B11 P_TOP sky130_fd_pr__cap_mim_m3_1 l=3 w=3
X1810 N_B11 N_TOP sky130_fd_pr__cap_mim_m3_1 l=3 w=3
X1811 P_B9 P_TOP sky130_fd_pr__cap_mim_m3_1 l=3 w=3
X1812 P_B10 P_TOP sky130_fd_pr__cap_mim_m3_1 l=3 w=3
X1813 P_EDGE_BIAS P_EDGE_BIAS sky130_fd_pr__cap_mim_m3_1 l=3 w=3
X1814 N_B11 N_TOP sky130_fd_pr__cap_mim_m3_1 l=3 w=3
X1815 N_B11 N_TOP sky130_fd_pr__cap_mim_m3_1 l=3 w=3
X1816 P_B11 P_TOP sky130_fd_pr__cap_mim_m3_1 l=3 w=3
X1817 N_B11 N_TOP sky130_fd_pr__cap_mim_m3_1 l=3 w=3
X1818 N_B9 N_TOP sky130_fd_pr__cap_mim_m3_1 l=3 w=3
X1819 N_B9 N_TOP sky130_fd_pr__cap_mim_m3_1 l=3 w=3
X1820 N_B11 N_TOP sky130_fd_pr__cap_mim_m3_1 l=3 w=3
X1821 N_B10 N_TOP sky130_fd_pr__cap_mim_m3_1 l=3 w=3
X1822 N_B10 N_TOP sky130_fd_pr__cap_mim_m3_1 l=3 w=3
X1823 P_B11 P_TOP sky130_fd_pr__cap_mim_m3_1 l=3 w=3
X1824 N_B7 N_TOP sky130_fd_pr__cap_mim_m3_1 l=3 w=3
X1825 N_B10 N_TOP sky130_fd_pr__cap_mim_m3_1 l=3 w=3
X1826 P_EDGE_BIAS P_EDGE_BIAS sky130_fd_pr__cap_mim_m3_1 l=3 w=3
X1827 N_EDGE_BIAS N_EDGE_BIAS sky130_fd_pr__cap_mim_m3_1 l=3 w=3
X1828 N_B9 N_TOP sky130_fd_pr__cap_mim_m3_1 l=3 w=3
X1829 P_B11 P_TOP sky130_fd_pr__cap_mim_m3_1 l=3 w=3
X1830 N_B11 N_TOP sky130_fd_pr__cap_mim_m3_1 l=3 w=3
X1831 P_B11 P_TOP sky130_fd_pr__cap_mim_m3_1 l=3 w=3
X1832 P_B11 P_TOP sky130_fd_pr__cap_mim_m3_1 l=3 w=3
X1833 N_EDGE_BIAS N_EDGE_BIAS sky130_fd_pr__cap_mim_m3_1 l=3 w=3
X1834 N_B10 N_TOP sky130_fd_pr__cap_mim_m3_1 l=3 w=3
X1835 P_B9 P_TOP sky130_fd_pr__cap_mim_m3_1 l=3 w=3
X1836 P_B11 P_TOP sky130_fd_pr__cap_mim_m3_1 l=3 w=3
X1837 N_B11 N_TOP sky130_fd_pr__cap_mim_m3_1 l=3 w=3
X1838 N_B11 N_TOP sky130_fd_pr__cap_mim_m3_1 l=3 w=3
X1839 P_B11 P_TOP sky130_fd_pr__cap_mim_m3_1 l=3 w=3
X1840 N_EDGE_BIAS N_EDGE_BIAS sky130_fd_pr__cap_mim_m3_1 l=3 w=3
X1841 P_B11 P_TOP sky130_fd_pr__cap_mim_m3_1 l=3 w=3
X1842 P_B10 P_TOP sky130_fd_pr__cap_mim_m3_1 l=3 w=3
X1843 N_B11 N_TOP sky130_fd_pr__cap_mim_m3_1 l=3 w=3
X1844 P_B11 P_TOP sky130_fd_pr__cap_mim_m3_1 l=3 w=3
X1845 P_B9 P_TOP sky130_fd_pr__cap_mim_m3_1 l=3 w=3
X1846 P_B9 P_TOP sky130_fd_pr__cap_mim_m3_1 l=3 w=3
X1847 N_B11 N_TOP sky130_fd_pr__cap_mim_m3_1 l=3 w=3
X1848 P_B11 P_TOP sky130_fd_pr__cap_mim_m3_1 l=3 w=3
X1849 P_B10 P_TOP sky130_fd_pr__cap_mim_m3_1 l=3 w=3
X1850 N_B10 N_TOP sky130_fd_pr__cap_mim_m3_1 l=3 w=3
X1851 N_B11 N_TOP sky130_fd_pr__cap_mim_m3_1 l=3 w=3
X1852 N_B11 N_TOP sky130_fd_pr__cap_mim_m3_1 l=3 w=3
X1853 P_B10 P_TOP sky130_fd_pr__cap_mim_m3_1 l=3 w=3
X1854 N_B11 N_TOP sky130_fd_pr__cap_mim_m3_1 l=3 w=3
X1855 N_B11 N_TOP sky130_fd_pr__cap_mim_m3_1 l=3 w=3
X1856 P_B10 P_TOP sky130_fd_pr__cap_mim_m3_1 l=3 w=3
X1857 N_B11 N_TOP sky130_fd_pr__cap_mim_m3_1 l=3 w=3
X1858 P_B11 P_TOP sky130_fd_pr__cap_mim_m3_1 l=3 w=3
X1859 P_B11 P_TOP sky130_fd_pr__cap_mim_m3_1 l=3 w=3
X1860 P_B10 P_TOP sky130_fd_pr__cap_mim_m3_1 l=3 w=3
X1861 N_B9 N_TOP sky130_fd_pr__cap_mim_m3_1 l=3 w=3
X1862 N_B8 N_TOP sky130_fd_pr__cap_mim_m3_1 l=3 w=3
X1863 N_B9 N_TOP sky130_fd_pr__cap_mim_m3_1 l=3 w=3
X1864 P_B8 P_TOP sky130_fd_pr__cap_mim_m3_1 l=3 w=3
X1865 N_B11 N_TOP sky130_fd_pr__cap_mim_m3_1 l=3 w=3
X1866 P_B11 P_TOP sky130_fd_pr__cap_mim_m3_1 l=3 w=3
X1867 P_EDGE_BIAS P_EDGE_BIAS sky130_fd_pr__cap_mim_m3_1 l=3 w=3
X1868 P_B10 P_TOP sky130_fd_pr__cap_mim_m3_1 l=3 w=3
X1869 N_B10 N_TOP sky130_fd_pr__cap_mim_m3_1 l=3 w=3
X1870 N_B10 N_TOP sky130_fd_pr__cap_mim_m3_1 l=3 w=3
X1871 P_B11 P_TOP sky130_fd_pr__cap_mim_m3_1 l=3 w=3
X1872 P_B10 P_TOP sky130_fd_pr__cap_mim_m3_1 l=3 w=3
X1873 N_B7 N_TOP sky130_fd_pr__cap_mim_m3_1 l=3 w=3
X1874 N_B9 N_TOP sky130_fd_pr__cap_mim_m3_1 l=3 w=3
X1875 N_B11 N_TOP sky130_fd_pr__cap_mim_m3_1 l=3 w=3
X1876 N_B7 N_TOP sky130_fd_pr__cap_mim_m3_1 l=3 w=3
X1877 N_B10 N_TOP sky130_fd_pr__cap_mim_m3_1 l=3 w=3
X1878 N_B11 N_TOP sky130_fd_pr__cap_mim_m3_1 l=3 w=3
X1879 N_B8 N_TOP sky130_fd_pr__cap_mim_m3_1 l=3 w=3
X1880 P_B10 P_TOP sky130_fd_pr__cap_mim_m3_1 l=3 w=3
X1881 P_B11 P_TOP sky130_fd_pr__cap_mim_m3_1 l=3 w=3
X1882 N_EDGE_BIAS N_EDGE_BIAS sky130_fd_pr__cap_mim_m3_1 l=3 w=3
X1883 N_B6 N_TOP sky130_fd_pr__cap_mim_m3_1 l=3 w=3
X1884 N_B11 N_TOP sky130_fd_pr__cap_mim_m3_1 l=3 w=3
X1885 P_B11 P_TOP sky130_fd_pr__cap_mim_m3_1 l=3 w=3
X1886 N_B11 N_TOP sky130_fd_pr__cap_mim_m3_1 l=3 w=3
X1887 P_EDGE_BIAS P_EDGE_BIAS sky130_fd_pr__cap_mim_m3_1 l=3 w=3
X1888 N_B9 N_TOP sky130_fd_pr__cap_mim_m3_1 l=3 w=3
X1889 N_EDGE_BIAS N_EDGE_BIAS sky130_fd_pr__cap_mim_m3_1 l=3 w=3
X1890 P_B11 P_TOP sky130_fd_pr__cap_mim_m3_1 l=3 w=3
X1891 P_B11 P_TOP sky130_fd_pr__cap_mim_m3_1 l=3 w=3
X1892 N_EDGE_BIAS N_EDGE_BIAS sky130_fd_pr__cap_mim_m3_1 l=3 w=3
X1893 P_B10 P_TOP sky130_fd_pr__cap_mim_m3_1 l=3 w=3
X1894 N_B11 N_TOP sky130_fd_pr__cap_mim_m3_1 l=3 w=3
X1895 P_B10 P_TOP sky130_fd_pr__cap_mim_m3_1 l=3 w=3
X1896 P_B11 P_TOP sky130_fd_pr__cap_mim_m3_1 l=3 w=3
X1897 P_B11 P_TOP sky130_fd_pr__cap_mim_m3_1 l=3 w=3
X1898 N_B11 N_TOP sky130_fd_pr__cap_mim_m3_1 l=3 w=3
X1899 P_EDGE_BIAS P_EDGE_BIAS sky130_fd_pr__cap_mim_m3_1 l=3 w=3
X1900 N_B11 N_TOP sky130_fd_pr__cap_mim_m3_1 l=3 w=3
X1901 P_B11 P_TOP sky130_fd_pr__cap_mim_m3_1 l=3 w=3
X1902 P_B11 P_TOP sky130_fd_pr__cap_mim_m3_1 l=3 w=3
X1903 P_B9 P_TOP sky130_fd_pr__cap_mim_m3_1 l=3 w=3
X1904 N_B11 N_TOP sky130_fd_pr__cap_mim_m3_1 l=3 w=3
X1905 N_B9 N_TOP sky130_fd_pr__cap_mim_m3_1 l=3 w=3
X1906 P_B9 P_TOP sky130_fd_pr__cap_mim_m3_1 l=3 w=3
X1907 P_B10 P_TOP sky130_fd_pr__cap_mim_m3_1 l=3 w=3
X1908 P_B10 P_TOP sky130_fd_pr__cap_mim_m3_1 l=3 w=3
X1909 P_B11 P_TOP sky130_fd_pr__cap_mim_m3_1 l=3 w=3
X1910 P_B4 P_TOP sky130_fd_pr__cap_mim_m3_1 l=3 w=3
X1911 N_B10 N_TOP sky130_fd_pr__cap_mim_m3_1 l=3 w=3
X1912 N_B11 N_TOP sky130_fd_pr__cap_mim_m3_1 l=3 w=3
X1913 P_B10 P_TOP sky130_fd_pr__cap_mim_m3_1 l=3 w=3
X1914 P_B11 P_TOP sky130_fd_pr__cap_mim_m3_1 l=3 w=3
X1915 P_B9 P_TOP sky130_fd_pr__cap_mim_m3_1 l=3 w=3
X1916 N_B11 N_TOP sky130_fd_pr__cap_mim_m3_1 l=3 w=3
X1917 N_B11 N_TOP sky130_fd_pr__cap_mim_m3_1 l=3 w=3
X1918 N_EDGE_BIAS N_EDGE_BIAS sky130_fd_pr__cap_mim_m3_1 l=3 w=3
X1919 N_B9 N_TOP sky130_fd_pr__cap_mim_m3_1 l=3 w=3
X1920 N_B11 N_TOP sky130_fd_pr__cap_mim_m3_1 l=3 w=3
X1921 P_B11 P_TOP sky130_fd_pr__cap_mim_m3_1 l=3 w=3
X1922 N_B7 N_TOP sky130_fd_pr__cap_mim_m3_1 l=3 w=3
X1923 N_B10 N_TOP sky130_fd_pr__cap_mim_m3_1 l=3 w=3
X1924 N_B7 N_TOP sky130_fd_pr__cap_mim_m3_1 l=3 w=3
X1925 P_EDGE_BIAS P_EDGE_BIAS sky130_fd_pr__cap_mim_m3_1 l=3 w=3
X1926 P_EDGE_BIAS P_EDGE_BIAS sky130_fd_pr__cap_mim_m3_1 l=3 w=3
X1927 N_EDGE_BIAS N_EDGE_BIAS sky130_fd_pr__cap_mim_m3_1 l=3 w=3
X1928 N_B9 N_TOP sky130_fd_pr__cap_mim_m3_1 l=3 w=3
X1929 N_B11 N_TOP sky130_fd_pr__cap_mim_m3_1 l=3 w=3
X1930 N_B8 N_TOP sky130_fd_pr__cap_mim_m3_1 l=3 w=3
X1931 N_EDGE_BIAS N_EDGE_BIAS sky130_fd_pr__cap_mim_m3_1 l=3 w=3
X1932 P_B10 P_TOP sky130_fd_pr__cap_mim_m3_1 l=3 w=3
X1933 N_B11 N_TOP sky130_fd_pr__cap_mim_m3_1 l=3 w=3
X1934 P_B11 P_TOP sky130_fd_pr__cap_mim_m3_1 l=3 w=3
X1935 N_B11 N_TOP sky130_fd_pr__cap_mim_m3_1 l=3 w=3
X1936 P_B11 P_TOP sky130_fd_pr__cap_mim_m3_1 l=3 w=3
X1937 P_B11 P_TOP sky130_fd_pr__cap_mim_m3_1 l=3 w=3
X1938 P_B9 P_TOP sky130_fd_pr__cap_mim_m3_1 l=3 w=3
X1939 N_B10 N_TOP sky130_fd_pr__cap_mim_m3_1 l=3 w=3
X1940 N_B11 N_TOP sky130_fd_pr__cap_mim_m3_1 l=3 w=3
X1941 P_B11 P_TOP sky130_fd_pr__cap_mim_m3_1 l=3 w=3
X1942 N_B10 N_TOP sky130_fd_pr__cap_mim_m3_1 l=3 w=3
X1943 N_B11 N_TOP sky130_fd_pr__cap_mim_m3_1 l=3 w=3
X1944 N_B11 N_TOP sky130_fd_pr__cap_mim_m3_1 l=3 w=3
X1945 P_B11 P_TOP sky130_fd_pr__cap_mim_m3_1 l=3 w=3
X1946 P_B10 P_TOP sky130_fd_pr__cap_mim_m3_1 l=3 w=3
X1947 N_B11 N_TOP sky130_fd_pr__cap_mim_m3_1 l=3 w=3
X1948 P_B9 P_TOP sky130_fd_pr__cap_mim_m3_1 l=3 w=3
X1949 P_B10 P_TOP sky130_fd_pr__cap_mim_m3_1 l=3 w=3
X1950 P_EDGE_BIAS P_EDGE_BIAS sky130_fd_pr__cap_mim_m3_1 l=3 w=3
X1951 N_B9 N_TOP sky130_fd_pr__cap_mim_m3_1 l=3 w=3
X1952 N_B8 N_TOP sky130_fd_pr__cap_mim_m3_1 l=3 w=3
X1953 P_B8 P_TOP sky130_fd_pr__cap_mim_m3_1 l=3 w=3
X1954 N_B11 N_TOP sky130_fd_pr__cap_mim_m3_1 l=3 w=3
X1955 N_B11 N_TOP sky130_fd_pr__cap_mim_m3_1 l=3 w=3
X1956 P_B10 P_TOP sky130_fd_pr__cap_mim_m3_1 l=3 w=3
X1957 N_B10 N_TOP sky130_fd_pr__cap_mim_m3_1 l=3 w=3
X1958 N_B11 N_TOP sky130_fd_pr__cap_mim_m3_1 l=3 w=3
X1959 P_B11 P_TOP sky130_fd_pr__cap_mim_m3_1 l=3 w=3
X1960 P_B10 P_TOP sky130_fd_pr__cap_mim_m3_1 l=3 w=3
X1961 N_B11 N_TOP sky130_fd_pr__cap_mim_m3_1 l=3 w=3
X1962 N_B7 N_TOP sky130_fd_pr__cap_mim_m3_1 l=3 w=3
X1963 N_B11 N_TOP sky130_fd_pr__cap_mim_m3_1 l=3 w=3
X1964 N_EDGE_BIAS N_EDGE_BIAS sky130_fd_pr__cap_mim_m3_1 l=3 w=3
X1965 N_B10 N_TOP sky130_fd_pr__cap_mim_m3_1 l=3 w=3
X1966 N_B6 N_TOP sky130_fd_pr__cap_mim_m3_1 l=3 w=3
X1967 P_B11 P_TOP sky130_fd_pr__cap_mim_m3_1 l=3 w=3
X1968 N_B10 N_TOP sky130_fd_pr__cap_mim_m3_1 l=3 w=3
X1969 P_B11 P_TOP sky130_fd_pr__cap_mim_m3_1 l=3 w=3
X1970 N_B11 N_TOP sky130_fd_pr__cap_mim_m3_1 l=3 w=3
X1971 N_B11 N_TOP sky130_fd_pr__cap_mim_m3_1 l=3 w=3
X1972 P_B11 P_TOP sky130_fd_pr__cap_mim_m3_1 l=3 w=3
X1973 N_B10 N_TOP sky130_fd_pr__cap_mim_m3_1 l=3 w=3
X1974 P_B9 P_TOP sky130_fd_pr__cap_mim_m3_1 l=3 w=3
X1975 N_B11 N_TOP sky130_fd_pr__cap_mim_m3_1 l=3 w=3
X1976 P_B11 P_TOP sky130_fd_pr__cap_mim_m3_1 l=3 w=3
X1977 N_B11 N_TOP sky130_fd_pr__cap_mim_m3_1 l=3 w=3
X1978 N_B9 N_TOP sky130_fd_pr__cap_mim_m3_1 l=3 w=3
X1979 P_B11 P_TOP sky130_fd_pr__cap_mim_m3_1 l=3 w=3
X1980 P_B10 P_TOP sky130_fd_pr__cap_mim_m3_1 l=3 w=3
X1981 P_B11 P_TOP sky130_fd_pr__cap_mim_m3_1 l=3 w=3
X1982 N_B11 N_TOP sky130_fd_pr__cap_mim_m3_1 l=3 w=3
X1983 N_EDGE_BIAS N_EDGE_BIAS sky130_fd_pr__cap_mim_m3_1 l=3 w=3
X1984 P_B8 P_TOP sky130_fd_pr__cap_mim_m3_1 l=3 w=3
X1985 N_B11 N_TOP sky130_fd_pr__cap_mim_m3_1 l=3 w=3
X1986 N_B11 N_TOP sky130_fd_pr__cap_mim_m3_1 l=3 w=3
X1987 N_B11 N_TOP sky130_fd_pr__cap_mim_m3_1 l=3 w=3
X1988 N_B11 N_TOP sky130_fd_pr__cap_mim_m3_1 l=3 w=3
X1989 N_B11 N_TOP sky130_fd_pr__cap_mim_m3_1 l=3 w=3
X1990 N_B11 N_TOP sky130_fd_pr__cap_mim_m3_1 l=3 w=3
X1991 P_B11 P_TOP sky130_fd_pr__cap_mim_m3_1 l=3 w=3
X1992 N_B11 N_TOP sky130_fd_pr__cap_mim_m3_1 l=3 w=3
X1993 P_B11 P_TOP sky130_fd_pr__cap_mim_m3_1 l=3 w=3
X1994 N_B11 N_TOP sky130_fd_pr__cap_mim_m3_1 l=3 w=3
X1995 P_B9 P_TOP sky130_fd_pr__cap_mim_m3_1 l=3 w=3
X1996 N_B9 N_TOP sky130_fd_pr__cap_mim_m3_1 l=3 w=3
X1997 P_B10 P_TOP sky130_fd_pr__cap_mim_m3_1 l=3 w=3
X1998 N_B11 N_TOP sky130_fd_pr__cap_mim_m3_1 l=3 w=3
X1999 P_B11 P_TOP sky130_fd_pr__cap_mim_m3_1 l=3 w=3
X2000 N_B10 N_TOP sky130_fd_pr__cap_mim_m3_1 l=3 w=3
X2001 N_B11 N_TOP sky130_fd_pr__cap_mim_m3_1 l=3 w=3
X2002 P_B11 P_TOP sky130_fd_pr__cap_mim_m3_1 l=3 w=3
X2003 N_B11 N_TOP sky130_fd_pr__cap_mim_m3_1 l=3 w=3
X2004 P_B11 P_TOP sky130_fd_pr__cap_mim_m3_1 l=3 w=3
X2005 N_B9 N_TOP sky130_fd_pr__cap_mim_m3_1 l=3 w=3
X2006 P_B9 P_TOP sky130_fd_pr__cap_mim_m3_1 l=3 w=3
X2007 P_B11 P_TOP sky130_fd_pr__cap_mim_m3_1 l=3 w=3
X2008 N_B9 N_TOP sky130_fd_pr__cap_mim_m3_1 l=3 w=3
X2009 N_B11 N_TOP sky130_fd_pr__cap_mim_m3_1 l=3 w=3
X2010 N_B10 N_TOP sky130_fd_pr__cap_mim_m3_1 l=3 w=3
X2011 P_B11 P_TOP sky130_fd_pr__cap_mim_m3_1 l=3 w=3
X2012 P_B11 P_TOP sky130_fd_pr__cap_mim_m3_1 l=3 w=3
X2013 N_B7 N_TOP sky130_fd_pr__cap_mim_m3_1 l=3 w=3
X2014 N_B10 N_TOP sky130_fd_pr__cap_mim_m3_1 l=3 w=3
X2015 P_EDGE_BIAS P_EDGE_BIAS sky130_fd_pr__cap_mim_m3_1 l=3 w=3
X2016 N_EDGE_BIAS N_EDGE_BIAS sky130_fd_pr__cap_mim_m3_1 l=3 w=3
X2017 P_EDGE_BIAS P_EDGE_BIAS sky130_fd_pr__cap_mim_m3_1 l=3 w=3
X2018 N_B11 N_TOP sky130_fd_pr__cap_mim_m3_1 l=3 w=3
X2019 N_B10 N_TOP sky130_fd_pr__cap_mim_m3_1 l=3 w=3
X2020 P_B11 P_TOP sky130_fd_pr__cap_mim_m3_1 l=3 w=3
X2021 P_B11 P_TOP sky130_fd_pr__cap_mim_m3_1 l=3 w=3
X2022 N_B8 N_TOP sky130_fd_pr__cap_mim_m3_1 l=3 w=3
X2023 P_B11 P_TOP sky130_fd_pr__cap_mim_m3_1 l=3 w=3
X2024 N_B11 N_TOP sky130_fd_pr__cap_mim_m3_1 l=3 w=3
X2025 N_B10 N_TOP sky130_fd_pr__cap_mim_m3_1 l=3 w=3
X2026 N_B11 N_TOP sky130_fd_pr__cap_mim_m3_1 l=3 w=3
X2027 N_B11 N_TOP sky130_fd_pr__cap_mim_m3_1 l=3 w=3
X2028 P_B11 P_TOP sky130_fd_pr__cap_mim_m3_1 l=3 w=3
X2029 N_B10 N_TOP sky130_fd_pr__cap_mim_m3_1 l=3 w=3
X2030 N_B11 N_TOP sky130_fd_pr__cap_mim_m3_1 l=3 w=3
X2031 P_B11 P_TOP sky130_fd_pr__cap_mim_m3_1 l=3 w=3
X2032 N_B11 N_TOP sky130_fd_pr__cap_mim_m3_1 l=3 w=3
X2033 P_B11 P_TOP sky130_fd_pr__cap_mim_m3_1 l=3 w=3
X2034 P_B11 P_TOP sky130_fd_pr__cap_mim_m3_1 l=3 w=3
X2035 N_B11 N_TOP sky130_fd_pr__cap_mim_m3_1 l=3 w=3
X2036 N_B10 N_TOP sky130_fd_pr__cap_mim_m3_1 l=3 w=3
X2037 P_B11 P_TOP sky130_fd_pr__cap_mim_m3_1 l=3 w=3
X2038 P_B11 P_TOP sky130_fd_pr__cap_mim_m3_1 l=3 w=3
X2039 N_B10 N_TOP sky130_fd_pr__cap_mim_m3_1 l=3 w=3
X2040 N_B11 N_TOP sky130_fd_pr__cap_mim_m3_1 l=3 w=3
X2041 N_B10 N_TOP sky130_fd_pr__cap_mim_m3_1 l=3 w=3
X2042 N_B11 N_TOP sky130_fd_pr__cap_mim_m3_1 l=3 w=3
X2043 P_B11 P_TOP sky130_fd_pr__cap_mim_m3_1 l=3 w=3
X2044 P_B10 P_TOP sky130_fd_pr__cap_mim_m3_1 l=3 w=3
X2045 N_B11 N_TOP sky130_fd_pr__cap_mim_m3_1 l=3 w=3
X2046 P_B9 P_TOP sky130_fd_pr__cap_mim_m3_1 l=3 w=3
X2047 P_EDGE_BIAS P_EDGE_BIAS sky130_fd_pr__cap_mim_m3_1 l=3 w=3
X2048 N_B11 N_TOP sky130_fd_pr__cap_mim_m3_1 l=3 w=3
X2049 N_B8 N_TOP sky130_fd_pr__cap_mim_m3_1 l=3 w=3
X2050 N_B11 N_TOP sky130_fd_pr__cap_mim_m3_1 l=3 w=3
X2051 P_B11 P_TOP sky130_fd_pr__cap_mim_m3_1 l=3 w=3
X2052 N_B10 N_TOP sky130_fd_pr__cap_mim_m3_1 l=3 w=3
X2053 N_B11 N_TOP sky130_fd_pr__cap_mim_m3_1 l=3 w=3
X2054 N_B10 N_TOP sky130_fd_pr__cap_mim_m3_1 l=3 w=3
X2055 P_B10 P_TOP sky130_fd_pr__cap_mim_m3_1 l=3 w=3
X2056 N_B10 N_TOP sky130_fd_pr__cap_mim_m3_1 l=3 w=3
X2057 N_EDGE_BIAS N_EDGE_BIAS sky130_fd_pr__cap_mim_m3_1 l=3 w=3
X2058 N_B11 N_TOP sky130_fd_pr__cap_mim_m3_1 l=3 w=3
X2059 N_B11 N_TOP sky130_fd_pr__cap_mim_m3_1 l=3 w=3
X2060 P_B10 P_TOP sky130_fd_pr__cap_mim_m3_1 l=3 w=3
X2061 N_B7 N_TOP sky130_fd_pr__cap_mim_m3_1 l=3 w=3
X2062 N_B11 N_TOP sky130_fd_pr__cap_mim_m3_1 l=3 w=3
X2063 N_B10 N_TOP sky130_fd_pr__cap_mim_m3_1 l=3 w=3
X2064 P_B10 P_TOP sky130_fd_pr__cap_mim_m3_1 l=3 w=3
X2065 N_B10 N_TOP sky130_fd_pr__cap_mim_m3_1 l=3 w=3
X2066 N_B11 N_TOP sky130_fd_pr__cap_mim_m3_1 l=3 w=3
X2067 P_B11 P_TOP sky130_fd_pr__cap_mim_m3_1 l=3 w=3
X2068 P_B10 P_TOP sky130_fd_pr__cap_mim_m3_1 l=3 w=3
X2069 P_B11 P_TOP sky130_fd_pr__cap_mim_m3_1 l=3 w=3
X2070 N_B10 N_TOP sky130_fd_pr__cap_mim_m3_1 l=3 w=3
X2071 N_B6 N_TOP sky130_fd_pr__cap_mim_m3_1 l=3 w=3
X2072 N_B11 N_TOP sky130_fd_pr__cap_mim_m3_1 l=3 w=3
X2073 P_B11 P_TOP sky130_fd_pr__cap_mim_m3_1 l=3 w=3
X2074 N_B11 N_TOP sky130_fd_pr__cap_mim_m3_1 l=3 w=3
X2075 N_B11 N_TOP sky130_fd_pr__cap_mim_m3_1 l=3 w=3
X2076 P_B11 P_TOP sky130_fd_pr__cap_mim_m3_1 l=3 w=3
X2077 P_B11 P_TOP sky130_fd_pr__cap_mim_m3_1 l=3 w=3
X2078 P_B8 P_TOP sky130_fd_pr__cap_mim_m3_1 l=3 w=3
X2079 N_EDGE_BIAS N_EDGE_BIAS sky130_fd_pr__cap_mim_m3_1 l=3 w=3
X2080 P_B11 P_TOP sky130_fd_pr__cap_mim_m3_1 l=3 w=3
X2081 P_B11 P_TOP sky130_fd_pr__cap_mim_m3_1 l=3 w=3
X2082 P_B8 P_TOP sky130_fd_pr__cap_mim_m3_1 l=3 w=3
X2083 P_B11 P_TOP sky130_fd_pr__cap_mim_m3_1 l=3 w=3
X2084 N_B11 N_TOP sky130_fd_pr__cap_mim_m3_1 l=3 w=3
X2085 P_B11 P_TOP sky130_fd_pr__cap_mim_m3_1 l=3 w=3
X2086 P_B9 P_TOP sky130_fd_pr__cap_mim_m3_1 l=3 w=3
X2087 N_B9 N_TOP sky130_fd_pr__cap_mim_m3_1 l=3 w=3
X2088 N_B11 N_TOP sky130_fd_pr__cap_mim_m3_1 l=3 w=3
X2089 P_B11 P_TOP sky130_fd_pr__cap_mim_m3_1 l=3 w=3
X2090 P_B9 P_TOP sky130_fd_pr__cap_mim_m3_1 l=3 w=3
X2091 P_B11 P_TOP sky130_fd_pr__cap_mim_m3_1 l=3 w=3
X2092 P_B9 P_TOP sky130_fd_pr__cap_mim_m3_1 l=3 w=3
X2093 P_EDGE_BIAS P_EDGE_BIAS sky130_fd_pr__cap_mim_m3_1 l=3 w=3
X2094 P_B5 P_TOP sky130_fd_pr__cap_mim_m3_1 l=3 w=3
X2095 N_B11 N_TOP sky130_fd_pr__cap_mim_m3_1 l=3 w=3
X2096 P_B10 P_TOP sky130_fd_pr__cap_mim_m3_1 l=3 w=3
X2097 N_B11 N_TOP sky130_fd_pr__cap_mim_m3_1 l=3 w=3
X2098 P_EDGE_BIAS P_EDGE_BIAS sky130_fd_pr__cap_mim_m3_1 l=3 w=3
X2099 P_B9 P_TOP sky130_fd_pr__cap_mim_m3_1 l=3 w=3
X2100 N_B11 N_TOP sky130_fd_pr__cap_mim_m3_1 l=3 w=3
X2101 N_B11 N_TOP sky130_fd_pr__cap_mim_m3_1 l=3 w=3
X2102 N_B9 N_TOP sky130_fd_pr__cap_mim_m3_1 l=3 w=3
X2103 P_B11 P_TOP sky130_fd_pr__cap_mim_m3_1 l=3 w=3
X2104 P_B10 P_TOP sky130_fd_pr__cap_mim_m3_1 l=3 w=3
X2105 N_B9 N_TOP sky130_fd_pr__cap_mim_m3_1 l=3 w=3
X2106 P_B11 P_TOP sky130_fd_pr__cap_mim_m3_1 l=3 w=3
X2107 N_B11 N_TOP sky130_fd_pr__cap_mim_m3_1 l=3 w=3
X2108 N_B7 N_TOP sky130_fd_pr__cap_mim_m3_1 l=3 w=3
X2109 N_B10 N_TOP sky130_fd_pr__cap_mim_m3_1 l=3 w=3
X2110 P_EDGE_BIAS P_EDGE_BIAS sky130_fd_pr__cap_mim_m3_1 l=3 w=3
X2111 N_EDGE_BIAS N_EDGE_BIAS sky130_fd_pr__cap_mim_m3_1 l=3 w=3
X2112 N_EDGE_BIAS N_EDGE_BIAS sky130_fd_pr__cap_mim_m3_1 l=3 w=3
X2113 N_B9 N_TOP sky130_fd_pr__cap_mim_m3_1 l=3 w=3
X2114 N_B11 N_TOP sky130_fd_pr__cap_mim_m3_1 l=3 w=3
X2115 N_B8 N_TOP sky130_fd_pr__cap_mim_m3_1 l=3 w=3
X2116 P_B11 P_TOP sky130_fd_pr__cap_mim_m3_1 l=3 w=3
X2117 N_B8 N_TOP sky130_fd_pr__cap_mim_m3_1 l=3 w=3
X2118 N_B10 N_TOP sky130_fd_pr__cap_mim_m3_1 l=3 w=3
X2119 P_B11 P_TOP sky130_fd_pr__cap_mim_m3_1 l=3 w=3
X2120 N_B11 N_TOP sky130_fd_pr__cap_mim_m3_1 l=3 w=3
X2121 P_B11 P_TOP sky130_fd_pr__cap_mim_m3_1 l=3 w=3
X2122 P_B11 P_TOP sky130_fd_pr__cap_mim_m3_1 l=3 w=3
X2123 P_B10 P_TOP sky130_fd_pr__cap_mim_m3_1 l=3 w=3
X2124 P_B11 P_TOP sky130_fd_pr__cap_mim_m3_1 l=3 w=3
X2125 N_B10 N_TOP sky130_fd_pr__cap_mim_m3_1 l=3 w=3
X2126 N_B10 N_TOP sky130_fd_pr__cap_mim_m3_1 l=3 w=3
X2127 N_B11 N_TOP sky130_fd_pr__cap_mim_m3_1 l=3 w=3
X2128 N_B11 N_TOP sky130_fd_pr__cap_mim_m3_1 l=3 w=3
X2129 P_B10 P_TOP sky130_fd_pr__cap_mim_m3_1 l=3 w=3
X2130 N_B11 N_TOP sky130_fd_pr__cap_mim_m3_1 l=3 w=3
X2131 N_B11 N_TOP sky130_fd_pr__cap_mim_m3_1 l=3 w=3
X2132 P_B10 P_TOP sky130_fd_pr__cap_mim_m3_1 l=3 w=3
X2133 N_B11 N_TOP sky130_fd_pr__cap_mim_m3_1 l=3 w=3
X2134 P_B11 P_TOP sky130_fd_pr__cap_mim_m3_1 l=3 w=3
X2135 P_B11 P_TOP sky130_fd_pr__cap_mim_m3_1 l=3 w=3
X2136 P_B10 P_TOP sky130_fd_pr__cap_mim_m3_1 l=3 w=3
X2137 P_B8 P_TOP sky130_fd_pr__cap_mim_m3_1 l=3 w=3
X2138 N_B11 N_TOP sky130_fd_pr__cap_mim_m3_1 l=3 w=3
X2139 P_B11 P_TOP sky130_fd_pr__cap_mim_m3_1 l=3 w=3
X2140 N_B10 N_TOP sky130_fd_pr__cap_mim_m3_1 l=3 w=3
X2141 N_B11 N_TOP sky130_fd_pr__cap_mim_m3_1 l=3 w=3
X2142 P_B10 P_TOP sky130_fd_pr__cap_mim_m3_1 l=3 w=3
X2143 N_B10 N_TOP sky130_fd_pr__cap_mim_m3_1 l=3 w=3
X2144 P_B11 P_TOP sky130_fd_pr__cap_mim_m3_1 l=3 w=3
X2145 P_B11 P_TOP sky130_fd_pr__cap_mim_m3_1 l=3 w=3
X2146 P_B10 P_TOP sky130_fd_pr__cap_mim_m3_1 l=3 w=3
X2147 N_EDGE_BIAS N_EDGE_BIAS sky130_fd_pr__cap_mim_m3_1 l=3 w=3
X2148 P_B11 P_TOP sky130_fd_pr__cap_mim_m3_1 l=3 w=3
X2149 P_B10 P_TOP sky130_fd_pr__cap_mim_m3_1 l=3 w=3
X2150 N_B7 N_TOP sky130_fd_pr__cap_mim_m3_1 l=3 w=3
X2151 N_B11 N_TOP sky130_fd_pr__cap_mim_m3_1 l=3 w=3
X2152 N_B11 N_TOP sky130_fd_pr__cap_mim_m3_1 l=3 w=3
X2153 N_B10 N_TOP sky130_fd_pr__cap_mim_m3_1 l=3 w=3
X2154 P_B11 P_TOP sky130_fd_pr__cap_mim_m3_1 l=3 w=3
X2155 P_B11 P_TOP sky130_fd_pr__cap_mim_m3_1 l=3 w=3
X2156 N_B11 N_TOP sky130_fd_pr__cap_mim_m3_1 l=3 w=3
X2157 N_B11 N_TOP sky130_fd_pr__cap_mim_m3_1 l=3 w=3
X2158 P_EDGE_BIAS P_EDGE_BIAS sky130_fd_pr__cap_mim_m3_1 l=3 w=3
X2159 N_B10 N_TOP sky130_fd_pr__cap_mim_m3_1 l=3 w=3
X2160 N_B6 N_TOP sky130_fd_pr__cap_mim_m3_1 l=3 w=3
X2161 P_B11 P_TOP sky130_fd_pr__cap_mim_m3_1 l=3 w=3
X2162 N_B11 N_TOP sky130_fd_pr__cap_mim_m3_1 l=3 w=3
X2163 N_B9 N_TOP sky130_fd_pr__cap_mim_m3_1 l=3 w=3
X2164 P_B11 P_TOP sky130_fd_pr__cap_mim_m3_1 l=3 w=3
X2165 P_B11 P_TOP sky130_fd_pr__cap_mim_m3_1 l=3 w=3
X2166 N_EDGE_BIAS N_EDGE_BIAS sky130_fd_pr__cap_mim_m3_1 l=3 w=3
X2167 P_B11 P_TOP sky130_fd_pr__cap_mim_m3_1 l=3 w=3
X2168 P_B11 P_TOP sky130_fd_pr__cap_mim_m3_1 l=3 w=3
X2169 P_B11 P_TOP sky130_fd_pr__cap_mim_m3_1 l=3 w=3
X2170 P_B8 P_TOP sky130_fd_pr__cap_mim_m3_1 l=3 w=3
X2171 N_B11 N_TOP sky130_fd_pr__cap_mim_m3_1 l=3 w=3
X2172 P_B11 P_TOP sky130_fd_pr__cap_mim_m3_1 l=3 w=3
X2173 N_B11 N_TOP sky130_fd_pr__cap_mim_m3_1 l=3 w=3
X2174 P_B11 P_TOP sky130_fd_pr__cap_mim_m3_1 l=3 w=3
X2175 P_B9 P_TOP sky130_fd_pr__cap_mim_m3_1 l=3 w=3
X2176 N_B11 N_TOP sky130_fd_pr__cap_mim_m3_1 l=3 w=3
X2177 N_B9 N_TOP sky130_fd_pr__cap_mim_m3_1 l=3 w=3
X2178 P_B9 P_TOP sky130_fd_pr__cap_mim_m3_1 l=3 w=3
X2179 P_B11 P_TOP sky130_fd_pr__cap_mim_m3_1 l=3 w=3
X2180 P_B11 P_TOP sky130_fd_pr__cap_mim_m3_1 l=3 w=3
X2181 N_B11 N_TOP sky130_fd_pr__cap_mim_m3_1 l=3 w=3
X2182 P_B10 P_TOP sky130_fd_pr__cap_mim_m3_1 l=3 w=3
X2183 N_B11 N_TOP sky130_fd_pr__cap_mim_m3_1 l=3 w=3
X2184 P_B11 P_TOP sky130_fd_pr__cap_mim_m3_1 l=3 w=3
X2185 P_B9 P_TOP sky130_fd_pr__cap_mim_m3_1 l=3 w=3
X2186 N_B9 N_TOP sky130_fd_pr__cap_mim_m3_1 l=3 w=3
X2187 N_B11 N_TOP sky130_fd_pr__cap_mim_m3_1 l=3 w=3
X2188 P_B11 P_TOP sky130_fd_pr__cap_mim_m3_1 l=3 w=3
X2189 P_B11 P_TOP sky130_fd_pr__cap_mim_m3_1 l=3 w=3
X2190 P_B10 P_TOP sky130_fd_pr__cap_mim_m3_1 l=3 w=3
X2191 N_B7 N_TOP sky130_fd_pr__cap_mim_m3_1 l=3 w=3
X2192 N_B11 N_TOP sky130_fd_pr__cap_mim_m3_1 l=3 w=3
X2193 P_B9 P_TOP sky130_fd_pr__cap_mim_m3_1 l=3 w=3
X2194 P_EDGE_BIAS P_EDGE_BIAS sky130_fd_pr__cap_mim_m3_1 l=3 w=3
X2195 N_B11 N_TOP sky130_fd_pr__cap_mim_m3_1 l=3 w=3
X2196 P_B11 P_TOP sky130_fd_pr__cap_mim_m3_1 l=3 w=3
X2197 N_B9 N_TOP sky130_fd_pr__cap_mim_m3_1 l=3 w=3
X2198 P_B11 P_TOP sky130_fd_pr__cap_mim_m3_1 l=3 w=3
X2199 N_B11 N_TOP sky130_fd_pr__cap_mim_m3_1 l=3 w=3
X2200 P_B11 P_TOP sky130_fd_pr__cap_mim_m3_1 l=3 w=3
X2201 N_B8 N_TOP sky130_fd_pr__cap_mim_m3_1 l=3 w=3
X2202 P_B10 P_TOP sky130_fd_pr__cap_mim_m3_1 l=3 w=3
X2203 N_B11 N_TOP sky130_fd_pr__cap_mim_m3_1 l=3 w=3
X2204 P_B11 P_TOP sky130_fd_pr__cap_mim_m3_1 l=3 w=3
X2205 N_B11 N_TOP sky130_fd_pr__cap_mim_m3_1 l=3 w=3
X2206 P_B11 P_TOP sky130_fd_pr__cap_mim_m3_1 l=3 w=3
X2207 N_B11 N_TOP sky130_fd_pr__cap_mim_m3_1 l=3 w=3
X2208 N_EDGE_BIAS N_EDGE_BIAS sky130_fd_pr__cap_mim_m3_1 l=3 w=3
X2209 N_B11 N_TOP sky130_fd_pr__cap_mim_m3_1 l=3 w=3
X2210 P_B11 P_TOP sky130_fd_pr__cap_mim_m3_1 l=3 w=3
X2211 P_B11 P_TOP sky130_fd_pr__cap_mim_m3_1 l=3 w=3
X2212 P_B10 P_TOP sky130_fd_pr__cap_mim_m3_1 l=3 w=3
X2213 N_B10 N_TOP sky130_fd_pr__cap_mim_m3_1 l=3 w=3
X2214 N_B11 N_TOP sky130_fd_pr__cap_mim_m3_1 l=3 w=3
X2215 P_B11 P_TOP sky130_fd_pr__cap_mim_m3_1 l=3 w=3
X2216 P_B10 P_TOP sky130_fd_pr__cap_mim_m3_1 l=3 w=3
X2217 N_B11 N_TOP sky130_fd_pr__cap_mim_m3_1 l=3 w=3
X2218 N_B11 N_TOP sky130_fd_pr__cap_mim_m3_1 l=3 w=3
X2219 P_B11 P_TOP sky130_fd_pr__cap_mim_m3_1 l=3 w=3
X2220 P_B8 P_TOP sky130_fd_pr__cap_mim_m3_1 l=3 w=3
X2221 P_B10 P_TOP sky130_fd_pr__cap_mim_m3_1 l=3 w=3
X2222 N_B11 N_TOP sky130_fd_pr__cap_mim_m3_1 l=3 w=3
X2223 N_B11 N_TOP sky130_fd_pr__cap_mim_m3_1 l=3 w=3
X2224 N_B8 N_TOP sky130_fd_pr__cap_mim_m3_1 l=3 w=3
X2225 N_B11 N_TOP sky130_fd_pr__cap_mim_m3_1 l=3 w=3
X2226 P_B11 P_TOP sky130_fd_pr__cap_mim_m3_1 l=3 w=3
X2227 N_B11 N_TOP sky130_fd_pr__cap_mim_m3_1 l=3 w=3
X2228 P_B10 P_TOP sky130_fd_pr__cap_mim_m3_1 l=3 w=3
X2229 N_B10 N_TOP sky130_fd_pr__cap_mim_m3_1 l=3 w=3
X2230 P_EDGE_BIAS P_EDGE_BIAS sky130_fd_pr__cap_mim_m3_1 l=3 w=3
X2231 P_B10 P_TOP sky130_fd_pr__cap_mim_m3_1 l=3 w=3
X2232 N_B11 N_TOP sky130_fd_pr__cap_mim_m3_1 l=3 w=3
X2233 P_B7 P_TOP sky130_fd_pr__cap_mim_m3_1 l=3 w=3
X2234 N_B11 N_TOP sky130_fd_pr__cap_mim_m3_1 l=3 w=3
X2235 N_B9 N_TOP sky130_fd_pr__cap_mim_m3_1 l=3 w=3
X2236 N_B9 N_TOP sky130_fd_pr__cap_mim_m3_1 l=3 w=3
X2237 N_B11 N_TOP sky130_fd_pr__cap_mim_m3_1 l=3 w=3
X2238 P_B10 P_TOP sky130_fd_pr__cap_mim_m3_1 l=3 w=3
X2239 P_B10 P_TOP sky130_fd_pr__cap_mim_m3_1 l=3 w=3
X2240 N_B10 N_TOP sky130_fd_pr__cap_mim_m3_1 l=3 w=3
X2241 N_B10 N_TOP sky130_fd_pr__cap_mim_m3_1 l=3 w=3
X2242 N_B6 N_TOP sky130_fd_pr__cap_mim_m3_1 l=3 w=3
X2243 N_EDGE_BIAS N_EDGE_BIAS sky130_fd_pr__cap_mim_m3_1 l=3 w=3
X2244 N_B10 N_TOP sky130_fd_pr__cap_mim_m3_1 l=3 w=3
X2245 N_EDGE_BIAS N_EDGE_BIAS sky130_fd_pr__cap_mim_m3_1 l=3 w=3
X2246 N_B11 N_TOP sky130_fd_pr__cap_mim_m3_1 l=3 w=3
X2247 N_B11 N_TOP sky130_fd_pr__cap_mim_m3_1 l=3 w=3
X2248 N_B10 N_TOP sky130_fd_pr__cap_mim_m3_1 l=3 w=3
X2249 N_B9 N_TOP sky130_fd_pr__cap_mim_m3_1 l=3 w=3
X2250 P_B9 P_TOP sky130_fd_pr__cap_mim_m3_1 l=3 w=3
X2251 N_B11 N_TOP sky130_fd_pr__cap_mim_m3_1 l=3 w=3
X2252 P_B11 P_TOP sky130_fd_pr__cap_mim_m3_1 l=3 w=3
X2253 N_B9 N_TOP sky130_fd_pr__cap_mim_m3_1 l=3 w=3
X2254 N_B11 N_TOP sky130_fd_pr__cap_mim_m3_1 l=3 w=3
X2255 P_B11 P_TOP sky130_fd_pr__cap_mim_m3_1 l=3 w=3
X2256 N_B11 N_TOP sky130_fd_pr__cap_mim_m3_1 l=3 w=3
X2257 N_EDGE_BIAS N_EDGE_BIAS sky130_fd_pr__cap_mim_m3_1 l=3 w=3
X2258 P_B8 P_TOP sky130_fd_pr__cap_mim_m3_1 l=3 w=3
X2259 P_B11 P_TOP sky130_fd_pr__cap_mim_m3_1 l=3 w=3
X2260 N_B11 N_TOP sky130_fd_pr__cap_mim_m3_1 l=3 w=3
X2261 N_B10 N_TOP sky130_fd_pr__cap_mim_m3_1 l=3 w=3
X2262 P_B6 P_TOP sky130_fd_pr__cap_mim_m3_1 l=3 w=3
X2263 P_B11 P_TOP sky130_fd_pr__cap_mim_m3_1 l=3 w=3
X2264 P_B11 P_TOP sky130_fd_pr__cap_mim_m3_1 l=3 w=3
X2265 N_B9 N_TOP sky130_fd_pr__cap_mim_m3_1 l=3 w=3
X2266 P_B10 P_TOP sky130_fd_pr__cap_mim_m3_1 l=3 w=3
X2267 N_B11 N_TOP sky130_fd_pr__cap_mim_m3_1 l=3 w=3
X2268 P_B11 P_TOP sky130_fd_pr__cap_mim_m3_1 l=3 w=3
X2269 N_B11 N_TOP sky130_fd_pr__cap_mim_m3_1 l=3 w=3
X2270 P_B10 P_TOP sky130_fd_pr__cap_mim_m3_1 l=3 w=3
X2271 N_B11 N_TOP sky130_fd_pr__cap_mim_m3_1 l=3 w=3
X2272 N_B11 N_TOP sky130_fd_pr__cap_mim_m3_1 l=3 w=3
X2273 N_B10 N_TOP sky130_fd_pr__cap_mim_m3_1 l=3 w=3
X2274 N_B11 N_TOP sky130_fd_pr__cap_mim_m3_1 l=3 w=3
X2275 P_B11 P_TOP sky130_fd_pr__cap_mim_m3_1 l=3 w=3
X2276 P_B11 P_TOP sky130_fd_pr__cap_mim_m3_1 l=3 w=3
X2277 P_B9 P_TOP sky130_fd_pr__cap_mim_m3_1 l=3 w=3
X2278 N_B9 N_TOP sky130_fd_pr__cap_mim_m3_1 l=3 w=3
X2279 N_B11 N_TOP sky130_fd_pr__cap_mim_m3_1 l=3 w=3
X2280 P_B11 P_TOP sky130_fd_pr__cap_mim_m3_1 l=3 w=3
X2281 P_B7 P_TOP sky130_fd_pr__cap_mim_m3_1 l=3 w=3
X2282 N_B10 N_TOP sky130_fd_pr__cap_mim_m3_1 l=3 w=3
X2283 N_B10 N_TOP sky130_fd_pr__cap_mim_m3_1 l=3 w=3
X2284 P_EDGE_BIAS P_EDGE_BIAS sky130_fd_pr__cap_mim_m3_1 l=3 w=3
X2285 N_B11 N_TOP sky130_fd_pr__cap_mim_m3_1 l=3 w=3
X2286 N_B9 N_TOP sky130_fd_pr__cap_mim_m3_1 l=3 w=3
X2287 N_B11 N_TOP sky130_fd_pr__cap_mim_m3_1 l=3 w=3
X2288 N_B10 N_TOP sky130_fd_pr__cap_mim_m3_1 l=3 w=3
X2289 N_B11 N_TOP sky130_fd_pr__cap_mim_m3_1 l=3 w=3
X2290 N_B8 N_TOP sky130_fd_pr__cap_mim_m3_1 l=3 w=3
X2291 P_B11 P_TOP sky130_fd_pr__cap_mim_m3_1 l=3 w=3
X2292 N_B10 N_TOP sky130_fd_pr__cap_mim_m3_1 l=3 w=3
X2293 N_B11 N_TOP sky130_fd_pr__cap_mim_m3_1 l=3 w=3
X2294 P_B11 P_TOP sky130_fd_pr__cap_mim_m3_1 l=3 w=3
X2295 N_B10 N_TOP sky130_fd_pr__cap_mim_m3_1 l=3 w=3
X2296 P_B11 P_TOP sky130_fd_pr__cap_mim_m3_1 l=3 w=3
X2297 N_B11 N_TOP sky130_fd_pr__cap_mim_m3_1 l=3 w=3
X2298 P_B11 P_TOP sky130_fd_pr__cap_mim_m3_1 l=3 w=3
X2299 N_B10 N_TOP sky130_fd_pr__cap_mim_m3_1 l=3 w=3
X2300 N_B11 N_TOP sky130_fd_pr__cap_mim_m3_1 l=3 w=3
X2301 N_B11 N_TOP sky130_fd_pr__cap_mim_m3_1 l=3 w=3
X2302 P_B11 P_TOP sky130_fd_pr__cap_mim_m3_1 l=3 w=3
X2303 N_B10 N_TOP sky130_fd_pr__cap_mim_m3_1 l=3 w=3
X2304 N_B10 N_TOP sky130_fd_pr__cap_mim_m3_1 l=3 w=3
X2305 P_B10 P_TOP sky130_fd_pr__cap_mim_m3_1 l=3 w=3
X2306 P_B11 P_TOP sky130_fd_pr__cap_mim_m3_1 l=3 w=3
X2307 N_B11 N_TOP sky130_fd_pr__cap_mim_m3_1 l=3 w=3
X2308 P_B8 P_TOP sky130_fd_pr__cap_mim_m3_1 l=3 w=3
X2309 N_B11 N_TOP sky130_fd_pr__cap_mim_m3_1 l=3 w=3
X2310 N_B11 N_TOP sky130_fd_pr__cap_mim_m3_1 l=3 w=3
X2311 P_B11 P_TOP sky130_fd_pr__cap_mim_m3_1 l=3 w=3
X2312 P_B11 P_TOP sky130_fd_pr__cap_mim_m3_1 l=3 w=3
X2313 N_B11 N_TOP sky130_fd_pr__cap_mim_m3_1 l=3 w=3
X2314 N_B11 N_TOP sky130_fd_pr__cap_mim_m3_1 l=3 w=3
X2315 P_B8 P_TOP sky130_fd_pr__cap_mim_m3_1 l=3 w=3
X2316 N_B11 N_TOP sky130_fd_pr__cap_mim_m3_1 l=3 w=3
X2317 N_B11 N_TOP sky130_fd_pr__cap_mim_m3_1 l=3 w=3
X2318 P_B11 P_TOP sky130_fd_pr__cap_mim_m3_1 l=3 w=3
X2319 N_B11 N_TOP sky130_fd_pr__cap_mim_m3_1 l=3 w=3
X2320 P_B10 P_TOP sky130_fd_pr__cap_mim_m3_1 l=3 w=3
X2321 P_B11 P_TOP sky130_fd_pr__cap_mim_m3_1 l=3 w=3
X2322 N_B10 N_TOP sky130_fd_pr__cap_mim_m3_1 l=3 w=3
X2323 P_B10 P_TOP sky130_fd_pr__cap_mim_m3_1 l=3 w=3
X2324 N_B7 N_TOP sky130_fd_pr__cap_mim_m3_1 l=3 w=3
X2325 N_B11 N_TOP sky130_fd_pr__cap_mim_m3_1 l=3 w=3
X2326 N_B11 N_TOP sky130_fd_pr__cap_mim_m3_1 l=3 w=3
X2327 P_B11 P_TOP sky130_fd_pr__cap_mim_m3_1 l=3 w=3
X2328 N_B10 N_TOP sky130_fd_pr__cap_mim_m3_1 l=3 w=3
X2329 P_B10 P_TOP sky130_fd_pr__cap_mim_m3_1 l=3 w=3
X2330 N_B9 N_TOP sky130_fd_pr__cap_mim_m3_1 l=3 w=3
X2331 P_B6 P_TOP sky130_fd_pr__cap_mim_m3_1 l=3 w=3
X2332 N_B10 N_TOP sky130_fd_pr__cap_mim_m3_1 l=3 w=3
X2333 N_B11 N_TOP sky130_fd_pr__cap_mim_m3_1 l=3 w=3
X2334 N_B6 N_TOP sky130_fd_pr__cap_mim_m3_1 l=3 w=3
X2335 P_B11 P_TOP sky130_fd_pr__cap_mim_m3_1 l=3 w=3
X2336 N_B11 N_TOP sky130_fd_pr__cap_mim_m3_1 l=3 w=3
X2337 N_B10 N_TOP sky130_fd_pr__cap_mim_m3_1 l=3 w=3
X2338 P_B11 P_TOP sky130_fd_pr__cap_mim_m3_1 l=3 w=3
X2339 N_B6 N_TOP sky130_fd_pr__cap_mim_m3_1 l=3 w=3
X2340 N_B11 N_TOP sky130_fd_pr__cap_mim_m3_1 l=3 w=3
X2341 N_B11 N_TOP sky130_fd_pr__cap_mim_m3_1 l=3 w=3
X2342 P_B11 P_TOP sky130_fd_pr__cap_mim_m3_1 l=3 w=3
X2343 P_B11 P_TOP sky130_fd_pr__cap_mim_m3_1 l=3 w=3
X2344 N_B10 N_TOP sky130_fd_pr__cap_mim_m3_1 l=3 w=3
X2345 P_B11 P_TOP sky130_fd_pr__cap_mim_m3_1 l=3 w=3
X2346 N_B11 N_TOP sky130_fd_pr__cap_mim_m3_1 l=3 w=3
X2347 N_B10 N_TOP sky130_fd_pr__cap_mim_m3_1 l=3 w=3
X2348 N_B11 N_TOP sky130_fd_pr__cap_mim_m3_1 l=3 w=3
X2349 N_EDGE_BIAS N_EDGE_BIAS sky130_fd_pr__cap_mim_m3_1 l=3 w=3
X2350 P_B11 P_TOP sky130_fd_pr__cap_mim_m3_1 l=3 w=3
X2351 N_B11 N_TOP sky130_fd_pr__cap_mim_m3_1 l=3 w=3
X2352 P_B11 P_TOP sky130_fd_pr__cap_mim_m3_1 l=3 w=3
X2353 N_EDGE_BIAS N_EDGE_BIAS sky130_fd_pr__cap_mim_m3_1 l=3 w=3
X2354 P_B8 P_TOP sky130_fd_pr__cap_mim_m3_1 l=3 w=3
X2355 P_B11 P_TOP sky130_fd_pr__cap_mim_m3_1 l=3 w=3
X2356 N_B11 N_TOP sky130_fd_pr__cap_mim_m3_1 l=3 w=3
X2357 N_B11 N_TOP sky130_fd_pr__cap_mim_m3_1 l=3 w=3
X2358 P_B10 P_TOP sky130_fd_pr__cap_mim_m3_1 l=3 w=3
X2359 P_B9 P_TOP sky130_fd_pr__cap_mim_m3_1 l=3 w=3
X2360 P_B9 P_TOP sky130_fd_pr__cap_mim_m3_1 l=3 w=3
X2361 P_B11 P_TOP sky130_fd_pr__cap_mim_m3_1 l=3 w=3
X2362 P_B9 P_TOP sky130_fd_pr__cap_mim_m3_1 l=3 w=3
X2363 N_B10 N_TOP sky130_fd_pr__cap_mim_m3_1 l=3 w=3
X2364 N_B11 N_TOP sky130_fd_pr__cap_mim_m3_1 l=3 w=3
X2365 P_B3 P_TOP sky130_fd_pr__cap_mim_m3_1 l=3 w=3
X2366 N_B11 N_TOP sky130_fd_pr__cap_mim_m3_1 l=3 w=3
X2367 N_B11 N_TOP sky130_fd_pr__cap_mim_m3_1 l=3 w=3
X2368 P_B10 P_TOP sky130_fd_pr__cap_mim_m3_1 l=3 w=3
X2369 P_B10 P_TOP sky130_fd_pr__cap_mim_m3_1 l=3 w=3
X2370 P_B11 P_TOP sky130_fd_pr__cap_mim_m3_1 l=3 w=3
X2371 N_B11 N_TOP sky130_fd_pr__cap_mim_m3_1 l=3 w=3
X2372 P_B9 P_TOP sky130_fd_pr__cap_mim_m3_1 l=3 w=3
X2373 P_B11 P_TOP sky130_fd_pr__cap_mim_m3_1 l=3 w=3
X2374 P_B11 P_TOP sky130_fd_pr__cap_mim_m3_1 l=3 w=3
X2375 P_B11 P_TOP sky130_fd_pr__cap_mim_m3_1 l=3 w=3
X2376 N_B11 N_TOP sky130_fd_pr__cap_mim_m3_1 l=3 w=3
X2377 P_B10 P_TOP sky130_fd_pr__cap_mim_m3_1 l=3 w=3
X2378 P_B9 P_TOP sky130_fd_pr__cap_mim_m3_1 l=3 w=3
X2379 N_B9 N_TOP sky130_fd_pr__cap_mim_m3_1 l=3 w=3
X2380 N_B11 N_TOP sky130_fd_pr__cap_mim_m3_1 l=3 w=3
X2381 P_B11 P_TOP sky130_fd_pr__cap_mim_m3_1 l=3 w=3
X2382 N_B7 N_TOP sky130_fd_pr__cap_mim_m3_1 l=3 w=3
X2383 N_B10 N_TOP sky130_fd_pr__cap_mim_m3_1 l=3 w=3
X2384 P_EDGE_BIAS P_EDGE_BIAS sky130_fd_pr__cap_mim_m3_1 l=3 w=3
X2385 P_B11 P_TOP sky130_fd_pr__cap_mim_m3_1 l=3 w=3
X2386 P_B10 P_TOP sky130_fd_pr__cap_mim_m3_1 l=3 w=3
X2387 N_B9 N_TOP sky130_fd_pr__cap_mim_m3_1 l=3 w=3
X2388 N_B9 N_TOP sky130_fd_pr__cap_mim_m3_1 l=3 w=3
X2389 N_B11 N_TOP sky130_fd_pr__cap_mim_m3_1 l=3 w=3
X2390 N_B10 N_TOP sky130_fd_pr__cap_mim_m3_1 l=3 w=3
X2391 N_B8 N_TOP sky130_fd_pr__cap_mim_m3_1 l=3 w=3
X2392 N_B11 N_TOP sky130_fd_pr__cap_mim_m3_1 l=3 w=3
X2393 P_B11 P_TOP sky130_fd_pr__cap_mim_m3_1 l=3 w=3
X2394 N_B8 N_TOP sky130_fd_pr__cap_mim_m3_1 l=3 w=3
X2395 N_B10 N_TOP sky130_fd_pr__cap_mim_m3_1 l=3 w=3
X2396 P_B11 P_TOP sky130_fd_pr__cap_mim_m3_1 l=3 w=3
X2397 N_B9 N_TOP sky130_fd_pr__cap_mim_m3_1 l=3 w=3
X2398 N_B10 N_TOP sky130_fd_pr__cap_mim_m3_1 l=3 w=3
X2399 N_B7 N_TOP sky130_fd_pr__cap_mim_m3_1 l=3 w=3
X2400 P_B11 P_TOP sky130_fd_pr__cap_mim_m3_1 l=3 w=3
X2401 P_B11 P_TOP sky130_fd_pr__cap_mim_m3_1 l=3 w=3
X2402 N_B10 N_TOP sky130_fd_pr__cap_mim_m3_1 l=3 w=3
X2403 N_B10 N_TOP sky130_fd_pr__cap_mim_m3_1 l=3 w=3
X2404 N_B11 N_TOP sky130_fd_pr__cap_mim_m3_1 l=3 w=3
X2405 P_B11 P_TOP sky130_fd_pr__cap_mim_m3_1 l=3 w=3
X2406 N_B11 N_TOP sky130_fd_pr__cap_mim_m3_1 l=3 w=3
X2407 P_B10 P_TOP sky130_fd_pr__cap_mim_m3_1 l=3 w=3
X2408 P_B11 P_TOP sky130_fd_pr__cap_mim_m3_1 l=3 w=3
X2409 N_EDGE_BIAS N_EDGE_BIAS sky130_fd_pr__cap_mim_m3_1 l=3 w=3
X2410 P_B10 P_TOP sky130_fd_pr__cap_mim_m3_1 l=3 w=3
X2411 P_B11 P_TOP sky130_fd_pr__cap_mim_m3_1 l=3 w=3
X2412 P_B11 P_TOP sky130_fd_pr__cap_mim_m3_1 l=3 w=3
X2413 N_B9 N_TOP sky130_fd_pr__cap_mim_m3_1 l=3 w=3
X2414 N_B11 N_TOP sky130_fd_pr__cap_mim_m3_1 l=3 w=3
X2415 P_B10 P_TOP sky130_fd_pr__cap_mim_m3_1 l=3 w=3
X2416 P_EDGE_BIAS P_EDGE_BIAS sky130_fd_pr__cap_mim_m3_1 l=3 w=3
X2417 P_B8 P_TOP sky130_fd_pr__cap_mim_m3_1 l=3 w=3
X2418 N_B11 N_TOP sky130_fd_pr__cap_mim_m3_1 l=3 w=3
X2419 N_B11 N_TOP sky130_fd_pr__cap_mim_m3_1 l=3 w=3
X2420 P_B11 P_TOP sky130_fd_pr__cap_mim_m3_1 l=3 w=3
X2421 P_B11 P_TOP sky130_fd_pr__cap_mim_m3_1 l=3 w=3
X2422 N_B11 N_TOP sky130_fd_pr__cap_mim_m3_1 l=3 w=3
X2423 P_B10 P_TOP sky130_fd_pr__cap_mim_m3_1 l=3 w=3
X2424 P_B10 P_TOP sky130_fd_pr__cap_mim_m3_1 l=3 w=3
X2425 P_B11 P_TOP sky130_fd_pr__cap_mim_m3_1 l=3 w=3
X2426 P_B10 P_TOP sky130_fd_pr__cap_mim_m3_1 l=3 w=3
X2427 N_B8 N_TOP sky130_fd_pr__cap_mim_m3_1 l=3 w=3
X2428 N_B11 N_TOP sky130_fd_pr__cap_mim_m3_1 l=3 w=3
X2429 P_B10 P_TOP sky130_fd_pr__cap_mim_m3_1 l=3 w=3
X2430 P_B6 P_TOP sky130_fd_pr__cap_mim_m3_1 l=3 w=3
X2431 N_B11 N_TOP sky130_fd_pr__cap_mim_m3_1 l=3 w=3
X2432 P_B11 P_TOP sky130_fd_pr__cap_mim_m3_1 l=3 w=3
X2433 N_EDGE_BIAS N_EDGE_BIAS sky130_fd_pr__cap_mim_m3_1 l=3 w=3
X2434 N_B7 N_TOP sky130_fd_pr__cap_mim_m3_1 l=3 w=3
X2435 N_B11 N_TOP sky130_fd_pr__cap_mim_m3_1 l=3 w=3
X2436 N_B11 N_TOP sky130_fd_pr__cap_mim_m3_1 l=3 w=3
X2437 N_B10 N_TOP sky130_fd_pr__cap_mim_m3_1 l=3 w=3
X2438 P_B11 P_TOP sky130_fd_pr__cap_mim_m3_1 l=3 w=3
X2439 P_B10 P_TOP sky130_fd_pr__cap_mim_m3_1 l=3 w=3
X2440 P_B6 P_TOP sky130_fd_pr__cap_mim_m3_1 l=3 w=3
X2441 N_B10 N_TOP sky130_fd_pr__cap_mim_m3_1 l=3 w=3
X2442 P_EDGE_BIAS P_EDGE_BIAS sky130_fd_pr__cap_mim_m3_1 l=3 w=3
X2443 N_B11 N_TOP sky130_fd_pr__cap_mim_m3_1 l=3 w=3
X2444 N_B11 N_TOP sky130_fd_pr__cap_mim_m3_1 l=3 w=3
X2445 N_B10 N_TOP sky130_fd_pr__cap_mim_m3_1 l=3 w=3
X2446 N_B5 N_TOP sky130_fd_pr__cap_mim_m3_1 l=3 w=3
X2447 P_B11 P_TOP sky130_fd_pr__cap_mim_m3_1 l=3 w=3
X2448 N_B11 N_TOP sky130_fd_pr__cap_mim_m3_1 l=3 w=3
X2449 N_B7 N_TOP sky130_fd_pr__cap_mim_m3_1 l=3 w=3
X2450 N_EDGE_BIAS N_EDGE_BIAS sky130_fd_pr__cap_mim_m3_1 l=3 w=3
X2451 P_B10 P_TOP sky130_fd_pr__cap_mim_m3_1 l=3 w=3
X2452 N_EDGE_BIAS N_EDGE_BIAS sky130_fd_pr__cap_mim_m3_1 l=3 w=3
X2453 P_EDGE_BIAS P_EDGE_BIAS sky130_fd_pr__cap_mim_m3_1 l=3 w=3
X2454 N_EDGE_BIAS N_EDGE_BIAS sky130_fd_pr__cap_mim_m3_1 l=3 w=3
X2455 N_B11 N_TOP sky130_fd_pr__cap_mim_m3_1 l=3 w=3
X2456 P_B11 P_TOP sky130_fd_pr__cap_mim_m3_1 l=3 w=3
X2457 N_B11 N_TOP sky130_fd_pr__cap_mim_m3_1 l=3 w=3
X2458 P_B11 P_TOP sky130_fd_pr__cap_mim_m3_1 l=3 w=3
X2459 P_B11 P_TOP sky130_fd_pr__cap_mim_m3_1 l=3 w=3
X2460 P_B10 P_TOP sky130_fd_pr__cap_mim_m3_1 l=3 w=3
X2461 P_B9 P_TOP sky130_fd_pr__cap_mim_m3_1 l=3 w=3
X2462 N_B11 N_TOP sky130_fd_pr__cap_mim_m3_1 l=3 w=3
X2463 P_B11 P_TOP sky130_fd_pr__cap_mim_m3_1 l=3 w=3
X2464 N_B11 N_TOP sky130_fd_pr__cap_mim_m3_1 l=3 w=3
X2465 N_B11 N_TOP sky130_fd_pr__cap_mim_m3_1 l=3 w=3
X2466 N_B11 N_TOP sky130_fd_pr__cap_mim_m3_1 l=3 w=3
X2467 P_B10 P_TOP sky130_fd_pr__cap_mim_m3_1 l=3 w=3
X2468 P_B11 P_TOP sky130_fd_pr__cap_mim_m3_1 l=3 w=3
X2469 N_B11 N_TOP sky130_fd_pr__cap_mim_m3_1 l=3 w=3
X2470 P_B11 P_TOP sky130_fd_pr__cap_mim_m3_1 l=3 w=3
X2471 P_B9 P_TOP sky130_fd_pr__cap_mim_m3_1 l=3 w=3
X2472 N_B11 N_TOP sky130_fd_pr__cap_mim_m3_1 l=3 w=3
X2473 P_B11 P_TOP sky130_fd_pr__cap_mim_m3_1 l=3 w=3
X2474 P_B10 P_TOP sky130_fd_pr__cap_mim_m3_1 l=3 w=3
X2475 P_B9 P_TOP sky130_fd_pr__cap_mim_m3_1 l=3 w=3
X2476 N_B11 N_TOP sky130_fd_pr__cap_mim_m3_1 l=3 w=3
X2477 N_B11 N_TOP sky130_fd_pr__cap_mim_m3_1 l=3 w=3
X2478 P_B11 P_TOP sky130_fd_pr__cap_mim_m3_1 l=3 w=3
X2479 N_B10 N_TOP sky130_fd_pr__cap_mim_m3_1 l=3 w=3
X2480 P_B10 P_TOP sky130_fd_pr__cap_mim_m3_1 l=3 w=3
X2481 P_B10 P_TOP sky130_fd_pr__cap_mim_m3_1 l=3 w=3
X2482 N_B7 N_TOP sky130_fd_pr__cap_mim_m3_1 l=3 w=3
X2483 N_B11 N_TOP sky130_fd_pr__cap_mim_m3_1 l=3 w=3
X2484 N_B11 N_TOP sky130_fd_pr__cap_mim_m3_1 l=3 w=3
X2485 N_B11 N_TOP sky130_fd_pr__cap_mim_m3_1 l=3 w=3
X2486 P_B11 P_TOP sky130_fd_pr__cap_mim_m3_1 l=3 w=3
X2487 P_B10 P_TOP sky130_fd_pr__cap_mim_m3_1 l=3 w=3
X2488 N_B9 N_TOP sky130_fd_pr__cap_mim_m3_1 l=3 w=3
X2489 N_B8 N_TOP sky130_fd_pr__cap_mim_m3_1 l=3 w=3
X2490 P_B11 P_TOP sky130_fd_pr__cap_mim_m3_1 l=3 w=3
X2491 P_B11 P_TOP sky130_fd_pr__cap_mim_m3_1 l=3 w=3
X2492 P_B11 P_TOP sky130_fd_pr__cap_mim_m3_1 l=3 w=3
X2493 N_B8 N_TOP sky130_fd_pr__cap_mim_m3_1 l=3 w=3
X2494 P_B11 P_TOP sky130_fd_pr__cap_mim_m3_1 l=3 w=3
X2495 N_EDGE_BIAS N_EDGE_BIAS sky130_fd_pr__cap_mim_m3_1 l=3 w=3
X2496 N_B6 N_TOP sky130_fd_pr__cap_mim_m3_1 l=3 w=3
X2497 N_EDGE_BIAS N_EDGE_BIAS sky130_fd_pr__cap_mim_m3_1 l=3 w=3
X2498 N_B10 N_TOP sky130_fd_pr__cap_mim_m3_1 l=3 w=3
X2499 P_B11 P_TOP sky130_fd_pr__cap_mim_m3_1 l=3 w=3
X2500 P_B9 P_TOP sky130_fd_pr__cap_mim_m3_1 l=3 w=3
X2501 N_B8 N_TOP sky130_fd_pr__cap_mim_m3_1 l=3 w=3
X2502 N_B11 N_TOP sky130_fd_pr__cap_mim_m3_1 l=3 w=3
X2503 N_B11 N_TOP sky130_fd_pr__cap_mim_m3_1 l=3 w=3
X2504 P_B11 P_TOP sky130_fd_pr__cap_mim_m3_1 l=3 w=3
X2505 P_B10 P_TOP sky130_fd_pr__cap_mim_m3_1 l=3 w=3
X2506 N_B10 N_TOP sky130_fd_pr__cap_mim_m3_1 l=3 w=3
X2507 N_B11 N_TOP sky130_fd_pr__cap_mim_m3_1 l=3 w=3
X2508 P_B11 P_TOP sky130_fd_pr__cap_mim_m3_1 l=3 w=3
X2509 P_B11 P_TOP sky130_fd_pr__cap_mim_m3_1 l=3 w=3
X2510 P_B9 P_TOP sky130_fd_pr__cap_mim_m3_1 l=3 w=3
X2511 N_B11 N_TOP sky130_fd_pr__cap_mim_m3_1 l=3 w=3
X2512 N_B11 N_TOP sky130_fd_pr__cap_mim_m3_1 l=3 w=3
X2513 P_B8 P_TOP sky130_fd_pr__cap_mim_m3_1 l=3 w=3
X2514 P_B10 P_TOP sky130_fd_pr__cap_mim_m3_1 l=3 w=3
X2515 N_B11 N_TOP sky130_fd_pr__cap_mim_m3_1 l=3 w=3
X2516 N_B11 N_TOP sky130_fd_pr__cap_mim_m3_1 l=3 w=3
X2517 N_B11 N_TOP sky130_fd_pr__cap_mim_m3_1 l=3 w=3
X2518 N_B11 N_TOP sky130_fd_pr__cap_mim_m3_1 l=3 w=3
X2519 P_B10 P_TOP sky130_fd_pr__cap_mim_m3_1 l=3 w=3
X2520 N_B10 N_TOP sky130_fd_pr__cap_mim_m3_1 l=3 w=3
X2521 P_B11 P_TOP sky130_fd_pr__cap_mim_m3_1 l=3 w=3
X2522 N_B11 N_TOP sky130_fd_pr__cap_mim_m3_1 l=3 w=3
X2523 P_B10 P_TOP sky130_fd_pr__cap_mim_m3_1 l=3 w=3
X2524 P_B7 P_TOP sky130_fd_pr__cap_mim_m3_1 l=3 w=3
X2525 N_B11 N_TOP sky130_fd_pr__cap_mim_m3_1 l=3 w=3
X2526 P_B11 P_TOP sky130_fd_pr__cap_mim_m3_1 l=3 w=3
X2527 N_B9 N_TOP sky130_fd_pr__cap_mim_m3_1 l=3 w=3
X2528 N_B9 N_TOP sky130_fd_pr__cap_mim_m3_1 l=3 w=3
X2529 N_B11 N_TOP sky130_fd_pr__cap_mim_m3_1 l=3 w=3
X2530 P_B10 P_TOP sky130_fd_pr__cap_mim_m3_1 l=3 w=3
X2531 N_B10 N_TOP sky130_fd_pr__cap_mim_m3_1 l=3 w=3
X2532 P_B11 P_TOP sky130_fd_pr__cap_mim_m3_1 l=3 w=3
X2533 P_B10 P_TOP sky130_fd_pr__cap_mim_m3_1 l=3 w=3
X2534 N_B6 N_TOP sky130_fd_pr__cap_mim_m3_1 l=3 w=3
X2535 P_B11 P_TOP sky130_fd_pr__cap_mim_m3_1 l=3 w=3
X2536 P_B5 P_TOP sky130_fd_pr__cap_mim_m3_1 l=3 w=3
X2537 N_B10 N_TOP sky130_fd_pr__cap_mim_m3_1 l=3 w=3
X2538 N_B10 N_TOP sky130_fd_pr__cap_mim_m3_1 l=3 w=3
X2539 N_B9 N_TOP sky130_fd_pr__cap_mim_m3_1 l=3 w=3
X2540 N_B11 N_TOP sky130_fd_pr__cap_mim_m3_1 l=3 w=3
X2541 P_B11 P_TOP sky130_fd_pr__cap_mim_m3_1 l=3 w=3
X2542 N_B11 N_TOP sky130_fd_pr__cap_mim_m3_1 l=3 w=3
X2543 N_EDGE_BIAS N_EDGE_BIAS sky130_fd_pr__cap_mim_m3_1 l=3 w=3
X2544 P_B11 P_TOP sky130_fd_pr__cap_mim_m3_1 l=3 w=3
X2545 P_B11 P_TOP sky130_fd_pr__cap_mim_m3_1 l=3 w=3
X2546 N_B10 N_TOP sky130_fd_pr__cap_mim_m3_1 l=3 w=3
X2547 P_EDGE_BIAS P_EDGE_BIAS sky130_fd_pr__cap_mim_m3_1 l=3 w=3
X2548 N_EDGE_BIAS N_EDGE_BIAS sky130_fd_pr__cap_mim_m3_1 l=3 w=3
X2549 P_B8 P_TOP sky130_fd_pr__cap_mim_m3_1 l=3 w=3
X2550 P_B11 P_TOP sky130_fd_pr__cap_mim_m3_1 l=3 w=3
X2551 P_B6 P_TOP sky130_fd_pr__cap_mim_m3_1 l=3 w=3
X2552 N_B11 N_TOP sky130_fd_pr__cap_mim_m3_1 l=3 w=3
X2553 P_B10 P_TOP sky130_fd_pr__cap_mim_m3_1 l=3 w=3
X2554 P_B11 P_TOP sky130_fd_pr__cap_mim_m3_1 l=3 w=3
X2555 P_B11 P_TOP sky130_fd_pr__cap_mim_m3_1 l=3 w=3
X2556 P_B11 P_TOP sky130_fd_pr__cap_mim_m3_1 l=3 w=3
X2557 N_B11 N_TOP sky130_fd_pr__cap_mim_m3_1 l=3 w=3
X2558 P_B11 P_TOP sky130_fd_pr__cap_mim_m3_1 l=3 w=3
X2559 P_B11 P_TOP sky130_fd_pr__cap_mim_m3_1 l=3 w=3
X2560 N_B11 N_TOP sky130_fd_pr__cap_mim_m3_1 l=3 w=3
X2561 N_B11 N_TOP sky130_fd_pr__cap_mim_m3_1 l=3 w=3
X2562 N_B11 N_TOP sky130_fd_pr__cap_mim_m3_1 l=3 w=3
X2563 P_B11 P_TOP sky130_fd_pr__cap_mim_m3_1 l=3 w=3
X2564 P_B9 P_TOP sky130_fd_pr__cap_mim_m3_1 l=3 w=3
X2565 N_B9 N_TOP sky130_fd_pr__cap_mim_m3_1 l=3 w=3
X2566 N_B11 N_TOP sky130_fd_pr__cap_mim_m3_1 l=3 w=3
X2567 P_B10 P_TOP sky130_fd_pr__cap_mim_m3_1 l=3 w=3
X2568 N_B11 N_TOP sky130_fd_pr__cap_mim_m3_1 l=3 w=3
X2569 P_B11 P_TOP sky130_fd_pr__cap_mim_m3_1 l=3 w=3
X2570 N_B10 N_TOP sky130_fd_pr__cap_mim_m3_1 l=3 w=3
X2571 N_B9 N_TOP sky130_fd_pr__cap_mim_m3_1 l=3 w=3
X2572 P_B7 P_TOP sky130_fd_pr__cap_mim_m3_1 l=3 w=3
X2573 N_B10 N_TOP sky130_fd_pr__cap_mim_m3_1 l=3 w=3
X2574 N_B11 N_TOP sky130_fd_pr__cap_mim_m3_1 l=3 w=3
X2575 N_EDGE_BIAS N_EDGE_BIAS sky130_fd_pr__cap_mim_m3_1 l=3 w=3
X2576 N_B9 N_TOP sky130_fd_pr__cap_mim_m3_1 l=3 w=3
X2577 N_B11 N_TOP sky130_fd_pr__cap_mim_m3_1 l=3 w=3
X2578 N_B11 N_TOP sky130_fd_pr__cap_mim_m3_1 l=3 w=3
X2579 N_B10 N_TOP sky130_fd_pr__cap_mim_m3_1 l=3 w=3
X2580 P_B10 P_TOP sky130_fd_pr__cap_mim_m3_1 l=3 w=3
X2581 N_B8 N_TOP sky130_fd_pr__cap_mim_m3_1 l=3 w=3
X2582 P_B11 P_TOP sky130_fd_pr__cap_mim_m3_1 l=3 w=3
X2583 P_B11 P_TOP sky130_fd_pr__cap_mim_m3_1 l=3 w=3
X2584 N_B10 N_TOP sky130_fd_pr__cap_mim_m3_1 l=3 w=3
X2585 N_B10 N_TOP sky130_fd_pr__cap_mim_m3_1 l=3 w=3
X2586 P_B11 P_TOP sky130_fd_pr__cap_mim_m3_1 l=3 w=3
X2587 N_B10 N_TOP sky130_fd_pr__cap_mim_m3_1 l=3 w=3
X2588 P_B10 P_TOP sky130_fd_pr__cap_mim_m3_1 l=3 w=3
X2589 N_EDGE_BIAS N_EDGE_BIAS sky130_fd_pr__cap_mim_m3_1 l=3 w=3
X2590 N_B11 N_TOP sky130_fd_pr__cap_mim_m3_1 l=3 w=3
X2591 P_B11 P_TOP sky130_fd_pr__cap_mim_m3_1 l=3 w=3
X2592 N_B11 N_TOP sky130_fd_pr__cap_mim_m3_1 l=3 w=3
X2593 P_B9 P_TOP sky130_fd_pr__cap_mim_m3_1 l=3 w=3
X2594 P_B11 P_TOP sky130_fd_pr__cap_mim_m3_1 l=3 w=3
X2595 P_B8 P_TOP sky130_fd_pr__cap_mim_m3_1 l=3 w=3
X2596 P_B10 P_TOP sky130_fd_pr__cap_mim_m3_1 l=3 w=3
X2597 N_B11 N_TOP sky130_fd_pr__cap_mim_m3_1 l=3 w=3
X2598 P_B11 P_TOP sky130_fd_pr__cap_mim_m3_1 l=3 w=3
X2599 P_B11 P_TOP sky130_fd_pr__cap_mim_m3_1 l=3 w=3
X2600 N_B11 N_TOP sky130_fd_pr__cap_mim_m3_1 l=3 w=3
X2601 P_B11 P_TOP sky130_fd_pr__cap_mim_m3_1 l=3 w=3
X2602 P_B11 P_TOP sky130_fd_pr__cap_mim_m3_1 l=3 w=3
X2603 P_B11 P_TOP sky130_fd_pr__cap_mim_m3_1 l=3 w=3
X2604 P_B8 P_TOP sky130_fd_pr__cap_mim_m3_1 l=3 w=3
X2605 P_B10 P_TOP sky130_fd_pr__cap_mim_m3_1 l=3 w=3
X2606 N_B11 N_TOP sky130_fd_pr__cap_mim_m3_1 l=3 w=3
X2607 P_B11 P_TOP sky130_fd_pr__cap_mim_m3_1 l=3 w=3
X2608 P_EDGE_BIAS P_EDGE_BIAS sky130_fd_pr__cap_mim_m3_1 l=3 w=3
X2609 P_B10 P_TOP sky130_fd_pr__cap_mim_m3_1 l=3 w=3
X2610 N_B10 N_TOP sky130_fd_pr__cap_mim_m3_1 l=3 w=3
X2611 P_B11 P_TOP sky130_fd_pr__cap_mim_m3_1 l=3 w=3
X2612 P_EDGE_BIAS P_EDGE_BIAS sky130_fd_pr__cap_mim_m3_1 l=3 w=3
X2613 P_EDGE_BIAS P_EDGE_BIAS sky130_fd_pr__cap_mim_m3_1 l=3 w=3
X2614 P_B9 P_TOP sky130_fd_pr__cap_mim_m3_1 l=3 w=3
X2615 N_B11 N_TOP sky130_fd_pr__cap_mim_m3_1 l=3 w=3
X2616 N_B11 N_TOP sky130_fd_pr__cap_mim_m3_1 l=3 w=3
X2617 P_B11 P_TOP sky130_fd_pr__cap_mim_m3_1 l=3 w=3
X2618 N_B9 N_TOP sky130_fd_pr__cap_mim_m3_1 l=3 w=3
X2619 N_B11 N_TOP sky130_fd_pr__cap_mim_m3_1 l=3 w=3
X2620 N_B10 N_TOP sky130_fd_pr__cap_mim_m3_1 l=3 w=3
X2621 P_B10 P_TOP sky130_fd_pr__cap_mim_m3_1 l=3 w=3
X2622 N_B9 N_TOP sky130_fd_pr__cap_mim_m3_1 l=3 w=3
X2623 P_B6 P_TOP sky130_fd_pr__cap_mim_m3_1 l=3 w=3
X2624 N_B10 N_TOP sky130_fd_pr__cap_mim_m3_1 l=3 w=3
X2625 N_B10 N_TOP sky130_fd_pr__cap_mim_m3_1 l=3 w=3
X2626 N_B11 N_TOP sky130_fd_pr__cap_mim_m3_1 l=3 w=3
X2627 P_B11 P_TOP sky130_fd_pr__cap_mim_m3_1 l=3 w=3
X2628 N_B10 N_TOP sky130_fd_pr__cap_mim_m3_1 l=3 w=3
X2629 N_B11 N_TOP sky130_fd_pr__cap_mim_m3_1 l=3 w=3
X2630 N_B9 N_TOP sky130_fd_pr__cap_mim_m3_1 l=3 w=3
X2631 N_B9 N_TOP sky130_fd_pr__cap_mim_m3_1 l=3 w=3
X2632 P_B11 P_TOP sky130_fd_pr__cap_mim_m3_1 l=3 w=3
X2633 P_B11 P_TOP sky130_fd_pr__cap_mim_m3_1 l=3 w=3
X2634 N_B10 N_TOP sky130_fd_pr__cap_mim_m3_1 l=3 w=3
X2635 N_B11 N_TOP sky130_fd_pr__cap_mim_m3_1 l=3 w=3
X2636 P_B11 P_TOP sky130_fd_pr__cap_mim_m3_1 l=3 w=3
X2637 N_EDGE_BIAS N_EDGE_BIAS sky130_fd_pr__cap_mim_m3_1 l=3 w=3
X2638 N_B10 N_TOP sky130_fd_pr__cap_mim_m3_1 l=3 w=3
X2639 N_EDGE_BIAS N_EDGE_BIAS sky130_fd_pr__cap_mim_m3_1 l=3 w=3
X2640 N_B11 N_TOP sky130_fd_pr__cap_mim_m3_1 l=3 w=3
X2641 P_EDGE_BIAS P_EDGE_BIAS sky130_fd_pr__cap_mim_m3_1 l=3 w=3
X2642 N_B11 N_TOP sky130_fd_pr__cap_mim_m3_1 l=3 w=3
X2643 P_B11 P_TOP sky130_fd_pr__cap_mim_m3_1 l=3 w=3
X2644 N_EDGE_BIAS N_EDGE_BIAS sky130_fd_pr__cap_mim_m3_1 l=3 w=3
X2645 P_B8 P_TOP sky130_fd_pr__cap_mim_m3_1 l=3 w=3
X2646 P_B11 P_TOP sky130_fd_pr__cap_mim_m3_1 l=3 w=3
X2647 N_B11 N_TOP sky130_fd_pr__cap_mim_m3_1 l=3 w=3
X2648 P_B10 P_TOP sky130_fd_pr__cap_mim_m3_1 l=3 w=3
X2649 P_B9 P_TOP sky130_fd_pr__cap_mim_m3_1 l=3 w=3
X2650 P_B9 P_TOP sky130_fd_pr__cap_mim_m3_1 l=3 w=3
X2651 N_B11 N_TOP sky130_fd_pr__cap_mim_m3_1 l=3 w=3
X2652 P_B11 P_TOP sky130_fd_pr__cap_mim_m3_1 l=3 w=3
X2653 P_B9 P_TOP sky130_fd_pr__cap_mim_m3_1 l=3 w=3
X2654 N_B11 N_TOP sky130_fd_pr__cap_mim_m3_1 l=3 w=3
X2655 N_B11 N_TOP sky130_fd_pr__cap_mim_m3_1 l=3 w=3
X2656 N_B11 N_TOP sky130_fd_pr__cap_mim_m3_1 l=3 w=3
X2657 P_B11 P_TOP sky130_fd_pr__cap_mim_m3_1 l=3 w=3
X2658 P_B10 P_TOP sky130_fd_pr__cap_mim_m3_1 l=3 w=3
X2659 P_B11 P_TOP sky130_fd_pr__cap_mim_m3_1 l=3 w=3
X2660 N_B11 N_TOP sky130_fd_pr__cap_mim_m3_1 l=3 w=3
X2661 P_B9 P_TOP sky130_fd_pr__cap_mim_m3_1 l=3 w=3
X2662 P_B11 P_TOP sky130_fd_pr__cap_mim_m3_1 l=3 w=3
X2663 P_B11 P_TOP sky130_fd_pr__cap_mim_m3_1 l=3 w=3
X2664 P_B10 P_TOP sky130_fd_pr__cap_mim_m3_1 l=3 w=3
X2665 N_B9 N_TOP sky130_fd_pr__cap_mim_m3_1 l=3 w=3
X2666 N_B11 N_TOP sky130_fd_pr__cap_mim_m3_1 l=3 w=3
X2667 P_B11 P_TOP sky130_fd_pr__cap_mim_m3_1 l=3 w=3
X2668 P_EDGE_BIAS P_EDGE_BIAS sky130_fd_pr__cap_mim_m3_1 l=3 w=3
X2669 P_B10 P_TOP sky130_fd_pr__cap_mim_m3_1 l=3 w=3
X2670 N_B11 N_TOP sky130_fd_pr__cap_mim_m3_1 l=3 w=3
X2671 N_B10 N_TOP sky130_fd_pr__cap_mim_m3_1 l=3 w=3
X2672 P_B11 P_TOP sky130_fd_pr__cap_mim_m3_1 l=3 w=3
X2673 P_B11 P_TOP sky130_fd_pr__cap_mim_m3_1 l=3 w=3
X2674 P_B10 P_TOP sky130_fd_pr__cap_mim_m3_1 l=3 w=3
X2675 N_B9 N_TOP sky130_fd_pr__cap_mim_m3_1 l=3 w=3
X2676 N_B8 N_TOP sky130_fd_pr__cap_mim_m3_1 l=3 w=3
X2677 N_B9 N_TOP sky130_fd_pr__cap_mim_m3_1 l=3 w=3
X2678 N_B8 N_TOP sky130_fd_pr__cap_mim_m3_1 l=3 w=3
X2679 P_B11 P_TOP sky130_fd_pr__cap_mim_m3_1 l=3 w=3
X2680 N_B10 N_TOP sky130_fd_pr__cap_mim_m3_1 l=3 w=3
X2681 N_B11 N_TOP sky130_fd_pr__cap_mim_m3_1 l=3 w=3
X2682 P_B11 P_TOP sky130_fd_pr__cap_mim_m3_1 l=3 w=3
X2683 N_B9 N_TOP sky130_fd_pr__cap_mim_m3_1 l=3 w=3
X2684 N_B11 N_TOP sky130_fd_pr__cap_mim_m3_1 l=3 w=3
X2685 N_B10 N_TOP sky130_fd_pr__cap_mim_m3_1 l=3 w=3
X2686 N_B7 N_TOP sky130_fd_pr__cap_mim_m3_1 l=3 w=3
X2687 P_B11 P_TOP sky130_fd_pr__cap_mim_m3_1 l=3 w=3
X2688 N_B11 N_TOP sky130_fd_pr__cap_mim_m3_1 l=3 w=3
X2689 N_B10 N_TOP sky130_fd_pr__cap_mim_m3_1 l=3 w=3
X2690 P_B11 P_TOP sky130_fd_pr__cap_mim_m3_1 l=3 w=3
X2691 P_B10 P_TOP sky130_fd_pr__cap_mim_m3_1 l=3 w=3
X2692 P_B10 P_TOP sky130_fd_pr__cap_mim_m3_1 l=3 w=3
X2693 N_B11 N_TOP sky130_fd_pr__cap_mim_m3_1 l=3 w=3
X2694 P_B11 P_TOP sky130_fd_pr__cap_mim_m3_1 l=3 w=3
X2695 P_B11 P_TOP sky130_fd_pr__cap_mim_m3_1 l=3 w=3
X2696 P_B11 P_TOP sky130_fd_pr__cap_mim_m3_1 l=3 w=3
X2697 N_B11 N_TOP sky130_fd_pr__cap_mim_m3_1 l=3 w=3
X2698 N_B11 N_TOP sky130_fd_pr__cap_mim_m3_1 l=3 w=3
X2699 P_B11 P_TOP sky130_fd_pr__cap_mim_m3_1 l=3 w=3
X2700 P_B11 P_TOP sky130_fd_pr__cap_mim_m3_1 l=3 w=3
X2701 P_B8 P_TOP sky130_fd_pr__cap_mim_m3_1 l=3 w=3
X2702 P_B10 P_TOP sky130_fd_pr__cap_mim_m3_1 l=3 w=3
X2703 N_B11 N_TOP sky130_fd_pr__cap_mim_m3_1 l=3 w=3
X2704 P_B10 P_TOP sky130_fd_pr__cap_mim_m3_1 l=3 w=3
X2705 P_B10 P_TOP sky130_fd_pr__cap_mim_m3_1 l=3 w=3
X2706 N_B11 N_TOP sky130_fd_pr__cap_mim_m3_1 l=3 w=3
X2707 P_B11 P_TOP sky130_fd_pr__cap_mim_m3_1 l=3 w=3
X2708 N_B8 N_TOP sky130_fd_pr__cap_mim_m3_1 l=3 w=3
X2709 N_B11 N_TOP sky130_fd_pr__cap_mim_m3_1 l=3 w=3
X2710 N_B11 N_TOP sky130_fd_pr__cap_mim_m3_1 l=3 w=3
X2711 P_B11 P_TOP sky130_fd_pr__cap_mim_m3_1 l=3 w=3
X2712 P_B9 P_TOP sky130_fd_pr__cap_mim_m3_1 l=3 w=3
X2713 N_B11 N_TOP sky130_fd_pr__cap_mim_m3_1 l=3 w=3
X2714 N_B9 N_TOP sky130_fd_pr__cap_mim_m3_1 l=3 w=3
X2715 N_B11 N_TOP sky130_fd_pr__cap_mim_m3_1 l=3 w=3
X2716 P_B10 P_TOP sky130_fd_pr__cap_mim_m3_1 l=3 w=3
X2717 N_B11 N_TOP sky130_fd_pr__cap_mim_m3_1 l=3 w=3
X2718 P_B11 P_TOP sky130_fd_pr__cap_mim_m3_1 l=3 w=3
X2719 P_B10 P_TOP sky130_fd_pr__cap_mim_m3_1 l=3 w=3
X2720 P_B6 P_TOP sky130_fd_pr__cap_mim_m3_1 l=3 w=3
X2721 N_B10 N_TOP sky130_fd_pr__cap_mim_m3_1 l=3 w=3
X2722 N_EDGE_BIAS N_EDGE_BIAS sky130_fd_pr__cap_mim_m3_1 l=3 w=3
X2723 N_B11 N_TOP sky130_fd_pr__cap_mim_m3_1 l=3 w=3
X2724 N_B9 N_TOP sky130_fd_pr__cap_mim_m3_1 l=3 w=3
X2725 N_B11 N_TOP sky130_fd_pr__cap_mim_m3_1 l=3 w=3
X2726 P_B11 P_TOP sky130_fd_pr__cap_mim_m3_1 l=3 w=3
X2727 N_B7 N_TOP sky130_fd_pr__cap_mim_m3_1 l=3 w=3
X2728 P_B10 P_TOP sky130_fd_pr__cap_mim_m3_1 l=3 w=3
X2729 N_EDGE_BIAS N_EDGE_BIAS sky130_fd_pr__cap_mim_m3_1 l=3 w=3
X2730 P_EDGE_BIAS P_EDGE_BIAS sky130_fd_pr__cap_mim_m3_1 l=3 w=3
X2731 P_B11 P_TOP sky130_fd_pr__cap_mim_m3_1 l=3 w=3
X2732 N_B11 N_TOP sky130_fd_pr__cap_mim_m3_1 l=3 w=3
X2733 P_B11 P_TOP sky130_fd_pr__cap_mim_m3_1 l=3 w=3
X2734 P_B10 P_TOP sky130_fd_pr__cap_mim_m3_1 l=3 w=3
X2735 N_B11 N_TOP sky130_fd_pr__cap_mim_m3_1 l=3 w=3
X2736 P_B9 P_TOP sky130_fd_pr__cap_mim_m3_1 l=3 w=3
X2737 P_B11 P_TOP sky130_fd_pr__cap_mim_m3_1 l=3 w=3
X2738 N_B11 N_TOP sky130_fd_pr__cap_mim_m3_1 l=3 w=3
X2739 N_B11 N_TOP sky130_fd_pr__cap_mim_m3_1 l=3 w=3
X2740 P_B10 P_TOP sky130_fd_pr__cap_mim_m3_1 l=3 w=3
X2741 N_B11 N_TOP sky130_fd_pr__cap_mim_m3_1 l=3 w=3
X2742 P_B11 P_TOP sky130_fd_pr__cap_mim_m3_1 l=3 w=3
X2743 P_B9 P_TOP sky130_fd_pr__cap_mim_m3_1 l=3 w=3
X2744 P_B9 P_TOP sky130_fd_pr__cap_mim_m3_1 l=3 w=3
X2745 P_B10 P_TOP sky130_fd_pr__cap_mim_m3_1 l=3 w=3
X2746 N_B11 N_TOP sky130_fd_pr__cap_mim_m3_1 l=3 w=3
X2747 N_B10 N_TOP sky130_fd_pr__cap_mim_m3_1 l=3 w=3
X2748 N_B11 N_TOP sky130_fd_pr__cap_mim_m3_1 l=3 w=3
X2749 P_B10 P_TOP sky130_fd_pr__cap_mim_m3_1 l=3 w=3
X2750 N_B11 N_TOP sky130_fd_pr__cap_mim_m3_1 l=3 w=3
X2751 P_EDGE_BIAS P_EDGE_BIAS sky130_fd_pr__cap_mim_m3_1 l=3 w=3
X2752 P_B11 P_TOP sky130_fd_pr__cap_mim_m3_1 l=3 w=3
X2753 P_B10 P_TOP sky130_fd_pr__cap_mim_m3_1 l=3 w=3
X2754 N_B9 N_TOP sky130_fd_pr__cap_mim_m3_1 l=3 w=3
X2755 N_B8 N_TOP sky130_fd_pr__cap_mim_m3_1 l=3 w=3
X2756 N_B11 N_TOP sky130_fd_pr__cap_mim_m3_1 l=3 w=3
X2757 N_B11 N_TOP sky130_fd_pr__cap_mim_m3_1 l=3 w=3
X2758 P_B11 P_TOP sky130_fd_pr__cap_mim_m3_1 l=3 w=3
X2759 N_EDGE_BIAS N_EDGE_BIAS sky130_fd_pr__cap_mim_m3_1 l=3 w=3
X2760 N_B10 N_TOP sky130_fd_pr__cap_mim_m3_1 l=3 w=3
X2761 P_B11 P_TOP sky130_fd_pr__cap_mim_m3_1 l=3 w=3
X2762 N_EDGE_BIAS N_EDGE_BIAS sky130_fd_pr__cap_mim_m3_1 l=3 w=3
X2763 P_B10 P_TOP sky130_fd_pr__cap_mim_m3_1 l=3 w=3
X2764 N_B11 N_TOP sky130_fd_pr__cap_mim_m3_1 l=3 w=3
X2765 N_B10 N_TOP sky130_fd_pr__cap_mim_m3_1 l=3 w=3
X2766 N_B11 N_TOP sky130_fd_pr__cap_mim_m3_1 l=3 w=3
X2767 P_B9 P_TOP sky130_fd_pr__cap_mim_m3_1 l=3 w=3
X2768 N_B10 N_TOP sky130_fd_pr__cap_mim_m3_1 l=3 w=3
X2769 N_B4 N_TOP sky130_fd_pr__cap_mim_m3_1 l=3 w=3
X2770 P_B11 P_TOP sky130_fd_pr__cap_mim_m3_1 l=3 w=3
X2771 P_B10 P_TOP sky130_fd_pr__cap_mim_m3_1 l=3 w=3
X2772 N_B11 N_TOP sky130_fd_pr__cap_mim_m3_1 l=3 w=3
X2773 P_B11 P_TOP sky130_fd_pr__cap_mim_m3_1 l=3 w=3
X2774 P_B11 P_TOP sky130_fd_pr__cap_mim_m3_1 l=3 w=3
X2775 P_B9 P_TOP sky130_fd_pr__cap_mim_m3_1 l=3 w=3
X2776 N_B11 N_TOP sky130_fd_pr__cap_mim_m3_1 l=3 w=3
X2777 N_B11 N_TOP sky130_fd_pr__cap_mim_m3_1 l=3 w=3
X2778 N_B11 N_TOP sky130_fd_pr__cap_mim_m3_1 l=3 w=3
X2779 P_B10 P_TOP sky130_fd_pr__cap_mim_m3_1 l=3 w=3
X2780 N_B11 N_TOP sky130_fd_pr__cap_mim_m3_1 l=3 w=3
X2781 N_B11 N_TOP sky130_fd_pr__cap_mim_m3_1 l=3 w=3
X2782 P_B11 P_TOP sky130_fd_pr__cap_mim_m3_1 l=3 w=3
X2783 P_B11 P_TOP sky130_fd_pr__cap_mim_m3_1 l=3 w=3
X2784 N_B11 N_TOP sky130_fd_pr__cap_mim_m3_1 l=3 w=3
X2785 P_B8 P_TOP sky130_fd_pr__cap_mim_m3_1 l=3 w=3
X2786 P_B10 P_TOP sky130_fd_pr__cap_mim_m3_1 l=3 w=3
X2787 N_EDGE_BIAS N_EDGE_BIAS sky130_fd_pr__cap_mim_m3_1 l=3 w=3
X2788 P_B8 P_TOP sky130_fd_pr__cap_mim_m3_1 l=3 w=3
X2789 P_B11 P_TOP sky130_fd_pr__cap_mim_m3_1 l=3 w=3
X2790 N_B8 N_TOP sky130_fd_pr__cap_mim_m3_1 l=3 w=3
X2791 N_B11 N_TOP sky130_fd_pr__cap_mim_m3_1 l=3 w=3
X2792 P_B10 P_TOP sky130_fd_pr__cap_mim_m3_1 l=3 w=3
X2793 N_B11 N_TOP sky130_fd_pr__cap_mim_m3_1 l=3 w=3
X2794 N_B11 N_TOP sky130_fd_pr__cap_mim_m3_1 l=3 w=3
X2795 P_B11 P_TOP sky130_fd_pr__cap_mim_m3_1 l=3 w=3
X2796 N_B9 N_TOP sky130_fd_pr__cap_mim_m3_1 l=3 w=3
X2797 P_B9 P_TOP sky130_fd_pr__cap_mim_m3_1 l=3 w=3
X2798 P_B11 P_TOP sky130_fd_pr__cap_mim_m3_1 l=3 w=3
X2799 N_B9 N_TOP sky130_fd_pr__cap_mim_m3_1 l=3 w=3
X2800 N_B11 N_TOP sky130_fd_pr__cap_mim_m3_1 l=3 w=3
X2801 P_B10 P_TOP sky130_fd_pr__cap_mim_m3_1 l=3 w=3
X2802 N_B9 N_TOP sky130_fd_pr__cap_mim_m3_1 l=3 w=3
X2803 P_B11 P_TOP sky130_fd_pr__cap_mim_m3_1 l=3 w=3
X2804 P_B10 P_TOP sky130_fd_pr__cap_mim_m3_1 l=3 w=3
X2805 P_B11 P_TOP sky130_fd_pr__cap_mim_m3_1 l=3 w=3
X2806 P_B5 P_TOP sky130_fd_pr__cap_mim_m3_1 l=3 w=3
X2807 N_B10 N_TOP sky130_fd_pr__cap_mim_m3_1 l=3 w=3
X2808 N_B11 N_TOP sky130_fd_pr__cap_mim_m3_1 l=3 w=3
X2809 N_B9 N_TOP sky130_fd_pr__cap_mim_m3_1 l=3 w=3
X2810 P_B9 P_TOP sky130_fd_pr__cap_mim_m3_1 l=3 w=3
X2811 N_EDGE_BIAS N_EDGE_BIAS sky130_fd_pr__cap_mim_m3_1 l=3 w=3
X2812 N_B11 N_TOP sky130_fd_pr__cap_mim_m3_1 l=3 w=3
X2813 N_B11 N_TOP sky130_fd_pr__cap_mim_m3_1 l=3 w=3
X2814 N_B10 N_TOP sky130_fd_pr__cap_mim_m3_1 l=3 w=3
X2815 P_B11 P_TOP sky130_fd_pr__cap_mim_m3_1 l=3 w=3
X2816 P_B11 P_TOP sky130_fd_pr__cap_mim_m3_1 l=3 w=3
X2817 P_B11 P_TOP sky130_fd_pr__cap_mim_m3_1 l=3 w=3
X2818 N_B11 N_TOP sky130_fd_pr__cap_mim_m3_1 l=3 w=3
X2819 N_B10 N_TOP sky130_fd_pr__cap_mim_m3_1 l=3 w=3
X2820 N_B11 N_TOP sky130_fd_pr__cap_mim_m3_1 l=3 w=3
X2821 N_B11 N_TOP sky130_fd_pr__cap_mim_m3_1 l=3 w=3
X2822 P_EDGE_BIAS P_EDGE_BIAS sky130_fd_pr__cap_mim_m3_1 l=3 w=3
X2823 N_EDGE_BIAS N_EDGE_BIAS sky130_fd_pr__cap_mim_m3_1 l=3 w=3
X2824 N_B10 N_TOP sky130_fd_pr__cap_mim_m3_1 l=3 w=3
X2825 P_B8 P_TOP sky130_fd_pr__cap_mim_m3_1 l=3 w=3
X2826 P_B11 P_TOP sky130_fd_pr__cap_mim_m3_1 l=3 w=3
X2827 N_B11 N_TOP sky130_fd_pr__cap_mim_m3_1 l=3 w=3
X2828 P_B6 P_TOP sky130_fd_pr__cap_mim_m3_1 l=3 w=3
X2829 N_B11 N_TOP sky130_fd_pr__cap_mim_m3_1 l=3 w=3
X2830 P_B10 P_TOP sky130_fd_pr__cap_mim_m3_1 l=3 w=3
X2831 P_B11 P_TOP sky130_fd_pr__cap_mim_m3_1 l=3 w=3
X2832 N_B11 N_TOP sky130_fd_pr__cap_mim_m3_1 l=3 w=3
X2833 P_B11 P_TOP sky130_fd_pr__cap_mim_m3_1 l=3 w=3
X2834 N_B10 N_TOP sky130_fd_pr__cap_mim_m3_1 l=3 w=3
X2835 P_EDGE_BIAS P_EDGE_BIAS sky130_fd_pr__cap_mim_m3_1 l=3 w=3
X2836 N_B11 N_TOP sky130_fd_pr__cap_mim_m3_1 l=3 w=3
X2837 N_B11 N_TOP sky130_fd_pr__cap_mim_m3_1 l=3 w=3
X2838 P_B11 P_TOP sky130_fd_pr__cap_mim_m3_1 l=3 w=3
X2839 P_B10 P_TOP sky130_fd_pr__cap_mim_m3_1 l=3 w=3
X2840 P_B11 P_TOP sky130_fd_pr__cap_mim_m3_1 l=3 w=3
X2841 P_EDGE_BIAS P_EDGE_BIAS sky130_fd_pr__cap_mim_m3_1 l=3 w=3
X2842 N_B11 N_TOP sky130_fd_pr__cap_mim_m3_1 l=3 w=3
X2843 P_B11 P_TOP sky130_fd_pr__cap_mim_m3_1 l=3 w=3
X2844 N_B10 N_TOP sky130_fd_pr__cap_mim_m3_1 l=3 w=3
X2845 N_B11 N_TOP sky130_fd_pr__cap_mim_m3_1 l=3 w=3
X2846 N_B11 N_TOP sky130_fd_pr__cap_mim_m3_1 l=3 w=3
X2847 N_B11 N_TOP sky130_fd_pr__cap_mim_m3_1 l=3 w=3
X2848 N_B10 N_TOP sky130_fd_pr__cap_mim_m3_1 l=3 w=3
X2849 P_B10 P_TOP sky130_fd_pr__cap_mim_m3_1 l=3 w=3
X2850 N_B11 N_TOP sky130_fd_pr__cap_mim_m3_1 l=3 w=3
X2851 N_B11 N_TOP sky130_fd_pr__cap_mim_m3_1 l=3 w=3
X2852 N_B11 N_TOP sky130_fd_pr__cap_mim_m3_1 l=3 w=3
X2853 P_B10 P_TOP sky130_fd_pr__cap_mim_m3_1 l=3 w=3
X2854 N_B8 N_TOP sky130_fd_pr__cap_mim_m3_1 l=3 w=3
X2855 P_B11 P_TOP sky130_fd_pr__cap_mim_m3_1 l=3 w=3
X2856 N_B10 N_TOP sky130_fd_pr__cap_mim_m3_1 l=3 w=3
X2857 P_B10 P_TOP sky130_fd_pr__cap_mim_m3_1 l=3 w=3
X2858 N_B10 N_TOP sky130_fd_pr__cap_mim_m3_1 l=3 w=3
X2859 N_B11 N_TOP sky130_fd_pr__cap_mim_m3_1 l=3 w=3
X2860 P_B11 P_TOP sky130_fd_pr__cap_mim_m3_1 l=3 w=3
X2861 P_B11 P_TOP sky130_fd_pr__cap_mim_m3_1 l=3 w=3
X2862 N_B10 N_TOP sky130_fd_pr__cap_mim_m3_1 l=3 w=3
X2863 P_B10 P_TOP sky130_fd_pr__cap_mim_m3_1 l=3 w=3
X2864 N_B7 N_TOP sky130_fd_pr__cap_mim_m3_1 l=3 w=3
X2865 N_B11 N_TOP sky130_fd_pr__cap_mim_m3_1 l=3 w=3
X2866 P_B11 P_TOP sky130_fd_pr__cap_mim_m3_1 l=3 w=3
X2867 N_B11 N_TOP sky130_fd_pr__cap_mim_m3_1 l=3 w=3
X2868 N_B10 N_TOP sky130_fd_pr__cap_mim_m3_1 l=3 w=3
X2869 P_B9 P_TOP sky130_fd_pr__cap_mim_m3_1 l=3 w=3
X2870 N_B11 N_TOP sky130_fd_pr__cap_mim_m3_1 l=3 w=3
X2871 P_B11 P_TOP sky130_fd_pr__cap_mim_m3_1 l=3 w=3
X2872 P_B11 P_TOP sky130_fd_pr__cap_mim_m3_1 l=3 w=3
X2873 P_B10 P_TOP sky130_fd_pr__cap_mim_m3_1 l=3 w=3
X2874 P_B8 P_TOP sky130_fd_pr__cap_mim_m3_1 l=3 w=3
X2875 P_B11 P_TOP sky130_fd_pr__cap_mim_m3_1 l=3 w=3
X2876 N_B11 N_TOP sky130_fd_pr__cap_mim_m3_1 l=3 w=3
X2877 N_B11 N_TOP sky130_fd_pr__cap_mim_m3_1 l=3 w=3
X2878 P_B11 P_TOP sky130_fd_pr__cap_mim_m3_1 l=3 w=3
X2879 P_B9 P_TOP sky130_fd_pr__cap_mim_m3_1 l=3 w=3
X2880 N_B11 N_TOP sky130_fd_pr__cap_mim_m3_1 l=3 w=3
X2881 N_B11 N_TOP sky130_fd_pr__cap_mim_m3_1 l=3 w=3
X2882 P_B11 P_TOP sky130_fd_pr__cap_mim_m3_1 l=3 w=3
X2883 N_B11 N_TOP sky130_fd_pr__cap_mim_m3_1 l=3 w=3
X2884 P_B11 P_TOP sky130_fd_pr__cap_mim_m3_1 l=3 w=3
X2885 P_B8 P_TOP sky130_fd_pr__cap_mim_m3_1 l=3 w=3
X2886 P_B10 P_TOP sky130_fd_pr__cap_mim_m3_1 l=3 w=3
X2887 N_B11 N_TOP sky130_fd_pr__cap_mim_m3_1 l=3 w=3
X2888 P_B11 P_TOP sky130_fd_pr__cap_mim_m3_1 l=3 w=3
X2889 P_B11 P_TOP sky130_fd_pr__cap_mim_m3_1 l=3 w=3
X2890 P_EDGE_BIAS P_EDGE_BIAS sky130_fd_pr__cap_mim_m3_1 l=3 w=3
X2891 P_B8 P_TOP sky130_fd_pr__cap_mim_m3_1 l=3 w=3
X2892 N_B11 N_TOP sky130_fd_pr__cap_mim_m3_1 l=3 w=3
X2893 N_B11 N_TOP sky130_fd_pr__cap_mim_m3_1 l=3 w=3
X2894 P_B9 P_TOP sky130_fd_pr__cap_mim_m3_1 l=3 w=3
X2895 N_B11 N_TOP sky130_fd_pr__cap_mim_m3_1 l=3 w=3
X2896 N_B9 N_TOP sky130_fd_pr__cap_mim_m3_1 l=3 w=3
X2897 N_B11 N_TOP sky130_fd_pr__cap_mim_m3_1 l=3 w=3
X2898 P_B11 P_TOP sky130_fd_pr__cap_mim_m3_1 l=3 w=3
X2899 P_B9 P_TOP sky130_fd_pr__cap_mim_m3_1 l=3 w=3
X2900 N_B9 N_TOP sky130_fd_pr__cap_mim_m3_1 l=3 w=3
X2901 P_B10 P_TOP sky130_fd_pr__cap_mim_m3_1 l=3 w=3
X2902 P_B6 P_TOP sky130_fd_pr__cap_mim_m3_1 l=3 w=3
X2903 P_B11 P_TOP sky130_fd_pr__cap_mim_m3_1 l=3 w=3
X2904 P_B2 P_TOP sky130_fd_pr__cap_mim_m3_1 l=3 w=3
X2905 N_B10 N_TOP sky130_fd_pr__cap_mim_m3_1 l=3 w=3
X2906 N_B11 N_TOP sky130_fd_pr__cap_mim_m3_1 l=3 w=3
X2907 P_B11 P_TOP sky130_fd_pr__cap_mim_m3_1 l=3 w=3
X2908 N_B9 N_TOP sky130_fd_pr__cap_mim_m3_1 l=3 w=3
X2909 N_B9 N_TOP sky130_fd_pr__cap_mim_m3_1 l=3 w=3
X2910 P_B11 P_TOP sky130_fd_pr__cap_mim_m3_1 l=3 w=3
X2911 P_B11 P_TOP sky130_fd_pr__cap_mim_m3_1 l=3 w=3
X2912 N_B11 N_TOP sky130_fd_pr__cap_mim_m3_1 l=3 w=3
X2913 P_B11 P_TOP sky130_fd_pr__cap_mim_m3_1 l=3 w=3
X2914 N_B7 N_TOP sky130_fd_pr__cap_mim_m3_1 l=3 w=3
X2915 N_B10 N_TOP sky130_fd_pr__cap_mim_m3_1 l=3 w=3
X2916 N_EDGE_BIAS N_EDGE_BIAS sky130_fd_pr__cap_mim_m3_1 l=3 w=3
X2917 P_EDGE_BIAS P_EDGE_BIAS sky130_fd_pr__cap_mim_m3_1 l=3 w=3
X2918 P_B11 P_TOP sky130_fd_pr__cap_mim_m3_1 l=3 w=3
X2919 N_B11 N_TOP sky130_fd_pr__cap_mim_m3_1 l=3 w=3
X2920 P_B10 P_TOP sky130_fd_pr__cap_mim_m3_1 l=3 w=3
X2921 N_B10 N_TOP sky130_fd_pr__cap_mim_m3_1 l=3 w=3
X2922 N_B11 N_TOP sky130_fd_pr__cap_mim_m3_1 l=3 w=3
X2923 P_B10 P_TOP sky130_fd_pr__cap_mim_m3_1 l=3 w=3
X2924 N_B11 N_TOP sky130_fd_pr__cap_mim_m3_1 l=3 w=3
X2925 P_B11 P_TOP sky130_fd_pr__cap_mim_m3_1 l=3 w=3
X2926 P_B10 P_TOP sky130_fd_pr__cap_mim_m3_1 l=3 w=3
X2927 P_B11 P_TOP sky130_fd_pr__cap_mim_m3_1 l=3 w=3
X2928 N_B11 N_TOP sky130_fd_pr__cap_mim_m3_1 l=3 w=3
X2929 P_EDGE_BIAS P_EDGE_BIAS sky130_fd_pr__cap_mim_m3_1 l=3 w=3
X2930 P_B10 P_TOP sky130_fd_pr__cap_mim_m3_1 l=3 w=3
X2931 P_EDGE_BIAS P_EDGE_BIAS sky130_fd_pr__cap_mim_m3_1 l=3 w=3
X2932 N_B10 N_TOP sky130_fd_pr__cap_mim_m3_1 l=3 w=3
X2933 N_B11 N_TOP sky130_fd_pr__cap_mim_m3_1 l=3 w=3
X2934 P_B11 P_TOP sky130_fd_pr__cap_mim_m3_1 l=3 w=3
X2935 N_B10 N_TOP sky130_fd_pr__cap_mim_m3_1 l=3 w=3
X2936 N_B11 N_TOP sky130_fd_pr__cap_mim_m3_1 l=3 w=3
X2937 P_B10 P_TOP sky130_fd_pr__cap_mim_m3_1 l=3 w=3
X2938 N_B11 N_TOP sky130_fd_pr__cap_mim_m3_1 l=3 w=3
X2939 P_B11 P_TOP sky130_fd_pr__cap_mim_m3_1 l=3 w=3
X2940 P_B10 P_TOP sky130_fd_pr__cap_mim_m3_1 l=3 w=3
X2941 N_EDGE_BIAS N_EDGE_BIAS sky130_fd_pr__cap_mim_m3_1 l=3 w=3
X2942 P_B10 P_TOP sky130_fd_pr__cap_mim_m3_1 l=3 w=3
X2943 N_B8 N_TOP sky130_fd_pr__cap_mim_m3_1 l=3 w=3
X2944 N_B10 N_TOP sky130_fd_pr__cap_mim_m3_1 l=3 w=3
X2945 P_B11 P_TOP sky130_fd_pr__cap_mim_m3_1 l=3 w=3
X2946 N_B11 N_TOP sky130_fd_pr__cap_mim_m3_1 l=3 w=3
X2947 N_B11 N_TOP sky130_fd_pr__cap_mim_m3_1 l=3 w=3
X2948 N_B10 N_TOP sky130_fd_pr__cap_mim_m3_1 l=3 w=3
X2949 P_EDGE_BIAS P_EDGE_BIAS sky130_fd_pr__cap_mim_m3_1 l=3 w=3
X2950 P_EDGE_BIAS P_EDGE_BIAS sky130_fd_pr__cap_mim_m3_1 l=3 w=3
X2951 N_B11 N_TOP sky130_fd_pr__cap_mim_m3_1 l=3 w=3
X2952 N_B10 N_TOP sky130_fd_pr__cap_mim_m3_1 l=3 w=3
X2953 P_B10 P_TOP sky130_fd_pr__cap_mim_m3_1 l=3 w=3
X2954 P_EDGE_BIAS P_EDGE_BIAS sky130_fd_pr__cap_mim_m3_1 l=3 w=3
X2955 N_B7 N_TOP sky130_fd_pr__cap_mim_m3_1 l=3 w=3
X2956 P_B11 P_TOP sky130_fd_pr__cap_mim_m3_1 l=3 w=3
X2957 N_B10 N_TOP sky130_fd_pr__cap_mim_m3_1 l=3 w=3
X2958 N_B11 N_TOP sky130_fd_pr__cap_mim_m3_1 l=3 w=3
X2959 P_B11 P_TOP sky130_fd_pr__cap_mim_m3_1 l=3 w=3
X2960 P_B10 P_TOP sky130_fd_pr__cap_mim_m3_1 l=3 w=3
X2961 N_B6 N_TOP sky130_fd_pr__cap_mim_m3_1 l=3 w=3
X2962 P_B9 P_TOP sky130_fd_pr__cap_mim_m3_1 l=3 w=3
X2963 N_B11 N_TOP sky130_fd_pr__cap_mim_m3_1 l=3 w=3
X2964 P_B11 P_TOP sky130_fd_pr__cap_mim_m3_1 l=3 w=3
X2965 N_B11 N_TOP sky130_fd_pr__cap_mim_m3_1 l=3 w=3
X2966 P_B11 P_TOP sky130_fd_pr__cap_mim_m3_1 l=3 w=3
X2967 P_B8 P_TOP sky130_fd_pr__cap_mim_m3_1 l=3 w=3
X2968 N_B11 N_TOP sky130_fd_pr__cap_mim_m3_1 l=3 w=3
X2969 P_B11 P_TOP sky130_fd_pr__cap_mim_m3_1 l=3 w=3
X2970 N_B8 N_TOP sky130_fd_pr__cap_mim_m3_1 l=3 w=3
X2971 P_B8 P_TOP sky130_fd_pr__cap_mim_m3_1 l=3 w=3
X2972 N_B11 N_TOP sky130_fd_pr__cap_mim_m3_1 l=3 w=3
X2973 P_B11 P_TOP sky130_fd_pr__cap_mim_m3_1 l=3 w=3
X2974 N_B2 N_TOP sky130_fd_pr__cap_mim_m3_1 l=3 w=3
X2975 P_B11 P_TOP sky130_fd_pr__cap_mim_m3_1 l=3 w=3
X2976 P_B9 P_TOP sky130_fd_pr__cap_mim_m3_1 l=3 w=3
X2977 N_B9 N_TOP sky130_fd_pr__cap_mim_m3_1 l=3 w=3
X2978 N_B11 N_TOP sky130_fd_pr__cap_mim_m3_1 l=3 w=3
X2979 P_B11 P_TOP sky130_fd_pr__cap_mim_m3_1 l=3 w=3
X2980 P_B10 P_TOP sky130_fd_pr__cap_mim_m3_1 l=3 w=3
X2981 P_B5 P_TOP sky130_fd_pr__cap_mim_m3_1 l=3 w=3
X2982 P_B10 P_TOP sky130_fd_pr__cap_mim_m3_1 l=3 w=3
X2983 N_EDGE_BIAS N_EDGE_BIAS sky130_fd_pr__cap_mim_m3_1 l=3 w=3
X2984 P_B11 P_TOP sky130_fd_pr__cap_mim_m3_1 l=3 w=3
X2985 N_B11 N_TOP sky130_fd_pr__cap_mim_m3_1 l=3 w=3
X2986 P_B9 P_TOP sky130_fd_pr__cap_mim_m3_1 l=3 w=3
X2987 P_B9 P_TOP sky130_fd_pr__cap_mim_m3_1 l=3 w=3
X2988 N_B11 N_TOP sky130_fd_pr__cap_mim_m3_1 l=3 w=3
X2989 N_B11 N_TOP sky130_fd_pr__cap_mim_m3_1 l=3 w=3
X2990 N_B9 N_TOP sky130_fd_pr__cap_mim_m3_1 l=3 w=3
X2991 P_B11 P_TOP sky130_fd_pr__cap_mim_m3_1 l=3 w=3
X2992 N_B11 N_TOP sky130_fd_pr__cap_mim_m3_1 l=3 w=3
X2993 N_B11 N_TOP sky130_fd_pr__cap_mim_m3_1 l=3 w=3
X2994 P_B11 P_TOP sky130_fd_pr__cap_mim_m3_1 l=3 w=3
X2995 P_B11 P_TOP sky130_fd_pr__cap_mim_m3_1 l=3 w=3
X2996 N_B7 N_TOP sky130_fd_pr__cap_mim_m3_1 l=3 w=3
X2997 P_B11 P_TOP sky130_fd_pr__cap_mim_m3_1 l=3 w=3
X2998 P_B10 P_TOP sky130_fd_pr__cap_mim_m3_1 l=3 w=3
X2999 N_EDGE_BIAS N_EDGE_BIAS sky130_fd_pr__cap_mim_m3_1 l=3 w=3
X3000 P_EDGE_BIAS P_EDGE_BIAS sky130_fd_pr__cap_mim_m3_1 l=3 w=3
X3001 N_B11 N_TOP sky130_fd_pr__cap_mim_m3_1 l=3 w=3
X3002 N_B11 N_TOP sky130_fd_pr__cap_mim_m3_1 l=3 w=3
X3003 P_B11 P_TOP sky130_fd_pr__cap_mim_m3_1 l=3 w=3
X3004 N_B11 N_TOP sky130_fd_pr__cap_mim_m3_1 l=3 w=3
X3005 P_EDGE_BIAS P_EDGE_BIAS sky130_fd_pr__cap_mim_m3_1 l=3 w=3
X3006 P_B10 P_TOP sky130_fd_pr__cap_mim_m3_1 l=3 w=3
X3007 N_EDGE_BIAS N_EDGE_BIAS sky130_fd_pr__cap_mim_m3_1 l=3 w=3
X3008 P_B11 P_TOP sky130_fd_pr__cap_mim_m3_1 l=3 w=3
X3009 N_B11 N_TOP sky130_fd_pr__cap_mim_m3_1 l=3 w=3
X3010 P_B11 P_TOP sky130_fd_pr__cap_mim_m3_1 l=3 w=3
X3011 N_B11 N_TOP sky130_fd_pr__cap_mim_m3_1 l=3 w=3
X3012 P_B10 P_TOP sky130_fd_pr__cap_mim_m3_1 l=3 w=3
X3013 N_B11 N_TOP sky130_fd_pr__cap_mim_m3_1 l=3 w=3
X3014 P_B10 P_TOP sky130_fd_pr__cap_mim_m3_1 l=3 w=3
X3015 N_B11 N_TOP sky130_fd_pr__cap_mim_m3_1 l=3 w=3
X3016 P_B9 P_TOP sky130_fd_pr__cap_mim_m3_1 l=3 w=3
X3017 N_B11 N_TOP sky130_fd_pr__cap_mim_m3_1 l=3 w=3
X3018 P_B11 P_TOP sky130_fd_pr__cap_mim_m3_1 l=3 w=3
X3019 P_B10 P_TOP sky130_fd_pr__cap_mim_m3_1 l=3 w=3
X3020 N_B11 N_TOP sky130_fd_pr__cap_mim_m3_1 l=3 w=3
X3021 N_B11 N_TOP sky130_fd_pr__cap_mim_m3_1 l=3 w=3
X3022 N_B10 N_TOP sky130_fd_pr__cap_mim_m3_1 l=3 w=3
X3023 N_B11 N_TOP sky130_fd_pr__cap_mim_m3_1 l=3 w=3
X3024 N_B8 N_TOP sky130_fd_pr__cap_mim_m3_1 l=3 w=3
X3025 N_B11 N_TOP sky130_fd_pr__cap_mim_m3_1 l=3 w=3
X3026 P_B10 P_TOP sky130_fd_pr__cap_mim_m3_1 l=3 w=3
X3027 N_B11 N_TOP sky130_fd_pr__cap_mim_m3_1 l=3 w=3
X3028 P_B10 P_TOP sky130_fd_pr__cap_mim_m3_1 l=3 w=3
X3029 P_B8 P_TOP sky130_fd_pr__cap_mim_m3_1 l=3 w=3
X3030 N_B11 N_TOP sky130_fd_pr__cap_mim_m3_1 l=3 w=3
X3031 N_B8 N_TOP sky130_fd_pr__cap_mim_m3_1 l=3 w=3
X3032 N_B11 N_TOP sky130_fd_pr__cap_mim_m3_1 l=3 w=3
X3033 P_B10 P_TOP sky130_fd_pr__cap_mim_m3_1 l=3 w=3
X3034 N_B10 N_TOP sky130_fd_pr__cap_mim_m3_1 l=3 w=3
X3035 N_B10 N_TOP sky130_fd_pr__cap_mim_m3_1 l=3 w=3
X3036 P_B11 P_TOP sky130_fd_pr__cap_mim_m3_1 l=3 w=3
X3037 P_B10 P_TOP sky130_fd_pr__cap_mim_m3_1 l=3 w=3
X3038 N_B11 N_TOP sky130_fd_pr__cap_mim_m3_1 l=3 w=3
X3039 N_B11 N_TOP sky130_fd_pr__cap_mim_m3_1 l=3 w=3
X3040 P_B10 P_TOP sky130_fd_pr__cap_mim_m3_1 l=3 w=3
X3041 N_B9 N_TOP sky130_fd_pr__cap_mim_m3_1 l=3 w=3
X3042 P_B11 P_TOP sky130_fd_pr__cap_mim_m3_1 l=3 w=3
X3043 P_B9 P_TOP sky130_fd_pr__cap_mim_m3_1 l=3 w=3
X3044 N_B10 N_TOP sky130_fd_pr__cap_mim_m3_1 l=3 w=3
X3045 N_B5 N_TOP sky130_fd_pr__cap_mim_m3_1 l=3 w=3
X3046 P_B11 P_TOP sky130_fd_pr__cap_mim_m3_1 l=3 w=3
X3047 P_B11 P_TOP sky130_fd_pr__cap_mim_m3_1 l=3 w=3
X3048 N_B11 N_TOP sky130_fd_pr__cap_mim_m3_1 l=3 w=3
X3049 P_B9 P_TOP sky130_fd_pr__cap_mim_m3_1 l=3 w=3
X3050 P_B11 P_TOP sky130_fd_pr__cap_mim_m3_1 l=3 w=3
X3051 N_B11 N_TOP sky130_fd_pr__cap_mim_m3_1 l=3 w=3
X3052 P_B11 P_TOP sky130_fd_pr__cap_mim_m3_1 l=3 w=3
X3053 P_B7 P_TOP sky130_fd_pr__cap_mim_m3_1 l=3 w=3
X3054 N_B9 N_TOP sky130_fd_pr__cap_mim_m3_1 l=3 w=3
X3055 P_B10 P_TOP sky130_fd_pr__cap_mim_m3_1 l=3 w=3
X3056 P_B11 P_TOP sky130_fd_pr__cap_mim_m3_1 l=3 w=3
X3057 P_B11 P_TOP sky130_fd_pr__cap_mim_m3_1 l=3 w=3
X3058 P_B10 P_TOP sky130_fd_pr__cap_mim_m3_1 l=3 w=3
X3059 N_EDGE_BIAS N_EDGE_BIAS sky130_fd_pr__cap_mim_m3_1 l=3 w=3
X3060 P_B11 P_TOP sky130_fd_pr__cap_mim_m3_1 l=3 w=3
X3061 P_B8 P_TOP sky130_fd_pr__cap_mim_m3_1 l=3 w=3
X3062 N_B11 N_TOP sky130_fd_pr__cap_mim_m3_1 l=3 w=3
X3063 P_B10 P_TOP sky130_fd_pr__cap_mim_m3_1 l=3 w=3
X3064 P_B5 P_TOP sky130_fd_pr__cap_mim_m3_1 l=3 w=3
X3065 N_B11 N_TOP sky130_fd_pr__cap_mim_m3_1 l=3 w=3
X3066 N_B10 N_TOP sky130_fd_pr__cap_mim_m3_1 l=3 w=3
X3067 P_B11 P_TOP sky130_fd_pr__cap_mim_m3_1 l=3 w=3
X3068 P_B11 P_TOP sky130_fd_pr__cap_mim_m3_1 l=3 w=3
X3069 P_B9 P_TOP sky130_fd_pr__cap_mim_m3_1 l=3 w=3
X3070 N_B9 N_TOP sky130_fd_pr__cap_mim_m3_1 l=3 w=3
X3071 N_B11 N_TOP sky130_fd_pr__cap_mim_m3_1 l=3 w=3
X3072 P_B10 P_TOP sky130_fd_pr__cap_mim_m3_1 l=3 w=3
X3073 P_B11 P_TOP sky130_fd_pr__cap_mim_m3_1 l=3 w=3
X3074 P_B4 P_TOP sky130_fd_pr__cap_mim_m3_1 l=3 w=3
X3075 N_B10 N_TOP sky130_fd_pr__cap_mim_m3_1 l=3 w=3
X3076 N_B11 N_TOP sky130_fd_pr__cap_mim_m3_1 l=3 w=3
X3077 N_B10 N_TOP sky130_fd_pr__cap_mim_m3_1 l=3 w=3
X3078 N_B11 N_TOP sky130_fd_pr__cap_mim_m3_1 l=3 w=3
X3079 P_B11 P_TOP sky130_fd_pr__cap_mim_m3_1 l=3 w=3
X3080 N_B9 N_TOP sky130_fd_pr__cap_mim_m3_1 l=3 w=3
X3081 P_B9 P_TOP sky130_fd_pr__cap_mim_m3_1 l=3 w=3
X3082 N_B11 N_TOP sky130_fd_pr__cap_mim_m3_1 l=3 w=3
X3083 N_B11 N_TOP sky130_fd_pr__cap_mim_m3_1 l=3 w=3
X3084 N_B9 N_TOP sky130_fd_pr__cap_mim_m3_1 l=3 w=3
X3085 N_B11 N_TOP sky130_fd_pr__cap_mim_m3_1 l=3 w=3
X3086 N_B10 N_TOP sky130_fd_pr__cap_mim_m3_1 l=3 w=3
X3087 P_B11 P_TOP sky130_fd_pr__cap_mim_m3_1 l=3 w=3
X3088 N_B10 N_TOP sky130_fd_pr__cap_mim_m3_1 l=3 w=3
X3089 P_B11 P_TOP sky130_fd_pr__cap_mim_m3_1 l=3 w=3
X3090 N_B10 N_TOP sky130_fd_pr__cap_mim_m3_1 l=3 w=3
X3091 P_EDGE_BIAS P_EDGE_BIAS sky130_fd_pr__cap_mim_m3_1 l=3 w=3
X3092 N_B11 N_TOP sky130_fd_pr__cap_mim_m3_1 l=3 w=3
X3093 P_EDGE_BIAS P_EDGE_BIAS sky130_fd_pr__cap_mim_m3_1 l=3 w=3
X3094 N_B11 N_TOP sky130_fd_pr__cap_mim_m3_1 l=3 w=3
X3095 N_B10 N_TOP sky130_fd_pr__cap_mim_m3_1 l=3 w=3
X3096 N_B11 N_TOP sky130_fd_pr__cap_mim_m3_1 l=3 w=3
X3097 P_B11 P_TOP sky130_fd_pr__cap_mim_m3_1 l=3 w=3
X3098 N_EDGE_BIAS N_EDGE_BIAS sky130_fd_pr__cap_mim_m3_1 l=3 w=3
X3099 P_B10 P_TOP sky130_fd_pr__cap_mim_m3_1 l=3 w=3
X3100 P_B11 P_TOP sky130_fd_pr__cap_mim_m3_1 l=3 w=3
X3101 N_B11 N_TOP sky130_fd_pr__cap_mim_m3_1 l=3 w=3
X3102 N_B11 N_TOP sky130_fd_pr__cap_mim_m3_1 l=3 w=3
X3103 P_B7 P_TOP sky130_fd_pr__cap_mim_m3_1 l=3 w=3
X3104 P_B11 P_TOP sky130_fd_pr__cap_mim_m3_1 l=3 w=3
X3105 N_B11 N_TOP sky130_fd_pr__cap_mim_m3_1 l=3 w=3
X3106 P_B11 P_TOP sky130_fd_pr__cap_mim_m3_1 l=3 w=3
X3107 N_B10 N_TOP sky130_fd_pr__cap_mim_m3_1 l=3 w=3
X3108 N_B11 N_TOP sky130_fd_pr__cap_mim_m3_1 l=3 w=3
X3109 P_B8 P_TOP sky130_fd_pr__cap_mim_m3_1 l=3 w=3
X3110 N_B10 N_TOP sky130_fd_pr__cap_mim_m3_1 l=3 w=3
X3111 P_B11 P_TOP sky130_fd_pr__cap_mim_m3_1 l=3 w=3
X3112 N_B11 N_TOP sky130_fd_pr__cap_mim_m3_1 l=3 w=3
X3113 P_B11 P_TOP sky130_fd_pr__cap_mim_m3_1 l=3 w=3
X3114 P_B10 P_TOP sky130_fd_pr__cap_mim_m3_1 l=3 w=3
X3115 N_B11 N_TOP sky130_fd_pr__cap_mim_m3_1 l=3 w=3
X3116 P_B10 P_TOP sky130_fd_pr__cap_mim_m3_1 l=3 w=3
X3117 P_EDGE_BIAS P_EDGE_BIAS sky130_fd_pr__cap_mim_m3_1 l=3 w=3
X3118 N_B8 N_TOP sky130_fd_pr__cap_mim_m3_1 l=3 w=3
X3119 N_B11 N_TOP sky130_fd_pr__cap_mim_m3_1 l=3 w=3
X3120 P_B11 P_TOP sky130_fd_pr__cap_mim_m3_1 l=3 w=3
X3121 N_B11 N_TOP sky130_fd_pr__cap_mim_m3_1 l=3 w=3
X3122 N_B10 N_TOP sky130_fd_pr__cap_mim_m3_1 l=3 w=3
X3123 P_B10 P_TOP sky130_fd_pr__cap_mim_m3_1 l=3 w=3
X3124 N_B10 N_TOP sky130_fd_pr__cap_mim_m3_1 l=3 w=3
X3125 N_B11 N_TOP sky130_fd_pr__cap_mim_m3_1 l=3 w=3
X3126 N_B11 N_TOP sky130_fd_pr__cap_mim_m3_1 l=3 w=3
X3127 P_B11 P_TOP sky130_fd_pr__cap_mim_m3_1 l=3 w=3
X3128 N_B10 N_TOP sky130_fd_pr__cap_mim_m3_1 l=3 w=3
X3129 P_B10 P_TOP sky130_fd_pr__cap_mim_m3_1 l=3 w=3
X3130 N_B7 N_TOP sky130_fd_pr__cap_mim_m3_1 l=3 w=3
X3131 N_B11 N_TOP sky130_fd_pr__cap_mim_m3_1 l=3 w=3
X3132 N_B11 N_TOP sky130_fd_pr__cap_mim_m3_1 l=3 w=3
X3133 N_B10 N_TOP sky130_fd_pr__cap_mim_m3_1 l=3 w=3
X3134 P_B9 P_TOP sky130_fd_pr__cap_mim_m3_1 l=3 w=3
X3135 N_B10 N_TOP sky130_fd_pr__cap_mim_m3_1 l=3 w=3
X3136 N_B11 N_TOP sky130_fd_pr__cap_mim_m3_1 l=3 w=3
X3137 N_B10 N_TOP sky130_fd_pr__cap_mim_m3_1 l=3 w=3
X3138 N_B6 N_TOP sky130_fd_pr__cap_mim_m3_1 l=3 w=3
X3139 N_B10 N_TOP sky130_fd_pr__cap_mim_m3_1 l=3 w=3
X3140 P_B11 P_TOP sky130_fd_pr__cap_mim_m3_1 l=3 w=3
X3141 N_B11 N_TOP sky130_fd_pr__cap_mim_m3_1 l=3 w=3
X3142 N_B11 N_TOP sky130_fd_pr__cap_mim_m3_1 l=3 w=3
X3143 N_B11 N_TOP sky130_fd_pr__cap_mim_m3_1 l=3 w=3
X3144 P_B11 P_TOP sky130_fd_pr__cap_mim_m3_1 l=3 w=3
X3145 P_B9 P_TOP sky130_fd_pr__cap_mim_m3_1 l=3 w=3
X3146 N_B11 N_TOP sky130_fd_pr__cap_mim_m3_1 l=3 w=3
X3147 P_B11 P_TOP sky130_fd_pr__cap_mim_m3_1 l=3 w=3
X3148 N_B11 N_TOP sky130_fd_pr__cap_mim_m3_1 l=3 w=3
X3149 P_B11 P_TOP sky130_fd_pr__cap_mim_m3_1 l=3 w=3
X3150 P_B8 P_TOP sky130_fd_pr__cap_mim_m3_1 l=3 w=3
X3151 P_B10 P_TOP sky130_fd_pr__cap_mim_m3_1 l=3 w=3
X3152 P_B11 P_TOP sky130_fd_pr__cap_mim_m3_1 l=3 w=3
X3153 N_B10 N_TOP sky130_fd_pr__cap_mim_m3_1 l=3 w=3
X3154 N_EDGE_BIAS N_EDGE_BIAS sky130_fd_pr__cap_mim_m3_1 l=3 w=3
X3155 P_B8 P_TOP sky130_fd_pr__cap_mim_m3_1 l=3 w=3
X3156 N_B11 N_TOP sky130_fd_pr__cap_mim_m3_1 l=3 w=3
X3157 N_B11 N_TOP sky130_fd_pr__cap_mim_m3_1 l=3 w=3
X3158 P_B10 P_TOP sky130_fd_pr__cap_mim_m3_1 l=3 w=3
X3159 P_B9 P_TOP sky130_fd_pr__cap_mim_m3_1 l=3 w=3
X3160 P_B11 P_TOP sky130_fd_pr__cap_mim_m3_1 l=3 w=3
X3161 P_B11 P_TOP sky130_fd_pr__cap_mim_m3_1 l=3 w=3
X3162 P_B9 P_TOP sky130_fd_pr__cap_mim_m3_1 l=3 w=3
X3163 P_B11 P_TOP sky130_fd_pr__cap_mim_m3_1 l=3 w=3
X3164 N_B11 N_TOP sky130_fd_pr__cap_mim_m3_1 l=3 w=3
X3165 P_B9 P_TOP sky130_fd_pr__cap_mim_m3_1 l=3 w=3
X3166 N_B10 N_TOP sky130_fd_pr__cap_mim_m3_1 l=3 w=3
X3167 N_B9 N_TOP sky130_fd_pr__cap_mim_m3_1 l=3 w=3
X3168 N_B11 N_TOP sky130_fd_pr__cap_mim_m3_1 l=3 w=3
X3169 P_B10 P_TOP sky130_fd_pr__cap_mim_m3_1 l=3 w=3
X3170 P_B5 P_TOP sky130_fd_pr__cap_mim_m3_1 l=3 w=3
X3171 P_B11 P_TOP sky130_fd_pr__cap_mim_m3_1 l=3 w=3
X3172 P_B11 P_TOP sky130_fd_pr__cap_mim_m3_1 l=3 w=3
X3173 N_B10 N_TOP sky130_fd_pr__cap_mim_m3_1 l=3 w=3
X3174 N_B11 N_TOP sky130_fd_pr__cap_mim_m3_1 l=3 w=3
X3175 P_B11 P_TOP sky130_fd_pr__cap_mim_m3_1 l=3 w=3
X3176 P_B11 P_TOP sky130_fd_pr__cap_mim_m3_1 l=3 w=3
X3177 N_B9 N_TOP sky130_fd_pr__cap_mim_m3_1 l=3 w=3
X3178 P_B11 P_TOP sky130_fd_pr__cap_mim_m3_1 l=3 w=3
X3179 P_B10 P_TOP sky130_fd_pr__cap_mim_m3_1 l=3 w=3
X3180 P_B9 P_TOP sky130_fd_pr__cap_mim_m3_1 l=3 w=3
X3181 N_B9 N_TOP sky130_fd_pr__cap_mim_m3_1 l=3 w=3
X3182 N_B10 N_TOP sky130_fd_pr__cap_mim_m3_1 l=3 w=3
X3183 P_B11 P_TOP sky130_fd_pr__cap_mim_m3_1 l=3 w=3
X3184 N_B11 N_TOP sky130_fd_pr__cap_mim_m3_1 l=3 w=3
X3185 N_B11 N_TOP sky130_fd_pr__cap_mim_m3_1 l=3 w=3
X3186 P_B11 P_TOP sky130_fd_pr__cap_mim_m3_1 l=3 w=3
X3187 P_B11 P_TOP sky130_fd_pr__cap_mim_m3_1 l=3 w=3
X3188 N_B7 N_TOP sky130_fd_pr__cap_mim_m3_1 l=3 w=3
X3189 N_B10 N_TOP sky130_fd_pr__cap_mim_m3_1 l=3 w=3
X3190 P_EDGE_BIAS P_EDGE_BIAS sky130_fd_pr__cap_mim_m3_1 l=3 w=3
X3191 N_B9 N_TOP sky130_fd_pr__cap_mim_m3_1 l=3 w=3
X3192 N_B10 N_TOP sky130_fd_pr__cap_mim_m3_1 l=3 w=3
X3193 N_B11 N_TOP sky130_fd_pr__cap_mim_m3_1 l=3 w=3
X3194 N_B8 N_TOP sky130_fd_pr__cap_mim_m3_1 l=3 w=3
X3195 P_B11 P_TOP sky130_fd_pr__cap_mim_m3_1 l=3 w=3
X3196 P_B11 P_TOP sky130_fd_pr__cap_mim_m3_1 l=3 w=3
X3197 N_B10 N_TOP sky130_fd_pr__cap_mim_m3_1 l=3 w=3
X3198 N_EDGE_BIAS N_EDGE_BIAS sky130_fd_pr__cap_mim_m3_1 l=3 w=3
X3199 N_B11 N_TOP sky130_fd_pr__cap_mim_m3_1 l=3 w=3
X3200 P_B11 P_TOP sky130_fd_pr__cap_mim_m3_1 l=3 w=3
X3201 N_B11 N_TOP sky130_fd_pr__cap_mim_m3_1 l=3 w=3
X3202 N_B10 N_TOP sky130_fd_pr__cap_mim_m3_1 l=3 w=3
X3203 P_B10 P_TOP sky130_fd_pr__cap_mim_m3_1 l=3 w=3
X3204 P_B11 P_TOP sky130_fd_pr__cap_mim_m3_1 l=3 w=3
X3205 P_B11 P_TOP sky130_fd_pr__cap_mim_m3_1 l=3 w=3
X3206 N_B9 N_TOP sky130_fd_pr__cap_mim_m3_1 l=3 w=3
X3207 P_B10 P_TOP sky130_fd_pr__cap_mim_m3_1 l=3 w=3
X3208 N_B11 N_TOP sky130_fd_pr__cap_mim_m3_1 l=3 w=3
X3209 N_B11 N_TOP sky130_fd_pr__cap_mim_m3_1 l=3 w=3
X3210 N_B10 N_TOP sky130_fd_pr__cap_mim_m3_1 l=3 w=3
X3211 P_B11 P_TOP sky130_fd_pr__cap_mim_m3_1 l=3 w=3
X3212 N_B11 N_TOP sky130_fd_pr__cap_mim_m3_1 l=3 w=3
X3213 P_B10 P_TOP sky130_fd_pr__cap_mim_m3_1 l=3 w=3
X3214 P_B11 P_TOP sky130_fd_pr__cap_mim_m3_1 l=3 w=3
X3215 P_B11 P_TOP sky130_fd_pr__cap_mim_m3_1 l=3 w=3
X3216 P_B10 P_TOP sky130_fd_pr__cap_mim_m3_1 l=3 w=3
X3217 N_B9 N_TOP sky130_fd_pr__cap_mim_m3_1 l=3 w=3
X3218 N_B11 N_TOP sky130_fd_pr__cap_mim_m3_1 l=3 w=3
X3219 P_B10 P_TOP sky130_fd_pr__cap_mim_m3_1 l=3 w=3
X3220 P_EDGE_BIAS P_EDGE_BIAS sky130_fd_pr__cap_mim_m3_1 l=3 w=3
X3221 N_B11 N_TOP sky130_fd_pr__cap_mim_m3_1 l=3 w=3
X3222 N_B10 N_TOP sky130_fd_pr__cap_mim_m3_1 l=3 w=3
X3223 N_B8 N_TOP sky130_fd_pr__cap_mim_m3_1 l=3 w=3
X3224 N_B11 N_TOP sky130_fd_pr__cap_mim_m3_1 l=3 w=3
X3225 N_B11 N_TOP sky130_fd_pr__cap_mim_m3_1 l=3 w=3
X3226 N_B10 N_TOP sky130_fd_pr__cap_mim_m3_1 l=3 w=3
X3227 P_B11 P_TOP sky130_fd_pr__cap_mim_m3_1 l=3 w=3
X3228 P_B10 P_TOP sky130_fd_pr__cap_mim_m3_1 l=3 w=3
X3229 N_B8 N_TOP sky130_fd_pr__cap_mim_m3_1 l=3 w=3
X3230 N_EDGE_BIAS N_EDGE_BIAS sky130_fd_pr__cap_mim_m3_1 l=3 w=3
X3231 N_B11 N_TOP sky130_fd_pr__cap_mim_m3_1 l=3 w=3
X3232 P_B10 P_TOP sky130_fd_pr__cap_mim_m3_1 l=3 w=3
X3233 P_B10 P_TOP sky130_fd_pr__cap_mim_m3_1 l=3 w=3
X3234 N_B11 N_TOP sky130_fd_pr__cap_mim_m3_1 l=3 w=3
X3235 N_B7 N_TOP sky130_fd_pr__cap_mim_m3_1 l=3 w=3
X3236 N_B10 N_TOP sky130_fd_pr__cap_mim_m3_1 l=3 w=3
X3237 P_B10 P_TOP sky130_fd_pr__cap_mim_m3_1 l=3 w=3
X3238 N_B11 N_TOP sky130_fd_pr__cap_mim_m3_1 l=3 w=3
X3239 N_B11 N_TOP sky130_fd_pr__cap_mim_m3_1 l=3 w=3
X3240 N_B6 N_TOP sky130_fd_pr__cap_mim_m3_1 l=3 w=3
X3241 P_B10 P_TOP sky130_fd_pr__cap_mim_m3_1 l=3 w=3
X3242 N_B6 N_TOP sky130_fd_pr__cap_mim_m3_1 l=3 w=3
X3243 N_B11 N_TOP sky130_fd_pr__cap_mim_m3_1 l=3 w=3
X3244 P_B11 P_TOP sky130_fd_pr__cap_mim_m3_1 l=3 w=3
X3245 N_EDGE_BIAS N_EDGE_BIAS sky130_fd_pr__cap_mim_m3_1 l=3 w=3
X3246 N_B11 N_TOP sky130_fd_pr__cap_mim_m3_1 l=3 w=3
X3247 P_B11 P_TOP sky130_fd_pr__cap_mim_m3_1 l=3 w=3
X3248 P_B11 P_TOP sky130_fd_pr__cap_mim_m3_1 l=3 w=3
X3249 P_B10 P_TOP sky130_fd_pr__cap_mim_m3_1 l=3 w=3
X3250 N_EDGE_BIAS N_EDGE_BIAS sky130_fd_pr__cap_mim_m3_1 l=3 w=3
X3251 N_EDGE_BIAS N_EDGE_BIAS sky130_fd_pr__cap_mim_m3_1 l=3 w=3
X3252 P_B11 P_TOP sky130_fd_pr__cap_mim_m3_1 l=3 w=3
X3253 P_B8 P_TOP sky130_fd_pr__cap_mim_m3_1 l=3 w=3
X3254 P_B11 P_TOP sky130_fd_pr__cap_mim_m3_1 l=3 w=3
X3255 N_B11 N_TOP sky130_fd_pr__cap_mim_m3_1 l=3 w=3
X3256 N_B11 N_TOP sky130_fd_pr__cap_mim_m3_1 l=3 w=3
X3257 P_B11 P_TOP sky130_fd_pr__cap_mim_m3_1 l=3 w=3
X3258 P_B9 P_TOP sky130_fd_pr__cap_mim_m3_1 l=3 w=3
X3259 N_B11 N_TOP sky130_fd_pr__cap_mim_m3_1 l=3 w=3
X3260 P_B11 P_TOP sky130_fd_pr__cap_mim_m3_1 l=3 w=3
X3261 P_B9 P_TOP sky130_fd_pr__cap_mim_m3_1 l=3 w=3
X3262 P_B9 P_TOP sky130_fd_pr__cap_mim_m3_1 l=3 w=3
X3263 P_B11 P_TOP sky130_fd_pr__cap_mim_m3_1 l=3 w=3
X3264 P_B4 P_TOP sky130_fd_pr__cap_mim_m3_1 l=3 w=3
X3265 N_B11 N_TOP sky130_fd_pr__cap_mim_m3_1 l=3 w=3
X3266 P_B10 P_TOP sky130_fd_pr__cap_mim_m3_1 l=3 w=3
X3267 N_B11 N_TOP sky130_fd_pr__cap_mim_m3_1 l=3 w=3
X3268 N_B11 N_TOP sky130_fd_pr__cap_mim_m3_1 l=3 w=3
X3269 P_EDGE_BIAS P_EDGE_BIAS sky130_fd_pr__cap_mim_m3_1 l=3 w=3
X3270 P_B9 P_TOP sky130_fd_pr__cap_mim_m3_1 l=3 w=3
X3271 N_B11 N_TOP sky130_fd_pr__cap_mim_m3_1 l=3 w=3
X3272 P_B11 P_TOP sky130_fd_pr__cap_mim_m3_1 l=3 w=3
X3273 N_B11 N_TOP sky130_fd_pr__cap_mim_m3_1 l=3 w=3
X3274 P_B11 P_TOP sky130_fd_pr__cap_mim_m3_1 l=3 w=3
X3275 P_B10 P_TOP sky130_fd_pr__cap_mim_m3_1 l=3 w=3
X3276 P_B9 P_TOP sky130_fd_pr__cap_mim_m3_1 l=3 w=3
X3277 P_B11 P_TOP sky130_fd_pr__cap_mim_m3_1 l=3 w=3
X3278 P_B11 P_TOP sky130_fd_pr__cap_mim_m3_1 l=3 w=3
X3279 N_B7 N_TOP sky130_fd_pr__cap_mim_m3_1 l=3 w=3
X3280 P_B11 P_TOP sky130_fd_pr__cap_mim_m3_1 l=3 w=3
X3281 P_EDGE_BIAS P_EDGE_BIAS sky130_fd_pr__cap_mim_m3_1 l=3 w=3
X3282 N_B11 N_TOP sky130_fd_pr__cap_mim_m3_1 l=3 w=3
X3283 N_EDGE_BIAS N_EDGE_BIAS sky130_fd_pr__cap_mim_m3_1 l=3 w=3
X3284 N_B10 N_TOP sky130_fd_pr__cap_mim_m3_1 l=3 w=3
X3285 N_B11 N_TOP sky130_fd_pr__cap_mim_m3_1 l=3 w=3
X3286 P_B11 P_TOP sky130_fd_pr__cap_mim_m3_1 l=3 w=3
X3287 N_B8 N_TOP sky130_fd_pr__cap_mim_m3_1 l=3 w=3
X3288 P_B9 P_TOP sky130_fd_pr__cap_mim_m3_1 l=3 w=3
X3289 P_B10 P_TOP sky130_fd_pr__cap_mim_m3_1 l=3 w=3
X3290 N_B11 N_TOP sky130_fd_pr__cap_mim_m3_1 l=3 w=3
X3291 P_B11 P_TOP sky130_fd_pr__cap_mim_m3_1 l=3 w=3
X3292 P_B10 P_TOP sky130_fd_pr__cap_mim_m3_1 l=3 w=3
X3293 N_B10 N_TOP sky130_fd_pr__cap_mim_m3_1 l=3 w=3
X3294 P_B11 P_TOP sky130_fd_pr__cap_mim_m3_1 l=3 w=3
X3295 P_B9 P_TOP sky130_fd_pr__cap_mim_m3_1 l=3 w=3
X3296 N_B9 N_TOP sky130_fd_pr__cap_mim_m3_1 l=3 w=3
X3297 P_B10 P_TOP sky130_fd_pr__cap_mim_m3_1 l=3 w=3
X3298 N_B11 N_TOP sky130_fd_pr__cap_mim_m3_1 l=3 w=3
X3299 N_B10 N_TOP sky130_fd_pr__cap_mim_m3_1 l=3 w=3
X3300 N_B11 N_TOP sky130_fd_pr__cap_mim_m3_1 l=3 w=3
X3301 N_B11 N_TOP sky130_fd_pr__cap_mim_m3_1 l=3 w=3
X3302 N_B11 N_TOP sky130_fd_pr__cap_mim_m3_1 l=3 w=3
X3303 P_B10 P_TOP sky130_fd_pr__cap_mim_m3_1 l=3 w=3
X3304 N_B11 N_TOP sky130_fd_pr__cap_mim_m3_1 l=3 w=3
X3305 P_B11 P_TOP sky130_fd_pr__cap_mim_m3_1 l=3 w=3
X3306 N_B11 N_TOP sky130_fd_pr__cap_mim_m3_1 l=3 w=3
X3307 P_B10 P_TOP sky130_fd_pr__cap_mim_m3_1 l=3 w=3
X3308 P_B10 P_TOP sky130_fd_pr__cap_mim_m3_1 l=3 w=3
X3309 P_B8 P_TOP sky130_fd_pr__cap_mim_m3_1 l=3 w=3
X3310 N_B11 N_TOP sky130_fd_pr__cap_mim_m3_1 l=3 w=3
X3311 P_B11 P_TOP sky130_fd_pr__cap_mim_m3_1 l=3 w=3
X3312 N_B8 N_TOP sky130_fd_pr__cap_mim_m3_1 l=3 w=3
X3313 N_B10 N_TOP sky130_fd_pr__cap_mim_m3_1 l=3 w=3
X3314 N_B11 N_TOP sky130_fd_pr__cap_mim_m3_1 l=3 w=3
X3315 P_B10 P_TOP sky130_fd_pr__cap_mim_m3_1 l=3 w=3
X3316 N_B10 N_TOP sky130_fd_pr__cap_mim_m3_1 l=3 w=3
X3317 P_B11 P_TOP sky130_fd_pr__cap_mim_m3_1 l=3 w=3
X3318 P_B10 P_TOP sky130_fd_pr__cap_mim_m3_1 l=3 w=3
X3319 P_B11 P_TOP sky130_fd_pr__cap_mim_m3_1 l=3 w=3
X3320 P_B11 P_TOP sky130_fd_pr__cap_mim_m3_1 l=3 w=3
X3321 P_B10 P_TOP sky130_fd_pr__cap_mim_m3_1 l=3 w=3
X3322 N_B11 N_TOP sky130_fd_pr__cap_mim_m3_1 l=3 w=3
X3323 P_B10 P_TOP sky130_fd_pr__cap_mim_m3_1 l=3 w=3
X3324 N_B9 N_TOP sky130_fd_pr__cap_mim_m3_1 l=3 w=3
X3325 N_B11 N_TOP sky130_fd_pr__cap_mim_m3_1 l=3 w=3
X3326 N_B10 N_TOP sky130_fd_pr__cap_mim_m3_1 l=3 w=3
X3327 P_B10 P_TOP sky130_fd_pr__cap_mim_m3_1 l=3 w=3
X3328 N_B5 N_TOP sky130_fd_pr__cap_mim_m3_1 l=3 w=3
X3329 P_B6 P_TOP sky130_fd_pr__cap_mim_m3_1 l=3 w=3
X3330 N_EDGE_BIAS N_EDGE_BIAS sky130_fd_pr__cap_mim_m3_1 l=3 w=3
X3331 N_B11 N_TOP sky130_fd_pr__cap_mim_m3_1 l=3 w=3
X3332 P_B11 P_TOP sky130_fd_pr__cap_mim_m3_1 l=3 w=3
X3333 P_B11 P_TOP sky130_fd_pr__cap_mim_m3_1 l=3 w=3
X3334 N_B11 N_TOP sky130_fd_pr__cap_mim_m3_1 l=3 w=3
X3335 N_B10 N_TOP sky130_fd_pr__cap_mim_m3_1 l=3 w=3
X3336 P_B9 P_TOP sky130_fd_pr__cap_mim_m3_1 l=3 w=3
X3337 P_B11 P_TOP sky130_fd_pr__cap_mim_m3_1 l=3 w=3
X3338 N_B11 N_TOP sky130_fd_pr__cap_mim_m3_1 l=3 w=3
X3339 P_B7 P_TOP sky130_fd_pr__cap_mim_m3_1 l=3 w=3
X3340 N_B11 N_TOP sky130_fd_pr__cap_mim_m3_1 l=3 w=3
X3341 N_B11 N_TOP sky130_fd_pr__cap_mim_m3_1 l=3 w=3
X3342 P_B10 P_TOP sky130_fd_pr__cap_mim_m3_1 l=3 w=3
X3343 P_B11 P_TOP sky130_fd_pr__cap_mim_m3_1 l=3 w=3
X3344 P_B10 P_TOP sky130_fd_pr__cap_mim_m3_1 l=3 w=3
X3345 N_EDGE_BIAS N_EDGE_BIAS sky130_fd_pr__cap_mim_m3_1 l=3 w=3
X3346 P_EDGE_BIAS P_EDGE_BIAS sky130_fd_pr__cap_mim_m3_1 l=3 w=3
X3347 P_B11 P_TOP sky130_fd_pr__cap_mim_m3_1 l=3 w=3
X3348 P_B8 P_TOP sky130_fd_pr__cap_mim_m3_1 l=3 w=3
X3349 P_B11 P_TOP sky130_fd_pr__cap_mim_m3_1 l=3 w=3
X3350 P_B11 P_TOP sky130_fd_pr__cap_mim_m3_1 l=3 w=3
X3351 P_B5 P_TOP sky130_fd_pr__cap_mim_m3_1 l=3 w=3
X3352 P_B8 P_TOP sky130_fd_pr__cap_mim_m3_1 l=3 w=3
X3353 N_B11 N_TOP sky130_fd_pr__cap_mim_m3_1 l=3 w=3
X3354 N_B11 N_TOP sky130_fd_pr__cap_mim_m3_1 l=3 w=3
X3355 N_B11 N_TOP sky130_fd_pr__cap_mim_m3_1 l=3 w=3
X3356 P_B11 P_TOP sky130_fd_pr__cap_mim_m3_1 l=3 w=3
X3357 P_EDGE_BIAS P_EDGE_BIAS sky130_fd_pr__cap_mim_m3_1 l=3 w=3
X3358 P_B9 P_TOP sky130_fd_pr__cap_mim_m3_1 l=3 w=3
X3359 N_B11 N_TOP sky130_fd_pr__cap_mim_m3_1 l=3 w=3
X3360 N_B9 N_TOP sky130_fd_pr__cap_mim_m3_1 l=3 w=3
X3361 P_B9 P_TOP sky130_fd_pr__cap_mim_m3_1 l=3 w=3
X3362 P_B11 P_TOP sky130_fd_pr__cap_mim_m3_1 l=3 w=3
X3363 P_EDGE_BIAS P_EDGE_BIAS sky130_fd_pr__cap_mim_m3_1 l=3 w=3
X3364 N_B9 N_TOP sky130_fd_pr__cap_mim_m3_1 l=3 w=3
X3365 N_B11 N_TOP sky130_fd_pr__cap_mim_m3_1 l=3 w=3
X3366 N_B10 N_TOP sky130_fd_pr__cap_mim_m3_1 l=3 w=3
X3367 N_B11 N_TOP sky130_fd_pr__cap_mim_m3_1 l=3 w=3
X3368 N_B11 N_TOP sky130_fd_pr__cap_mim_m3_1 l=3 w=3
X3369 P_B11 P_TOP sky130_fd_pr__cap_mim_m3_1 l=3 w=3
X3370 N_B9 N_TOP sky130_fd_pr__cap_mim_m3_1 l=3 w=3
X3371 P_B9 P_TOP sky130_fd_pr__cap_mim_m3_1 l=3 w=3
X3372 N_B11 N_TOP sky130_fd_pr__cap_mim_m3_1 l=3 w=3
X3373 N_B9 N_TOP sky130_fd_pr__cap_mim_m3_1 l=3 w=3
X3374 P_B11 P_TOP sky130_fd_pr__cap_mim_m3_1 l=3 w=3
X3375 N_B11 N_TOP sky130_fd_pr__cap_mim_m3_1 l=3 w=3
X3376 N_B10 N_TOP sky130_fd_pr__cap_mim_m3_1 l=3 w=3
X3377 P_B10 P_TOP sky130_fd_pr__cap_mim_m3_1 l=3 w=3
X3378 P_B11 P_TOP sky130_fd_pr__cap_mim_m3_1 l=3 w=3
X3379 P_B11 P_TOP sky130_fd_pr__cap_mim_m3_1 l=3 w=3
X3380 N_B10 N_TOP sky130_fd_pr__cap_mim_m3_1 l=3 w=3
X3381 N_B11 N_TOP sky130_fd_pr__cap_mim_m3_1 l=3 w=3
X3382 P_EDGE_BIAS P_EDGE_BIAS sky130_fd_pr__cap_mim_m3_1 l=3 w=3
X3383 N_B11 N_TOP sky130_fd_pr__cap_mim_m3_1 l=3 w=3
X3384 P_B11 P_TOP sky130_fd_pr__cap_mim_m3_1 l=3 w=3
X3385 N_B10 N_TOP sky130_fd_pr__cap_mim_m3_1 l=3 w=3
X3386 P_B10 P_TOP sky130_fd_pr__cap_mim_m3_1 l=3 w=3
X3387 N_EDGE_BIAS N_EDGE_BIAS sky130_fd_pr__cap_mim_m3_1 l=3 w=3
X3388 P_B11 P_TOP sky130_fd_pr__cap_mim_m3_1 l=3 w=3
X3389 N_B11 N_TOP sky130_fd_pr__cap_mim_m3_1 l=3 w=3
X3390 P_B11 P_TOP sky130_fd_pr__cap_mim_m3_1 l=3 w=3
X3391 P_B10 P_TOP sky130_fd_pr__cap_mim_m3_1 l=3 w=3
X3392 P_B11 P_TOP sky130_fd_pr__cap_mim_m3_1 l=3 w=3
X3393 N_B10 N_TOP sky130_fd_pr__cap_mim_m3_1 l=3 w=3
X3394 P_B7 P_TOP sky130_fd_pr__cap_mim_m3_1 l=3 w=3
X3395 P_B11 P_TOP sky130_fd_pr__cap_mim_m3_1 l=3 w=3
X3396 P_B9 P_TOP sky130_fd_pr__cap_mim_m3_1 l=3 w=3
X3397 N_B11 N_TOP sky130_fd_pr__cap_mim_m3_1 l=3 w=3
X3398 P_B11 P_TOP sky130_fd_pr__cap_mim_m3_1 l=3 w=3
X3399 P_B11 P_TOP sky130_fd_pr__cap_mim_m3_1 l=3 w=3
X3400 P_B8 P_TOP sky130_fd_pr__cap_mim_m3_1 l=3 w=3
X3401 P_B10 P_TOP sky130_fd_pr__cap_mim_m3_1 l=3 w=3
X3402 N_B10 N_TOP sky130_fd_pr__cap_mim_m3_1 l=3 w=3
X3403 P_B11 P_TOP sky130_fd_pr__cap_mim_m3_1 l=3 w=3
X3404 N_B11 N_TOP sky130_fd_pr__cap_mim_m3_1 l=3 w=3
X3405 P_EDGE_BIAS P_EDGE_BIAS sky130_fd_pr__cap_mim_m3_1 l=3 w=3
X3406 P_B10 P_TOP sky130_fd_pr__cap_mim_m3_1 l=3 w=3
X3407 N_B11 N_TOP sky130_fd_pr__cap_mim_m3_1 l=3 w=3
X3408 P_B11 P_TOP sky130_fd_pr__cap_mim_m3_1 l=3 w=3
X3409 P_B11 P_TOP sky130_fd_pr__cap_mim_m3_1 l=3 w=3
X3410 P_EDGE_BIAS P_EDGE_BIAS sky130_fd_pr__cap_mim_m3_1 l=3 w=3
X3411 P_B8 P_TOP sky130_fd_pr__cap_mim_m3_1 l=3 w=3
X3412 N_B11 N_TOP sky130_fd_pr__cap_mim_m3_1 l=3 w=3
X3413 P_B10 P_TOP sky130_fd_pr__cap_mim_m3_1 l=3 w=3
X3414 N_B11 N_TOP sky130_fd_pr__cap_mim_m3_1 l=3 w=3
X3415 N_B8 N_TOP sky130_fd_pr__cap_mim_m3_1 l=3 w=3
X3416 P_B11 P_TOP sky130_fd_pr__cap_mim_m3_1 l=3 w=3
X3417 N_B11 N_TOP sky130_fd_pr__cap_mim_m3_1 l=3 w=3
X3418 N_B10 N_TOP sky130_fd_pr__cap_mim_m3_1 l=3 w=3
X3419 P_B10 P_TOP sky130_fd_pr__cap_mim_m3_1 l=3 w=3
X3420 N_B10 N_TOP sky130_fd_pr__cap_mim_m3_1 l=3 w=3
X3421 P_EDGE_BIAS P_EDGE_BIAS sky130_fd_pr__cap_mim_m3_1 l=3 w=3
X3422 N_B11 N_TOP sky130_fd_pr__cap_mim_m3_1 l=3 w=3
X3423 P_B11 P_TOP sky130_fd_pr__cap_mim_m3_1 l=3 w=3
X3424 P_B10 P_TOP sky130_fd_pr__cap_mim_m3_1 l=3 w=3
X3425 N_B11 N_TOP sky130_fd_pr__cap_mim_m3_1 l=3 w=3
X3426 N_B9 N_TOP sky130_fd_pr__cap_mim_m3_1 l=3 w=3
X3427 N_B10 N_TOP sky130_fd_pr__cap_mim_m3_1 l=3 w=3
X3428 N_B9 N_TOP sky130_fd_pr__cap_mim_m3_1 l=3 w=3
X3429 P_B10 P_TOP sky130_fd_pr__cap_mim_m3_1 l=3 w=3
X3430 P_B11 P_TOP sky130_fd_pr__cap_mim_m3_1 l=3 w=3
X3431 N_B10 N_TOP sky130_fd_pr__cap_mim_m3_1 l=3 w=3
X3432 N_B11 N_TOP sky130_fd_pr__cap_mim_m3_1 l=3 w=3
X3433 N_EDGE_BIAS N_EDGE_BIAS sky130_fd_pr__cap_mim_m3_1 l=3 w=3
X3434 P_B11 P_TOP sky130_fd_pr__cap_mim_m3_1 l=3 w=3
X3435 N_B6 N_TOP sky130_fd_pr__cap_mim_m3_1 l=3 w=3
X3436 N_EDGE_BIAS N_EDGE_BIAS sky130_fd_pr__cap_mim_m3_1 l=3 w=3
X3437 N_B10 N_TOP sky130_fd_pr__cap_mim_m3_1 l=3 w=3
X3438 N_EDGE_BIAS N_EDGE_BIAS sky130_fd_pr__cap_mim_m3_1 l=3 w=3
X3439 N_B11 N_TOP sky130_fd_pr__cap_mim_m3_1 l=3 w=3
X3440 N_B9 N_TOP sky130_fd_pr__cap_mim_m3_1 l=3 w=3
X3441 P_B9 P_TOP sky130_fd_pr__cap_mim_m3_1 l=3 w=3
X3442 P_B11 P_TOP sky130_fd_pr__cap_mim_m3_1 l=3 w=3
X3443 P_B11 P_TOP sky130_fd_pr__cap_mim_m3_1 l=3 w=3
X3444 N_B11 N_TOP sky130_fd_pr__cap_mim_m3_1 l=3 w=3
X3445 P_B8 P_TOP sky130_fd_pr__cap_mim_m3_1 l=3 w=3
X3446 N_EDGE_BIAS N_EDGE_BIAS sky130_fd_pr__cap_mim_m3_1 l=3 w=3
X3447 P_B11 P_TOP sky130_fd_pr__cap_mim_m3_1 l=3 w=3
X3448 N_EDGE_BIAS N_EDGE_BIAS sky130_fd_pr__cap_mim_m3_1 l=3 w=3
X3449 P_B8 P_TOP sky130_fd_pr__cap_mim_m3_1 l=3 w=3
X3450 P_B11 P_TOP sky130_fd_pr__cap_mim_m3_1 l=3 w=3
X3451 P_B10 P_TOP sky130_fd_pr__cap_mim_m3_1 l=3 w=3
X3452 P_B6 P_TOP sky130_fd_pr__cap_mim_m3_1 l=3 w=3
X3453 P_B11 P_TOP sky130_fd_pr__cap_mim_m3_1 l=3 w=3
X3454 P_B9 P_TOP sky130_fd_pr__cap_mim_m3_1 l=3 w=3
X3455 P_B11 P_TOP sky130_fd_pr__cap_mim_m3_1 l=3 w=3
X3456 P_B11 P_TOP sky130_fd_pr__cap_mim_m3_1 l=3 w=3
X3457 P_B9 P_TOP sky130_fd_pr__cap_mim_m3_1 l=3 w=3
X3458 N_B9 N_TOP sky130_fd_pr__cap_mim_m3_1 l=3 w=3
X3459 N_B10 N_TOP sky130_fd_pr__cap_mim_m3_1 l=3 w=3
X3460 N_B11 N_TOP sky130_fd_pr__cap_mim_m3_1 l=3 w=3
X3461 P_B11 P_TOP sky130_fd_pr__cap_mim_m3_1 l=3 w=3
X3462 P_EDGE_BIAS P_EDGE_BIAS sky130_fd_pr__cap_mim_m3_1 l=3 w=3
X3463 P_B10 P_TOP sky130_fd_pr__cap_mim_m3_1 l=3 w=3
X3464 N_B11 N_TOP sky130_fd_pr__cap_mim_m3_1 l=3 w=3
X3465 N_B10 N_TOP sky130_fd_pr__cap_mim_m3_1 l=3 w=3
X3466 P_B9 P_TOP sky130_fd_pr__cap_mim_m3_1 l=3 w=3
X3467 P_B11 P_TOP sky130_fd_pr__cap_mim_m3_1 l=3 w=3
X3468 N_B11 N_TOP sky130_fd_pr__cap_mim_m3_1 l=3 w=3
X3469 P_B11 P_TOP sky130_fd_pr__cap_mim_m3_1 l=3 w=3
X3470 P_B10 P_TOP sky130_fd_pr__cap_mim_m3_1 l=3 w=3
X3471 P_B9 P_TOP sky130_fd_pr__cap_mim_m3_1 l=3 w=3
X3472 N_B9 N_TOP sky130_fd_pr__cap_mim_m3_1 l=3 w=3
X3473 P_B11 P_TOP sky130_fd_pr__cap_mim_m3_1 l=3 w=3
X3474 N_B10 N_TOP sky130_fd_pr__cap_mim_m3_1 l=3 w=3
X3475 P_EDGE_BIAS P_EDGE_BIAS sky130_fd_pr__cap_mim_m3_1 l=3 w=3
X3476 P_B11 P_TOP sky130_fd_pr__cap_mim_m3_1 l=3 w=3
X3477 N_B9 N_TOP sky130_fd_pr__cap_mim_m3_1 l=3 w=3
X3478 N_B10 N_TOP sky130_fd_pr__cap_mim_m3_1 l=3 w=3
X3479 N_B11 N_TOP sky130_fd_pr__cap_mim_m3_1 l=3 w=3
X3480 N_B8 N_TOP sky130_fd_pr__cap_mim_m3_1 l=3 w=3
X3481 P_B11 P_TOP sky130_fd_pr__cap_mim_m3_1 l=3 w=3
X3482 P_B11 P_TOP sky130_fd_pr__cap_mim_m3_1 l=3 w=3
X3483 N_B11 N_TOP sky130_fd_pr__cap_mim_m3_1 l=3 w=3
X3484 N_B10 N_TOP sky130_fd_pr__cap_mim_m3_1 l=3 w=3
X3485 N_B10 N_TOP sky130_fd_pr__cap_mim_m3_1 l=3 w=3
X3486 P_B10 P_TOP sky130_fd_pr__cap_mim_m3_1 l=3 w=3
X3487 P_B11 P_TOP sky130_fd_pr__cap_mim_m3_1 l=3 w=3
X3488 P_B11 P_TOP sky130_fd_pr__cap_mim_m3_1 l=3 w=3
X3489 N_B11 N_TOP sky130_fd_pr__cap_mim_m3_1 l=3 w=3
X3490 P_B10 P_TOP sky130_fd_pr__cap_mim_m3_1 l=3 w=3
X3491 P_B11 P_TOP sky130_fd_pr__cap_mim_m3_1 l=3 w=3
X3492 P_B8 P_TOP sky130_fd_pr__cap_mim_m3_1 l=3 w=3
X3493 P_B10 P_TOP sky130_fd_pr__cap_mim_m3_1 l=3 w=3
X3494 N_B11 N_TOP sky130_fd_pr__cap_mim_m3_1 l=3 w=3
X3495 P_B10 P_TOP sky130_fd_pr__cap_mim_m3_1 l=3 w=3
X3496 N_B11 N_TOP sky130_fd_pr__cap_mim_m3_1 l=3 w=3
X3497 P_B11 P_TOP sky130_fd_pr__cap_mim_m3_1 l=3 w=3
X3498 P_B11 P_TOP sky130_fd_pr__cap_mim_m3_1 l=3 w=3
X3499 N_B9 N_TOP sky130_fd_pr__cap_mim_m3_1 l=3 w=3
X3500 N_B11 N_TOP sky130_fd_pr__cap_mim_m3_1 l=3 w=3
X3501 N_B11 N_TOP sky130_fd_pr__cap_mim_m3_1 l=3 w=3
X3502 P_B11 P_TOP sky130_fd_pr__cap_mim_m3_1 l=3 w=3
X3503 P_B8 P_TOP sky130_fd_pr__cap_mim_m3_1 l=3 w=3
X3504 N_B10 N_TOP sky130_fd_pr__cap_mim_m3_1 l=3 w=3
X3505 P_B10 P_TOP sky130_fd_pr__cap_mim_m3_1 l=3 w=3
X3506 N_B11 N_TOP sky130_fd_pr__cap_mim_m3_1 l=3 w=3
X3507 N_B11 N_TOP sky130_fd_pr__cap_mim_m3_1 l=3 w=3
X3508 P_B10 P_TOP sky130_fd_pr__cap_mim_m3_1 l=3 w=3
X3509 N_B11 N_TOP sky130_fd_pr__cap_mim_m3_1 l=3 w=3
X3510 P_B11 P_TOP sky130_fd_pr__cap_mim_m3_1 l=3 w=3
X3511 P_B10 P_TOP sky130_fd_pr__cap_mim_m3_1 l=3 w=3
X3512 N_B8 N_TOP sky130_fd_pr__cap_mim_m3_1 l=3 w=3
X3513 N_B11 N_TOP sky130_fd_pr__cap_mim_m3_1 l=3 w=3
X3514 P_B10 P_TOP sky130_fd_pr__cap_mim_m3_1 l=3 w=3
X3515 N_EDGE_BIAS N_EDGE_BIAS sky130_fd_pr__cap_mim_m3_1 l=3 w=3
X3516 N_B11 N_TOP sky130_fd_pr__cap_mim_m3_1 l=3 w=3
X3517 N_B9 N_TOP sky130_fd_pr__cap_mim_m3_1 l=3 w=3
X3518 N_B10 N_TOP sky130_fd_pr__cap_mim_m3_1 l=3 w=3
X3519 P_B10 P_TOP sky130_fd_pr__cap_mim_m3_1 l=3 w=3
X3520 P_B6 P_TOP sky130_fd_pr__cap_mim_m3_1 l=3 w=3
X3521 N_B11 N_TOP sky130_fd_pr__cap_mim_m3_1 l=3 w=3
X3522 P_B11 P_TOP sky130_fd_pr__cap_mim_m3_1 l=3 w=3
X3523 N_B6 N_TOP sky130_fd_pr__cap_mim_m3_1 l=3 w=3
X3524 N_B11 N_TOP sky130_fd_pr__cap_mim_m3_1 l=3 w=3
X3525 P_B11 P_TOP sky130_fd_pr__cap_mim_m3_1 l=3 w=3
X3526 P_B10 P_TOP sky130_fd_pr__cap_mim_m3_1 l=3 w=3
X3527 P_B11 P_TOP sky130_fd_pr__cap_mim_m3_1 l=3 w=3
X3528 N_B11 N_TOP sky130_fd_pr__cap_mim_m3_1 l=3 w=3
X3529 N_B9 N_TOP sky130_fd_pr__cap_mim_m3_1 l=3 w=3
X3530 P_B11 P_TOP sky130_fd_pr__cap_mim_m3_1 l=3 w=3
X3531 P_B11 P_TOP sky130_fd_pr__cap_mim_m3_1 l=3 w=3
X3532 N_B11 N_TOP sky130_fd_pr__cap_mim_m3_1 l=3 w=3
X3533 P_B11 P_TOP sky130_fd_pr__cap_mim_m3_1 l=3 w=3
X3534 P_B10 P_TOP sky130_fd_pr__cap_mim_m3_1 l=3 w=3
X3535 N_B11 N_TOP sky130_fd_pr__cap_mim_m3_1 l=3 w=3
X3536 N_EDGE_BIAS N_EDGE_BIAS sky130_fd_pr__cap_mim_m3_1 l=3 w=3
X3537 P_B11 P_TOP sky130_fd_pr__cap_mim_m3_1 l=3 w=3
X3538 N_EDGE_BIAS N_EDGE_BIAS sky130_fd_pr__cap_mim_m3_1 l=3 w=3
X3539 P_B8 P_TOP sky130_fd_pr__cap_mim_m3_1 l=3 w=3
X3540 P_B11 P_TOP sky130_fd_pr__cap_mim_m3_1 l=3 w=3
X3541 N_B11 N_TOP sky130_fd_pr__cap_mim_m3_1 l=3 w=3
X3542 N_B11 N_TOP sky130_fd_pr__cap_mim_m3_1 l=3 w=3
X3543 P_B10 P_TOP sky130_fd_pr__cap_mim_m3_1 l=3 w=3
X3544 P_B6 P_TOP sky130_fd_pr__cap_mim_m3_1 l=3 w=3
X3545 P_B11 P_TOP sky130_fd_pr__cap_mim_m3_1 l=3 w=3
X3546 P_B9 P_TOP sky130_fd_pr__cap_mim_m3_1 l=3 w=3
X3547 P_B10 P_TOP sky130_fd_pr__cap_mim_m3_1 l=3 w=3
X3548 P_B9 P_TOP sky130_fd_pr__cap_mim_m3_1 l=3 w=3
X3549 P_B9 P_TOP sky130_fd_pr__cap_mim_m3_1 l=3 w=3
X3550 N_B10 N_TOP sky130_fd_pr__cap_mim_m3_1 l=3 w=3
X3551 N_B11 N_TOP sky130_fd_pr__cap_mim_m3_1 l=3 w=3
X3552 P_B3 P_TOP sky130_fd_pr__cap_mim_m3_1 l=3 w=3
X3553 N_B11 N_TOP sky130_fd_pr__cap_mim_m3_1 l=3 w=3
X3554 N_B11 N_TOP sky130_fd_pr__cap_mim_m3_1 l=3 w=3
X3555 P_B10 P_TOP sky130_fd_pr__cap_mim_m3_1 l=3 w=3
X3556 N_B11 N_TOP sky130_fd_pr__cap_mim_m3_1 l=3 w=3
X3557 P_B11 P_TOP sky130_fd_pr__cap_mim_m3_1 l=3 w=3
X3558 P_B9 P_TOP sky130_fd_pr__cap_mim_m3_1 l=3 w=3
X3559 P_B11 P_TOP sky130_fd_pr__cap_mim_m3_1 l=3 w=3
X3560 P_B11 P_TOP sky130_fd_pr__cap_mim_m3_1 l=3 w=3
X3561 P_B10 P_TOP sky130_fd_pr__cap_mim_m3_1 l=3 w=3
X3562 P_B9 P_TOP sky130_fd_pr__cap_mim_m3_1 l=3 w=3
X3563 N_B11 N_TOP sky130_fd_pr__cap_mim_m3_1 l=3 w=3
X3564 P_B11 P_TOP sky130_fd_pr__cap_mim_m3_1 l=3 w=3
X3565 N_EDGE_BIAS N_EDGE_BIAS sky130_fd_pr__cap_mim_m3_1 l=3 w=3
X3566 N_B10 N_TOP sky130_fd_pr__cap_mim_m3_1 l=3 w=3
X3567 P_EDGE_BIAS P_EDGE_BIAS sky130_fd_pr__cap_mim_m3_1 l=3 w=3
X3568 P_B10 P_TOP sky130_fd_pr__cap_mim_m3_1 l=3 w=3
X3569 N_B9 N_TOP sky130_fd_pr__cap_mim_m3_1 l=3 w=3
X3570 N_B10 N_TOP sky130_fd_pr__cap_mim_m3_1 l=3 w=3
X3571 N_B11 N_TOP sky130_fd_pr__cap_mim_m3_1 l=3 w=3
X3572 N_B11 N_TOP sky130_fd_pr__cap_mim_m3_1 l=3 w=3
X3573 P_B11 P_TOP sky130_fd_pr__cap_mim_m3_1 l=3 w=3
X3574 P_B11 P_TOP sky130_fd_pr__cap_mim_m3_1 l=3 w=3
X3575 N_EDGE_BIAS N_EDGE_BIAS sky130_fd_pr__cap_mim_m3_1 l=3 w=3
X3576 P_B9 P_TOP sky130_fd_pr__cap_mim_m3_1 l=3 w=3
X3577 P_B10 P_TOP sky130_fd_pr__cap_mim_m3_1 l=3 w=3
X3578 N_B10 N_TOP sky130_fd_pr__cap_mim_m3_1 l=3 w=3
X3579 P_B11 P_TOP sky130_fd_pr__cap_mim_m3_1 l=3 w=3
X3580 P_B10 P_TOP sky130_fd_pr__cap_mim_m3_1 l=3 w=3
X3581 N_B10 N_TOP sky130_fd_pr__cap_mim_m3_1 l=3 w=3
X3582 P_B9 P_TOP sky130_fd_pr__cap_mim_m3_1 l=3 w=3
X3583 P_B11 P_TOP sky130_fd_pr__cap_mim_m3_1 l=3 w=3
X3584 P_B11 P_TOP sky130_fd_pr__cap_mim_m3_1 l=3 w=3
X3585 N_B10 N_TOP sky130_fd_pr__cap_mim_m3_1 l=3 w=3
X3586 P_EDGE_BIAS P_EDGE_BIAS sky130_fd_pr__cap_mim_m3_1 l=3 w=3
X3587 P_B10 P_TOP sky130_fd_pr__cap_mim_m3_1 l=3 w=3
X3588 N_B11 N_TOP sky130_fd_pr__cap_mim_m3_1 l=3 w=3
X3589 N_B10 N_TOP sky130_fd_pr__cap_mim_m3_1 l=3 w=3
X3590 N_B11 N_TOP sky130_fd_pr__cap_mim_m3_1 l=3 w=3
X3591 P_B11 P_TOP sky130_fd_pr__cap_mim_m3_1 l=3 w=3
X3592 P_B8 P_TOP sky130_fd_pr__cap_mim_m3_1 l=3 w=3
X3593 P_B10 P_TOP sky130_fd_pr__cap_mim_m3_1 l=3 w=3
X3594 P_B9 P_TOP sky130_fd_pr__cap_mim_m3_1 l=3 w=3
X3595 P_B11 P_TOP sky130_fd_pr__cap_mim_m3_1 l=3 w=3
X3596 N_B9 N_TOP sky130_fd_pr__cap_mim_m3_1 l=3 w=3
X3597 N_B11 N_TOP sky130_fd_pr__cap_mim_m3_1 l=3 w=3
X3598 P_B10 P_TOP sky130_fd_pr__cap_mim_m3_1 l=3 w=3
X3599 P_EDGE_BIAS P_EDGE_BIAS sky130_fd_pr__cap_mim_m3_1 l=3 w=3
X3600 P_B10 P_TOP sky130_fd_pr__cap_mim_m3_1 l=3 w=3
X3601 N_B11 N_TOP sky130_fd_pr__cap_mim_m3_1 l=3 w=3
X3602 N_B11 N_TOP sky130_fd_pr__cap_mim_m3_1 l=3 w=3
X3603 P_B11 P_TOP sky130_fd_pr__cap_mim_m3_1 l=3 w=3
X3604 N_B8 N_TOP sky130_fd_pr__cap_mim_m3_1 l=3 w=3
X3605 P_B11 P_TOP sky130_fd_pr__cap_mim_m3_1 l=3 w=3
X3606 P_B8 P_TOP sky130_fd_pr__cap_mim_m3_1 l=3 w=3
X3607 N_B11 N_TOP sky130_fd_pr__cap_mim_m3_1 l=3 w=3
X3608 P_B10 P_TOP sky130_fd_pr__cap_mim_m3_1 l=3 w=3
X3609 P_B11 P_TOP sky130_fd_pr__cap_mim_m3_1 l=3 w=3
X3610 P_B10 P_TOP sky130_fd_pr__cap_mim_m3_1 l=3 w=3
X3611 N_B8 N_TOP sky130_fd_pr__cap_mim_m3_1 l=3 w=3
X3612 N_B11 N_TOP sky130_fd_pr__cap_mim_m3_1 l=3 w=3
X3613 P_B10 P_TOP sky130_fd_pr__cap_mim_m3_1 l=3 w=3
X3614 N_B11 N_TOP sky130_fd_pr__cap_mim_m3_1 l=3 w=3
X3615 N_B9 N_TOP sky130_fd_pr__cap_mim_m3_1 l=3 w=3
X3616 P_B9 P_TOP sky130_fd_pr__cap_mim_m3_1 l=3 w=3
X3617 N_B11 N_TOP sky130_fd_pr__cap_mim_m3_1 l=3 w=3
X3618 N_B11 N_TOP sky130_fd_pr__cap_mim_m3_1 l=3 w=3
X3619 N_EDGE_BIAS N_EDGE_BIAS sky130_fd_pr__cap_mim_m3_1 l=3 w=3
X3620 N_B9 N_TOP sky130_fd_pr__cap_mim_m3_1 l=3 w=3
X3621 P_B11 P_TOP sky130_fd_pr__cap_mim_m3_1 l=3 w=3
X3622 N_B10 N_TOP sky130_fd_pr__cap_mim_m3_1 l=3 w=3
X3623 P_B10 P_TOP sky130_fd_pr__cap_mim_m3_1 l=3 w=3
X3624 N_B6 N_TOP sky130_fd_pr__cap_mim_m3_1 l=3 w=3
X3625 P_B6 P_TOP sky130_fd_pr__cap_mim_m3_1 l=3 w=3
X3626 P_EDGE_BIAS P_EDGE_BIAS sky130_fd_pr__cap_mim_m3_1 l=3 w=3
X3627 N_B10 N_TOP sky130_fd_pr__cap_mim_m3_1 l=3 w=3
X3628 N_B11 N_TOP sky130_fd_pr__cap_mim_m3_1 l=3 w=3
X3629 N_B11 N_TOP sky130_fd_pr__cap_mim_m3_1 l=3 w=3
X3630 N_B9 N_TOP sky130_fd_pr__cap_mim_m3_1 l=3 w=3
X3631 N_B11 N_TOP sky130_fd_pr__cap_mim_m3_1 l=3 w=3
X3632 N_B10 N_TOP sky130_fd_pr__cap_mim_m3_1 l=3 w=3
X3633 P_B9 P_TOP sky130_fd_pr__cap_mim_m3_1 l=3 w=3
X3634 P_B11 P_TOP sky130_fd_pr__cap_mim_m3_1 l=3 w=3
X3635 N_B11 N_TOP sky130_fd_pr__cap_mim_m3_1 l=3 w=3
X3636 P_B7 P_TOP sky130_fd_pr__cap_mim_m3_1 l=3 w=3
X3637 N_B11 N_TOP sky130_fd_pr__cap_mim_m3_1 l=3 w=3
X3638 N_EDGE_BIAS N_EDGE_BIAS sky130_fd_pr__cap_mim_m3_1 l=3 w=3
X3639 P_B10 P_TOP sky130_fd_pr__cap_mim_m3_1 l=3 w=3
X3640 N_EDGE_BIAS N_EDGE_BIAS sky130_fd_pr__cap_mim_m3_1 l=3 w=3
X3641 P_EDGE_BIAS P_EDGE_BIAS sky130_fd_pr__cap_mim_m3_1 l=3 w=3
X3642 P_B8 P_TOP sky130_fd_pr__cap_mim_m3_1 l=3 w=3
X3643 P_EDGE_BIAS P_EDGE_BIAS sky130_fd_pr__cap_mim_m3_1 l=3 w=3
X3644 P_B11 P_TOP sky130_fd_pr__cap_mim_m3_1 l=3 w=3
X3645 P_B6 P_TOP sky130_fd_pr__cap_mim_m3_1 l=3 w=3
X3646 N_B11 N_TOP sky130_fd_pr__cap_mim_m3_1 l=3 w=3
X3647 N_B11 N_TOP sky130_fd_pr__cap_mim_m3_1 l=3 w=3
X3648 P_B10 P_TOP sky130_fd_pr__cap_mim_m3_1 l=3 w=3
X3649 P_B11 P_TOP sky130_fd_pr__cap_mim_m3_1 l=3 w=3
X3650 P_EDGE_BIAS P_EDGE_BIAS sky130_fd_pr__cap_mim_m3_1 l=3 w=3
X3651 P_B10 P_TOP sky130_fd_pr__cap_mim_m3_1 l=3 w=3
X3652 N_B11 N_TOP sky130_fd_pr__cap_mim_m3_1 l=3 w=3
X3653 P_B11 P_TOP sky130_fd_pr__cap_mim_m3_1 l=3 w=3
X3654 N_B11 N_TOP sky130_fd_pr__cap_mim_m3_1 l=3 w=3
X3655 N_B11 N_TOP sky130_fd_pr__cap_mim_m3_1 l=3 w=3
X3656 N_B10 N_TOP sky130_fd_pr__cap_mim_m3_1 l=3 w=3
X3657 P_B10 P_TOP sky130_fd_pr__cap_mim_m3_1 l=3 w=3
X3658 N_B11 N_TOP sky130_fd_pr__cap_mim_m3_1 l=3 w=3
X3659 P_B11 P_TOP sky130_fd_pr__cap_mim_m3_1 l=3 w=3
X3660 P_B9 P_TOP sky130_fd_pr__cap_mim_m3_1 l=3 w=3
X3661 P_B11 P_TOP sky130_fd_pr__cap_mim_m3_1 l=3 w=3
X3662 N_B11 N_TOP sky130_fd_pr__cap_mim_m3_1 l=3 w=3
X3663 P_B10 P_TOP sky130_fd_pr__cap_mim_m3_1 l=3 w=3
X3664 P_B11 P_TOP sky130_fd_pr__cap_mim_m3_1 l=3 w=3
X3665 N_B10 N_TOP sky130_fd_pr__cap_mim_m3_1 l=3 w=3
X3666 N_B10 N_TOP sky130_fd_pr__cap_mim_m3_1 l=3 w=3
X3667 N_B11 N_TOP sky130_fd_pr__cap_mim_m3_1 l=3 w=3
X3668 P_B10 P_TOP sky130_fd_pr__cap_mim_m3_1 l=3 w=3
X3669 N_B11 N_TOP sky130_fd_pr__cap_mim_m3_1 l=3 w=3
X3670 N_B11 N_TOP sky130_fd_pr__cap_mim_m3_1 l=3 w=3
X3671 P_B11 P_TOP sky130_fd_pr__cap_mim_m3_1 l=3 w=3
X3672 P_B11 P_TOP sky130_fd_pr__cap_mim_m3_1 l=3 w=3
X3673 N_B10 N_TOP sky130_fd_pr__cap_mim_m3_1 l=3 w=3
X3674 P_B10 P_TOP sky130_fd_pr__cap_mim_m3_1 l=3 w=3
X3675 P_B11 P_TOP sky130_fd_pr__cap_mim_m3_1 l=3 w=3
X3676 N_B8 N_TOP sky130_fd_pr__cap_mim_m3_1 l=3 w=3
X3677 P_B11 P_TOP sky130_fd_pr__cap_mim_m3_1 l=3 w=3
X3678 N_B10 N_TOP sky130_fd_pr__cap_mim_m3_1 l=3 w=3
X3679 P_B11 P_TOP sky130_fd_pr__cap_mim_m3_1 l=3 w=3
X3680 N_B11 N_TOP sky130_fd_pr__cap_mim_m3_1 l=3 w=3
X3681 P_B11 P_TOP sky130_fd_pr__cap_mim_m3_1 l=3 w=3
X3682 N_B10 N_TOP sky130_fd_pr__cap_mim_m3_1 l=3 w=3
X3683 P_B7 P_TOP sky130_fd_pr__cap_mim_m3_1 l=3 w=3
X3684 N_B11 N_TOP sky130_fd_pr__cap_mim_m3_1 l=3 w=3
X3685 N_B11 N_TOP sky130_fd_pr__cap_mim_m3_1 l=3 w=3
X3686 N_B10 N_TOP sky130_fd_pr__cap_mim_m3_1 l=3 w=3
X3687 P_B11 P_TOP sky130_fd_pr__cap_mim_m3_1 l=3 w=3
X3688 P_B9 P_TOP sky130_fd_pr__cap_mim_m3_1 l=3 w=3
X3689 P_B9 P_TOP sky130_fd_pr__cap_mim_m3_1 l=3 w=3
X3690 P_B11 P_TOP sky130_fd_pr__cap_mim_m3_1 l=3 w=3
X3691 N_B11 N_TOP sky130_fd_pr__cap_mim_m3_1 l=3 w=3
X3692 N_B11 N_TOP sky130_fd_pr__cap_mim_m3_1 l=3 w=3
X3693 N_B11 N_TOP sky130_fd_pr__cap_mim_m3_1 l=3 w=3
X3694 P_EDGE_BIAS P_EDGE_BIAS sky130_fd_pr__cap_mim_m3_1 l=3 w=3
X3695 P_B11 P_TOP sky130_fd_pr__cap_mim_m3_1 l=3 w=3
X3696 P_B8 P_TOP sky130_fd_pr__cap_mim_m3_1 l=3 w=3
X3697 P_B10 P_TOP sky130_fd_pr__cap_mim_m3_1 l=3 w=3
X3698 N_B10 N_TOP sky130_fd_pr__cap_mim_m3_1 l=3 w=3
X3699 P_B11 P_TOP sky130_fd_pr__cap_mim_m3_1 l=3 w=3
X3700 N_B11 N_TOP sky130_fd_pr__cap_mim_m3_1 l=3 w=3
X3701 P_EDGE_BIAS P_EDGE_BIAS sky130_fd_pr__cap_mim_m3_1 l=3 w=3
X3702 P_B9 P_TOP sky130_fd_pr__cap_mim_m3_1 l=3 w=3
X3703 N_B11 N_TOP sky130_fd_pr__cap_mim_m3_1 l=3 w=3
X3704 N_B11 N_TOP sky130_fd_pr__cap_mim_m3_1 l=3 w=3
X3705 P_B8 P_TOP sky130_fd_pr__cap_mim_m3_1 l=3 w=3
X3706 P_B10 P_TOP sky130_fd_pr__cap_mim_m3_1 l=3 w=3
X3707 N_B11 N_TOP sky130_fd_pr__cap_mim_m3_1 l=3 w=3
X3708 N_B11 N_TOP sky130_fd_pr__cap_mim_m3_1 l=3 w=3
X3709 P_B11 P_TOP sky130_fd_pr__cap_mim_m3_1 l=3 w=3
X3710 P_B10 P_TOP sky130_fd_pr__cap_mim_m3_1 l=3 w=3
X3711 P_B11 P_TOP sky130_fd_pr__cap_mim_m3_1 l=3 w=3
X3712 P_B11 P_TOP sky130_fd_pr__cap_mim_m3_1 l=3 w=3
X3713 N_B11 N_TOP sky130_fd_pr__cap_mim_m3_1 l=3 w=3
X3714 N_B8 N_TOP sky130_fd_pr__cap_mim_m3_1 l=3 w=3
X3715 P_B10 P_TOP sky130_fd_pr__cap_mim_m3_1 l=3 w=3
X3716 P_B11 P_TOP sky130_fd_pr__cap_mim_m3_1 l=3 w=3
X3717 N_B11 N_TOP sky130_fd_pr__cap_mim_m3_1 l=3 w=3
X3718 N_B9 N_TOP sky130_fd_pr__cap_mim_m3_1 l=3 w=3
X3719 P_B11 P_TOP sky130_fd_pr__cap_mim_m3_1 l=3 w=3
X3720 N_B9 N_TOP sky130_fd_pr__cap_mim_m3_1 l=3 w=3
X3721 P_B10 P_TOP sky130_fd_pr__cap_mim_m3_1 l=3 w=3
X3722 P_B11 P_TOP sky130_fd_pr__cap_mim_m3_1 l=3 w=3
X3723 N_B11 N_TOP sky130_fd_pr__cap_mim_m3_1 l=3 w=3
X3724 P_B11 P_TOP sky130_fd_pr__cap_mim_m3_1 l=3 w=3
X3725 N_B6 N_TOP sky130_fd_pr__cap_mim_m3_1 l=3 w=3
X3726 P_B5 P_TOP sky130_fd_pr__cap_mim_m3_1 l=3 w=3
X3727 P_B11 P_TOP sky130_fd_pr__cap_mim_m3_1 l=3 w=3
X3728 N_B10 N_TOP sky130_fd_pr__cap_mim_m3_1 l=3 w=3
X3729 N_B11 N_TOP sky130_fd_pr__cap_mim_m3_1 l=3 w=3
X3730 N_B9 N_TOP sky130_fd_pr__cap_mim_m3_1 l=3 w=3
X3731 P_B11 P_TOP sky130_fd_pr__cap_mim_m3_1 l=3 w=3
X3732 P_B11 P_TOP sky130_fd_pr__cap_mim_m3_1 l=3 w=3
X3733 N_B11 N_TOP sky130_fd_pr__cap_mim_m3_1 l=3 w=3
X3734 N_B11 N_TOP sky130_fd_pr__cap_mim_m3_1 l=3 w=3
X3735 N_B10 N_TOP sky130_fd_pr__cap_mim_m3_1 l=3 w=3
X3736 P_B11 P_TOP sky130_fd_pr__cap_mim_m3_1 l=3 w=3
X3737 P_B10 P_TOP sky130_fd_pr__cap_mim_m3_1 l=3 w=3
X3738 N_EDGE_BIAS N_EDGE_BIAS sky130_fd_pr__cap_mim_m3_1 l=3 w=3
X3739 P_B8 P_TOP sky130_fd_pr__cap_mim_m3_1 l=3 w=3
X3740 P_B11 P_TOP sky130_fd_pr__cap_mim_m3_1 l=3 w=3
X3741 P_B11 P_TOP sky130_fd_pr__cap_mim_m3_1 l=3 w=3
X3742 P_B10 P_TOP sky130_fd_pr__cap_mim_m3_1 l=3 w=3
X3743 P_B6 P_TOP sky130_fd_pr__cap_mim_m3_1 l=3 w=3
X3744 N_B11 N_TOP sky130_fd_pr__cap_mim_m3_1 l=3 w=3
X3745 P_EDGE_BIAS P_EDGE_BIAS sky130_fd_pr__cap_mim_m3_1 l=3 w=3
X3746 P_B9 P_TOP sky130_fd_pr__cap_mim_m3_1 l=3 w=3
X3747 P_B10 P_TOP sky130_fd_pr__cap_mim_m3_1 l=3 w=3
X3748 N_B10 N_TOP sky130_fd_pr__cap_mim_m3_1 l=3 w=3
X3749 N_B11 N_TOP sky130_fd_pr__cap_mim_m3_1 l=3 w=3
X3750 P_B11 P_TOP sky130_fd_pr__cap_mim_m3_1 l=3 w=3
X3751 N_B11 N_TOP sky130_fd_pr__cap_mim_m3_1 l=3 w=3
X3752 N_B10 N_TOP sky130_fd_pr__cap_mim_m3_1 l=3 w=3
X3753 P_B10 P_TOP sky130_fd_pr__cap_mim_m3_1 l=3 w=3
X3754 N_B11 N_TOP sky130_fd_pr__cap_mim_m3_1 l=3 w=3
X3755 P_B11 P_TOP sky130_fd_pr__cap_mim_m3_1 l=3 w=3
X3756 P_B10 P_TOP sky130_fd_pr__cap_mim_m3_1 l=3 w=3
X3757 P_B9 P_TOP sky130_fd_pr__cap_mim_m3_1 l=3 w=3
X3758 N_EDGE_BIAS N_EDGE_BIAS sky130_fd_pr__cap_mim_m3_1 l=3 w=3
X3759 N_B11 N_TOP sky130_fd_pr__cap_mim_m3_1 l=3 w=3
X3760 P_B10 P_TOP sky130_fd_pr__cap_mim_m3_1 l=3 w=3
X3761 N_B10 N_TOP sky130_fd_pr__cap_mim_m3_1 l=3 w=3
X3762 N_B11 N_TOP sky130_fd_pr__cap_mim_m3_1 l=3 w=3
X3763 P_B11 P_TOP sky130_fd_pr__cap_mim_m3_1 l=3 w=3
X3764 N_B11 N_TOP sky130_fd_pr__cap_mim_m3_1 l=3 w=3
X3765 N_B10 N_TOP sky130_fd_pr__cap_mim_m3_1 l=3 w=3
X3766 P_B11 P_TOP sky130_fd_pr__cap_mim_m3_1 l=3 w=3
X3767 N_B11 N_TOP sky130_fd_pr__cap_mim_m3_1 l=3 w=3
X3768 N_B10 N_TOP sky130_fd_pr__cap_mim_m3_1 l=3 w=3
X3769 P_EDGE_BIAS P_EDGE_BIAS sky130_fd_pr__cap_mim_m3_1 l=3 w=3
X3770 P_B10 P_TOP sky130_fd_pr__cap_mim_m3_1 l=3 w=3
X3771 N_B8 N_TOP sky130_fd_pr__cap_mim_m3_1 l=3 w=3
X3772 N_B10 N_TOP sky130_fd_pr__cap_mim_m3_1 l=3 w=3
X3773 P_B11 P_TOP sky130_fd_pr__cap_mim_m3_1 l=3 w=3
X3774 P_B11 P_TOP sky130_fd_pr__cap_mim_m3_1 l=3 w=3
X3775 N_B10 N_TOP sky130_fd_pr__cap_mim_m3_1 l=3 w=3
X3776 N_B10 N_TOP sky130_fd_pr__cap_mim_m3_1 l=3 w=3
X3777 P_B10 P_TOP sky130_fd_pr__cap_mim_m3_1 l=3 w=3
X3778 N_B7 N_TOP sky130_fd_pr__cap_mim_m3_1 l=3 w=3
X3779 P_B11 P_TOP sky130_fd_pr__cap_mim_m3_1 l=3 w=3
X3780 P_B9 P_TOP sky130_fd_pr__cap_mim_m3_1 l=3 w=3
X3781 P_B9 P_TOP sky130_fd_pr__cap_mim_m3_1 l=3 w=3
X3782 N_B11 N_TOP sky130_fd_pr__cap_mim_m3_1 l=3 w=3
X3783 P_B10 P_TOP sky130_fd_pr__cap_mim_m3_1 l=3 w=3
X3784 P_B8 P_TOP sky130_fd_pr__cap_mim_m3_1 l=3 w=3
X3785 N_B11 N_TOP sky130_fd_pr__cap_mim_m3_1 l=3 w=3
X3786 P_B11 P_TOP sky130_fd_pr__cap_mim_m3_1 l=3 w=3
X3787 N_B9 N_TOP sky130_fd_pr__cap_mim_m3_1 l=3 w=3
X3788 P_B11 P_TOP sky130_fd_pr__cap_mim_m3_1 l=3 w=3
X3789 P_B9 P_TOP sky130_fd_pr__cap_mim_m3_1 l=3 w=3
X3790 N_B11 N_TOP sky130_fd_pr__cap_mim_m3_1 l=3 w=3
X3791 N_B11 N_TOP sky130_fd_pr__cap_mim_m3_1 l=3 w=3
X3792 N_B7 N_TOP sky130_fd_pr__cap_mim_m3_1 l=3 w=3
X3793 P_B11 P_TOP sky130_fd_pr__cap_mim_m3_1 l=3 w=3
X3794 P_B8 P_TOP sky130_fd_pr__cap_mim_m3_1 l=3 w=3
X3795 P_B10 P_TOP sky130_fd_pr__cap_mim_m3_1 l=3 w=3
X3796 N_B11 N_TOP sky130_fd_pr__cap_mim_m3_1 l=3 w=3
X3797 P_B11 P_TOP sky130_fd_pr__cap_mim_m3_1 l=3 w=3
X3798 P_B11 P_TOP sky130_fd_pr__cap_mim_m3_1 l=3 w=3
X3799 P_B10 P_TOP sky130_fd_pr__cap_mim_m3_1 l=3 w=3
X3800 N_B8 N_TOP sky130_fd_pr__cap_mim_m3_1 l=3 w=3
X3801 P_B8 P_TOP sky130_fd_pr__cap_mim_m3_1 l=3 w=3
X3802 N_EDGE_BIAS N_EDGE_BIAS sky130_fd_pr__cap_mim_m3_1 l=3 w=3
X3803 P_B11 P_TOP sky130_fd_pr__cap_mim_m3_1 l=3 w=3
X3804 N_B5 N_TOP sky130_fd_pr__cap_mim_m3_1 l=3 w=3
X3805 P_B9 P_TOP sky130_fd_pr__cap_mim_m3_1 l=3 w=3
X3806 N_B11 N_TOP sky130_fd_pr__cap_mim_m3_1 l=3 w=3
X3807 N_B11 N_TOP sky130_fd_pr__cap_mim_m3_1 l=3 w=3
X3808 P_B11 P_TOP sky130_fd_pr__cap_mim_m3_1 l=3 w=3
X3809 N_B11 N_TOP sky130_fd_pr__cap_mim_m3_1 l=3 w=3
X3810 N_B9 N_TOP sky130_fd_pr__cap_mim_m3_1 l=3 w=3
X3811 N_B10 N_TOP sky130_fd_pr__cap_mim_m3_1 l=3 w=3
X3812 P_B10 P_TOP sky130_fd_pr__cap_mim_m3_1 l=3 w=3
X3813 P_B6 P_TOP sky130_fd_pr__cap_mim_m3_1 l=3 w=3
X3814 N_B11 N_TOP sky130_fd_pr__cap_mim_m3_1 l=3 w=3
X3815 P_B11 P_TOP sky130_fd_pr__cap_mim_m3_1 l=3 w=3
X3816 P_B4 P_TOP sky130_fd_pr__cap_mim_m3_1 l=3 w=3
X3817 P_B11 P_TOP sky130_fd_pr__cap_mim_m3_1 l=3 w=3
X3818 P_EDGE_BIAS P_EDGE_BIAS sky130_fd_pr__cap_mim_m3_1 l=3 w=3
X3819 P_B10 P_TOP sky130_fd_pr__cap_mim_m3_1 l=3 w=3
X3820 N_B11 N_TOP sky130_fd_pr__cap_mim_m3_1 l=3 w=3
X3821 N_B9 N_TOP sky130_fd_pr__cap_mim_m3_1 l=3 w=3
X3822 P_B11 P_TOP sky130_fd_pr__cap_mim_m3_1 l=3 w=3
X3823 N_B11 N_TOP sky130_fd_pr__cap_mim_m3_1 l=3 w=3
X3824 P_B11 P_TOP sky130_fd_pr__cap_mim_m3_1 l=3 w=3
X3825 N_B11 N_TOP sky130_fd_pr__cap_mim_m3_1 l=3 w=3
X3826 P_B10 P_TOP sky130_fd_pr__cap_mim_m3_1 l=3 w=3
X3827 P_EDGE_BIAS P_EDGE_BIAS sky130_fd_pr__cap_mim_m3_1 l=3 w=3
X3828 N_EDGE_BIAS N_EDGE_BIAS sky130_fd_pr__cap_mim_m3_1 l=3 w=3
X3829 N_B11 N_TOP sky130_fd_pr__cap_mim_m3_1 l=3 w=3
X3830 P_B11 P_TOP sky130_fd_pr__cap_mim_m3_1 l=3 w=3
X3831 P_B10 P_TOP sky130_fd_pr__cap_mim_m3_1 l=3 w=3
X3832 P_B11 P_TOP sky130_fd_pr__cap_mim_m3_1 l=3 w=3
X3833 P_EDGE_BIAS P_EDGE_BIAS sky130_fd_pr__cap_mim_m3_1 l=3 w=3
X3834 N_B11 N_TOP sky130_fd_pr__cap_mim_m3_1 l=3 w=3
X3835 N_B11 N_TOP sky130_fd_pr__cap_mim_m3_1 l=3 w=3
X3836 P_B10 P_TOP sky130_fd_pr__cap_mim_m3_1 l=3 w=3
X3837 N_B11 N_TOP sky130_fd_pr__cap_mim_m3_1 l=3 w=3
X3838 N_B11 N_TOP sky130_fd_pr__cap_mim_m3_1 l=3 w=3
X3839 P_B9 P_TOP sky130_fd_pr__cap_mim_m3_1 l=3 w=3
X3840 P_B10 P_TOP sky130_fd_pr__cap_mim_m3_1 l=3 w=3
X3841 N_B11 N_TOP sky130_fd_pr__cap_mim_m3_1 l=3 w=3
X3842 P_B11 P_TOP sky130_fd_pr__cap_mim_m3_1 l=3 w=3
X3843 P_B10 P_TOP sky130_fd_pr__cap_mim_m3_1 l=3 w=3
X3844 N_B11 N_TOP sky130_fd_pr__cap_mim_m3_1 l=3 w=3
X3845 N_B7 N_TOP sky130_fd_pr__cap_mim_m3_1 l=3 w=3
X3846 N_B11 N_TOP sky130_fd_pr__cap_mim_m3_1 l=3 w=3
X3847 P_B10 P_TOP sky130_fd_pr__cap_mim_m3_1 l=3 w=3
X3848 N_B11 N_TOP sky130_fd_pr__cap_mim_m3_1 l=3 w=3
X3849 P_B9 P_TOP sky130_fd_pr__cap_mim_m3_1 l=3 w=3
X3850 P_B11 P_TOP sky130_fd_pr__cap_mim_m3_1 l=3 w=3
X3851 P_B10 P_TOP sky130_fd_pr__cap_mim_m3_1 l=3 w=3
X3852 N_EDGE_BIAS N_EDGE_BIAS sky130_fd_pr__cap_mim_m3_1 l=3 w=3
X3853 N_B11 N_TOP sky130_fd_pr__cap_mim_m3_1 l=3 w=3
X3854 N_B8 N_TOP sky130_fd_pr__cap_mim_m3_1 l=3 w=3
X3855 N_B11 N_TOP sky130_fd_pr__cap_mim_m3_1 l=3 w=3
X3856 P_B10 P_TOP sky130_fd_pr__cap_mim_m3_1 l=3 w=3
X3857 N_B11 N_TOP sky130_fd_pr__cap_mim_m3_1 l=3 w=3
X3858 N_B10 N_TOP sky130_fd_pr__cap_mim_m3_1 l=3 w=3
X3859 P_B11 P_TOP sky130_fd_pr__cap_mim_m3_1 l=3 w=3
X3860 P_EDGE_BIAS P_EDGE_BIAS sky130_fd_pr__cap_mim_m3_1 l=3 w=3
X3861 P_B10 P_TOP sky130_fd_pr__cap_mim_m3_1 l=3 w=3
X3862 N_B11 N_TOP sky130_fd_pr__cap_mim_m3_1 l=3 w=3
X3863 P_B10 P_TOP sky130_fd_pr__cap_mim_m3_1 l=3 w=3
X3864 N_B8 N_TOP sky130_fd_pr__cap_mim_m3_1 l=3 w=3
X3865 P_B11 P_TOP sky130_fd_pr__cap_mim_m3_1 l=3 w=3
X3866 P_B11 P_TOP sky130_fd_pr__cap_mim_m3_1 l=3 w=3
X3867 P_B9 P_TOP sky130_fd_pr__cap_mim_m3_1 l=3 w=3
X3868 N_B10 N_TOP sky130_fd_pr__cap_mim_m3_1 l=3 w=3
X3869 N_B10 N_TOP sky130_fd_pr__cap_mim_m3_1 l=3 w=3
X3870 P_B11 P_TOP sky130_fd_pr__cap_mim_m3_1 l=3 w=3
X3871 P_B10 P_TOP sky130_fd_pr__cap_mim_m3_1 l=3 w=3
X3872 P_B9 P_TOP sky130_fd_pr__cap_mim_m3_1 l=3 w=3
X3873 P_B11 P_TOP sky130_fd_pr__cap_mim_m3_1 l=3 w=3
X3874 P_B11 P_TOP sky130_fd_pr__cap_mim_m3_1 l=3 w=3
X3875 N_B11 N_TOP sky130_fd_pr__cap_mim_m3_1 l=3 w=3
X3876 N_B10 N_TOP sky130_fd_pr__cap_mim_m3_1 l=3 w=3
X3877 P_B9 P_TOP sky130_fd_pr__cap_mim_m3_1 l=3 w=3
X3878 P_B8 P_TOP sky130_fd_pr__cap_mim_m3_1 l=3 w=3
X3879 P_B10 P_TOP sky130_fd_pr__cap_mim_m3_1 l=3 w=3
X3880 P_B11 P_TOP sky130_fd_pr__cap_mim_m3_1 l=3 w=3
X3881 N_B11 N_TOP sky130_fd_pr__cap_mim_m3_1 l=3 w=3
X3882 P_B10 P_TOP sky130_fd_pr__cap_mim_m3_1 l=3 w=3
X3883 P_B9 P_TOP sky130_fd_pr__cap_mim_m3_1 l=3 w=3
X3884 N_B11 N_TOP sky130_fd_pr__cap_mim_m3_1 l=3 w=3
X3885 P_B11 P_TOP sky130_fd_pr__cap_mim_m3_1 l=3 w=3
X3886 P_B10 P_TOP sky130_fd_pr__cap_mim_m3_1 l=3 w=3
X3887 P_B7 P_TOP sky130_fd_pr__cap_mim_m3_1 l=3 w=3
X3888 N_B11 N_TOP sky130_fd_pr__cap_mim_m3_1 l=3 w=3
X3889 N_B11 N_TOP sky130_fd_pr__cap_mim_m3_1 l=3 w=3
X3890 P_B10 P_TOP sky130_fd_pr__cap_mim_m3_1 l=3 w=3
X3891 P_B11 P_TOP sky130_fd_pr__cap_mim_m3_1 l=3 w=3
X3892 P_B11 P_TOP sky130_fd_pr__cap_mim_m3_1 l=3 w=3
X3893 P_B8 P_TOP sky130_fd_pr__cap_mim_m3_1 l=3 w=3
X3894 P_B10 P_TOP sky130_fd_pr__cap_mim_m3_1 l=3 w=3
X3895 N_B11 N_TOP sky130_fd_pr__cap_mim_m3_1 l=3 w=3
X3896 P_B10 P_TOP sky130_fd_pr__cap_mim_m3_1 l=3 w=3
X3897 N_B11 N_TOP sky130_fd_pr__cap_mim_m3_1 l=3 w=3
X3898 P_B11 P_TOP sky130_fd_pr__cap_mim_m3_1 l=3 w=3
X3899 N_B8 N_TOP sky130_fd_pr__cap_mim_m3_1 l=3 w=3
X3900 N_B11 N_TOP sky130_fd_pr__cap_mim_m3_1 l=3 w=3
X3901 N_B10 N_TOP sky130_fd_pr__cap_mim_m3_1 l=3 w=3
X3902 P_B11 P_TOP sky130_fd_pr__cap_mim_m3_1 l=3 w=3
X3903 N_B9 N_TOP sky130_fd_pr__cap_mim_m3_1 l=3 w=3
X3904 P_B9 P_TOP sky130_fd_pr__cap_mim_m3_1 l=3 w=3
X3905 N_B11 N_TOP sky130_fd_pr__cap_mim_m3_1 l=3 w=3
X3906 N_B9 N_TOP sky130_fd_pr__cap_mim_m3_1 l=3 w=3
X3907 N_B11 N_TOP sky130_fd_pr__cap_mim_m3_1 l=3 w=3
X3908 P_B10 P_TOP sky130_fd_pr__cap_mim_m3_1 l=3 w=3
X3909 N_B9 N_TOP sky130_fd_pr__cap_mim_m3_1 l=3 w=3
X3910 N_B11 N_TOP sky130_fd_pr__cap_mim_m3_1 l=3 w=3
X3911 P_B11 P_TOP sky130_fd_pr__cap_mim_m3_1 l=3 w=3
X3912 P_B10 P_TOP sky130_fd_pr__cap_mim_m3_1 l=3 w=3
X3913 N_B6 N_TOP sky130_fd_pr__cap_mim_m3_1 l=3 w=3
X3914 P_B6 P_TOP sky130_fd_pr__cap_mim_m3_1 l=3 w=3
X3915 N_B10 N_TOP sky130_fd_pr__cap_mim_m3_1 l=3 w=3
X3916 P_B11 P_TOP sky130_fd_pr__cap_mim_m3_1 l=3 w=3
X3917 N_B10 N_TOP sky130_fd_pr__cap_mim_m3_1 l=3 w=3
X3918 N_B11 N_TOP sky130_fd_pr__cap_mim_m3_1 l=3 w=3
X3919 N_B9 N_TOP sky130_fd_pr__cap_mim_m3_1 l=3 w=3
X3920 N_B11 N_TOP sky130_fd_pr__cap_mim_m3_1 l=3 w=3
X3921 N_B11 N_TOP sky130_fd_pr__cap_mim_m3_1 l=3 w=3
X3922 N_B10 N_TOP sky130_fd_pr__cap_mim_m3_1 l=3 w=3
X3923 N_B9 N_TOP sky130_fd_pr__cap_mim_m3_1 l=3 w=3
X3924 P_B11 P_TOP sky130_fd_pr__cap_mim_m3_1 l=3 w=3
X3925 N_B11 N_TOP sky130_fd_pr__cap_mim_m3_1 l=3 w=3
X3926 P_B11 P_TOP sky130_fd_pr__cap_mim_m3_1 l=3 w=3
X3927 P_B11 P_TOP sky130_fd_pr__cap_mim_m3_1 l=3 w=3
X3928 P_B10 P_TOP sky130_fd_pr__cap_mim_m3_1 l=3 w=3
X3929 N_EDGE_BIAS N_EDGE_BIAS sky130_fd_pr__cap_mim_m3_1 l=3 w=3
X3930 P_EDGE_BIAS P_EDGE_BIAS sky130_fd_pr__cap_mim_m3_1 l=3 w=3
X3931 P_B11 P_TOP sky130_fd_pr__cap_mim_m3_1 l=3 w=3
X3932 P_B6 P_TOP sky130_fd_pr__cap_mim_m3_1 l=3 w=3
X3933 N_B11 N_TOP sky130_fd_pr__cap_mim_m3_1 l=3 w=3
X3934 P_B11 P_TOP sky130_fd_pr__cap_mim_m3_1 l=3 w=3
X3935 N_B11 N_TOP sky130_fd_pr__cap_mim_m3_1 l=3 w=3
X3936 P_B11 P_TOP sky130_fd_pr__cap_mim_m3_1 l=3 w=3
X3937 P_B10 P_TOP sky130_fd_pr__cap_mim_m3_1 l=3 w=3
X3938 N_B11 N_TOP sky130_fd_pr__cap_mim_m3_1 l=3 w=3
X3939 P_B7 P_TOP sky130_fd_pr__cap_mim_m3_1 l=3 w=3
X3940 P_B10 P_TOP sky130_fd_pr__cap_mim_m3_1 l=3 w=3
X3941 N_B11 N_TOP sky130_fd_pr__cap_mim_m3_1 l=3 w=3
X3942 N_B11 N_TOP sky130_fd_pr__cap_mim_m3_1 l=3 w=3
X3943 P_B11 P_TOP sky130_fd_pr__cap_mim_m3_1 l=3 w=3
X3944 P_B9 P_TOP sky130_fd_pr__cap_mim_m3_1 l=3 w=3
X3945 P_B11 P_TOP sky130_fd_pr__cap_mim_m3_1 l=3 w=3
X3946 P_B10 P_TOP sky130_fd_pr__cap_mim_m3_1 l=3 w=3
X3947 N_B10 N_TOP sky130_fd_pr__cap_mim_m3_1 l=3 w=3
X3948 P_B11 P_TOP sky130_fd_pr__cap_mim_m3_1 l=3 w=3
X3949 N_B10 N_TOP sky130_fd_pr__cap_mim_m3_1 l=3 w=3
X3950 P_B10 P_TOP sky130_fd_pr__cap_mim_m3_1 l=3 w=3
X3951 N_B11 N_TOP sky130_fd_pr__cap_mim_m3_1 l=3 w=3
X3952 P_EDGE_BIAS P_EDGE_BIAS sky130_fd_pr__cap_mim_m3_1 l=3 w=3
X3953 N_B11 N_TOP sky130_fd_pr__cap_mim_m3_1 l=3 w=3
X3954 P_B11 P_TOP sky130_fd_pr__cap_mim_m3_1 l=3 w=3
X3955 N_B10 N_TOP sky130_fd_pr__cap_mim_m3_1 l=3 w=3
X3956 P_B10 P_TOP sky130_fd_pr__cap_mim_m3_1 l=3 w=3
X3957 N_B8 N_TOP sky130_fd_pr__cap_mim_m3_1 l=3 w=3
X3958 N_B11 N_TOP sky130_fd_pr__cap_mim_m3_1 l=3 w=3
X3959 P_B11 P_TOP sky130_fd_pr__cap_mim_m3_1 l=3 w=3
X3960 N_B10 N_TOP sky130_fd_pr__cap_mim_m3_1 l=3 w=3
X3961 N_B10 N_TOP sky130_fd_pr__cap_mim_m3_1 l=3 w=3
X3962 N_B11 N_TOP sky130_fd_pr__cap_mim_m3_1 l=3 w=3
X3963 N_B10 N_TOP sky130_fd_pr__cap_mim_m3_1 l=3 w=3
X3964 N_EDGE_BIAS N_EDGE_BIAS sky130_fd_pr__cap_mim_m3_1 l=3 w=3
X3965 N_B10 N_TOP sky130_fd_pr__cap_mim_m3_1 l=3 w=3
X3966 P_B10 P_TOP sky130_fd_pr__cap_mim_m3_1 l=3 w=3
X3967 N_B11 N_TOP sky130_fd_pr__cap_mim_m3_1 l=3 w=3
X3968 N_B11 N_TOP sky130_fd_pr__cap_mim_m3_1 l=3 w=3
X3969 N_B11 N_TOP sky130_fd_pr__cap_mim_m3_1 l=3 w=3
X3970 N_EDGE_BIAS N_EDGE_BIAS sky130_fd_pr__cap_mim_m3_1 l=3 w=3
X3971 P_B9 P_TOP sky130_fd_pr__cap_mim_m3_1 l=3 w=3
X3972 P_B9 P_TOP sky130_fd_pr__cap_mim_m3_1 l=3 w=3
X3973 P_EDGE_BIAS P_EDGE_BIAS sky130_fd_pr__cap_mim_m3_1 l=3 w=3
X3974 N_B10 N_TOP sky130_fd_pr__cap_mim_m3_1 l=3 w=3
X3975 N_B4 N_TOP sky130_fd_pr__cap_mim_m3_1 l=3 w=3
X3976 P_B8 P_TOP sky130_fd_pr__cap_mim_m3_1 l=3 w=3
X3977 P_B10 P_TOP sky130_fd_pr__cap_mim_m3_1 l=3 w=3
X3978 P_B11 P_TOP sky130_fd_pr__cap_mim_m3_1 l=3 w=3
X3979 N_B10 N_TOP sky130_fd_pr__cap_mim_m3_1 l=3 w=3
X3980 P_B9 P_TOP sky130_fd_pr__cap_mim_m3_1 l=3 w=3
X3981 N_B11 N_TOP sky130_fd_pr__cap_mim_m3_1 l=3 w=3
X3982 N_EDGE_BIAS N_EDGE_BIAS sky130_fd_pr__cap_mim_m3_1 l=3 w=3
X3983 P_B8 P_TOP sky130_fd_pr__cap_mim_m3_1 l=3 w=3
X3984 P_B10 P_TOP sky130_fd_pr__cap_mim_m3_1 l=3 w=3
X3985 P_B11 P_TOP sky130_fd_pr__cap_mim_m3_1 l=3 w=3
X3986 P_B11 P_TOP sky130_fd_pr__cap_mim_m3_1 l=3 w=3
X3987 N_B11 N_TOP sky130_fd_pr__cap_mim_m3_1 l=3 w=3
X3988 P_B8 P_TOP sky130_fd_pr__cap_mim_m3_1 l=3 w=3
X3989 N_B10 N_TOP sky130_fd_pr__cap_mim_m3_1 l=3 w=3
X3990 P_B10 P_TOP sky130_fd_pr__cap_mim_m3_1 l=3 w=3
X3991 N_EDGE_BIAS N_EDGE_BIAS sky130_fd_pr__cap_mim_m3_1 l=3 w=3
X3992 P_B8 P_TOP sky130_fd_pr__cap_mim_m3_1 l=3 w=3
X3993 P_B11 P_TOP sky130_fd_pr__cap_mim_m3_1 l=3 w=3
X3994 N_B11 N_TOP sky130_fd_pr__cap_mim_m3_1 l=3 w=3
X3995 N_B11 N_TOP sky130_fd_pr__cap_mim_m3_1 l=3 w=3
X3996 P_B11 P_TOP sky130_fd_pr__cap_mim_m3_1 l=3 w=3
X3997 N_B11 N_TOP sky130_fd_pr__cap_mim_m3_1 l=3 w=3
X3998 N_B9 N_TOP sky130_fd_pr__cap_mim_m3_1 l=3 w=3
X3999 P_B9 P_TOP sky130_fd_pr__cap_mim_m3_1 l=3 w=3
X4000 P_B9 P_TOP sky130_fd_pr__cap_mim_m3_1 l=3 w=3
X4001 P_B11 P_TOP sky130_fd_pr__cap_mim_m3_1 l=3 w=3
X4002 N_B9 N_TOP sky130_fd_pr__cap_mim_m3_1 l=3 w=3
X4003 N_B10 N_TOP sky130_fd_pr__cap_mim_m3_1 l=3 w=3
X4004 P_B10 P_TOP sky130_fd_pr__cap_mim_m3_1 l=3 w=3
X4005 N_B9 N_TOP sky130_fd_pr__cap_mim_m3_1 l=3 w=3
X4006 P_B6 P_TOP sky130_fd_pr__cap_mim_m3_1 l=3 w=3
X4007 P_B11 P_TOP sky130_fd_pr__cap_mim_m3_1 l=3 w=3
X4008 N_B11 N_TOP sky130_fd_pr__cap_mim_m3_1 l=3 w=3
X4009 P_B11 P_TOP sky130_fd_pr__cap_mim_m3_1 l=3 w=3
X4010 P_B11 P_TOP sky130_fd_pr__cap_mim_m3_1 l=3 w=3
X4011 P_B5 P_TOP sky130_fd_pr__cap_mim_m3_1 l=3 w=3
X4012 N_B10 N_TOP sky130_fd_pr__cap_mim_m3_1 l=3 w=3
X4013 N_B11 N_TOP sky130_fd_pr__cap_mim_m3_1 l=3 w=3
X4014 N_B9 N_TOP sky130_fd_pr__cap_mim_m3_1 l=3 w=3
X4015 P_B9 P_TOP sky130_fd_pr__cap_mim_m3_1 l=3 w=3
X4016 N_B9 N_TOP sky130_fd_pr__cap_mim_m3_1 l=3 w=3
X4017 N_B11 N_TOP sky130_fd_pr__cap_mim_m3_1 l=3 w=3
X4018 N_B10 N_TOP sky130_fd_pr__cap_mim_m3_1 l=3 w=3
X4019 P_B11 P_TOP sky130_fd_pr__cap_mim_m3_1 l=3 w=3
X4020 N_B11 N_TOP sky130_fd_pr__cap_mim_m3_1 l=3 w=3
X4021 P_B11 P_TOP sky130_fd_pr__cap_mim_m3_1 l=3 w=3
X4022 P_B11 P_TOP sky130_fd_pr__cap_mim_m3_1 l=3 w=3
X4023 N_EDGE_BIAS N_EDGE_BIAS sky130_fd_pr__cap_mim_m3_1 l=3 w=3
X4024 N_B10 N_TOP sky130_fd_pr__cap_mim_m3_1 l=3 w=3
X4025 N_B11 N_TOP sky130_fd_pr__cap_mim_m3_1 l=3 w=3
X4026 P_B11 P_TOP sky130_fd_pr__cap_mim_m3_1 l=3 w=3
X4027 N_B11 N_TOP sky130_fd_pr__cap_mim_m3_1 l=3 w=3
X4028 N_EDGE_BIAS N_EDGE_BIAS sky130_fd_pr__cap_mim_m3_1 l=3 w=3
X4029 N_B10 N_TOP sky130_fd_pr__cap_mim_m3_1 l=3 w=3
X4030 P_B8 P_TOP sky130_fd_pr__cap_mim_m3_1 l=3 w=3
X4031 N_B11 N_TOP sky130_fd_pr__cap_mim_m3_1 l=3 w=3
X4032 P_B10 P_TOP sky130_fd_pr__cap_mim_m3_1 l=3 w=3
X4033 P_B6 P_TOP sky130_fd_pr__cap_mim_m3_1 l=3 w=3
X4034 P_B11 P_TOP sky130_fd_pr__cap_mim_m3_1 l=3 w=3
X4035 N_B11 N_TOP sky130_fd_pr__cap_mim_m3_1 l=3 w=3
X4036 N_B9 N_TOP sky130_fd_pr__cap_mim_m3_1 l=3 w=3
X4037 P_B9 P_TOP sky130_fd_pr__cap_mim_m3_1 l=3 w=3
X4038 P_B10 P_TOP sky130_fd_pr__cap_mim_m3_1 l=3 w=3
X4039 N_B11 N_TOP sky130_fd_pr__cap_mim_m3_1 l=3 w=3
X4040 P_B11 P_TOP sky130_fd_pr__cap_mim_m3_1 l=3 w=3
X4041 P_B10 P_TOP sky130_fd_pr__cap_mim_m3_1 l=3 w=3
X4042 P_B10 P_TOP sky130_fd_pr__cap_mim_m3_1 l=3 w=3
X4043 P_B11 P_TOP sky130_fd_pr__cap_mim_m3_1 l=3 w=3
X4044 P_B10 P_TOP sky130_fd_pr__cap_mim_m3_1 l=3 w=3
X4045 N_B9 N_TOP sky130_fd_pr__cap_mim_m3_1 l=3 w=3
X4046 P_B11 P_TOP sky130_fd_pr__cap_mim_m3_1 l=3 w=3
X4047 P_B10 P_TOP sky130_fd_pr__cap_mim_m3_1 l=3 w=3
X4048 N_B11 N_TOP sky130_fd_pr__cap_mim_m3_1 l=3 w=3
X4049 N_B10 N_TOP sky130_fd_pr__cap_mim_m3_1 l=3 w=3
X4050 N_B11 N_TOP sky130_fd_pr__cap_mim_m3_1 l=3 w=3
X4051 N_B11 N_TOP sky130_fd_pr__cap_mim_m3_1 l=3 w=3
X4052 P_B11 P_TOP sky130_fd_pr__cap_mim_m3_1 l=3 w=3
X4053 N_B10 N_TOP sky130_fd_pr__cap_mim_m3_1 l=3 w=3
X4054 P_B10 P_TOP sky130_fd_pr__cap_mim_m3_1 l=3 w=3
X4055 N_B9 N_TOP sky130_fd_pr__cap_mim_m3_1 l=3 w=3
X4056 N_B11 N_TOP sky130_fd_pr__cap_mim_m3_1 l=3 w=3
X4057 N_B11 N_TOP sky130_fd_pr__cap_mim_m3_1 l=3 w=3
X4058 P_B10 P_TOP sky130_fd_pr__cap_mim_m3_1 l=3 w=3
X4059 P_B11 P_TOP sky130_fd_pr__cap_mim_m3_1 l=3 w=3
X4060 N_B11 N_TOP sky130_fd_pr__cap_mim_m3_1 l=3 w=3
X4061 P_B10 P_TOP sky130_fd_pr__cap_mim_m3_1 l=3 w=3
X4062 N_B8 N_TOP sky130_fd_pr__cap_mim_m3_1 l=3 w=3
X4063 N_B10 N_TOP sky130_fd_pr__cap_mim_m3_1 l=3 w=3
X4064 N_B10 N_TOP sky130_fd_pr__cap_mim_m3_1 l=3 w=3
X4065 P_B10 P_TOP sky130_fd_pr__cap_mim_m3_1 l=3 w=3
X4066 N_B11 N_TOP sky130_fd_pr__cap_mim_m3_1 l=3 w=3
X4067 P_B11 P_TOP sky130_fd_pr__cap_mim_m3_1 l=3 w=3
X4068 N_B10 N_TOP sky130_fd_pr__cap_mim_m3_1 l=3 w=3
X4069 P_B10 P_TOP sky130_fd_pr__cap_mim_m3_1 l=3 w=3
X4070 P_B11 P_TOP sky130_fd_pr__cap_mim_m3_1 l=3 w=3
X4071 N_B7 N_TOP sky130_fd_pr__cap_mim_m3_1 l=3 w=3
X4072 P_B11 P_TOP sky130_fd_pr__cap_mim_m3_1 l=3 w=3
X4073 P_B11 P_TOP sky130_fd_pr__cap_mim_m3_1 l=3 w=3
X4074 P_B11 P_TOP sky130_fd_pr__cap_mim_m3_1 l=3 w=3
X4075 N_B10 N_TOP sky130_fd_pr__cap_mim_m3_1 l=3 w=3
X4076 P_B9 P_TOP sky130_fd_pr__cap_mim_m3_1 l=3 w=3
X4077 N_B11 N_TOP sky130_fd_pr__cap_mim_m3_1 l=3 w=3
X4078 N_B10 N_TOP sky130_fd_pr__cap_mim_m3_1 l=3 w=3
X4079 N_B5 N_TOP sky130_fd_pr__cap_mim_m3_1 l=3 w=3
X4080 P_B11 P_TOP sky130_fd_pr__cap_mim_m3_1 l=3 w=3
X4081 P_B10 P_TOP sky130_fd_pr__cap_mim_m3_1 l=3 w=3
X4082 N_B11 N_TOP sky130_fd_pr__cap_mim_m3_1 l=3 w=3
X4083 P_B11 P_TOP sky130_fd_pr__cap_mim_m3_1 l=3 w=3
X4084 P_B11 P_TOP sky130_fd_pr__cap_mim_m3_1 l=3 w=3
X4085 P_B9 P_TOP sky130_fd_pr__cap_mim_m3_1 l=3 w=3
X4086 N_B11 N_TOP sky130_fd_pr__cap_mim_m3_1 l=3 w=3
X4087 N_B11 N_TOP sky130_fd_pr__cap_mim_m3_1 l=3 w=3
X4088 P_B11 P_TOP sky130_fd_pr__cap_mim_m3_1 l=3 w=3
X4089 P_B11 P_TOP sky130_fd_pr__cap_mim_m3_1 l=3 w=3
X4090 P_B8 P_TOP sky130_fd_pr__cap_mim_m3_1 l=3 w=3
X4091 P_B10 P_TOP sky130_fd_pr__cap_mim_m3_1 l=3 w=3
X4092 N_B11 N_TOP sky130_fd_pr__cap_mim_m3_1 l=3 w=3
X4093 P_B11 P_TOP sky130_fd_pr__cap_mim_m3_1 l=3 w=3
X4094 P_B11 P_TOP sky130_fd_pr__cap_mim_m3_1 l=3 w=3
X4095 N_EDGE_BIAS N_EDGE_BIAS sky130_fd_pr__cap_mim_m3_1 l=3 w=3
X4096 N_B8 N_TOP sky130_fd_pr__cap_mim_m3_1 l=3 w=3
X4097 P_B11 P_TOP sky130_fd_pr__cap_mim_m3_1 l=3 w=3
X4098 P_B8 P_TOP sky130_fd_pr__cap_mim_m3_1 l=3 w=3
X4099 N_B11 N_TOP sky130_fd_pr__cap_mim_m3_1 l=3 w=3
X4100 N_B5 N_TOP sky130_fd_pr__cap_mim_m3_1 l=3 w=3
X4101 N_B11 N_TOP sky130_fd_pr__cap_mim_m3_1 l=3 w=3
X4102 P_B11 P_TOP sky130_fd_pr__cap_mim_m3_1 l=3 w=3
X4103 P_B9 P_TOP sky130_fd_pr__cap_mim_m3_1 l=3 w=3
X4104 N_B11 N_TOP sky130_fd_pr__cap_mim_m3_1 l=3 w=3
X4105 N_B11 N_TOP sky130_fd_pr__cap_mim_m3_1 l=3 w=3
X4106 P_B11 P_TOP sky130_fd_pr__cap_mim_m3_1 l=3 w=3
X4107 P_B11 P_TOP sky130_fd_pr__cap_mim_m3_1 l=3 w=3
X4108 P_B9 P_TOP sky130_fd_pr__cap_mim_m3_1 l=3 w=3
X4109 P_B9 P_TOP sky130_fd_pr__cap_mim_m3_1 l=3 w=3
X4110 P_B11 P_TOP sky130_fd_pr__cap_mim_m3_1 l=3 w=3
X4111 P_B10 P_TOP sky130_fd_pr__cap_mim_m3_1 l=3 w=3
X4112 P_B6 P_TOP sky130_fd_pr__cap_mim_m3_1 l=3 w=3
X4113 P_B11 P_TOP sky130_fd_pr__cap_mim_m3_1 l=3 w=3
X4114 P_B2 P_TOP sky130_fd_pr__cap_mim_m3_1 l=3 w=3
X4115 N_B11 N_TOP sky130_fd_pr__cap_mim_m3_1 l=3 w=3
X4116 P_B11 P_TOP sky130_fd_pr__cap_mim_m3_1 l=3 w=3
X4117 N_B9 N_TOP sky130_fd_pr__cap_mim_m3_1 l=3 w=3
X4118 P_B9 P_TOP sky130_fd_pr__cap_mim_m3_1 l=3 w=3
X4119 N_B10 N_TOP sky130_fd_pr__cap_mim_m3_1 l=3 w=3
X4120 N_EDGE_BIAS N_EDGE_BIAS sky130_fd_pr__cap_mim_m3_1 l=3 w=3
X4121 P_B11 P_TOP sky130_fd_pr__cap_mim_m3_1 l=3 w=3
X4122 N_B11 N_TOP sky130_fd_pr__cap_mim_m3_1 l=3 w=3
X4123 P_B11 P_TOP sky130_fd_pr__cap_mim_m3_1 l=3 w=3
X4124 N_B7 N_TOP sky130_fd_pr__cap_mim_m3_1 l=3 w=3
X4125 P_B9 P_TOP sky130_fd_pr__cap_mim_m3_1 l=3 w=3
X4126 N_EDGE_BIAS N_EDGE_BIAS sky130_fd_pr__cap_mim_m3_1 l=3 w=3
X4127 P_B10 P_TOP sky130_fd_pr__cap_mim_m3_1 l=3 w=3
X4128 N_B11 N_TOP sky130_fd_pr__cap_mim_m3_1 l=3 w=3
X4129 P_EDGE_BIAS P_EDGE_BIAS sky130_fd_pr__cap_mim_m3_1 l=3 w=3
X4130 P_B10 P_TOP sky130_fd_pr__cap_mim_m3_1 l=3 w=3
X4131 P_B11 P_TOP sky130_fd_pr__cap_mim_m3_1 l=3 w=3
X4132 N_B10 N_TOP sky130_fd_pr__cap_mim_m3_1 l=3 w=3
X4133 N_B11 N_TOP sky130_fd_pr__cap_mim_m3_1 l=3 w=3
X4134 P_B11 P_TOP sky130_fd_pr__cap_mim_m3_1 l=3 w=3
X4135 P_B9 P_TOP sky130_fd_pr__cap_mim_m3_1 l=3 w=3
X4136 N_B11 N_TOP sky130_fd_pr__cap_mim_m3_1 l=3 w=3
X4137 P_B10 P_TOP sky130_fd_pr__cap_mim_m3_1 l=3 w=3
X4138 P_B10 P_TOP sky130_fd_pr__cap_mim_m3_1 l=3 w=3
X4139 P_B10 P_TOP sky130_fd_pr__cap_mim_m3_1 l=3 w=3
X4140 N_B11 N_TOP sky130_fd_pr__cap_mim_m3_1 l=3 w=3
X4141 N_B10 N_TOP sky130_fd_pr__cap_mim_m3_1 l=3 w=3
X4142 P_B10 P_TOP sky130_fd_pr__cap_mim_m3_1 l=3 w=3
X4143 P_EDGE_BIAS P_EDGE_BIAS sky130_fd_pr__cap_mim_m3_1 l=3 w=3
X4144 N_B11 N_TOP sky130_fd_pr__cap_mim_m3_1 l=3 w=3
X4145 N_B9 N_TOP sky130_fd_pr__cap_mim_m3_1 l=3 w=3
X4146 P_B10 P_TOP sky130_fd_pr__cap_mim_m3_1 l=3 w=3
X4147 P_B10 P_TOP sky130_fd_pr__cap_mim_m3_1 l=3 w=3
X4148 N_B10 N_TOP sky130_fd_pr__cap_mim_m3_1 l=3 w=3
X4149 N_B11 N_TOP sky130_fd_pr__cap_mim_m3_1 l=3 w=3
X4150 N_B8 N_TOP sky130_fd_pr__cap_mim_m3_1 l=3 w=3
X4151 P_B11 P_TOP sky130_fd_pr__cap_mim_m3_1 l=3 w=3
X4152 N_B10 N_TOP sky130_fd_pr__cap_mim_m3_1 l=3 w=3
X4153 N_B11 N_TOP sky130_fd_pr__cap_mim_m3_1 l=3 w=3
X4154 P_B10 P_TOP sky130_fd_pr__cap_mim_m3_1 l=3 w=3
X4155 N_B11 N_TOP sky130_fd_pr__cap_mim_m3_1 l=3 w=3
X4156 P_B11 P_TOP sky130_fd_pr__cap_mim_m3_1 l=3 w=3
X4157 P_B10 P_TOP sky130_fd_pr__cap_mim_m3_1 l=3 w=3
X4158 P_B11 P_TOP sky130_fd_pr__cap_mim_m3_1 l=3 w=3
X4159 P_B10 P_TOP sky130_fd_pr__cap_mim_m3_1 l=3 w=3
X4160 N_B11 N_TOP sky130_fd_pr__cap_mim_m3_1 l=3 w=3
X4161 P_B10 P_TOP sky130_fd_pr__cap_mim_m3_1 l=3 w=3
X4162 N_B8 N_TOP sky130_fd_pr__cap_mim_m3_1 l=3 w=3
X4163 N_B10 N_TOP sky130_fd_pr__cap_mim_m3_1 l=3 w=3
X4164 P_B11 P_TOP sky130_fd_pr__cap_mim_m3_1 l=3 w=3
X4165 N_B11 N_TOP sky130_fd_pr__cap_mim_m3_1 l=3 w=3
X4166 N_B10 N_TOP sky130_fd_pr__cap_mim_m3_1 l=3 w=3
X4167 P_B10 P_TOP sky130_fd_pr__cap_mim_m3_1 l=3 w=3
X4168 P_EDGE_BIAS P_EDGE_BIAS sky130_fd_pr__cap_mim_m3_1 l=3 w=3
X4169 P_EDGE_BIAS P_EDGE_BIAS sky130_fd_pr__cap_mim_m3_1 l=3 w=3
X4170 N_B11 N_TOP sky130_fd_pr__cap_mim_m3_1 l=3 w=3
X4171 P_B11 P_TOP sky130_fd_pr__cap_mim_m3_1 l=3 w=3
X4172 N_B11 N_TOP sky130_fd_pr__cap_mim_m3_1 l=3 w=3
X4173 N_B10 N_TOP sky130_fd_pr__cap_mim_m3_1 l=3 w=3
X4174 P_B10 P_TOP sky130_fd_pr__cap_mim_m3_1 l=3 w=3
X4175 P_B9 P_TOP sky130_fd_pr__cap_mim_m3_1 l=3 w=3
X4176 P_B11 P_TOP sky130_fd_pr__cap_mim_m3_1 l=3 w=3
X4177 N_B11 N_TOP sky130_fd_pr__cap_mim_m3_1 l=3 w=3
X4178 N_B10 N_TOP sky130_fd_pr__cap_mim_m3_1 l=3 w=3
X4179 P_B10 P_TOP sky130_fd_pr__cap_mim_m3_1 l=3 w=3
X4180 N_B3 N_TOP sky130_fd_pr__cap_mim_m3_1 l=3 w=3
X4181 P_B8 P_TOP sky130_fd_pr__cap_mim_m3_1 l=3 w=3
X4182 N_B11 N_TOP sky130_fd_pr__cap_mim_m3_1 l=3 w=3
X4183 N_B11 N_TOP sky130_fd_pr__cap_mim_m3_1 l=3 w=3
X4184 P_B10 P_TOP sky130_fd_pr__cap_mim_m3_1 l=3 w=3
X4185 P_B11 P_TOP sky130_fd_pr__cap_mim_m3_1 l=3 w=3
X4186 N_EDGE_BIAS N_EDGE_BIAS sky130_fd_pr__cap_mim_m3_1 l=3 w=3
X4187 P_B9 P_TOP sky130_fd_pr__cap_mim_m3_1 l=3 w=3
X4188 P_B11 P_TOP sky130_fd_pr__cap_mim_m3_1 l=3 w=3
X4189 P_B7 P_TOP sky130_fd_pr__cap_mim_m3_1 l=3 w=3
X4190 P_B9 P_TOP sky130_fd_pr__cap_mim_m3_1 l=3 w=3
X4191 N_B11 N_TOP sky130_fd_pr__cap_mim_m3_1 l=3 w=3
X4192 N_B11 N_TOP sky130_fd_pr__cap_mim_m3_1 l=3 w=3
X4193 N_B11 N_TOP sky130_fd_pr__cap_mim_m3_1 l=3 w=3
X4194 N_B11 N_TOP sky130_fd_pr__cap_mim_m3_1 l=3 w=3
X4195 P_B10 P_TOP sky130_fd_pr__cap_mim_m3_1 l=3 w=3
X4196 N_B11 N_TOP sky130_fd_pr__cap_mim_m3_1 l=3 w=3
X4197 P_B11 P_TOP sky130_fd_pr__cap_mim_m3_1 l=3 w=3
X4198 P_EDGE_BIAS P_EDGE_BIAS sky130_fd_pr__cap_mim_m3_1 l=3 w=3
X4199 P_B8 P_TOP sky130_fd_pr__cap_mim_m3_1 l=3 w=3
X4200 N_B11 N_TOP sky130_fd_pr__cap_mim_m3_1 l=3 w=3
X4201 P_B11 P_TOP sky130_fd_pr__cap_mim_m3_1 l=3 w=3
X4202 N_B8 N_TOP sky130_fd_pr__cap_mim_m3_1 l=3 w=3
X4203 P_B2 P_TOP sky130_fd_pr__cap_mim_m3_1 l=3 w=3
X4204 P_B8 P_TOP sky130_fd_pr__cap_mim_m3_1 l=3 w=3
X4205 N_B11 N_TOP sky130_fd_pr__cap_mim_m3_1 l=3 w=3
X4206 P_B11 P_TOP sky130_fd_pr__cap_mim_m3_1 l=3 w=3
X4207 N_B10 N_TOP sky130_fd_pr__cap_mim_m3_1 l=3 w=3
X4208 N_B1 N_TOP sky130_fd_pr__cap_mim_m3_1 l=3 w=3
X4209 P_B11 P_TOP sky130_fd_pr__cap_mim_m3_1 l=3 w=3
X4210 N_B9 N_TOP sky130_fd_pr__cap_mim_m3_1 l=3 w=3
X4211 P_B9 P_TOP sky130_fd_pr__cap_mim_m3_1 l=3 w=3
X4212 N_B9 N_TOP sky130_fd_pr__cap_mim_m3_1 l=3 w=3
X4213 N_B11 N_TOP sky130_fd_pr__cap_mim_m3_1 l=3 w=3
X4214 P_B11 P_TOP sky130_fd_pr__cap_mim_m3_1 l=3 w=3
X4215 N_B11 N_TOP sky130_fd_pr__cap_mim_m3_1 l=3 w=3
X4216 N_B9 N_TOP sky130_fd_pr__cap_mim_m3_1 l=3 w=3
X4217 P_B9 P_TOP sky130_fd_pr__cap_mim_m3_1 l=3 w=3
X4218 P_B11 P_TOP sky130_fd_pr__cap_mim_m3_1 l=3 w=3
X4219 P_B10 P_TOP sky130_fd_pr__cap_mim_m3_1 l=3 w=3
X4220 P_B5 P_TOP sky130_fd_pr__cap_mim_m3_1 l=3 w=3
X4221 N_B11 N_TOP sky130_fd_pr__cap_mim_m3_1 l=3 w=3
X4222 P_B11 P_TOP sky130_fd_pr__cap_mim_m3_1 l=3 w=3
X4223 N_B10 N_TOP sky130_fd_pr__cap_mim_m3_1 l=3 w=3
X4224 N_B11 N_TOP sky130_fd_pr__cap_mim_m3_1 l=3 w=3
X4225 N_B9 N_TOP sky130_fd_pr__cap_mim_m3_1 l=3 w=3
X4226 P_B9 P_TOP sky130_fd_pr__cap_mim_m3_1 l=3 w=3
X4227 N_B11 N_TOP sky130_fd_pr__cap_mim_m3_1 l=3 w=3
X4228 N_B11 N_TOP sky130_fd_pr__cap_mim_m3_1 l=3 w=3
X4229 P_B11 P_TOP sky130_fd_pr__cap_mim_m3_1 l=3 w=3
X4230 P_B11 P_TOP sky130_fd_pr__cap_mim_m3_1 l=3 w=3
X4231 N_B10 N_TOP sky130_fd_pr__cap_mim_m3_1 l=3 w=3
X4232 N_EDGE_BIAS N_EDGE_BIAS sky130_fd_pr__cap_mim_m3_1 l=3 w=3
X4233 P_B11 P_TOP sky130_fd_pr__cap_mim_m3_1 l=3 w=3
X4234 P_B10 P_TOP sky130_fd_pr__cap_mim_m3_1 l=3 w=3
X4235 P_B11 P_TOP sky130_fd_pr__cap_mim_m3_1 l=3 w=3
X4236 N_B11 N_TOP sky130_fd_pr__cap_mim_m3_1 l=3 w=3
X4237 P_B11 P_TOP sky130_fd_pr__cap_mim_m3_1 l=3 w=3
X4238 P_B11 P_TOP sky130_fd_pr__cap_mim_m3_1 l=3 w=3
X4239 P_B10 P_TOP sky130_fd_pr__cap_mim_m3_1 l=3 w=3
X4240 P_EDGE_BIAS P_EDGE_BIAS sky130_fd_pr__cap_mim_m3_1 l=3 w=3
X4241 N_B10 N_TOP sky130_fd_pr__cap_mim_m3_1 l=3 w=3
X4242 N_B11 N_TOP sky130_fd_pr__cap_mim_m3_1 l=3 w=3
X4243 P_B6 P_TOP sky130_fd_pr__cap_mim_m3_1 l=3 w=3
X4244 N_B11 N_TOP sky130_fd_pr__cap_mim_m3_1 l=3 w=3
X4245 P_B11 P_TOP sky130_fd_pr__cap_mim_m3_1 l=3 w=3
X4246 N_B11 N_TOP sky130_fd_pr__cap_mim_m3_1 l=3 w=3
X4247 P_B10 P_TOP sky130_fd_pr__cap_mim_m3_1 l=3 w=3
X4248 P_B11 P_TOP sky130_fd_pr__cap_mim_m3_1 l=3 w=3
X4249 N_B11 N_TOP sky130_fd_pr__cap_mim_m3_1 l=3 w=3
X4250 P_B11 P_TOP sky130_fd_pr__cap_mim_m3_1 l=3 w=3
X4251 P_B11 P_TOP sky130_fd_pr__cap_mim_m3_1 l=3 w=3
X4252 P_B7 P_TOP sky130_fd_pr__cap_mim_m3_1 l=3 w=3
X4253 P_B10 P_TOP sky130_fd_pr__cap_mim_m3_1 l=3 w=3
X4254 N_B11 N_TOP sky130_fd_pr__cap_mim_m3_1 l=3 w=3
X4255 P_EDGE_BIAS P_EDGE_BIAS sky130_fd_pr__cap_mim_m3_1 l=3 w=3
X4256 P_B10 P_TOP sky130_fd_pr__cap_mim_m3_1 l=3 w=3
X4257 N_B11 N_TOP sky130_fd_pr__cap_mim_m3_1 l=3 w=3
X4258 N_B11 N_TOP sky130_fd_pr__cap_mim_m3_1 l=3 w=3
X4259 P_EDGE_BIAS P_EDGE_BIAS sky130_fd_pr__cap_mim_m3_1 l=3 w=3
X4260 P_B8 P_TOP sky130_fd_pr__cap_mim_m3_1 l=3 w=3
X4261 P_B10 P_TOP sky130_fd_pr__cap_mim_m3_1 l=3 w=3
X4262 N_B11 N_TOP sky130_fd_pr__cap_mim_m3_1 l=3 w=3
X4263 N_B8 N_TOP sky130_fd_pr__cap_mim_m3_1 l=3 w=3
X4264 N_B10 N_TOP sky130_fd_pr__cap_mim_m3_1 l=3 w=3
X4265 P_B11 P_TOP sky130_fd_pr__cap_mim_m3_1 l=3 w=3
X4266 N_B11 N_TOP sky130_fd_pr__cap_mim_m3_1 l=3 w=3
X4267 N_B10 N_TOP sky130_fd_pr__cap_mim_m3_1 l=3 w=3
X4268 P_B10 P_TOP sky130_fd_pr__cap_mim_m3_1 l=3 w=3
X4269 N_B11 N_TOP sky130_fd_pr__cap_mim_m3_1 l=3 w=3
X4270 N_B11 N_TOP sky130_fd_pr__cap_mim_m3_1 l=3 w=3
X4271 P_B11 P_TOP sky130_fd_pr__cap_mim_m3_1 l=3 w=3
X4272 P_B10 P_TOP sky130_fd_pr__cap_mim_m3_1 l=3 w=3
X4273 N_B11 N_TOP sky130_fd_pr__cap_mim_m3_1 l=3 w=3
X4274 N_B8 N_TOP sky130_fd_pr__cap_mim_m3_1 l=3 w=3
X4275 N_B10 N_TOP sky130_fd_pr__cap_mim_m3_1 l=3 w=3
X4276 N_B10 N_TOP sky130_fd_pr__cap_mim_m3_1 l=3 w=3
X4277 P_B10 P_TOP sky130_fd_pr__cap_mim_m3_1 l=3 w=3
X4278 P_B11 P_TOP sky130_fd_pr__cap_mim_m3_1 l=3 w=3
X4279 N_B10 N_TOP sky130_fd_pr__cap_mim_m3_1 l=3 w=3
X4280 N_B11 N_TOP sky130_fd_pr__cap_mim_m3_1 l=3 w=3
X4281 N_EDGE_BIAS N_EDGE_BIAS sky130_fd_pr__cap_mim_m3_1 l=3 w=3
X4282 P_B11 P_TOP sky130_fd_pr__cap_mim_m3_1 l=3 w=3
X4283 P_B11 P_TOP sky130_fd_pr__cap_mim_m3_1 l=3 w=3
X4284 P_B10 P_TOP sky130_fd_pr__cap_mim_m3_1 l=3 w=3
X4285 N_B11 N_TOP sky130_fd_pr__cap_mim_m3_1 l=3 w=3
X4286 N_B9 N_TOP sky130_fd_pr__cap_mim_m3_1 l=3 w=3
X4287 N_B10 N_TOP sky130_fd_pr__cap_mim_m3_1 l=3 w=3
X4288 P_B9 P_TOP sky130_fd_pr__cap_mim_m3_1 l=3 w=3
X4289 P_B9 P_TOP sky130_fd_pr__cap_mim_m3_1 l=3 w=3
X4290 P_B11 P_TOP sky130_fd_pr__cap_mim_m3_1 l=3 w=3
X4291 N_B11 N_TOP sky130_fd_pr__cap_mim_m3_1 l=3 w=3
X4292 N_B10 N_TOP sky130_fd_pr__cap_mim_m3_1 l=3 w=3
X4293 N_B5 N_TOP sky130_fd_pr__cap_mim_m3_1 l=3 w=3
X4294 P_B8 P_TOP sky130_fd_pr__cap_mim_m3_1 l=3 w=3
X4295 P_B11 P_TOP sky130_fd_pr__cap_mim_m3_1 l=3 w=3
X4296 P_B9 P_TOP sky130_fd_pr__cap_mim_m3_1 l=3 w=3
X4297 P_B11 P_TOP sky130_fd_pr__cap_mim_m3_1 l=3 w=3
X4298 P_B11 P_TOP sky130_fd_pr__cap_mim_m3_1 l=3 w=3
X4299 P_B7 P_TOP sky130_fd_pr__cap_mim_m3_1 l=3 w=3
X4300 P_B11 P_TOP sky130_fd_pr__cap_mim_m3_1 l=3 w=3
X4301 P_B8 P_TOP sky130_fd_pr__cap_mim_m3_1 l=3 w=3
X4302 P_B10 P_TOP sky130_fd_pr__cap_mim_m3_1 l=3 w=3
X4303 P_B11 P_TOP sky130_fd_pr__cap_mim_m3_1 l=3 w=3
X4304 P_B11 P_TOP sky130_fd_pr__cap_mim_m3_1 l=3 w=3
X4305 N_B10 N_TOP sky130_fd_pr__cap_mim_m3_1 l=3 w=3
X4306 N_EDGE_BIAS N_EDGE_BIAS sky130_fd_pr__cap_mim_m3_1 l=3 w=3
X4307 P_B8 P_TOP sky130_fd_pr__cap_mim_m3_1 l=3 w=3
X4308 P_B11 P_TOP sky130_fd_pr__cap_mim_m3_1 l=3 w=3
X4309 P_EDGE_BIAS P_EDGE_BIAS sky130_fd_pr__cap_mim_m3_1 l=3 w=3
X4310 N_B11 N_TOP sky130_fd_pr__cap_mim_m3_1 l=3 w=3
X4311 P_B10 P_TOP sky130_fd_pr__cap_mim_m3_1 l=3 w=3
X4312 P_B5 P_TOP sky130_fd_pr__cap_mim_m3_1 l=3 w=3
X4313 P_B8 P_TOP sky130_fd_pr__cap_mim_m3_1 l=3 w=3
X4314 P_B11 P_TOP sky130_fd_pr__cap_mim_m3_1 l=3 w=3
X4315 N_B11 N_TOP sky130_fd_pr__cap_mim_m3_1 l=3 w=3
X4316 N_B10 N_TOP sky130_fd_pr__cap_mim_m3_1 l=3 w=3
X4317 P_B9 P_TOP sky130_fd_pr__cap_mim_m3_1 l=3 w=3
X4318 P_B11 P_TOP sky130_fd_pr__cap_mim_m3_1 l=3 w=3
X4319 N_B11 N_TOP sky130_fd_pr__cap_mim_m3_1 l=3 w=3
X4320 P_B11 P_TOP sky130_fd_pr__cap_mim_m3_1 l=3 w=3
X4321 P_B9 P_TOP sky130_fd_pr__cap_mim_m3_1 l=3 w=3
X4322 P_B9 P_TOP sky130_fd_pr__cap_mim_m3_1 l=3 w=3
X4323 N_B9 N_TOP sky130_fd_pr__cap_mim_m3_1 l=3 w=3
X4324 N_B10 N_TOP sky130_fd_pr__cap_mim_m3_1 l=3 w=3
X4325 N_B11 N_TOP sky130_fd_pr__cap_mim_m3_1 l=3 w=3
X4326 P_B11 P_TOP sky130_fd_pr__cap_mim_m3_1 l=3 w=3
X4327 P_B4 P_TOP sky130_fd_pr__cap_mim_m3_1 l=3 w=3
X4328 N_B10 N_TOP sky130_fd_pr__cap_mim_m3_1 l=3 w=3
X4329 P_B11 P_TOP sky130_fd_pr__cap_mim_m3_1 l=3 w=3
X4330 N_B11 N_TOP sky130_fd_pr__cap_mim_m3_1 l=3 w=3
X4331 N_B9 N_TOP sky130_fd_pr__cap_mim_m3_1 l=3 w=3
X4332 P_B9 P_TOP sky130_fd_pr__cap_mim_m3_1 l=3 w=3
X4333 P_B11 P_TOP sky130_fd_pr__cap_mim_m3_1 l=3 w=3
X4334 N_B9 N_TOP sky130_fd_pr__cap_mim_m3_1 l=3 w=3
X4335 N_EDGE_BIAS N_EDGE_BIAS sky130_fd_pr__cap_mim_m3_1 l=3 w=3
X4336 N_B10 N_TOP sky130_fd_pr__cap_mim_m3_1 l=3 w=3
X4337 N_B11 N_TOP sky130_fd_pr__cap_mim_m3_1 l=3 w=3
X4338 P_B11 P_TOP sky130_fd_pr__cap_mim_m3_1 l=3 w=3
X4339 P_B11 P_TOP sky130_fd_pr__cap_mim_m3_1 l=3 w=3
X4340 P_B11 P_TOP sky130_fd_pr__cap_mim_m3_1 l=3 w=3
X4341 P_EDGE_BIAS P_EDGE_BIAS sky130_fd_pr__cap_mim_m3_1 l=3 w=3
X4342 N_B10 N_TOP sky130_fd_pr__cap_mim_m3_1 l=3 w=3
X4343 P_B11 P_TOP sky130_fd_pr__cap_mim_m3_1 l=3 w=3
X4344 N_B11 N_TOP sky130_fd_pr__cap_mim_m3_1 l=3 w=3
X4345 N_B10 N_TOP sky130_fd_pr__cap_mim_m3_1 l=3 w=3
X4346 P_B10 P_TOP sky130_fd_pr__cap_mim_m3_1 l=3 w=3
X4347 P_B11 P_TOP sky130_fd_pr__cap_mim_m3_1 l=3 w=3
X4348 N_B11 N_TOP sky130_fd_pr__cap_mim_m3_1 l=3 w=3
X4349 N_EDGE_BIAS N_EDGE_BIAS sky130_fd_pr__cap_mim_m3_1 l=3 w=3
X4350 P_B10 P_TOP sky130_fd_pr__cap_mim_m3_1 l=3 w=3
X4351 N_B11 N_TOP sky130_fd_pr__cap_mim_m3_1 l=3 w=3
X4352 P_B7 P_TOP sky130_fd_pr__cap_mim_m3_1 l=3 w=3
X4353 P_B10 P_TOP sky130_fd_pr__cap_mim_m3_1 l=3 w=3
X4354 P_B10 P_TOP sky130_fd_pr__cap_mim_m3_1 l=3 w=3
X4355 P_B11 P_TOP sky130_fd_pr__cap_mim_m3_1 l=3 w=3
X4356 P_B11 P_TOP sky130_fd_pr__cap_mim_m3_1 l=3 w=3
X4357 N_B9 N_TOP sky130_fd_pr__cap_mim_m3_1 l=3 w=3
X4358 N_B11 N_TOP sky130_fd_pr__cap_mim_m3_1 l=3 w=3
X4359 N_B11 N_TOP sky130_fd_pr__cap_mim_m3_1 l=3 w=3
X4360 P_B8 P_TOP sky130_fd_pr__cap_mim_m3_1 l=3 w=3
X4361 N_B10 N_TOP sky130_fd_pr__cap_mim_m3_1 l=3 w=3
X4362 P_B10 P_TOP sky130_fd_pr__cap_mim_m3_1 l=3 w=3
X4363 N_B11 N_TOP sky130_fd_pr__cap_mim_m3_1 l=3 w=3
X4364 P_B11 P_TOP sky130_fd_pr__cap_mim_m3_1 l=3 w=3
X4365 P_B10 P_TOP sky130_fd_pr__cap_mim_m3_1 l=3 w=3
X4366 P_B11 P_TOP sky130_fd_pr__cap_mim_m3_1 l=3 w=3
X4367 P_B10 P_TOP sky130_fd_pr__cap_mim_m3_1 l=3 w=3
X4368 N_B9 N_TOP sky130_fd_pr__cap_mim_m3_1 l=3 w=3
X4369 P_B10 P_TOP sky130_fd_pr__cap_mim_m3_1 l=3 w=3
X4370 N_B10 N_TOP sky130_fd_pr__cap_mim_m3_1 l=3 w=3
X4371 P_B10 P_TOP sky130_fd_pr__cap_mim_m3_1 l=3 w=3
X4372 N_EDGE_BIAS N_EDGE_BIAS sky130_fd_pr__cap_mim_m3_1 l=3 w=3
X4373 N_B11 N_TOP sky130_fd_pr__cap_mim_m3_1 l=3 w=3
X4374 N_B8 N_TOP sky130_fd_pr__cap_mim_m3_1 l=3 w=3
X4375 N_B10 N_TOP sky130_fd_pr__cap_mim_m3_1 l=3 w=3
X4376 P_B10 P_TOP sky130_fd_pr__cap_mim_m3_1 l=3 w=3
X4377 P_B10 P_TOP sky130_fd_pr__cap_mim_m3_1 l=3 w=3
X4378 N_B11 N_TOP sky130_fd_pr__cap_mim_m3_1 l=3 w=3
X4379 N_B11 N_TOP sky130_fd_pr__cap_mim_m3_1 l=3 w=3
X4380 P_B11 P_TOP sky130_fd_pr__cap_mim_m3_1 l=3 w=3
X4381 N_B10 N_TOP sky130_fd_pr__cap_mim_m3_1 l=3 w=3
X4382 P_B11 P_TOP sky130_fd_pr__cap_mim_m3_1 l=3 w=3
X4383 P_B10 P_TOP sky130_fd_pr__cap_mim_m3_1 l=3 w=3
X4384 P_B11 P_TOP sky130_fd_pr__cap_mim_m3_1 l=3 w=3
X4385 N_B11 N_TOP sky130_fd_pr__cap_mim_m3_1 l=3 w=3
X4386 P_B11 P_TOP sky130_fd_pr__cap_mim_m3_1 l=3 w=3
X4387 N_B9 N_TOP sky130_fd_pr__cap_mim_m3_1 l=3 w=3
X4388 P_B11 P_TOP sky130_fd_pr__cap_mim_m3_1 l=3 w=3
X4389 N_B10 N_TOP sky130_fd_pr__cap_mim_m3_1 l=3 w=3
X4390 P_B11 P_TOP sky130_fd_pr__cap_mim_m3_1 l=3 w=3
X4391 N_B11 N_TOP sky130_fd_pr__cap_mim_m3_1 l=3 w=3
X4392 N_B10 N_TOP sky130_fd_pr__cap_mim_m3_1 l=3 w=3
X4393 N_B6 N_TOP sky130_fd_pr__cap_mim_m3_1 l=3 w=3
X4394 P_B10 P_TOP sky130_fd_pr__cap_mim_m3_1 l=3 w=3
X4395 N_B11 N_TOP sky130_fd_pr__cap_mim_m3_1 l=3 w=3
X4396 N_B9 N_TOP sky130_fd_pr__cap_mim_m3_1 l=3 w=3
X4397 P_B11 P_TOP sky130_fd_pr__cap_mim_m3_1 l=3 w=3
X4398 P_B11 P_TOP sky130_fd_pr__cap_mim_m3_1 l=3 w=3
X4399 P_B9 P_TOP sky130_fd_pr__cap_mim_m3_1 l=3 w=3
X4400 N_B11 N_TOP sky130_fd_pr__cap_mim_m3_1 l=3 w=3
X4401 N_B11 N_TOP sky130_fd_pr__cap_mim_m3_1 l=3 w=3
X4402 P_B7 P_TOP sky130_fd_pr__cap_mim_m3_1 l=3 w=3
X4403 P_B11 P_TOP sky130_fd_pr__cap_mim_m3_1 l=3 w=3
X4404 P_B8 P_TOP sky130_fd_pr__cap_mim_m3_1 l=3 w=3
X4405 P_EDGE_BIAS P_EDGE_BIAS sky130_fd_pr__cap_mim_m3_1 l=3 w=3
X4406 P_B10 P_TOP sky130_fd_pr__cap_mim_m3_1 l=3 w=3
X4407 N_B10 N_TOP sky130_fd_pr__cap_mim_m3_1 l=3 w=3
X4408 N_B11 N_TOP sky130_fd_pr__cap_mim_m3_1 l=3 w=3
X4409 N_EDGE_BIAS N_EDGE_BIAS sky130_fd_pr__cap_mim_m3_1 l=3 w=3
X4410 N_B8 N_TOP sky130_fd_pr__cap_mim_m3_1 l=3 w=3
X4411 P_B11 P_TOP sky130_fd_pr__cap_mim_m3_1 l=3 w=3
X4412 P_B8 P_TOP sky130_fd_pr__cap_mim_m3_1 l=3 w=3
X4413 N_B11 N_TOP sky130_fd_pr__cap_mim_m3_1 l=3 w=3
X4414 N_B11 N_TOP sky130_fd_pr__cap_mim_m3_1 l=3 w=3
X4415 P_B10 P_TOP sky130_fd_pr__cap_mim_m3_1 l=3 w=3
X4416 N_B3 N_TOP sky130_fd_pr__cap_mim_m3_1 l=3 w=3
X4417 P_B6 P_TOP sky130_fd_pr__cap_mim_m3_1 l=3 w=3
X4418 P_B11 P_TOP sky130_fd_pr__cap_mim_m3_1 l=3 w=3
X4419 P_EDGE_BIAS P_EDGE_BIAS sky130_fd_pr__cap_mim_m3_1 l=3 w=3
X4420 P_B9 P_TOP sky130_fd_pr__cap_mim_m3_1 l=3 w=3
X4421 P_B11 P_TOP sky130_fd_pr__cap_mim_m3_1 l=3 w=3
X4422 P_B11 P_TOP sky130_fd_pr__cap_mim_m3_1 l=3 w=3
X4423 P_B9 P_TOP sky130_fd_pr__cap_mim_m3_1 l=3 w=3
X4424 P_B9 P_TOP sky130_fd_pr__cap_mim_m3_1 l=3 w=3
X4425 N_B10 N_TOP sky130_fd_pr__cap_mim_m3_1 l=3 w=3
X4426 P_B10 P_TOP sky130_fd_pr__cap_mim_m3_1 l=3 w=3
X4427 N_B11 N_TOP sky130_fd_pr__cap_mim_m3_1 l=3 w=3
X4428 P_B5 P_TOP sky130_fd_pr__cap_mim_m3_1 l=3 w=3
X4429 P_B11 P_TOP sky130_fd_pr__cap_mim_m3_1 l=3 w=3
X4430 N_EDGE_BIAS N_EDGE_BIAS sky130_fd_pr__cap_mim_m3_1 l=3 w=3
X4431 N_B10 N_TOP sky130_fd_pr__cap_mim_m3_1 l=3 w=3
X4432 N_B11 N_TOP sky130_fd_pr__cap_mim_m3_1 l=3 w=3
X4433 P_B11 P_TOP sky130_fd_pr__cap_mim_m3_1 l=3 w=3
X4434 P_B10 P_TOP sky130_fd_pr__cap_mim_m3_1 l=3 w=3
X4435 N_B9 N_TOP sky130_fd_pr__cap_mim_m3_1 l=3 w=3
X4436 P_B9 P_TOP sky130_fd_pr__cap_mim_m3_1 l=3 w=3
X4437 N_B11 N_TOP sky130_fd_pr__cap_mim_m3_1 l=3 w=3
X4438 N_B10 N_TOP sky130_fd_pr__cap_mim_m3_1 l=3 w=3
X4439 P_B11 P_TOP sky130_fd_pr__cap_mim_m3_1 l=3 w=3
X4440 N_B11 N_TOP sky130_fd_pr__cap_mim_m3_1 l=3 w=3
X4441 P_B11 P_TOP sky130_fd_pr__cap_mim_m3_1 l=3 w=3
X4442 P_EDGE_BIAS P_EDGE_BIAS sky130_fd_pr__cap_mim_m3_1 l=3 w=3
X4443 P_B9 P_TOP sky130_fd_pr__cap_mim_m3_1 l=3 w=3
X4444 N_B10 N_TOP sky130_fd_pr__cap_mim_m3_1 l=3 w=3
X4445 P_B10 P_TOP sky130_fd_pr__cap_mim_m3_1 l=3 w=3
X4446 P_EDGE_BIAS P_EDGE_BIAS sky130_fd_pr__cap_mim_m3_1 l=3 w=3
X4447 P_B10 P_TOP sky130_fd_pr__cap_mim_m3_1 l=3 w=3
X4448 N_B10 N_TOP sky130_fd_pr__cap_mim_m3_1 l=3 w=3
X4449 N_B11 N_TOP sky130_fd_pr__cap_mim_m3_1 l=3 w=3
X4450 P_B11 P_TOP sky130_fd_pr__cap_mim_m3_1 l=3 w=3
X4451 P_B9 P_TOP sky130_fd_pr__cap_mim_m3_1 l=3 w=3
X4452 P_B11 P_TOP sky130_fd_pr__cap_mim_m3_1 l=3 w=3
X4453 N_B10 N_TOP sky130_fd_pr__cap_mim_m3_1 l=3 w=3
X4454 P_B10 P_TOP sky130_fd_pr__cap_mim_m3_1 l=3 w=3
X4455 P_B11 P_TOP sky130_fd_pr__cap_mim_m3_1 l=3 w=3
X4456 P_B11 P_TOP sky130_fd_pr__cap_mim_m3_1 l=3 w=3
X4457 P_EDGE_BIAS P_EDGE_BIAS sky130_fd_pr__cap_mim_m3_1 l=3 w=3
X4458 P_B10 P_TOP sky130_fd_pr__cap_mim_m3_1 l=3 w=3
X4459 N_B11 N_TOP sky130_fd_pr__cap_mim_m3_1 l=3 w=3
X4460 N_B10 N_TOP sky130_fd_pr__cap_mim_m3_1 l=3 w=3
X4461 P_B7 P_TOP sky130_fd_pr__cap_mim_m3_1 l=3 w=3
X4462 N_B11 N_TOP sky130_fd_pr__cap_mim_m3_1 l=3 w=3
X4463 P_B10 P_TOP sky130_fd_pr__cap_mim_m3_1 l=3 w=3
X4464 P_B9 P_TOP sky130_fd_pr__cap_mim_m3_1 l=3 w=3
X4465 P_B11 P_TOP sky130_fd_pr__cap_mim_m3_1 l=3 w=3
X4466 N_B9 N_TOP sky130_fd_pr__cap_mim_m3_1 l=3 w=3
X4467 N_B9 N_TOP sky130_fd_pr__cap_mim_m3_1 l=3 w=3
X4468 P_B10 P_TOP sky130_fd_pr__cap_mim_m3_1 l=3 w=3
X4469 N_B11 N_TOP sky130_fd_pr__cap_mim_m3_1 l=3 w=3
X4470 P_B10 P_TOP sky130_fd_pr__cap_mim_m3_1 l=3 w=3
X4471 N_B10 N_TOP sky130_fd_pr__cap_mim_m3_1 l=3 w=3
X4472 N_B11 N_TOP sky130_fd_pr__cap_mim_m3_1 l=3 w=3
X4473 N_B11 N_TOP sky130_fd_pr__cap_mim_m3_1 l=3 w=3
X4474 N_B8 N_TOP sky130_fd_pr__cap_mim_m3_1 l=3 w=3
X4475 P_B11 P_TOP sky130_fd_pr__cap_mim_m3_1 l=3 w=3
X4476 P_B8 P_TOP sky130_fd_pr__cap_mim_m3_1 l=3 w=3
X4477 N_B11 N_TOP sky130_fd_pr__cap_mim_m3_1 l=3 w=3
X4478 P_B10 P_TOP sky130_fd_pr__cap_mim_m3_1 l=3 w=3
X4479 N_B11 N_TOP sky130_fd_pr__cap_mim_m3_1 l=3 w=3
X4480 P_B11 P_TOP sky130_fd_pr__cap_mim_m3_1 l=3 w=3
X4481 P_B10 P_TOP sky130_fd_pr__cap_mim_m3_1 l=3 w=3
X4482 N_B9 N_TOP sky130_fd_pr__cap_mim_m3_1 l=3 w=3
X4483 N_B11 N_TOP sky130_fd_pr__cap_mim_m3_1 l=3 w=3
X4484 P_B10 P_TOP sky130_fd_pr__cap_mim_m3_1 l=3 w=3
X4485 N_B11 N_TOP sky130_fd_pr__cap_mim_m3_1 l=3 w=3
X4486 N_B8 N_TOP sky130_fd_pr__cap_mim_m3_1 l=3 w=3
X4487 P_B8 P_TOP sky130_fd_pr__cap_mim_m3_1 l=3 w=3
X4488 N_B10 N_TOP sky130_fd_pr__cap_mim_m3_1 l=3 w=3
X4489 N_B11 N_TOP sky130_fd_pr__cap_mim_m3_1 l=3 w=3
X4490 N_B11 N_TOP sky130_fd_pr__cap_mim_m3_1 l=3 w=3
X4491 N_B10 N_TOP sky130_fd_pr__cap_mim_m3_1 l=3 w=3
X4492 P_B11 P_TOP sky130_fd_pr__cap_mim_m3_1 l=3 w=3
X4493 P_B10 P_TOP sky130_fd_pr__cap_mim_m3_1 l=3 w=3
X4494 N_B8 N_TOP sky130_fd_pr__cap_mim_m3_1 l=3 w=3
X4495 N_B11 N_TOP sky130_fd_pr__cap_mim_m3_1 l=3 w=3
X4496 P_B10 P_TOP sky130_fd_pr__cap_mim_m3_1 l=3 w=3
X4497 N_B11 N_TOP sky130_fd_pr__cap_mim_m3_1 l=3 w=3
X4498 P_B10 P_TOP sky130_fd_pr__cap_mim_m3_1 l=3 w=3
X4499 N_B9 N_TOP sky130_fd_pr__cap_mim_m3_1 l=3 w=3
X4500 N_B11 N_TOP sky130_fd_pr__cap_mim_m3_1 l=3 w=3
X4501 N_B9 N_TOP sky130_fd_pr__cap_mim_m3_1 l=3 w=3
X4502 P_B9 P_TOP sky130_fd_pr__cap_mim_m3_1 l=3 w=3
X4503 N_B10 N_TOP sky130_fd_pr__cap_mim_m3_1 l=3 w=3
X4504 P_B10 P_TOP sky130_fd_pr__cap_mim_m3_1 l=3 w=3
X4505 N_B5 N_TOP sky130_fd_pr__cap_mim_m3_1 l=3 w=3
X4506 P_B8 P_TOP sky130_fd_pr__cap_mim_m3_1 l=3 w=3
X4507 N_B11 N_TOP sky130_fd_pr__cap_mim_m3_1 l=3 w=3
X4508 N_B6 N_TOP sky130_fd_pr__cap_mim_m3_1 l=3 w=3
X4509 P_B10 P_TOP sky130_fd_pr__cap_mim_m3_1 l=3 w=3
X4510 N_B11 N_TOP sky130_fd_pr__cap_mim_m3_1 l=3 w=3
X4511 P_B9 P_TOP sky130_fd_pr__cap_mim_m3_1 l=3 w=3
X4512 P_B11 P_TOP sky130_fd_pr__cap_mim_m3_1 l=3 w=3
X4513 P_EDGE_BIAS P_EDGE_BIAS sky130_fd_pr__cap_mim_m3_1 l=3 w=3
X4514 P_B7 P_TOP sky130_fd_pr__cap_mim_m3_1 l=3 w=3
X4515 N_B11 N_TOP sky130_fd_pr__cap_mim_m3_1 l=3 w=3
X4516 N_B11 N_TOP sky130_fd_pr__cap_mim_m3_1 l=3 w=3
X4517 P_B11 P_TOP sky130_fd_pr__cap_mim_m3_1 l=3 w=3
X4518 N_EDGE_BIAS N_EDGE_BIAS sky130_fd_pr__cap_mim_m3_1 l=3 w=3
X4519 N_B11 N_TOP sky130_fd_pr__cap_mim_m3_1 l=3 w=3
X4520 P_B11 P_TOP sky130_fd_pr__cap_mim_m3_1 l=3 w=3
X4521 P_EDGE_BIAS P_EDGE_BIAS sky130_fd_pr__cap_mim_m3_1 l=3 w=3
X4522 P_B10 P_TOP sky130_fd_pr__cap_mim_m3_1 l=3 w=3
X4523 N_EDGE_BIAS N_EDGE_BIAS sky130_fd_pr__cap_mim_m3_1 l=3 w=3
X4524 P_B8 P_TOP sky130_fd_pr__cap_mim_m3_1 l=3 w=3
X4525 P_B11 P_TOP sky130_fd_pr__cap_mim_m3_1 l=3 w=3
X4526 P_B4 P_TOP sky130_fd_pr__cap_mim_m3_1 l=3 w=3
X4527 P_B8 P_TOP sky130_fd_pr__cap_mim_m3_1 l=3 w=3
X4528 N_B11 N_TOP sky130_fd_pr__cap_mim_m3_1 l=3 w=3
X4529 P_B11 P_TOP sky130_fd_pr__cap_mim_m3_1 l=3 w=3
X4530 N_B10 N_TOP sky130_fd_pr__cap_mim_m3_1 l=3 w=3
X4531 P_B10 P_TOP sky130_fd_pr__cap_mim_m3_1 l=3 w=3
X4532 P_B11 P_TOP sky130_fd_pr__cap_mim_m3_1 l=3 w=3
X4533 P_B9 P_TOP sky130_fd_pr__cap_mim_m3_1 l=3 w=3
X4534 P_B11 P_TOP sky130_fd_pr__cap_mim_m3_1 l=3 w=3
X4535 P_B9 P_TOP sky130_fd_pr__cap_mim_m3_1 l=3 w=3
X4536 N_B10 N_TOP sky130_fd_pr__cap_mim_m3_1 l=3 w=3
X4537 P_B11 P_TOP sky130_fd_pr__cap_mim_m3_1 l=3 w=3
X4538 P_B4 P_TOP sky130_fd_pr__cap_mim_m3_1 l=3 w=3
X4539 N_B11 N_TOP sky130_fd_pr__cap_mim_m3_1 l=3 w=3
X4540 N_B10 N_TOP sky130_fd_pr__cap_mim_m3_1 l=3 w=3
X4541 P_B10 P_TOP sky130_fd_pr__cap_mim_m3_1 l=3 w=3
X4542 N_B11 N_TOP sky130_fd_pr__cap_mim_m3_1 l=3 w=3
X4543 P_EDGE_BIAS P_EDGE_BIAS sky130_fd_pr__cap_mim_m3_1 l=3 w=3
X4544 P_B9 P_TOP sky130_fd_pr__cap_mim_m3_1 l=3 w=3
X4545 N_B11 N_TOP sky130_fd_pr__cap_mim_m3_1 l=3 w=3
X4546 P_B11 P_TOP sky130_fd_pr__cap_mim_m3_1 l=3 w=3
X4547 P_B11 P_TOP sky130_fd_pr__cap_mim_m3_1 l=3 w=3
X4548 N_B10 N_TOP sky130_fd_pr__cap_mim_m3_1 l=3 w=3
X4549 P_B10 P_TOP sky130_fd_pr__cap_mim_m3_1 l=3 w=3
X4550 P_B11 P_TOP sky130_fd_pr__cap_mim_m3_1 l=3 w=3
X4551 P_B11 P_TOP sky130_fd_pr__cap_mim_m3_1 l=3 w=3
X4552 N_B10 N_TOP sky130_fd_pr__cap_mim_m3_1 l=3 w=3
X4553 N_B11 N_TOP sky130_fd_pr__cap_mim_m3_1 l=3 w=3
X4554 P_EDGE_BIAS P_EDGE_BIAS sky130_fd_pr__cap_mim_m3_1 l=3 w=3
X4555 N_B10 N_TOP sky130_fd_pr__cap_mim_m3_1 l=3 w=3
X4556 N_B11 N_TOP sky130_fd_pr__cap_mim_m3_1 l=3 w=3
X4557 N_B10 N_TOP sky130_fd_pr__cap_mim_m3_1 l=3 w=3
X4558 N_B11 N_TOP sky130_fd_pr__cap_mim_m3_1 l=3 w=3
X4559 P_B11 P_TOP sky130_fd_pr__cap_mim_m3_1 l=3 w=3
X4560 P_B9 P_TOP sky130_fd_pr__cap_mim_m3_1 l=3 w=3
X4561 P_B11 P_TOP sky130_fd_pr__cap_mim_m3_1 l=3 w=3
X4562 P_B10 P_TOP sky130_fd_pr__cap_mim_m3_1 l=3 w=3
X4563 P_EDGE_BIAS P_EDGE_BIAS sky130_fd_pr__cap_mim_m3_1 l=3 w=3
X4564 N_B11 N_TOP sky130_fd_pr__cap_mim_m3_1 l=3 w=3
X4565 P_B11 P_TOP sky130_fd_pr__cap_mim_m3_1 l=3 w=3
X4566 P_B7 P_TOP sky130_fd_pr__cap_mim_m3_1 l=3 w=3
X4567 P_B10 P_TOP sky130_fd_pr__cap_mim_m3_1 l=3 w=3
X4568 N_B10 N_TOP sky130_fd_pr__cap_mim_m3_1 l=3 w=3
X4569 P_EDGE_BIAS P_EDGE_BIAS sky130_fd_pr__cap_mim_m3_1 l=3 w=3
X4570 P_B9 P_TOP sky130_fd_pr__cap_mim_m3_1 l=3 w=3
X4571 P_B11 P_TOP sky130_fd_pr__cap_mim_m3_1 l=3 w=3
X4572 N_B11 N_TOP sky130_fd_pr__cap_mim_m3_1 l=3 w=3
X4573 P_B9 P_TOP sky130_fd_pr__cap_mim_m3_1 l=3 w=3
X4574 N_B9 N_TOP sky130_fd_pr__cap_mim_m3_1 l=3 w=3
X4575 P_B8 P_TOP sky130_fd_pr__cap_mim_m3_1 l=3 w=3
X4576 P_B10 P_TOP sky130_fd_pr__cap_mim_m3_1 l=3 w=3
X4577 N_B11 N_TOP sky130_fd_pr__cap_mim_m3_1 l=3 w=3
X4578 N_B10 N_TOP sky130_fd_pr__cap_mim_m3_1 l=3 w=3
X4579 P_B10 P_TOP sky130_fd_pr__cap_mim_m3_1 l=3 w=3
X4580 P_B11 P_TOP sky130_fd_pr__cap_mim_m3_1 l=3 w=3
X4581 N_B11 N_TOP sky130_fd_pr__cap_mim_m3_1 l=3 w=3
X4582 N_B9 N_TOP sky130_fd_pr__cap_mim_m3_1 l=3 w=3
X4583 P_B10 P_TOP sky130_fd_pr__cap_mim_m3_1 l=3 w=3
X4584 P_B10 P_TOP sky130_fd_pr__cap_mim_m3_1 l=3 w=3
X4585 N_B11 N_TOP sky130_fd_pr__cap_mim_m3_1 l=3 w=3
X4586 P_B11 P_TOP sky130_fd_pr__cap_mim_m3_1 l=3 w=3
X4587 P_B11 P_TOP sky130_fd_pr__cap_mim_m3_1 l=3 w=3
X4588 N_B8 N_TOP sky130_fd_pr__cap_mim_m3_1 l=3 w=3
X4589 N_B11 N_TOP sky130_fd_pr__cap_mim_m3_1 l=3 w=3
X4590 P_B10 P_TOP sky130_fd_pr__cap_mim_m3_1 l=3 w=3
X4591 P_B11 P_TOP sky130_fd_pr__cap_mim_m3_1 l=3 w=3
X4592 N_B11 N_TOP sky130_fd_pr__cap_mim_m3_1 l=3 w=3
X4593 P_B11 P_TOP sky130_fd_pr__cap_mim_m3_1 l=3 w=3
X4594 N_B11 N_TOP sky130_fd_pr__cap_mim_m3_1 l=3 w=3
X4595 P_B11 P_TOP sky130_fd_pr__cap_mim_m3_1 l=3 w=3
X4596 N_B8 N_TOP sky130_fd_pr__cap_mim_m3_1 l=3 w=3
X4597 P_B10 P_TOP sky130_fd_pr__cap_mim_m3_1 l=3 w=3
X4598 N_B11 N_TOP sky130_fd_pr__cap_mim_m3_1 l=3 w=3
X4599 N_B9 N_TOP sky130_fd_pr__cap_mim_m3_1 l=3 w=3
X4600 P_B9 P_TOP sky130_fd_pr__cap_mim_m3_1 l=3 w=3
X4601 P_B11 P_TOP sky130_fd_pr__cap_mim_m3_1 l=3 w=3
X4602 N_B11 N_TOP sky130_fd_pr__cap_mim_m3_1 l=3 w=3
X4603 N_B10 N_TOP sky130_fd_pr__cap_mim_m3_1 l=3 w=3
X4604 P_B6 P_TOP sky130_fd_pr__cap_mim_m3_1 l=3 w=3
X4605 N_B11 N_TOP sky130_fd_pr__cap_mim_m3_1 l=3 w=3
X4606 N_B10 N_TOP sky130_fd_pr__cap_mim_m3_1 l=3 w=3
X4607 P_B11 P_TOP sky130_fd_pr__cap_mim_m3_1 l=3 w=3
X4608 N_B11 N_TOP sky130_fd_pr__cap_mim_m3_1 l=3 w=3
X4609 P_B10 P_TOP sky130_fd_pr__cap_mim_m3_1 l=3 w=3
X4610 P_B9 P_TOP sky130_fd_pr__cap_mim_m3_1 l=3 w=3
X4611 P_B11 P_TOP sky130_fd_pr__cap_mim_m3_1 l=3 w=3
X4612 P_B11 P_TOP sky130_fd_pr__cap_mim_m3_1 l=3 w=3
X4613 P_B11 P_TOP sky130_fd_pr__cap_mim_m3_1 l=3 w=3
X4614 N_B11 N_TOP sky130_fd_pr__cap_mim_m3_1 l=3 w=3
X4615 P_B7 P_TOP sky130_fd_pr__cap_mim_m3_1 l=3 w=3
X4616 N_B11 N_TOP sky130_fd_pr__cap_mim_m3_1 l=3 w=3
X4617 P_B11 P_TOP sky130_fd_pr__cap_mim_m3_1 l=3 w=3
X4618 N_B11 N_TOP sky130_fd_pr__cap_mim_m3_1 l=3 w=3
X4619 P_B10 P_TOP sky130_fd_pr__cap_mim_m3_1 l=3 w=3
X4620 P_EDGE_BIAS P_EDGE_BIAS sky130_fd_pr__cap_mim_m3_1 l=3 w=3
X4621 N_B10 N_TOP sky130_fd_pr__cap_mim_m3_1 l=3 w=3
X4622 P_B10 P_TOP sky130_fd_pr__cap_mim_m3_1 l=3 w=3
X4623 N_B11 N_TOP sky130_fd_pr__cap_mim_m3_1 l=3 w=3
X4624 N_EDGE_BIAS N_EDGE_BIAS sky130_fd_pr__cap_mim_m3_1 l=3 w=3
X4625 N_B11 N_TOP sky130_fd_pr__cap_mim_m3_1 l=3 w=3
X4626 P_B11 P_TOP sky130_fd_pr__cap_mim_m3_1 l=3 w=3
X4627 P_B8 P_TOP sky130_fd_pr__cap_mim_m3_1 l=3 w=3
X4628 N_B10 N_TOP sky130_fd_pr__cap_mim_m3_1 l=3 w=3
X4629 P_B10 P_TOP sky130_fd_pr__cap_mim_m3_1 l=3 w=3
X4630 P_B5 P_TOP sky130_fd_pr__cap_mim_m3_1 l=3 w=3
X4631 P_B8 P_TOP sky130_fd_pr__cap_mim_m3_1 l=3 w=3
X4632 P_B11 P_TOP sky130_fd_pr__cap_mim_m3_1 l=3 w=3
X4633 P_EDGE_BIAS P_EDGE_BIAS sky130_fd_pr__cap_mim_m3_1 l=3 w=3
X4634 N_B11 N_TOP sky130_fd_pr__cap_mim_m3_1 l=3 w=3
X4635 P_B11 P_TOP sky130_fd_pr__cap_mim_m3_1 l=3 w=3
X4636 N_B11 N_TOP sky130_fd_pr__cap_mim_m3_1 l=3 w=3
X4637 P_B10 P_TOP sky130_fd_pr__cap_mim_m3_1 l=3 w=3
X4638 P_B9 P_TOP sky130_fd_pr__cap_mim_m3_1 l=3 w=3
X4639 P_B9 P_TOP sky130_fd_pr__cap_mim_m3_1 l=3 w=3
X4640 N_B10 N_TOP sky130_fd_pr__cap_mim_m3_1 l=3 w=3
X4641 P_B10 P_TOP sky130_fd_pr__cap_mim_m3_1 l=3 w=3
X4642 N_EDGE_BIAS N_EDGE_BIAS sky130_fd_pr__cap_mim_m3_1 l=3 w=3
X4643 P_B9 P_TOP sky130_fd_pr__cap_mim_m3_1 l=3 w=3
X4644 N_B10 N_TOP sky130_fd_pr__cap_mim_m3_1 l=3 w=3
X4645 P_B11 P_TOP sky130_fd_pr__cap_mim_m3_1 l=3 w=3
X4646 N_B11 N_TOP sky130_fd_pr__cap_mim_m3_1 l=3 w=3
X4647 N_B10 N_TOP sky130_fd_pr__cap_mim_m3_1 l=3 w=3
X4648 P_B11 P_TOP sky130_fd_pr__cap_mim_m3_1 l=3 w=3
X4649 N_B9 N_TOP sky130_fd_pr__cap_mim_m3_1 l=3 w=3
X4650 P_B9 P_TOP sky130_fd_pr__cap_mim_m3_1 l=3 w=3
X4651 P_B11 P_TOP sky130_fd_pr__cap_mim_m3_1 l=3 w=3
X4652 N_B11 N_TOP sky130_fd_pr__cap_mim_m3_1 l=3 w=3
X4653 N_B10 N_TOP sky130_fd_pr__cap_mim_m3_1 l=3 w=3
X4654 P_B10 P_TOP sky130_fd_pr__cap_mim_m3_1 l=3 w=3
X4655 P_B11 P_TOP sky130_fd_pr__cap_mim_m3_1 l=3 w=3
X4656 N_B10 N_TOP sky130_fd_pr__cap_mim_m3_1 l=3 w=3
X4657 P_B11 P_TOP sky130_fd_pr__cap_mim_m3_1 l=3 w=3
X4658 P_B11 P_TOP sky130_fd_pr__cap_mim_m3_1 l=3 w=3
X4659 N_B10 N_TOP sky130_fd_pr__cap_mim_m3_1 l=3 w=3
X4660 P_B11 P_TOP sky130_fd_pr__cap_mim_m3_1 l=3 w=3
X4661 N_B10 N_TOP sky130_fd_pr__cap_mim_m3_1 l=3 w=3
X4662 P_B10 P_TOP sky130_fd_pr__cap_mim_m3_1 l=3 w=3
X4663 N_B8 N_TOP sky130_fd_pr__cap_mim_m3_1 l=3 w=3
X4664 P_EDGE_BIAS P_EDGE_BIAS sky130_fd_pr__cap_mim_m3_1 l=3 w=3
X4665 P_B11 P_TOP sky130_fd_pr__cap_mim_m3_1 l=3 w=3
X4666 N_B11 N_TOP sky130_fd_pr__cap_mim_m3_1 l=3 w=3
X4667 P_B11 P_TOP sky130_fd_pr__cap_mim_m3_1 l=3 w=3
X4668 P_B9 P_TOP sky130_fd_pr__cap_mim_m3_1 l=3 w=3
X4669 P_EDGE_BIAS P_EDGE_BIAS sky130_fd_pr__cap_mim_m3_1 l=3 w=3
X4670 N_B11 N_TOP sky130_fd_pr__cap_mim_m3_1 l=3 w=3
X4671 N_B10 N_TOP sky130_fd_pr__cap_mim_m3_1 l=3 w=3
X4672 P_B7 P_TOP sky130_fd_pr__cap_mim_m3_1 l=3 w=3
X4673 P_B11 P_TOP sky130_fd_pr__cap_mim_m3_1 l=3 w=3
X4674 N_B10 N_TOP sky130_fd_pr__cap_mim_m3_1 l=3 w=3
X4675 P_B11 P_TOP sky130_fd_pr__cap_mim_m3_1 l=3 w=3
X4676 P_B9 P_TOP sky130_fd_pr__cap_mim_m3_1 l=3 w=3
X4677 N_B9 N_TOP sky130_fd_pr__cap_mim_m3_1 l=3 w=3
X4678 P_B9 P_TOP sky130_fd_pr__cap_mim_m3_1 l=3 w=3
X4679 N_B11 N_TOP sky130_fd_pr__cap_mim_m3_1 l=3 w=3
X4680 N_B8 N_TOP sky130_fd_pr__cap_mim_m3_1 l=3 w=3
X4681 P_B8 P_TOP sky130_fd_pr__cap_mim_m3_1 l=3 w=3
X4682 P_B10 P_TOP sky130_fd_pr__cap_mim_m3_1 l=3 w=3
X4683 N_B11 N_TOP sky130_fd_pr__cap_mim_m3_1 l=3 w=3
X4684 P_B11 P_TOP sky130_fd_pr__cap_mim_m3_1 l=3 w=3
X4685 P_B11 P_TOP sky130_fd_pr__cap_mim_m3_1 l=3 w=3
X4686 P_B11 P_TOP sky130_fd_pr__cap_mim_m3_1 l=3 w=3
X4687 P_B10 P_TOP sky130_fd_pr__cap_mim_m3_1 l=3 w=3
X4688 N_B9 N_TOP sky130_fd_pr__cap_mim_m3_1 l=3 w=3
X4689 P_B9 P_TOP sky130_fd_pr__cap_mim_m3_1 l=3 w=3
X4690 N_EDGE_BIAS N_EDGE_BIAS sky130_fd_pr__cap_mim_m3_1 l=3 w=3
X4691 P_B11 P_TOP sky130_fd_pr__cap_mim_m3_1 l=3 w=3
X4692 N_B7 N_TOP sky130_fd_pr__cap_mim_m3_1 l=3 w=3
X4693 P_B8 P_TOP sky130_fd_pr__cap_mim_m3_1 l=3 w=3
X4694 N_B10 N_TOP sky130_fd_pr__cap_mim_m3_1 l=3 w=3
X4695 P_B10 P_TOP sky130_fd_pr__cap_mim_m3_1 l=3 w=3
X4696 N_B11 N_TOP sky130_fd_pr__cap_mim_m3_1 l=3 w=3
X4697 N_B11 N_TOP sky130_fd_pr__cap_mim_m3_1 l=3 w=3
X4698 P_B11 P_TOP sky130_fd_pr__cap_mim_m3_1 l=3 w=3
X4699 N_B8 N_TOP sky130_fd_pr__cap_mim_m3_1 l=3 w=3
X4700 N_B11 N_TOP sky130_fd_pr__cap_mim_m3_1 l=3 w=3
X4701 N_B10 N_TOP sky130_fd_pr__cap_mim_m3_1 l=3 w=3
X4702 P_B10 P_TOP sky130_fd_pr__cap_mim_m3_1 l=3 w=3
X4703 N_B8 N_TOP sky130_fd_pr__cap_mim_m3_1 l=3 w=3
X4704 P_B10 P_TOP sky130_fd_pr__cap_mim_m3_1 l=3 w=3
X4705 P_EDGE_BIAS P_EDGE_BIAS sky130_fd_pr__cap_mim_m3_1 l=3 w=3
X4706 N_B11 N_TOP sky130_fd_pr__cap_mim_m3_1 l=3 w=3
X4707 P_B11 P_TOP sky130_fd_pr__cap_mim_m3_1 l=3 w=3
X4708 N_B6 N_TOP sky130_fd_pr__cap_mim_m3_1 l=3 w=3
X4709 P_B11 P_TOP sky130_fd_pr__cap_mim_m3_1 l=3 w=3
X4710 P_B10 P_TOP sky130_fd_pr__cap_mim_m3_1 l=3 w=3
X4711 P_B11 P_TOP sky130_fd_pr__cap_mim_m3_1 l=3 w=3
X4712 N_B11 N_TOP sky130_fd_pr__cap_mim_m3_1 l=3 w=3
X4713 N_B9 N_TOP sky130_fd_pr__cap_mim_m3_1 l=3 w=3
X4714 N_B10 N_TOP sky130_fd_pr__cap_mim_m3_1 l=3 w=3
X4715 P_B10 P_TOP sky130_fd_pr__cap_mim_m3_1 l=3 w=3
X4716 P_B11 P_TOP sky130_fd_pr__cap_mim_m3_1 l=3 w=3
X4717 N_B11 N_TOP sky130_fd_pr__cap_mim_m3_1 l=3 w=3
X4718 P_B11 P_TOP sky130_fd_pr__cap_mim_m3_1 l=3 w=3
X4719 N_B6 N_TOP sky130_fd_pr__cap_mim_m3_1 l=3 w=3
X4720 P_B6 P_TOP sky130_fd_pr__cap_mim_m3_1 l=3 w=3
X4721 N_EDGE_BIAS N_EDGE_BIAS sky130_fd_pr__cap_mim_m3_1 l=3 w=3
X4722 P_B10 P_TOP sky130_fd_pr__cap_mim_m3_1 l=3 w=3
X4723 N_B11 N_TOP sky130_fd_pr__cap_mim_m3_1 l=3 w=3
X4724 N_B9 N_TOP sky130_fd_pr__cap_mim_m3_1 l=3 w=3
X4725 P_B11 P_TOP sky130_fd_pr__cap_mim_m3_1 l=3 w=3
X4726 P_EDGE_BIAS P_EDGE_BIAS sky130_fd_pr__cap_mim_m3_1 l=3 w=3
X4727 P_B11 P_TOP sky130_fd_pr__cap_mim_m3_1 l=3 w=3
X4728 N_B11 N_TOP sky130_fd_pr__cap_mim_m3_1 l=3 w=3
X4729 N_B11 N_TOP sky130_fd_pr__cap_mim_m3_1 l=3 w=3
X4730 N_B11 N_TOP sky130_fd_pr__cap_mim_m3_1 l=3 w=3
X4731 P_B8 P_TOP sky130_fd_pr__cap_mim_m3_1 l=3 w=3
X4732 P_B10 P_TOP sky130_fd_pr__cap_mim_m3_1 l=3 w=3
X4733 N_EDGE_BIAS N_EDGE_BIAS sky130_fd_pr__cap_mim_m3_1 l=3 w=3
X4734 P_B10 P_TOP sky130_fd_pr__cap_mim_m3_1 l=3 w=3
X4735 N_EDGE_BIAS N_EDGE_BIAS sky130_fd_pr__cap_mim_m3_1 l=3 w=3
X4736 P_B11 P_TOP sky130_fd_pr__cap_mim_m3_1 l=3 w=3
X4737 P_B8 P_TOP sky130_fd_pr__cap_mim_m3_1 l=3 w=3
X4738 P_B10 P_TOP sky130_fd_pr__cap_mim_m3_1 l=3 w=3
X4739 P_B11 P_TOP sky130_fd_pr__cap_mim_m3_1 l=3 w=3
X4740 N_EDGE_BIAS N_EDGE_BIAS sky130_fd_pr__cap_mim_m3_1 l=3 w=3
X4741 P_B6 P_TOP sky130_fd_pr__cap_mim_m3_1 l=3 w=3
X4742 N_B11 N_TOP sky130_fd_pr__cap_mim_m3_1 l=3 w=3
X4743 P_B9 P_TOP sky130_fd_pr__cap_mim_m3_1 l=3 w=3
X4744 P_B11 P_TOP sky130_fd_pr__cap_mim_m3_1 l=3 w=3
X4745 P_B9 P_TOP sky130_fd_pr__cap_mim_m3_1 l=3 w=3
X4746 N_B10 N_TOP sky130_fd_pr__cap_mim_m3_1 l=3 w=3
X4747 N_B11 N_TOP sky130_fd_pr__cap_mim_m3_1 l=3 w=3
X4748 N_B7 N_TOP sky130_fd_pr__cap_mim_m3_1 l=3 w=3
X4749 P_B10 P_TOP sky130_fd_pr__cap_mim_m3_1 l=3 w=3
X4750 N_B11 N_TOP sky130_fd_pr__cap_mim_m3_1 l=3 w=3
X4751 N_B10 N_TOP sky130_fd_pr__cap_mim_m3_1 l=3 w=3
X4752 P_B9 P_TOP sky130_fd_pr__cap_mim_m3_1 l=3 w=3
X4753 N_B11 N_TOP sky130_fd_pr__cap_mim_m3_1 l=3 w=3
X4754 P_B11 P_TOP sky130_fd_pr__cap_mim_m3_1 l=3 w=3
X4755 P_EDGE_BIAS P_EDGE_BIAS sky130_fd_pr__cap_mim_m3_1 l=3 w=3
X4756 P_B10 P_TOP sky130_fd_pr__cap_mim_m3_1 l=3 w=3
X4757 P_B9 P_TOP sky130_fd_pr__cap_mim_m3_1 l=3 w=3
X4758 P_B10 P_TOP sky130_fd_pr__cap_mim_m3_1 l=3 w=3
X4759 N_B8 N_TOP sky130_fd_pr__cap_mim_m3_1 l=3 w=3
X4760 P_B11 P_TOP sky130_fd_pr__cap_mim_m3_1 l=3 w=3
X4761 P_B11 P_TOP sky130_fd_pr__cap_mim_m3_1 l=3 w=3
X4762 P_B9 P_TOP sky130_fd_pr__cap_mim_m3_1 l=3 w=3
X4763 N_B10 N_TOP sky130_fd_pr__cap_mim_m3_1 l=3 w=3
X4764 P_EDGE_BIAS P_EDGE_BIAS sky130_fd_pr__cap_mim_m3_1 l=3 w=3
X4765 P_B11 P_TOP sky130_fd_pr__cap_mim_m3_1 l=3 w=3
X4766 P_B11 P_TOP sky130_fd_pr__cap_mim_m3_1 l=3 w=3
X4767 N_B10 N_TOP sky130_fd_pr__cap_mim_m3_1 l=3 w=3
X4768 P_B10 P_TOP sky130_fd_pr__cap_mim_m3_1 l=3 w=3
X4769 N_B11 N_TOP sky130_fd_pr__cap_mim_m3_1 l=3 w=3
X4770 P_B11 P_TOP sky130_fd_pr__cap_mim_m3_1 l=3 w=3
X4771 P_B9 P_TOP sky130_fd_pr__cap_mim_m3_1 l=3 w=3
X4772 P_B11 P_TOP sky130_fd_pr__cap_mim_m3_1 l=3 w=3
X4773 N_B11 N_TOP sky130_fd_pr__cap_mim_m3_1 l=3 w=3
X4774 N_B10 N_TOP sky130_fd_pr__cap_mim_m3_1 l=3 w=3
X4775 P_B10 P_TOP sky130_fd_pr__cap_mim_m3_1 l=3 w=3
X4776 N_B10 N_TOP sky130_fd_pr__cap_mim_m3_1 l=3 w=3
X4777 P_B10 P_TOP sky130_fd_pr__cap_mim_m3_1 l=3 w=3
X4778 P_B10 P_TOP sky130_fd_pr__cap_mim_m3_1 l=3 w=3
X4779 P_B9 P_TOP sky130_fd_pr__cap_mim_m3_1 l=3 w=3
X4780 P_B11 P_TOP sky130_fd_pr__cap_mim_m3_1 l=3 w=3
X4781 N_B9 N_TOP sky130_fd_pr__cap_mim_m3_1 l=3 w=3
X4782 P_B9 P_TOP sky130_fd_pr__cap_mim_m3_1 l=3 w=3
X4783 P_B8 P_TOP sky130_fd_pr__cap_mim_m3_1 l=3 w=3
X4784 N_B11 N_TOP sky130_fd_pr__cap_mim_m3_1 l=3 w=3
X4785 P_B10 P_TOP sky130_fd_pr__cap_mim_m3_1 l=3 w=3
X4786 P_B11 P_TOP sky130_fd_pr__cap_mim_m3_1 l=3 w=3
X4787 P_B8 P_TOP sky130_fd_pr__cap_mim_m3_1 l=3 w=3
X4788 P_B10 P_TOP sky130_fd_pr__cap_mim_m3_1 l=3 w=3
X4789 N_B11 N_TOP sky130_fd_pr__cap_mim_m3_1 l=3 w=3
X4790 P_B10 P_TOP sky130_fd_pr__cap_mim_m3_1 l=3 w=3
X4791 N_B11 N_TOP sky130_fd_pr__cap_mim_m3_1 l=3 w=3
X4792 P_B11 P_TOP sky130_fd_pr__cap_mim_m3_1 l=3 w=3
X4793 P_B11 P_TOP sky130_fd_pr__cap_mim_m3_1 l=3 w=3
X4794 N_B9 N_TOP sky130_fd_pr__cap_mim_m3_1 l=3 w=3
X4795 N_B11 N_TOP sky130_fd_pr__cap_mim_m3_1 l=3 w=3
X4796 P_B11 P_TOP sky130_fd_pr__cap_mim_m3_1 l=3 w=3
X4797 N_B8 N_TOP sky130_fd_pr__cap_mim_m3_1 l=3 w=3
X4798 P_B8 P_TOP sky130_fd_pr__cap_mim_m3_1 l=3 w=3
X4799 N_B10 N_TOP sky130_fd_pr__cap_mim_m3_1 l=3 w=3
X4800 P_B10 P_TOP sky130_fd_pr__cap_mim_m3_1 l=3 w=3
X4801 N_B11 N_TOP sky130_fd_pr__cap_mim_m3_1 l=3 w=3
X4802 N_B11 N_TOP sky130_fd_pr__cap_mim_m3_1 l=3 w=3
X4803 P_B10 P_TOP sky130_fd_pr__cap_mim_m3_1 l=3 w=3
X4804 N_B11 N_TOP sky130_fd_pr__cap_mim_m3_1 l=3 w=3
X4805 P_B11 P_TOP sky130_fd_pr__cap_mim_m3_1 l=3 w=3
X4806 P_B10 P_TOP sky130_fd_pr__cap_mim_m3_1 l=3 w=3
X4807 N_B8 N_TOP sky130_fd_pr__cap_mim_m3_1 l=3 w=3
X4808 P_B11 P_TOP sky130_fd_pr__cap_mim_m3_1 l=3 w=3
X4809 N_B10 N_TOP sky130_fd_pr__cap_mim_m3_1 l=3 w=3
X4810 N_B11 N_TOP sky130_fd_pr__cap_mim_m3_1 l=3 w=3
X4811 P_B10 P_TOP sky130_fd_pr__cap_mim_m3_1 l=3 w=3
X4812 N_B9 N_TOP sky130_fd_pr__cap_mim_m3_1 l=3 w=3
X4813 N_B11 N_TOP sky130_fd_pr__cap_mim_m3_1 l=3 w=3
X4814 N_B11 N_TOP sky130_fd_pr__cap_mim_m3_1 l=3 w=3
X4815 N_B9 N_TOP sky130_fd_pr__cap_mim_m3_1 l=3 w=3
X4816 N_B9 N_TOP sky130_fd_pr__cap_mim_m3_1 l=3 w=3
X4817 N_B10 N_TOP sky130_fd_pr__cap_mim_m3_1 l=3 w=3
X4818 P_B10 P_TOP sky130_fd_pr__cap_mim_m3_1 l=3 w=3
X4819 N_B5 N_TOP sky130_fd_pr__cap_mim_m3_1 l=3 w=3
X4820 P_B6 P_TOP sky130_fd_pr__cap_mim_m3_1 l=3 w=3
X4821 P_B11 P_TOP sky130_fd_pr__cap_mim_m3_1 l=3 w=3
X4822 N_B11 N_TOP sky130_fd_pr__cap_mim_m3_1 l=3 w=3
X4823 P_B11 P_TOP sky130_fd_pr__cap_mim_m3_1 l=3 w=3
X4824 P_B11 P_TOP sky130_fd_pr__cap_mim_m3_1 l=3 w=3
X4825 N_EDGE_BIAS N_EDGE_BIAS sky130_fd_pr__cap_mim_m3_1 l=3 w=3
X4826 P_B11 P_TOP sky130_fd_pr__cap_mim_m3_1 l=3 w=3
X4827 P_B11 P_TOP sky130_fd_pr__cap_mim_m3_1 l=3 w=3
X4828 P_B10 P_TOP sky130_fd_pr__cap_mim_m3_1 l=3 w=3
X4829 N_B11 N_TOP sky130_fd_pr__cap_mim_m3_1 l=3 w=3
X4830 N_B9 N_TOP sky130_fd_pr__cap_mim_m3_1 l=3 w=3
X4831 P_B11 P_TOP sky130_fd_pr__cap_mim_m3_1 l=3 w=3
X4832 P_B7 P_TOP sky130_fd_pr__cap_mim_m3_1 l=3 w=3
X4833 N_B11 N_TOP sky130_fd_pr__cap_mim_m3_1 l=3 w=3
X4834 P_B11 P_TOP sky130_fd_pr__cap_mim_m3_1 l=3 w=3
X4835 P_B11 P_TOP sky130_fd_pr__cap_mim_m3_1 l=3 w=3
X4836 N_B11 N_TOP sky130_fd_pr__cap_mim_m3_1 l=3 w=3
X4837 P_B11 P_TOP sky130_fd_pr__cap_mim_m3_1 l=3 w=3
X4838 N_B11 N_TOP sky130_fd_pr__cap_mim_m3_1 l=3 w=3
X4839 P_B11 P_TOP sky130_fd_pr__cap_mim_m3_1 l=3 w=3
X4840 P_B10 P_TOP sky130_fd_pr__cap_mim_m3_1 l=3 w=3
X4841 N_EDGE_BIAS N_EDGE_BIAS sky130_fd_pr__cap_mim_m3_1 l=3 w=3
X4842 N_B11 N_TOP sky130_fd_pr__cap_mim_m3_1 l=3 w=3
X4843 P_B5 P_TOP sky130_fd_pr__cap_mim_m3_1 l=3 w=3
X4844 P_B8 P_TOP sky130_fd_pr__cap_mim_m3_1 l=3 w=3
X4845 P_B11 P_TOP sky130_fd_pr__cap_mim_m3_1 l=3 w=3
X4846 N_B11 N_TOP sky130_fd_pr__cap_mim_m3_1 l=3 w=3
X4847 P_B10 P_TOP sky130_fd_pr__cap_mim_m3_1 l=3 w=3
X4848 P_B6 P_TOP sky130_fd_pr__cap_mim_m3_1 l=3 w=3
X4849 N_B11 N_TOP sky130_fd_pr__cap_mim_m3_1 l=3 w=3
X4850 P_B11 P_TOP sky130_fd_pr__cap_mim_m3_1 l=3 w=3
X4851 P_B9 P_TOP sky130_fd_pr__cap_mim_m3_1 l=3 w=3
X4852 P_B10 P_TOP sky130_fd_pr__cap_mim_m3_1 l=3 w=3
X4853 P_B9 P_TOP sky130_fd_pr__cap_mim_m3_1 l=3 w=3
X4854 N_B11 N_TOP sky130_fd_pr__cap_mim_m3_1 l=3 w=3
X4855 P_B11 P_TOP sky130_fd_pr__cap_mim_m3_1 l=3 w=3
X4856 N_B10 N_TOP sky130_fd_pr__cap_mim_m3_1 l=3 w=3
X4857 P_B10 P_TOP sky130_fd_pr__cap_mim_m3_1 l=3 w=3
X4858 N_B11 N_TOP sky130_fd_pr__cap_mim_m3_1 l=3 w=3
X4859 N_B11 N_TOP sky130_fd_pr__cap_mim_m3_1 l=3 w=3
X4860 P_B11 P_TOP sky130_fd_pr__cap_mim_m3_1 l=3 w=3
X4861 P_B9 P_TOP sky130_fd_pr__cap_mim_m3_1 l=3 w=3
X4862 P_B11 P_TOP sky130_fd_pr__cap_mim_m3_1 l=3 w=3
X4863 N_B10 N_TOP sky130_fd_pr__cap_mim_m3_1 l=3 w=3
X4864 P_B11 P_TOP sky130_fd_pr__cap_mim_m3_1 l=3 w=3
X4865 P_B10 P_TOP sky130_fd_pr__cap_mim_m3_1 l=3 w=3
X4866 P_B11 P_TOP sky130_fd_pr__cap_mim_m3_1 l=3 w=3
X4867 N_B10 N_TOP sky130_fd_pr__cap_mim_m3_1 l=3 w=3
X4868 N_B11 N_TOP sky130_fd_pr__cap_mim_m3_1 l=3 w=3
X4869 N_B11 N_TOP sky130_fd_pr__cap_mim_m3_1 l=3 w=3
X4870 N_B10 N_TOP sky130_fd_pr__cap_mim_m3_1 l=3 w=3
X4871 N_B10 N_TOP sky130_fd_pr__cap_mim_m3_1 l=3 w=3
X4872 P_B10 P_TOP sky130_fd_pr__cap_mim_m3_1 l=3 w=3
X4873 P_B11 P_TOP sky130_fd_pr__cap_mim_m3_1 l=3 w=3
X4874 N_B11 N_TOP sky130_fd_pr__cap_mim_m3_1 l=3 w=3
X4875 N_EDGE_BIAS N_EDGE_BIAS sky130_fd_pr__cap_mim_m3_1 l=3 w=3
X4876 N_B11 N_TOP sky130_fd_pr__cap_mim_m3_1 l=3 w=3
X4877 P_B11 P_TOP sky130_fd_pr__cap_mim_m3_1 l=3 w=3
X4878 N_EDGE_BIAS N_EDGE_BIAS sky130_fd_pr__cap_mim_m3_1 l=3 w=3
X4879 P_B9 P_TOP sky130_fd_pr__cap_mim_m3_1 l=3 w=3
X4880 P_B10 P_TOP sky130_fd_pr__cap_mim_m3_1 l=3 w=3
X4881 N_B10 N_TOP sky130_fd_pr__cap_mim_m3_1 l=3 w=3
X4882 N_B10 N_TOP sky130_fd_pr__cap_mim_m3_1 l=3 w=3
X4883 P_B7 P_TOP sky130_fd_pr__cap_mim_m3_1 l=3 w=3
X4884 P_B10 P_TOP sky130_fd_pr__cap_mim_m3_1 l=3 w=3
X4885 N_B10 N_TOP sky130_fd_pr__cap_mim_m3_1 l=3 w=3
X4886 N_B11 N_TOP sky130_fd_pr__cap_mim_m3_1 l=3 w=3
X4887 P_B9 P_TOP sky130_fd_pr__cap_mim_m3_1 l=3 w=3
X4888 P_B11 P_TOP sky130_fd_pr__cap_mim_m3_1 l=3 w=3
X4889 P_B9 P_TOP sky130_fd_pr__cap_mim_m3_1 l=3 w=3
X4890 N_B11 N_TOP sky130_fd_pr__cap_mim_m3_1 l=3 w=3
X4891 N_B10 N_TOP sky130_fd_pr__cap_mim_m3_1 l=3 w=3
X4892 P_B9 P_TOP sky130_fd_pr__cap_mim_m3_1 l=3 w=3
X4893 P_B8 P_TOP sky130_fd_pr__cap_mim_m3_1 l=3 w=3
X4894 P_B10 P_TOP sky130_fd_pr__cap_mim_m3_1 l=3 w=3
X4895 P_B11 P_TOP sky130_fd_pr__cap_mim_m3_1 l=3 w=3
X4896 P_B8 P_TOP sky130_fd_pr__cap_mim_m3_1 l=3 w=3
X4897 N_B10 N_TOP sky130_fd_pr__cap_mim_m3_1 l=3 w=3
X4898 P_B10 P_TOP sky130_fd_pr__cap_mim_m3_1 l=3 w=3
X4899 P_B9 P_TOP sky130_fd_pr__cap_mim_m3_1 l=3 w=3
X4900 P_B11 P_TOP sky130_fd_pr__cap_mim_m3_1 l=3 w=3
X4901 N_B11 N_TOP sky130_fd_pr__cap_mim_m3_1 l=3 w=3
X4902 N_B11 N_TOP sky130_fd_pr__cap_mim_m3_1 l=3 w=3
X4903 P_B10 P_TOP sky130_fd_pr__cap_mim_m3_1 l=3 w=3
X4904 N_B11 N_TOP sky130_fd_pr__cap_mim_m3_1 l=3 w=3
X4905 P_B11 P_TOP sky130_fd_pr__cap_mim_m3_1 l=3 w=3
X4906 N_B8 N_TOP sky130_fd_pr__cap_mim_m3_1 l=3 w=3
X4907 P_B8 P_TOP sky130_fd_pr__cap_mim_m3_1 l=3 w=3
X4908 N_B10 N_TOP sky130_fd_pr__cap_mim_m3_1 l=3 w=3
X4909 P_B11 P_TOP sky130_fd_pr__cap_mim_m3_1 l=3 w=3
X4910 P_B10 P_TOP sky130_fd_pr__cap_mim_m3_1 l=3 w=3
X4911 P_B10 P_TOP sky130_fd_pr__cap_mim_m3_1 l=3 w=3
X4912 P_B11 P_TOP sky130_fd_pr__cap_mim_m3_1 l=3 w=3
X4913 N_B11 N_TOP sky130_fd_pr__cap_mim_m3_1 l=3 w=3
X4914 P_B11 P_TOP sky130_fd_pr__cap_mim_m3_1 l=3 w=3
X4915 N_B8 N_TOP sky130_fd_pr__cap_mim_m3_1 l=3 w=3
X4916 N_B11 N_TOP sky130_fd_pr__cap_mim_m3_1 l=3 w=3
X4917 N_B11 N_TOP sky130_fd_pr__cap_mim_m3_1 l=3 w=3
X4918 N_B9 N_TOP sky130_fd_pr__cap_mim_m3_1 l=3 w=3
X4919 P_B9 P_TOP sky130_fd_pr__cap_mim_m3_1 l=3 w=3
X4920 N_B11 N_TOP sky130_fd_pr__cap_mim_m3_1 l=3 w=3
X4921 N_B9 N_TOP sky130_fd_pr__cap_mim_m3_1 l=3 w=3
X4922 N_B9 N_TOP sky130_fd_pr__cap_mim_m3_1 l=3 w=3
X4923 P_B11 P_TOP sky130_fd_pr__cap_mim_m3_1 l=3 w=3
X4924 N_B11 N_TOP sky130_fd_pr__cap_mim_m3_1 l=3 w=3
X4925 P_B11 P_TOP sky130_fd_pr__cap_mim_m3_1 l=3 w=3
X4926 N_B10 N_TOP sky130_fd_pr__cap_mim_m3_1 l=3 w=3
X4927 N_B6 N_TOP sky130_fd_pr__cap_mim_m3_1 l=3 w=3
X4928 P_B6 P_TOP sky130_fd_pr__cap_mim_m3_1 l=3 w=3
X4929 P_B11 P_TOP sky130_fd_pr__cap_mim_m3_1 l=3 w=3
X4930 P_EDGE_BIAS P_EDGE_BIAS sky130_fd_pr__cap_mim_m3_1 l=3 w=3
X4931 N_EDGE_BIAS N_EDGE_BIAS sky130_fd_pr__cap_mim_m3_1 l=3 w=3
X4932 N_B10 N_TOP sky130_fd_pr__cap_mim_m3_1 l=3 w=3
X4933 P_B11 P_TOP sky130_fd_pr__cap_mim_m3_1 l=3 w=3
X4934 N_B11 N_TOP sky130_fd_pr__cap_mim_m3_1 l=3 w=3
X4935 N_B9 N_TOP sky130_fd_pr__cap_mim_m3_1 l=3 w=3
X4936 N_B11 N_TOP sky130_fd_pr__cap_mim_m3_1 l=3 w=3
X4937 N_B11 N_TOP sky130_fd_pr__cap_mim_m3_1 l=3 w=3
X4938 N_B10 N_TOP sky130_fd_pr__cap_mim_m3_1 l=3 w=3
X4939 N_B9 N_TOP sky130_fd_pr__cap_mim_m3_1 l=3 w=3
X4940 P_B9 P_TOP sky130_fd_pr__cap_mim_m3_1 l=3 w=3
X4941 P_B11 P_TOP sky130_fd_pr__cap_mim_m3_1 l=3 w=3
X4942 N_B11 N_TOP sky130_fd_pr__cap_mim_m3_1 l=3 w=3
X4943 P_B7 P_TOP sky130_fd_pr__cap_mim_m3_1 l=3 w=3
X4944 P_B11 P_TOP sky130_fd_pr__cap_mim_m3_1 l=3 w=3
X4945 P_B11 P_TOP sky130_fd_pr__cap_mim_m3_1 l=3 w=3
X4946 N_B11 N_TOP sky130_fd_pr__cap_mim_m3_1 l=3 w=3
X4947 N_B9 N_TOP sky130_fd_pr__cap_mim_m3_1 l=3 w=3
X4948 N_EDGE_BIAS N_EDGE_BIAS sky130_fd_pr__cap_mim_m3_1 l=3 w=3
X4949 P_B10 P_TOP sky130_fd_pr__cap_mim_m3_1 l=3 w=3
X4950 N_EDGE_BIAS N_EDGE_BIAS sky130_fd_pr__cap_mim_m3_1 l=3 w=3
X4951 P_B8 P_TOP sky130_fd_pr__cap_mim_m3_1 l=3 w=3
X4952 P_B10 P_TOP sky130_fd_pr__cap_mim_m3_1 l=3 w=3
X4953 P_B10 P_TOP sky130_fd_pr__cap_mim_m3_1 l=3 w=3
X4954 P_B6 P_TOP sky130_fd_pr__cap_mim_m3_1 l=3 w=3
X4955 P_B11 P_TOP sky130_fd_pr__cap_mim_m3_1 l=3 w=3
X4956 N_B11 N_TOP sky130_fd_pr__cap_mim_m3_1 l=3 w=3
X4957 P_B10 P_TOP sky130_fd_pr__cap_mim_m3_1 l=3 w=3
X4958 N_B9 N_TOP sky130_fd_pr__cap_mim_m3_1 l=3 w=3
X4959 P_B11 P_TOP sky130_fd_pr__cap_mim_m3_1 l=3 w=3
X4960 P_B9 P_TOP sky130_fd_pr__cap_mim_m3_1 l=3 w=3
X4961 N_B10 N_TOP sky130_fd_pr__cap_mim_m3_1 l=3 w=3
X4962 P_B10 P_TOP sky130_fd_pr__cap_mim_m3_1 l=3 w=3
X4963 N_B11 N_TOP sky130_fd_pr__cap_mim_m3_1 l=3 w=3
X4964 N_B10 N_TOP sky130_fd_pr__cap_mim_m3_1 l=3 w=3
X4965 N_B10 N_TOP sky130_fd_pr__cap_mim_m3_1 l=3 w=3
X4966 P_B10 P_TOP sky130_fd_pr__cap_mim_m3_1 l=3 w=3
X4967 N_B9 N_TOP sky130_fd_pr__cap_mim_m3_1 l=3 w=3
X4968 P_B11 P_TOP sky130_fd_pr__cap_mim_m3_1 l=3 w=3
X4969 P_B10 P_TOP sky130_fd_pr__cap_mim_m3_1 l=3 w=3
X4970 P_B9 P_TOP sky130_fd_pr__cap_mim_m3_1 l=3 w=3
X4971 P_B11 P_TOP sky130_fd_pr__cap_mim_m3_1 l=3 w=3
X4972 N_B11 N_TOP sky130_fd_pr__cap_mim_m3_1 l=3 w=3
X4973 P_B10 P_TOP sky130_fd_pr__cap_mim_m3_1 l=3 w=3
X4974 N_B10 N_TOP sky130_fd_pr__cap_mim_m3_1 l=3 w=3
X4975 N_B10 N_TOP sky130_fd_pr__cap_mim_m3_1 l=3 w=3
X4976 P_B10 P_TOP sky130_fd_pr__cap_mim_m3_1 l=3 w=3
X4977 N_B11 N_TOP sky130_fd_pr__cap_mim_m3_1 l=3 w=3
X4978 P_B11 P_TOP sky130_fd_pr__cap_mim_m3_1 l=3 w=3
X4979 P_B11 P_TOP sky130_fd_pr__cap_mim_m3_1 l=3 w=3
X4980 N_B10 N_TOP sky130_fd_pr__cap_mim_m3_1 l=3 w=3
X4981 P_B10 P_TOP sky130_fd_pr__cap_mim_m3_1 l=3 w=3
X4982 P_B11 P_TOP sky130_fd_pr__cap_mim_m3_1 l=3 w=3
X4983 N_B8 N_TOP sky130_fd_pr__cap_mim_m3_1 l=3 w=3
X4984 P_B11 P_TOP sky130_fd_pr__cap_mim_m3_1 l=3 w=3
X4985 P_B11 P_TOP sky130_fd_pr__cap_mim_m3_1 l=3 w=3
X4986 N_B10 N_TOP sky130_fd_pr__cap_mim_m3_1 l=3 w=3
X4987 P_B11 P_TOP sky130_fd_pr__cap_mim_m3_1 l=3 w=3
X4988 P_B11 P_TOP sky130_fd_pr__cap_mim_m3_1 l=3 w=3
X4989 N_B11 N_TOP sky130_fd_pr__cap_mim_m3_1 l=3 w=3
X4990 N_B10 N_TOP sky130_fd_pr__cap_mim_m3_1 l=3 w=3
X4991 N_B10 N_TOP sky130_fd_pr__cap_mim_m3_1 l=3 w=3
X4992 P_B11 P_TOP sky130_fd_pr__cap_mim_m3_1 l=3 w=3
X4993 P_B11 P_TOP sky130_fd_pr__cap_mim_m3_1 l=3 w=3
X4994 N_B11 N_TOP sky130_fd_pr__cap_mim_m3_1 l=3 w=3
X4995 N_B10 N_TOP sky130_fd_pr__cap_mim_m3_1 l=3 w=3
X4996 P_B11 P_TOP sky130_fd_pr__cap_mim_m3_1 l=3 w=3
X4997 P_B9 P_TOP sky130_fd_pr__cap_mim_m3_1 l=3 w=3
X4998 P_B9 P_TOP sky130_fd_pr__cap_mim_m3_1 l=3 w=3
X4999 P_B11 P_TOP sky130_fd_pr__cap_mim_m3_1 l=3 w=3
X5000 N_B11 N_TOP sky130_fd_pr__cap_mim_m3_1 l=3 w=3
X5001 N_B10 N_TOP sky130_fd_pr__cap_mim_m3_1 l=3 w=3
X5002 P_B11 P_TOP sky130_fd_pr__cap_mim_m3_1 l=3 w=3
X5003 N_B11 N_TOP sky130_fd_pr__cap_mim_m3_1 l=3 w=3
X5004 N_B2 N_TOP sky130_fd_pr__cap_mim_m3_1 l=3 w=3
X5005 P_B11 P_TOP sky130_fd_pr__cap_mim_m3_1 l=3 w=3
X5006 P_B8 P_TOP sky130_fd_pr__cap_mim_m3_1 l=3 w=3
X5007 P_B10 P_TOP sky130_fd_pr__cap_mim_m3_1 l=3 w=3
X5008 N_B11 N_TOP sky130_fd_pr__cap_mim_m3_1 l=3 w=3
X5009 P_B11 P_TOP sky130_fd_pr__cap_mim_m3_1 l=3 w=3
X5010 N_B9 N_TOP sky130_fd_pr__cap_mim_m3_1 l=3 w=3
X5011 P_B9 P_TOP sky130_fd_pr__cap_mim_m3_1 l=3 w=3
X5012 N_B11 N_TOP sky130_fd_pr__cap_mim_m3_1 l=3 w=3
X5013 P_B11 P_TOP sky130_fd_pr__cap_mim_m3_1 l=3 w=3
X5014 N_B7 N_TOP sky130_fd_pr__cap_mim_m3_1 l=3 w=3
X5015 N_B11 N_TOP sky130_fd_pr__cap_mim_m3_1 l=3 w=3
X5016 P_B8 P_TOP sky130_fd_pr__cap_mim_m3_1 l=3 w=3
X5017 N_B10 N_TOP sky130_fd_pr__cap_mim_m3_1 l=3 w=3
X5018 P_B10 P_TOP sky130_fd_pr__cap_mim_m3_1 l=3 w=3
X5019 N_B11 N_TOP sky130_fd_pr__cap_mim_m3_1 l=3 w=3
X5020 N_B11 N_TOP sky130_fd_pr__cap_mim_m3_1 l=3 w=3
X5021 P_B11 P_TOP sky130_fd_pr__cap_mim_m3_1 l=3 w=3
X5022 P_B11 P_TOP sky130_fd_pr__cap_mim_m3_1 l=3 w=3
X5023 P_B8 P_TOP sky130_fd_pr__cap_mim_m3_1 l=3 w=3
X5024 P_B11 P_TOP sky130_fd_pr__cap_mim_m3_1 l=3 w=3
X5025 P_B10 P_TOP sky130_fd_pr__cap_mim_m3_1 l=3 w=3
X5026 N_B8 N_TOP sky130_fd_pr__cap_mim_m3_1 l=3 w=3
X5027 P_B10 P_TOP sky130_fd_pr__cap_mim_m3_1 l=3 w=3
X5028 P_B11 P_TOP sky130_fd_pr__cap_mim_m3_1 l=3 w=3
X5029 N_B6 N_TOP sky130_fd_pr__cap_mim_m3_1 l=3 w=3
X5030 N_B8 N_TOP sky130_fd_pr__cap_mim_m3_1 l=3 w=3
X5031 N_B11 N_TOP sky130_fd_pr__cap_mim_m3_1 l=3 w=3
X5032 P_B10 P_TOP sky130_fd_pr__cap_mim_m3_1 l=3 w=3
X5033 N_B11 N_TOP sky130_fd_pr__cap_mim_m3_1 l=3 w=3
X5034 P_B11 P_TOP sky130_fd_pr__cap_mim_m3_1 l=3 w=3
X5035 N_B9 N_TOP sky130_fd_pr__cap_mim_m3_1 l=3 w=3
X5036 P_B9 P_TOP sky130_fd_pr__cap_mim_m3_1 l=3 w=3
X5037 N_EDGE_BIAS N_EDGE_BIAS sky130_fd_pr__cap_mim_m3_1 l=3 w=3
X5038 P_B10 P_TOP sky130_fd_pr__cap_mim_m3_1 l=3 w=3
X5039 N_B9 N_TOP sky130_fd_pr__cap_mim_m3_1 l=3 w=3
X5040 P_B11 P_TOP sky130_fd_pr__cap_mim_m3_1 l=3 w=3
X5041 N_B11 N_TOP sky130_fd_pr__cap_mim_m3_1 l=3 w=3
X5042 P_B11 P_TOP sky130_fd_pr__cap_mim_m3_1 l=3 w=3
X5043 N_B6 N_TOP sky130_fd_pr__cap_mim_m3_1 l=3 w=3
X5044 N_B11 N_TOP sky130_fd_pr__cap_mim_m3_1 l=3 w=3
X5045 P_B5 P_TOP sky130_fd_pr__cap_mim_m3_1 l=3 w=3
X5046 P_B10 P_TOP sky130_fd_pr__cap_mim_m3_1 l=3 w=3
X5047 N_B11 N_TOP sky130_fd_pr__cap_mim_m3_1 l=3 w=3
X5048 N_B11 N_TOP sky130_fd_pr__cap_mim_m3_1 l=3 w=3
X5049 N_B9 N_TOP sky130_fd_pr__cap_mim_m3_1 l=3 w=3
X5050 P_B9 P_TOP sky130_fd_pr__cap_mim_m3_1 l=3 w=3
X5051 N_B11 N_TOP sky130_fd_pr__cap_mim_m3_1 l=3 w=3
X5052 P_B11 P_TOP sky130_fd_pr__cap_mim_m3_1 l=3 w=3
X5053 N_B10 N_TOP sky130_fd_pr__cap_mim_m3_1 l=3 w=3
X5054 P_B11 P_TOP sky130_fd_pr__cap_mim_m3_1 l=3 w=3
X5055 N_B11 N_TOP sky130_fd_pr__cap_mim_m3_1 l=3 w=3
X5056 P_B9 P_TOP sky130_fd_pr__cap_mim_m3_1 l=3 w=3
X5057 N_B11 N_TOP sky130_fd_pr__cap_mim_m3_1 l=3 w=3
X5058 P_B10 P_TOP sky130_fd_pr__cap_mim_m3_1 l=3 w=3
X5059 P_B11 P_TOP sky130_fd_pr__cap_mim_m3_1 l=3 w=3
X5060 P_B10 P_TOP sky130_fd_pr__cap_mim_m3_1 l=3 w=3
X5061 P_B10 P_TOP sky130_fd_pr__cap_mim_m3_1 l=3 w=3
X5062 N_EDGE_BIAS N_EDGE_BIAS sky130_fd_pr__cap_mim_m3_1 l=3 w=3
X5063 P_B11 P_TOP sky130_fd_pr__cap_mim_m3_1 l=3 w=3
X5064 N_B10 N_TOP sky130_fd_pr__cap_mim_m3_1 l=3 w=3
X5065 P_B8 P_TOP sky130_fd_pr__cap_mim_m3_1 l=3 w=3
X5066 P_B11 P_TOP sky130_fd_pr__cap_mim_m3_1 l=3 w=3
X5067 P_B10 P_TOP sky130_fd_pr__cap_mim_m3_1 l=3 w=3
X5068 P_B6 P_TOP sky130_fd_pr__cap_mim_m3_1 l=3 w=3
X5069 N_B11 N_TOP sky130_fd_pr__cap_mim_m3_1 l=3 w=3
X5070 P_B9 P_TOP sky130_fd_pr__cap_mim_m3_1 l=3 w=3
X5071 N_B10 N_TOP sky130_fd_pr__cap_mim_m3_1 l=3 w=3
X5072 P_B10 P_TOP sky130_fd_pr__cap_mim_m3_1 l=3 w=3
X5073 P_B10 P_TOP sky130_fd_pr__cap_mim_m3_1 l=3 w=3
X5074 N_B11 N_TOP sky130_fd_pr__cap_mim_m3_1 l=3 w=3
X5075 N_B7 N_TOP sky130_fd_pr__cap_mim_m3_1 l=3 w=3
X5076 P_B11 P_TOP sky130_fd_pr__cap_mim_m3_1 l=3 w=3
X5077 N_B10 N_TOP sky130_fd_pr__cap_mim_m3_1 l=3 w=3
X5078 P_B10 P_TOP sky130_fd_pr__cap_mim_m3_1 l=3 w=3
X5079 N_B11 N_TOP sky130_fd_pr__cap_mim_m3_1 l=3 w=3
X5080 N_B11 N_TOP sky130_fd_pr__cap_mim_m3_1 l=3 w=3
X5081 P_B10 P_TOP sky130_fd_pr__cap_mim_m3_1 l=3 w=3
X5082 N_B9 N_TOP sky130_fd_pr__cap_mim_m3_1 l=3 w=3
X5083 P_B11 P_TOP sky130_fd_pr__cap_mim_m3_1 l=3 w=3
X5084 P_B11 P_TOP sky130_fd_pr__cap_mim_m3_1 l=3 w=3
X5085 P_B10 P_TOP sky130_fd_pr__cap_mim_m3_1 l=3 w=3
X5086 P_B9 P_TOP sky130_fd_pr__cap_mim_m3_1 l=3 w=3
X5087 N_B11 N_TOP sky130_fd_pr__cap_mim_m3_1 l=3 w=3
X5088 P_B10 P_TOP sky130_fd_pr__cap_mim_m3_1 l=3 w=3
X5089 N_B8 N_TOP sky130_fd_pr__cap_mim_m3_1 l=3 w=3
X5090 N_B10 N_TOP sky130_fd_pr__cap_mim_m3_1 l=3 w=3
X5091 P_B11 P_TOP sky130_fd_pr__cap_mim_m3_1 l=3 w=3
X5092 N_B11 N_TOP sky130_fd_pr__cap_mim_m3_1 l=3 w=3
X5093 N_B10 N_TOP sky130_fd_pr__cap_mim_m3_1 l=3 w=3
X5094 P_B10 P_TOP sky130_fd_pr__cap_mim_m3_1 l=3 w=3
X5095 N_B11 N_TOP sky130_fd_pr__cap_mim_m3_1 l=3 w=3
X5096 P_B11 P_TOP sky130_fd_pr__cap_mim_m3_1 l=3 w=3
X5097 P_B11 P_TOP sky130_fd_pr__cap_mim_m3_1 l=3 w=3
X5098 N_B11 N_TOP sky130_fd_pr__cap_mim_m3_1 l=3 w=3
X5099 N_B10 N_TOP sky130_fd_pr__cap_mim_m3_1 l=3 w=3
X5100 P_B10 P_TOP sky130_fd_pr__cap_mim_m3_1 l=3 w=3
X5101 N_B10 N_TOP sky130_fd_pr__cap_mim_m3_1 l=3 w=3
X5102 P_B11 P_TOP sky130_fd_pr__cap_mim_m3_1 l=3 w=3
X5103 P_B9 P_TOP sky130_fd_pr__cap_mim_m3_1 l=3 w=3
X5104 P_B11 P_TOP sky130_fd_pr__cap_mim_m3_1 l=3 w=3
X5105 N_B10 N_TOP sky130_fd_pr__cap_mim_m3_1 l=3 w=3
X5106 P_B10 P_TOP sky130_fd_pr__cap_mim_m3_1 l=3 w=3
X5107 N_B11 N_TOP sky130_fd_pr__cap_mim_m3_1 l=3 w=3
X5108 N_B11 N_TOP sky130_fd_pr__cap_mim_m3_1 l=3 w=3
X5109 P_B10 P_TOP sky130_fd_pr__cap_mim_m3_1 l=3 w=3
X5110 N_B10 N_TOP sky130_fd_pr__cap_mim_m3_1 l=3 w=3
X5111 P_B10 P_TOP sky130_fd_pr__cap_mim_m3_1 l=3 w=3
X5112 P_B9 P_TOP sky130_fd_pr__cap_mim_m3_1 l=3 w=3
X5113 P_B11 P_TOP sky130_fd_pr__cap_mim_m3_1 l=3 w=3
X5114 P_B11 P_TOP sky130_fd_pr__cap_mim_m3_1 l=3 w=3
X5115 N_EDGE_BIAS N_EDGE_BIAS sky130_fd_pr__cap_mim_m3_1 l=3 w=3
X5116 P_B9 P_TOP sky130_fd_pr__cap_mim_m3_1 l=3 w=3
X5117 P_B8 P_TOP sky130_fd_pr__cap_mim_m3_1 l=3 w=3
X5118 P_B9 P_TOP sky130_fd_pr__cap_mim_m3_1 l=3 w=3
X5119 N_B11 N_TOP sky130_fd_pr__cap_mim_m3_1 l=3 w=3
X5120 N_B11 N_TOP sky130_fd_pr__cap_mim_m3_1 l=3 w=3
X5121 P_B10 P_TOP sky130_fd_pr__cap_mim_m3_1 l=3 w=3
X5122 N_B11 N_TOP sky130_fd_pr__cap_mim_m3_1 l=3 w=3
X5123 P_EDGE_BIAS P_EDGE_BIAS sky130_fd_pr__cap_mim_m3_1 l=3 w=3
X5124 P_B8 P_TOP sky130_fd_pr__cap_mim_m3_1 l=3 w=3
X5125 N_B11 N_TOP sky130_fd_pr__cap_mim_m3_1 l=3 w=3
X5126 P_B11 P_TOP sky130_fd_pr__cap_mim_m3_1 l=3 w=3
X5127 P_B7 P_TOP sky130_fd_pr__cap_mim_m3_1 l=3 w=3
X5128 N_B9 N_TOP sky130_fd_pr__cap_mim_m3_1 l=3 w=3
X5129 P_B9 P_TOP sky130_fd_pr__cap_mim_m3_1 l=3 w=3
X5130 N_B11 N_TOP sky130_fd_pr__cap_mim_m3_1 l=3 w=3
X5131 N_B11 N_TOP sky130_fd_pr__cap_mim_m3_1 l=3 w=3
X5132 P_B11 P_TOP sky130_fd_pr__cap_mim_m3_1 l=3 w=3
X5133 N_B7 N_TOP sky130_fd_pr__cap_mim_m3_1 l=3 w=3
X5134 P_B10 P_TOP sky130_fd_pr__cap_mim_m3_1 l=3 w=3
X5135 P_B11 P_TOP sky130_fd_pr__cap_mim_m3_1 l=3 w=3
X5136 N_B8 N_TOP sky130_fd_pr__cap_mim_m3_1 l=3 w=3
X5137 P_B8 P_TOP sky130_fd_pr__cap_mim_m3_1 l=3 w=3
X5138 P_B10 P_TOP sky130_fd_pr__cap_mim_m3_1 l=3 w=3
X5139 N_B11 N_TOP sky130_fd_pr__cap_mim_m3_1 l=3 w=3
X5140 P_B11 P_TOP sky130_fd_pr__cap_mim_m3_1 l=3 w=3
X5141 P_B11 P_TOP sky130_fd_pr__cap_mim_m3_1 l=3 w=3
X5142 P_B10 P_TOP sky130_fd_pr__cap_mim_m3_1 l=3 w=3
X5143 N_B8 N_TOP sky130_fd_pr__cap_mim_m3_1 l=3 w=3
X5144 P_B8 P_TOP sky130_fd_pr__cap_mim_m3_1 l=3 w=3
X5145 N_B11 N_TOP sky130_fd_pr__cap_mim_m3_1 l=3 w=3
X5146 P_B11 P_TOP sky130_fd_pr__cap_mim_m3_1 l=3 w=3
X5147 N_B10 N_TOP sky130_fd_pr__cap_mim_m3_1 l=3 w=3
X5148 N_B11 N_TOP sky130_fd_pr__cap_mim_m3_1 l=3 w=3
X5149 N_B5 N_TOP sky130_fd_pr__cap_mim_m3_1 l=3 w=3
X5150 N_B9 N_TOP sky130_fd_pr__cap_mim_m3_1 l=3 w=3
X5151 P_B9 P_TOP sky130_fd_pr__cap_mim_m3_1 l=3 w=3
X5152 N_B11 N_TOP sky130_fd_pr__cap_mim_m3_1 l=3 w=3
X5153 P_B11 P_TOP sky130_fd_pr__cap_mim_m3_1 l=3 w=3
X5154 N_B11 N_TOP sky130_fd_pr__cap_mim_m3_1 l=3 w=3
X5155 N_B9 N_TOP sky130_fd_pr__cap_mim_m3_1 l=3 w=3
X5156 N_EDGE_BIAS N_EDGE_BIAS sky130_fd_pr__cap_mim_m3_1 l=3 w=3
X5157 P_B11 P_TOP sky130_fd_pr__cap_mim_m3_1 l=3 w=3
X5158 P_B9 P_TOP sky130_fd_pr__cap_mim_m3_1 l=3 w=3
X5159 P_B10 P_TOP sky130_fd_pr__cap_mim_m3_1 l=3 w=3
X5160 P_B6 P_TOP sky130_fd_pr__cap_mim_m3_1 l=3 w=3
X5161 N_B11 N_TOP sky130_fd_pr__cap_mim_m3_1 l=3 w=3
X5162 P_B11 P_TOP sky130_fd_pr__cap_mim_m3_1 l=3 w=3
X5163 P_B11 P_TOP sky130_fd_pr__cap_mim_m3_1 l=3 w=3
X5164 P_B10 P_TOP sky130_fd_pr__cap_mim_m3_1 l=3 w=3
X5165 N_B9 N_TOP sky130_fd_pr__cap_mim_m3_1 l=3 w=3
X5166 P_B11 P_TOP sky130_fd_pr__cap_mim_m3_1 l=3 w=3
X5167 N_B11 N_TOP sky130_fd_pr__cap_mim_m3_1 l=3 w=3
X5168 N_B10 N_TOP sky130_fd_pr__cap_mim_m3_1 l=3 w=3
X5169 N_B9 N_TOP sky130_fd_pr__cap_mim_m3_1 l=3 w=3
X5170 N_B11 N_TOP sky130_fd_pr__cap_mim_m3_1 l=3 w=3
X5171 P_B7 P_TOP sky130_fd_pr__cap_mim_m3_1 l=3 w=3
X5172 P_B11 P_TOP sky130_fd_pr__cap_mim_m3_1 l=3 w=3
X5173 N_B11 N_TOP sky130_fd_pr__cap_mim_m3_1 l=3 w=3
X5174 P_B11 P_TOP sky130_fd_pr__cap_mim_m3_1 l=3 w=3
X5175 P_EDGE_BIAS P_EDGE_BIAS sky130_fd_pr__cap_mim_m3_1 l=3 w=3
X5176 P_B10 P_TOP sky130_fd_pr__cap_mim_m3_1 l=3 w=3
X5177 P_EDGE_BIAS P_EDGE_BIAS sky130_fd_pr__cap_mim_m3_1 l=3 w=3
X5178 P_B11 P_TOP sky130_fd_pr__cap_mim_m3_1 l=3 w=3
X5179 N_B11 N_TOP sky130_fd_pr__cap_mim_m3_1 l=3 w=3
X5180 N_B11 N_TOP sky130_fd_pr__cap_mim_m3_1 l=3 w=3
X5181 P_B10 P_TOP sky130_fd_pr__cap_mim_m3_1 l=3 w=3
X5182 P_B11 P_TOP sky130_fd_pr__cap_mim_m3_1 l=3 w=3
X5183 N_B11 N_TOP sky130_fd_pr__cap_mim_m3_1 l=3 w=3
X5184 N_B11 N_TOP sky130_fd_pr__cap_mim_m3_1 l=3 w=3
X5185 P_EDGE_BIAS P_EDGE_BIAS sky130_fd_pr__cap_mim_m3_1 l=3 w=3
X5186 P_B10 P_TOP sky130_fd_pr__cap_mim_m3_1 l=3 w=3
X5187 N_B11 N_TOP sky130_fd_pr__cap_mim_m3_1 l=3 w=3
X5188 P_B10 P_TOP sky130_fd_pr__cap_mim_m3_1 l=3 w=3
X5189 P_EDGE_BIAS P_EDGE_BIAS sky130_fd_pr__cap_mim_m3_1 l=3 w=3
X5190 P_B7 P_TOP sky130_fd_pr__cap_mim_m3_1 l=3 w=3
X5191 P_B10 P_TOP sky130_fd_pr__cap_mim_m3_1 l=3 w=3
X5192 P_B10 P_TOP sky130_fd_pr__cap_mim_m3_1 l=3 w=3
X5193 N_B11 N_TOP sky130_fd_pr__cap_mim_m3_1 l=3 w=3
X5194 N_B7 N_TOP sky130_fd_pr__cap_mim_m3_1 l=3 w=3
X5195 N_B10 N_TOP sky130_fd_pr__cap_mim_m3_1 l=3 w=3
X5196 P_B10 P_TOP sky130_fd_pr__cap_mim_m3_1 l=3 w=3
X5197 N_B11 N_TOP sky130_fd_pr__cap_mim_m3_1 l=3 w=3
X5198 N_B11 N_TOP sky130_fd_pr__cap_mim_m3_1 l=3 w=3
X5199 P_B11 P_TOP sky130_fd_pr__cap_mim_m3_1 l=3 w=3
X5200 P_B10 P_TOP sky130_fd_pr__cap_mim_m3_1 l=3 w=3
X5201 N_B10 N_TOP sky130_fd_pr__cap_mim_m3_1 l=3 w=3
X5202 N_B8 N_TOP sky130_fd_pr__cap_mim_m3_1 l=3 w=3
X5203 N_B10 N_TOP sky130_fd_pr__cap_mim_m3_1 l=3 w=3
X5204 N_B10 N_TOP sky130_fd_pr__cap_mim_m3_1 l=3 w=3
X5205 P_B10 P_TOP sky130_fd_pr__cap_mim_m3_1 l=3 w=3
X5206 P_B11 P_TOP sky130_fd_pr__cap_mim_m3_1 l=3 w=3
X5207 N_B11 N_TOP sky130_fd_pr__cap_mim_m3_1 l=3 w=3
X5208 N_B11 N_TOP sky130_fd_pr__cap_mim_m3_1 l=3 w=3
X5209 P_B11 P_TOP sky130_fd_pr__cap_mim_m3_1 l=3 w=3
X5210 N_EDGE_BIAS N_EDGE_BIAS sky130_fd_pr__cap_mim_m3_1 l=3 w=3
X5211 P_B11 P_TOP sky130_fd_pr__cap_mim_m3_1 l=3 w=3
X5212 P_B10 P_TOP sky130_fd_pr__cap_mim_m3_1 l=3 w=3
X5213 N_B11 N_TOP sky130_fd_pr__cap_mim_m3_1 l=3 w=3
X5214 N_B8 N_TOP sky130_fd_pr__cap_mim_m3_1 l=3 w=3
X5215 N_B10 N_TOP sky130_fd_pr__cap_mim_m3_1 l=3 w=3
X5216 P_B11 P_TOP sky130_fd_pr__cap_mim_m3_1 l=3 w=3
X5217 N_B10 N_TOP sky130_fd_pr__cap_mim_m3_1 l=3 w=3
X5218 N_B11 N_TOP sky130_fd_pr__cap_mim_m3_1 l=3 w=3
X5219 P_B9 P_TOP sky130_fd_pr__cap_mim_m3_1 l=3 w=3
X5220 P_B11 P_TOP sky130_fd_pr__cap_mim_m3_1 l=3 w=3
X5221 N_B11 N_TOP sky130_fd_pr__cap_mim_m3_1 l=3 w=3
X5222 N_B10 N_TOP sky130_fd_pr__cap_mim_m3_1 l=3 w=3
X5223 N_B10 N_TOP sky130_fd_pr__cap_mim_m3_1 l=3 w=3
X5224 P_B7 P_TOP sky130_fd_pr__cap_mim_m3_1 l=3 w=3
X5225 N_B10 N_TOP sky130_fd_pr__cap_mim_m3_1 l=3 w=3
X5226 P_B9 P_TOP sky130_fd_pr__cap_mim_m3_1 l=3 w=3
X5227 P_B11 P_TOP sky130_fd_pr__cap_mim_m3_1 l=3 w=3
X5228 P_B9 P_TOP sky130_fd_pr__cap_mim_m3_1 l=3 w=3
X5229 P_B11 P_TOP sky130_fd_pr__cap_mim_m3_1 l=3 w=3
X5230 N_B11 N_TOP sky130_fd_pr__cap_mim_m3_1 l=3 w=3
X5231 N_B10 N_TOP sky130_fd_pr__cap_mim_m3_1 l=3 w=3
X5232 P_B9 P_TOP sky130_fd_pr__cap_mim_m3_1 l=3 w=3
X5233 P_B8 P_TOP sky130_fd_pr__cap_mim_m3_1 l=3 w=3
X5234 P_B8 P_TOP sky130_fd_pr__cap_mim_m3_1 l=3 w=3
X5235 P_B10 P_TOP sky130_fd_pr__cap_mim_m3_1 l=3 w=3
X5236 P_B11 P_TOP sky130_fd_pr__cap_mim_m3_1 l=3 w=3
X5237 N_B10 N_TOP sky130_fd_pr__cap_mim_m3_1 l=3 w=3
X5238 P_B11 P_TOP sky130_fd_pr__cap_mim_m3_1 l=3 w=3
X5239 P_B11 P_TOP sky130_fd_pr__cap_mim_m3_1 l=3 w=3
X5240 P_B9 P_TOP sky130_fd_pr__cap_mim_m3_1 l=3 w=3
X5241 P_EDGE_BIAS P_EDGE_BIAS sky130_fd_pr__cap_mim_m3_1 l=3 w=3
X5242 P_B7 P_TOP sky130_fd_pr__cap_mim_m3_1 l=3 w=3
X5243 P_B11 P_TOP sky130_fd_pr__cap_mim_m3_1 l=3 w=3
X5244 N_B11 N_TOP sky130_fd_pr__cap_mim_m3_1 l=3 w=3
X5245 P_B9 P_TOP sky130_fd_pr__cap_mim_m3_1 l=3 w=3
X5246 N_B11 N_TOP sky130_fd_pr__cap_mim_m3_1 l=3 w=3
X5247 N_B11 N_TOP sky130_fd_pr__cap_mim_m3_1 l=3 w=3
X5248 P_B8 P_TOP sky130_fd_pr__cap_mim_m3_1 l=3 w=3
X5249 P_B10 P_TOP sky130_fd_pr__cap_mim_m3_1 l=3 w=3
X5250 N_B11 N_TOP sky130_fd_pr__cap_mim_m3_1 l=3 w=3
X5251 P_B11 P_TOP sky130_fd_pr__cap_mim_m3_1 l=3 w=3
X5252 P_B11 P_TOP sky130_fd_pr__cap_mim_m3_1 l=3 w=3
X5253 P_B8 P_TOP sky130_fd_pr__cap_mim_m3_1 l=3 w=3
X5254 N_B10 N_TOP sky130_fd_pr__cap_mim_m3_1 l=3 w=3
X5255 P_B10 P_TOP sky130_fd_pr__cap_mim_m3_1 l=3 w=3
X5256 N_B11 N_TOP sky130_fd_pr__cap_mim_m3_1 l=3 w=3
X5257 P_B11 P_TOP sky130_fd_pr__cap_mim_m3_1 l=3 w=3
X5258 N_B8 N_TOP sky130_fd_pr__cap_mim_m3_1 l=3 w=3
X5259 P_B11 P_TOP sky130_fd_pr__cap_mim_m3_1 l=3 w=3
X5260 N_B11 N_TOP sky130_fd_pr__cap_mim_m3_1 l=3 w=3
X5261 P_B8 P_TOP sky130_fd_pr__cap_mim_m3_1 l=3 w=3
X5262 N_B10 N_TOP sky130_fd_pr__cap_mim_m3_1 l=3 w=3
X5263 N_B4 N_TOP sky130_fd_pr__cap_mim_m3_1 l=3 w=3
X5264 N_B11 N_TOP sky130_fd_pr__cap_mim_m3_1 l=3 w=3
X5265 P_B11 P_TOP sky130_fd_pr__cap_mim_m3_1 l=3 w=3
X5266 N_B9 N_TOP sky130_fd_pr__cap_mim_m3_1 l=3 w=3
X5267 P_B9 P_TOP sky130_fd_pr__cap_mim_m3_1 l=3 w=3
X5268 P_B11 P_TOP sky130_fd_pr__cap_mim_m3_1 l=3 w=3
X5269 N_EDGE_BIAS N_EDGE_BIAS sky130_fd_pr__cap_mim_m3_1 l=3 w=3
X5270 N_B9 N_TOP sky130_fd_pr__cap_mim_m3_1 l=3 w=3
X5271 N_B11 N_TOP sky130_fd_pr__cap_mim_m3_1 l=3 w=3
X5272 N_B9 N_TOP sky130_fd_pr__cap_mim_m3_1 l=3 w=3
X5273 P_B11 P_TOP sky130_fd_pr__cap_mim_m3_1 l=3 w=3
X5274 P_B11 P_TOP sky130_fd_pr__cap_mim_m3_1 l=3 w=3
X5275 N_B6 N_TOP sky130_fd_pr__cap_mim_m3_1 l=3 w=3
X5276 P_B6 P_TOP sky130_fd_pr__cap_mim_m3_1 l=3 w=3
X5277 P_B11 P_TOP sky130_fd_pr__cap_mim_m3_1 l=3 w=3
X5278 N_B10 N_TOP sky130_fd_pr__cap_mim_m3_1 l=3 w=3
X5279 N_B11 N_TOP sky130_fd_pr__cap_mim_m3_1 l=3 w=3
X5280 N_B9 N_TOP sky130_fd_pr__cap_mim_m3_1 l=3 w=3
X5281 P_B11 P_TOP sky130_fd_pr__cap_mim_m3_1 l=3 w=3
X5282 N_B11 N_TOP sky130_fd_pr__cap_mim_m3_1 l=3 w=3
X5283 N_B10 N_TOP sky130_fd_pr__cap_mim_m3_1 l=3 w=3
X5284 N_B9 N_TOP sky130_fd_pr__cap_mim_m3_1 l=3 w=3
X5285 P_B11 P_TOP sky130_fd_pr__cap_mim_m3_1 l=3 w=3
X5286 P_B11 P_TOP sky130_fd_pr__cap_mim_m3_1 l=3 w=3
X5287 P_B11 P_TOP sky130_fd_pr__cap_mim_m3_1 l=3 w=3
X5288 N_B11 N_TOP sky130_fd_pr__cap_mim_m3_1 l=3 w=3
X5289 P_EDGE_BIAS P_EDGE_BIAS sky130_fd_pr__cap_mim_m3_1 l=3 w=3
X5290 P_B10 P_TOP sky130_fd_pr__cap_mim_m3_1 l=3 w=3
X5291 N_EDGE_BIAS N_EDGE_BIAS sky130_fd_pr__cap_mim_m3_1 l=3 w=3
X5292 P_B10 P_TOP sky130_fd_pr__cap_mim_m3_1 l=3 w=3
X5293 P_B10 P_TOP sky130_fd_pr__cap_mim_m3_1 l=3 w=3
X5294 P_B6 P_TOP sky130_fd_pr__cap_mim_m3_1 l=3 w=3
X5295 P_EDGE_BIAS P_EDGE_BIAS sky130_fd_pr__cap_mim_m3_1 l=3 w=3
X5296 P_B11 P_TOP sky130_fd_pr__cap_mim_m3_1 l=3 w=3
X5297 N_B11 N_TOP sky130_fd_pr__cap_mim_m3_1 l=3 w=3
X5298 N_B9 N_TOP sky130_fd_pr__cap_mim_m3_1 l=3 w=3
X5299 N_B11 N_TOP sky130_fd_pr__cap_mim_m3_1 l=3 w=3
X5300 N_B10 N_TOP sky130_fd_pr__cap_mim_m3_1 l=3 w=3
X5301 P_B10 P_TOP sky130_fd_pr__cap_mim_m3_1 l=3 w=3
X5302 N_B11 N_TOP sky130_fd_pr__cap_mim_m3_1 l=3 w=3
X5303 P_B7 P_TOP sky130_fd_pr__cap_mim_m3_1 l=3 w=3
X5304 N_B10 N_TOP sky130_fd_pr__cap_mim_m3_1 l=3 w=3
X5305 P_B10 P_TOP sky130_fd_pr__cap_mim_m3_1 l=3 w=3
X5306 P_B10 P_TOP sky130_fd_pr__cap_mim_m3_1 l=3 w=3
X5307 P_B10 P_TOP sky130_fd_pr__cap_mim_m3_1 l=3 w=3
X5308 N_B11 N_TOP sky130_fd_pr__cap_mim_m3_1 l=3 w=3
X5309 N_B9 N_TOP sky130_fd_pr__cap_mim_m3_1 l=3 w=3
X5310 P_B9 P_TOP sky130_fd_pr__cap_mim_m3_1 l=3 w=3
X5311 P_B10 P_TOP sky130_fd_pr__cap_mim_m3_1 l=3 w=3
X5312 N_B10 N_TOP sky130_fd_pr__cap_mim_m3_1 l=3 w=3
X5313 P_B10 P_TOP sky130_fd_pr__cap_mim_m3_1 l=3 w=3
X5314 N_EDGE_BIAS N_EDGE_BIAS sky130_fd_pr__cap_mim_m3_1 l=3 w=3
X5315 N_B8 N_TOP sky130_fd_pr__cap_mim_m3_1 l=3 w=3
X5316 N_B10 N_TOP sky130_fd_pr__cap_mim_m3_1 l=3 w=3
X5317 P_B10 P_TOP sky130_fd_pr__cap_mim_m3_1 l=3 w=3
X5318 P_EDGE_BIAS P_EDGE_BIAS sky130_fd_pr__cap_mim_m3_1 l=3 w=3
X5319 N_B11 N_TOP sky130_fd_pr__cap_mim_m3_1 l=3 w=3
X5320 P_B11 P_TOP sky130_fd_pr__cap_mim_m3_1 l=3 w=3
X5321 P_B11 P_TOP sky130_fd_pr__cap_mim_m3_1 l=3 w=3
X5322 P_B11 P_TOP sky130_fd_pr__cap_mim_m3_1 l=3 w=3
X5323 N_B10 N_TOP sky130_fd_pr__cap_mim_m3_1 l=3 w=3
X5324 P_B10 P_TOP sky130_fd_pr__cap_mim_m3_1 l=3 w=3
X5325 P_B11 P_TOP sky130_fd_pr__cap_mim_m3_1 l=3 w=3
X5326 N_B10 N_TOP sky130_fd_pr__cap_mim_m3_1 l=3 w=3
X5327 N_B11 N_TOP sky130_fd_pr__cap_mim_m3_1 l=3 w=3
X5328 N_B8 N_TOP sky130_fd_pr__cap_mim_m3_1 l=3 w=3
X5329 P_B11 P_TOP sky130_fd_pr__cap_mim_m3_1 l=3 w=3
X5330 N_B10 N_TOP sky130_fd_pr__cap_mim_m3_1 l=3 w=3
X5331 P_B10 P_TOP sky130_fd_pr__cap_mim_m3_1 l=3 w=3
X5332 N_B11 N_TOP sky130_fd_pr__cap_mim_m3_1 l=3 w=3
X5333 N_B10 N_TOP sky130_fd_pr__cap_mim_m3_1 l=3 w=3
X5334 N_EDGE_BIAS N_EDGE_BIAS sky130_fd_pr__cap_mim_m3_1 l=3 w=3
X5335 N_B10 N_TOP sky130_fd_pr__cap_mim_m3_1 l=3 w=3
X5336 P_B10 P_TOP sky130_fd_pr__cap_mim_m3_1 l=3 w=3
X5337 P_B11 P_TOP sky130_fd_pr__cap_mim_m3_1 l=3 w=3
X5338 N_B11 N_TOP sky130_fd_pr__cap_mim_m3_1 l=3 w=3
X5339 N_B9 N_TOP sky130_fd_pr__cap_mim_m3_1 l=3 w=3
X5340 P_B11 P_TOP sky130_fd_pr__cap_mim_m3_1 l=3 w=3
X5341 P_B9 P_TOP sky130_fd_pr__cap_mim_m3_1 l=3 w=3
X5342 P_EDGE_BIAS P_EDGE_BIAS sky130_fd_pr__cap_mim_m3_1 l=3 w=3
X5343 P_B9 P_TOP sky130_fd_pr__cap_mim_m3_1 l=3 w=3
X5344 N_B10 N_TOP sky130_fd_pr__cap_mim_m3_1 l=3 w=3
X5345 N_B4 N_TOP sky130_fd_pr__cap_mim_m3_1 l=3 w=3
X5346 P_B8 P_TOP sky130_fd_pr__cap_mim_m3_1 l=3 w=3
X5347 P_B8 P_TOP sky130_fd_pr__cap_mim_m3_1 l=3 w=3
X5348 P_EDGE_BIAS P_EDGE_BIAS sky130_fd_pr__cap_mim_m3_1 l=3 w=3
X5349 P_B10 P_TOP sky130_fd_pr__cap_mim_m3_1 l=3 w=3
X5350 N_B10 N_TOP sky130_fd_pr__cap_mim_m3_1 l=3 w=3
X5351 N_B11 N_TOP sky130_fd_pr__cap_mim_m3_1 l=3 w=3
X5352 N_B9 N_TOP sky130_fd_pr__cap_mim_m3_1 l=3 w=3
X5353 P_B9 P_TOP sky130_fd_pr__cap_mim_m3_1 l=3 w=3
X5354 N_B11 N_TOP sky130_fd_pr__cap_mim_m3_1 l=3 w=3
X5355 P_B11 P_TOP sky130_fd_pr__cap_mim_m3_1 l=3 w=3
X5356 N_B7 N_TOP sky130_fd_pr__cap_mim_m3_1 l=3 w=3
X5357 N_EDGE_BIAS N_EDGE_BIAS sky130_fd_pr__cap_mim_m3_1 l=3 w=3
X5358 P_B7 P_TOP sky130_fd_pr__cap_mim_m3_1 l=3 w=3
X5359 P_B11 P_TOP sky130_fd_pr__cap_mim_m3_1 l=3 w=3
X5360 P_B8 P_TOP sky130_fd_pr__cap_mim_m3_1 l=3 w=3
X5361 P_B10 P_TOP sky130_fd_pr__cap_mim_m3_1 l=3 w=3
X5362 P_B11 P_TOP sky130_fd_pr__cap_mim_m3_1 l=3 w=3
X5363 P_B8 P_TOP sky130_fd_pr__cap_mim_m3_1 l=3 w=3
X5364 N_B10 N_TOP sky130_fd_pr__cap_mim_m3_1 l=3 w=3
X5365 N_EDGE_BIAS N_EDGE_BIAS sky130_fd_pr__cap_mim_m3_1 l=3 w=3
X5366 P_B10 P_TOP sky130_fd_pr__cap_mim_m3_1 l=3 w=3
X5367 N_B8 N_TOP sky130_fd_pr__cap_mim_m3_1 l=3 w=3
X5368 P_B8 P_TOP sky130_fd_pr__cap_mim_m3_1 l=3 w=3
X5369 P_B11 P_TOP sky130_fd_pr__cap_mim_m3_1 l=3 w=3
X5370 N_EDGE_BIAS N_EDGE_BIAS sky130_fd_pr__cap_mim_m3_1 l=3 w=3
X5371 N_B11 N_TOP sky130_fd_pr__cap_mim_m3_1 l=3 w=3
X5372 P_B4 P_TOP sky130_fd_pr__cap_mim_m3_1 l=3 w=3
X5373 N_B10 N_TOP sky130_fd_pr__cap_mim_m3_1 l=3 w=3
X5374 N_B11 N_TOP sky130_fd_pr__cap_mim_m3_1 l=3 w=3
X5375 P_B11 P_TOP sky130_fd_pr__cap_mim_m3_1 l=3 w=3
X5376 N_B9 N_TOP sky130_fd_pr__cap_mim_m3_1 l=3 w=3
X5377 P_B9 P_TOP sky130_fd_pr__cap_mim_m3_1 l=3 w=3
X5378 P_B9 P_TOP sky130_fd_pr__cap_mim_m3_1 l=3 w=3
X5379 N_B10 N_TOP sky130_fd_pr__cap_mim_m3_1 l=3 w=3
X5380 P_B10 P_TOP sky130_fd_pr__cap_mim_m3_1 l=3 w=3
X5381 N_B9 N_TOP sky130_fd_pr__cap_mim_m3_1 l=3 w=3
X5382 P_B6 P_TOP sky130_fd_pr__cap_mim_m3_1 l=3 w=3
X5383 P_B11 P_TOP sky130_fd_pr__cap_mim_m3_1 l=3 w=3
X5384 N_B11 N_TOP sky130_fd_pr__cap_mim_m3_1 l=3 w=3
X5385 P_B11 P_TOP sky130_fd_pr__cap_mim_m3_1 l=3 w=3
X5386 P_EDGE_BIAS P_EDGE_BIAS sky130_fd_pr__cap_mim_m3_1 l=3 w=3
X5387 P_B5 P_TOP sky130_fd_pr__cap_mim_m3_1 l=3 w=3
X5388 P_B10 P_TOP sky130_fd_pr__cap_mim_m3_1 l=3 w=3
X5389 N_B10 N_TOP sky130_fd_pr__cap_mim_m3_1 l=3 w=3
X5390 N_B11 N_TOP sky130_fd_pr__cap_mim_m3_1 l=3 w=3
X5391 N_B9 N_TOP sky130_fd_pr__cap_mim_m3_1 l=3 w=3
X5392 P_B9 P_TOP sky130_fd_pr__cap_mim_m3_1 l=3 w=3
X5393 N_B11 N_TOP sky130_fd_pr__cap_mim_m3_1 l=3 w=3
X5394 N_B10 N_TOP sky130_fd_pr__cap_mim_m3_1 l=3 w=3
X5395 P_B11 P_TOP sky130_fd_pr__cap_mim_m3_1 l=3 w=3
X5396 N_B11 N_TOP sky130_fd_pr__cap_mim_m3_1 l=3 w=3
X5397 N_B11 N_TOP sky130_fd_pr__cap_mim_m3_1 l=3 w=3
X5398 P_B11 P_TOP sky130_fd_pr__cap_mim_m3_1 l=3 w=3
X5399 P_B9 P_TOP sky130_fd_pr__cap_mim_m3_1 l=3 w=3
X5400 P_B11 P_TOP sky130_fd_pr__cap_mim_m3_1 l=3 w=3
X5401 P_B10 P_TOP sky130_fd_pr__cap_mim_m3_1 l=3 w=3
X5402 P_B11 P_TOP sky130_fd_pr__cap_mim_m3_1 l=3 w=3
X5403 N_B10 N_TOP sky130_fd_pr__cap_mim_m3_1 l=3 w=3
X5404 P_B11 P_TOP sky130_fd_pr__cap_mim_m3_1 l=3 w=3
X5405 P_EDGE_BIAS P_EDGE_BIAS sky130_fd_pr__cap_mim_m3_1 l=3 w=3
X5406 P_B10 P_TOP sky130_fd_pr__cap_mim_m3_1 l=3 w=3
X5407 N_EDGE_BIAS N_EDGE_BIAS sky130_fd_pr__cap_mim_m3_1 l=3 w=3
X5408 N_B10 N_TOP sky130_fd_pr__cap_mim_m3_1 l=3 w=3
X5409 N_B11 N_TOP sky130_fd_pr__cap_mim_m3_1 l=3 w=3
X5410 P_B10 P_TOP sky130_fd_pr__cap_mim_m3_1 l=3 w=3
X5411 P_EDGE_BIAS P_EDGE_BIAS sky130_fd_pr__cap_mim_m3_1 l=3 w=3
X5412 P_B11 P_TOP sky130_fd_pr__cap_mim_m3_1 l=3 w=3
X5413 P_B9 P_TOP sky130_fd_pr__cap_mim_m3_1 l=3 w=3
X5414 N_B11 N_TOP sky130_fd_pr__cap_mim_m3_1 l=3 w=3
X5415 P_B10 P_TOP sky130_fd_pr__cap_mim_m3_1 l=3 w=3
X5416 N_B9 N_TOP sky130_fd_pr__cap_mim_m3_1 l=3 w=3
X5417 P_B9 P_TOP sky130_fd_pr__cap_mim_m3_1 l=3 w=3
X5418 P_B10 P_TOP sky130_fd_pr__cap_mim_m3_1 l=3 w=3
X5419 P_B10 P_TOP sky130_fd_pr__cap_mim_m3_1 l=3 w=3
X5420 N_B11 N_TOP sky130_fd_pr__cap_mim_m3_1 l=3 w=3
X5421 N_B11 N_TOP sky130_fd_pr__cap_mim_m3_1 l=3 w=3
X5422 N_B7 N_TOP sky130_fd_pr__cap_mim_m3_1 l=3 w=3
X5423 P_B7 P_TOP sky130_fd_pr__cap_mim_m3_1 l=3 w=3
X5424 P_B11 P_TOP sky130_fd_pr__cap_mim_m3_1 l=3 w=3
X5425 P_B10 P_TOP sky130_fd_pr__cap_mim_m3_1 l=3 w=3
X5426 N_B11 N_TOP sky130_fd_pr__cap_mim_m3_1 l=3 w=3
X5427 N_B11 N_TOP sky130_fd_pr__cap_mim_m3_1 l=3 w=3
X5428 P_B10 P_TOP sky130_fd_pr__cap_mim_m3_1 l=3 w=3
X5429 N_B9 N_TOP sky130_fd_pr__cap_mim_m3_1 l=3 w=3
X5430 N_B9 N_TOP sky130_fd_pr__cap_mim_m3_1 l=3 w=3
X5431 N_B11 N_TOP sky130_fd_pr__cap_mim_m3_1 l=3 w=3
X5432 P_B11 P_TOP sky130_fd_pr__cap_mim_m3_1 l=3 w=3
X5433 P_B10 P_TOP sky130_fd_pr__cap_mim_m3_1 l=3 w=3
X5434 N_B11 N_TOP sky130_fd_pr__cap_mim_m3_1 l=3 w=3
X5435 N_B8 N_TOP sky130_fd_pr__cap_mim_m3_1 l=3 w=3
X5436 P_B8 P_TOP sky130_fd_pr__cap_mim_m3_1 l=3 w=3
X5437 N_B10 N_TOP sky130_fd_pr__cap_mim_m3_1 l=3 w=3
X5438 N_B11 N_TOP sky130_fd_pr__cap_mim_m3_1 l=3 w=3
X5439 N_B10 N_TOP sky130_fd_pr__cap_mim_m3_1 l=3 w=3
X5440 P_B11 P_TOP sky130_fd_pr__cap_mim_m3_1 l=3 w=3
X5441 P_B10 P_TOP sky130_fd_pr__cap_mim_m3_1 l=3 w=3
X5442 N_B9 N_TOP sky130_fd_pr__cap_mim_m3_1 l=3 w=3
X5443 N_B11 N_TOP sky130_fd_pr__cap_mim_m3_1 l=3 w=3
X5444 P_B10 P_TOP sky130_fd_pr__cap_mim_m3_1 l=3 w=3
X5445 P_B11 P_TOP sky130_fd_pr__cap_mim_m3_1 l=3 w=3
X5446 N_B11 N_TOP sky130_fd_pr__cap_mim_m3_1 l=3 w=3
X5447 P_B10 P_TOP sky130_fd_pr__cap_mim_m3_1 l=3 w=3
X5448 N_B8 N_TOP sky130_fd_pr__cap_mim_m3_1 l=3 w=3
X5449 N_B10 N_TOP sky130_fd_pr__cap_mim_m3_1 l=3 w=3
X5450 N_B11 N_TOP sky130_fd_pr__cap_mim_m3_1 l=3 w=3
X5451 P_B9 P_TOP sky130_fd_pr__cap_mim_m3_1 l=3 w=3
X5452 N_B10 N_TOP sky130_fd_pr__cap_mim_m3_1 l=3 w=3
X5453 P_B10 P_TOP sky130_fd_pr__cap_mim_m3_1 l=3 w=3
X5454 N_B11 N_TOP sky130_fd_pr__cap_mim_m3_1 l=3 w=3
X5455 P_B11 P_TOP sky130_fd_pr__cap_mim_m3_1 l=3 w=3
X5456 N_B10 N_TOP sky130_fd_pr__cap_mim_m3_1 l=3 w=3
X5457 P_B11 P_TOP sky130_fd_pr__cap_mim_m3_1 l=3 w=3
X5458 P_B10 P_TOP sky130_fd_pr__cap_mim_m3_1 l=3 w=3
X5459 N_B11 N_TOP sky130_fd_pr__cap_mim_m3_1 l=3 w=3
X5460 P_B9 P_TOP sky130_fd_pr__cap_mim_m3_1 l=3 w=3
X5461 P_B11 P_TOP sky130_fd_pr__cap_mim_m3_1 l=3 w=3
X5462 P_B11 P_TOP sky130_fd_pr__cap_mim_m3_1 l=3 w=3
X5463 P_EDGE_BIAS P_EDGE_BIAS sky130_fd_pr__cap_mim_m3_1 l=3 w=3
X5464 P_B11 P_TOP sky130_fd_pr__cap_mim_m3_1 l=3 w=3
X5465 N_B10 N_TOP sky130_fd_pr__cap_mim_m3_1 l=3 w=3
X5466 P_B9 P_TOP sky130_fd_pr__cap_mim_m3_1 l=3 w=3
X5467 P_B8 P_TOP sky130_fd_pr__cap_mim_m3_1 l=3 w=3
X5468 N_B11 N_TOP sky130_fd_pr__cap_mim_m3_1 l=3 w=3
X5469 N_B11 N_TOP sky130_fd_pr__cap_mim_m3_1 l=3 w=3
X5470 N_B5 N_TOP sky130_fd_pr__cap_mim_m3_1 l=3 w=3
X5471 P_EDGE_BIAS P_EDGE_BIAS sky130_fd_pr__cap_mim_m3_1 l=3 w=3
X5472 P_B10 P_TOP sky130_fd_pr__cap_mim_m3_1 l=3 w=3
X5473 P_B9 P_TOP sky130_fd_pr__cap_mim_m3_1 l=3 w=3
X5474 P_B11 P_TOP sky130_fd_pr__cap_mim_m3_1 l=3 w=3
X5475 P_B7 P_TOP sky130_fd_pr__cap_mim_m3_1 l=3 w=3
X5476 P_B9 P_TOP sky130_fd_pr__cap_mim_m3_1 l=3 w=3
X5477 N_B11 N_TOP sky130_fd_pr__cap_mim_m3_1 l=3 w=3
X5478 P_B11 P_TOP sky130_fd_pr__cap_mim_m3_1 l=3 w=3
X5479 N_B11 N_TOP sky130_fd_pr__cap_mim_m3_1 l=3 w=3
X5480 N_B11 N_TOP sky130_fd_pr__cap_mim_m3_1 l=3 w=3
X5481 P_B11 P_TOP sky130_fd_pr__cap_mim_m3_1 l=3 w=3
X5482 P_B11 P_TOP sky130_fd_pr__cap_mim_m3_1 l=3 w=3
X5483 P_B8 P_TOP sky130_fd_pr__cap_mim_m3_1 l=3 w=3
X5484 P_B10 P_TOP sky130_fd_pr__cap_mim_m3_1 l=3 w=3
X5485 P_B11 P_TOP sky130_fd_pr__cap_mim_m3_1 l=3 w=3
X5486 N_B10 N_TOP sky130_fd_pr__cap_mim_m3_1 l=3 w=3
X5487 P_B11 P_TOP sky130_fd_pr__cap_mim_m3_1 l=3 w=3
X5488 N_B8 N_TOP sky130_fd_pr__cap_mim_m3_1 l=3 w=3
X5489 P_B8 P_TOP sky130_fd_pr__cap_mim_m3_1 l=3 w=3
X5490 P_B11 P_TOP sky130_fd_pr__cap_mim_m3_1 l=3 w=3
X5491 N_B11 N_TOP sky130_fd_pr__cap_mim_m3_1 l=3 w=3
X5492 N_B10 N_TOP sky130_fd_pr__cap_mim_m3_1 l=3 w=3
X5493 N_B10 N_TOP sky130_fd_pr__cap_mim_m3_1 l=3 w=3
X5494 P_B10 P_TOP sky130_fd_pr__cap_mim_m3_1 l=3 w=3
X5495 N_B5 N_TOP sky130_fd_pr__cap_mim_m3_1 l=3 w=3
X5496 P_B9 P_TOP sky130_fd_pr__cap_mim_m3_1 l=3 w=3
X5497 P_B11 P_TOP sky130_fd_pr__cap_mim_m3_1 l=3 w=3
X5498 N_B11 N_TOP sky130_fd_pr__cap_mim_m3_1 l=3 w=3
X5499 P_B11 P_TOP sky130_fd_pr__cap_mim_m3_1 l=3 w=3
X5500 N_B11 N_TOP sky130_fd_pr__cap_mim_m3_1 l=3 w=3
X5501 N_B9 N_TOP sky130_fd_pr__cap_mim_m3_1 l=3 w=3
X5502 P_B9 P_TOP sky130_fd_pr__cap_mim_m3_1 l=3 w=3
X5503 N_B10 N_TOP sky130_fd_pr__cap_mim_m3_1 l=3 w=3
X5504 P_B11 P_TOP sky130_fd_pr__cap_mim_m3_1 l=3 w=3
X5505 P_B10 P_TOP sky130_fd_pr__cap_mim_m3_1 l=3 w=3
X5506 P_B6 P_TOP sky130_fd_pr__cap_mim_m3_1 l=3 w=3
X5507 P_B11 P_TOP sky130_fd_pr__cap_mim_m3_1 l=3 w=3
X5508 N_B10 N_TOP sky130_fd_pr__cap_mim_m3_1 l=3 w=3
X5509 N_B11 N_TOP sky130_fd_pr__cap_mim_m3_1 l=3 w=3
X5510 P_B11 P_TOP sky130_fd_pr__cap_mim_m3_1 l=3 w=3
X5511 N_B11 N_TOP sky130_fd_pr__cap_mim_m3_1 l=3 w=3
X5512 N_B10 N_TOP sky130_fd_pr__cap_mim_m3_1 l=3 w=3
X5513 N_B9 N_TOP sky130_fd_pr__cap_mim_m3_1 l=3 w=3
X5514 N_B11 N_TOP sky130_fd_pr__cap_mim_m3_1 l=3 w=3
X5515 N_B10 N_TOP sky130_fd_pr__cap_mim_m3_1 l=3 w=3
X5516 P_B11 P_TOP sky130_fd_pr__cap_mim_m3_1 l=3 w=3
X5517 N_B11 N_TOP sky130_fd_pr__cap_mim_m3_1 l=3 w=3
X5518 P_B11 P_TOP sky130_fd_pr__cap_mim_m3_1 l=3 w=3
X5519 P_B11 P_TOP sky130_fd_pr__cap_mim_m3_1 l=3 w=3
X5520 P_B9 P_TOP sky130_fd_pr__cap_mim_m3_1 l=3 w=3
X5521 P_B10 P_TOP sky130_fd_pr__cap_mim_m3_1 l=3 w=3
X5522 N_B11 N_TOP sky130_fd_pr__cap_mim_m3_1 l=3 w=3
X5523 P_EDGE_BIAS P_EDGE_BIAS sky130_fd_pr__cap_mim_m3_1 l=3 w=3
X5524 P_EDGE_BIAS P_EDGE_BIAS sky130_fd_pr__cap_mim_m3_1 l=3 w=3
X5525 P_B10 P_TOP sky130_fd_pr__cap_mim_m3_1 l=3 w=3
X5526 N_B11 N_TOP sky130_fd_pr__cap_mim_m3_1 l=3 w=3
X5527 N_B10 N_TOP sky130_fd_pr__cap_mim_m3_1 l=3 w=3
X5528 P_B11 P_TOP sky130_fd_pr__cap_mim_m3_1 l=3 w=3
X5529 N_B11 N_TOP sky130_fd_pr__cap_mim_m3_1 l=3 w=3
X5530 P_EDGE_BIAS P_EDGE_BIAS sky130_fd_pr__cap_mim_m3_1 l=3 w=3
X5531 N_B11 N_TOP sky130_fd_pr__cap_mim_m3_1 l=3 w=3
X5532 P_B9 P_TOP sky130_fd_pr__cap_mim_m3_1 l=3 w=3
X5533 P_B11 P_TOP sky130_fd_pr__cap_mim_m3_1 l=3 w=3
X5534 P_B10 P_TOP sky130_fd_pr__cap_mim_m3_1 l=3 w=3
X5535 P_B7 P_TOP sky130_fd_pr__cap_mim_m3_1 l=3 w=3
X5536 P_B10 P_TOP sky130_fd_pr__cap_mim_m3_1 l=3 w=3
X5537 P_B10 P_TOP sky130_fd_pr__cap_mim_m3_1 l=3 w=3
X5538 N_B10 N_TOP sky130_fd_pr__cap_mim_m3_1 l=3 w=3
X5539 P_B10 P_TOP sky130_fd_pr__cap_mim_m3_1 l=3 w=3
X5540 P_B6 P_TOP sky130_fd_pr__cap_mim_m3_1 l=3 w=3
X5541 N_B11 N_TOP sky130_fd_pr__cap_mim_m3_1 l=3 w=3
X5542 P_B11 P_TOP sky130_fd_pr__cap_mim_m3_1 l=3 w=3
X5543 N_B9 N_TOP sky130_fd_pr__cap_mim_m3_1 l=3 w=3
X5544 N_B9 N_TOP sky130_fd_pr__cap_mim_m3_1 l=3 w=3
X5545 P_B10 P_TOP sky130_fd_pr__cap_mim_m3_1 l=3 w=3
X5546 P_B10 P_TOP sky130_fd_pr__cap_mim_m3_1 l=3 w=3
X5547 N_B10 N_TOP sky130_fd_pr__cap_mim_m3_1 l=3 w=3
X5548 P_B11 P_TOP sky130_fd_pr__cap_mim_m3_1 l=3 w=3
X5549 N_B8 N_TOP sky130_fd_pr__cap_mim_m3_1 l=3 w=3
X5550 N_B11 N_TOP sky130_fd_pr__cap_mim_m3_1 l=3 w=3
X5551 P_B10 P_TOP sky130_fd_pr__cap_mim_m3_1 l=3 w=3
X5552 P_B11 P_TOP sky130_fd_pr__cap_mim_m3_1 l=3 w=3
X5553 N_B11 N_TOP sky130_fd_pr__cap_mim_m3_1 l=3 w=3
X5554 N_B11 N_TOP sky130_fd_pr__cap_mim_m3_1 l=3 w=3
X5555 P_B11 P_TOP sky130_fd_pr__cap_mim_m3_1 l=3 w=3
X5556 N_B9 N_TOP sky130_fd_pr__cap_mim_m3_1 l=3 w=3
X5557 N_B11 N_TOP sky130_fd_pr__cap_mim_m3_1 l=3 w=3
X5558 P_B10 P_TOP sky130_fd_pr__cap_mim_m3_1 l=3 w=3
X5559 N_B11 N_TOP sky130_fd_pr__cap_mim_m3_1 l=3 w=3
X5560 N_B8 N_TOP sky130_fd_pr__cap_mim_m3_1 l=3 w=3
X5561 N_B10 N_TOP sky130_fd_pr__cap_mim_m3_1 l=3 w=3
X5562 P_B11 P_TOP sky130_fd_pr__cap_mim_m3_1 l=3 w=3
X5563 N_B11 N_TOP sky130_fd_pr__cap_mim_m3_1 l=3 w=3
X5564 N_B10 N_TOP sky130_fd_pr__cap_mim_m3_1 l=3 w=3
X5565 N_B8 N_TOP sky130_fd_pr__cap_mim_m3_1 l=3 w=3
X5566 P_EDGE_BIAS P_EDGE_BIAS sky130_fd_pr__cap_mim_m3_1 l=3 w=3
X5567 N_B11 N_TOP sky130_fd_pr__cap_mim_m3_1 l=3 w=3
X5568 P_EDGE_BIAS P_EDGE_BIAS sky130_fd_pr__cap_mim_m3_1 l=3 w=3
X5569 P_B11 P_TOP sky130_fd_pr__cap_mim_m3_1 l=3 w=3
X5570 N_B11 N_TOP sky130_fd_pr__cap_mim_m3_1 l=3 w=3
X5571 N_B10 N_TOP sky130_fd_pr__cap_mim_m3_1 l=3 w=3
X5572 P_B11 P_TOP sky130_fd_pr__cap_mim_m3_1 l=3 w=3
X5573 P_B9 P_TOP sky130_fd_pr__cap_mim_m3_1 l=3 w=3
X5574 P_EDGE_BIAS P_EDGE_BIAS sky130_fd_pr__cap_mim_m3_1 l=3 w=3
X5575 P_B9 P_TOP sky130_fd_pr__cap_mim_m3_1 l=3 w=3
X5576 P_B11 P_TOP sky130_fd_pr__cap_mim_m3_1 l=3 w=3
X5577 N_B11 N_TOP sky130_fd_pr__cap_mim_m3_1 l=3 w=3
X5578 N_B10 N_TOP sky130_fd_pr__cap_mim_m3_1 l=3 w=3
X5579 N_B3 N_TOP sky130_fd_pr__cap_mim_m3_1 l=3 w=3
X5580 P_B8 P_TOP sky130_fd_pr__cap_mim_m3_1 l=3 w=3
X5581 P_B11 P_TOP sky130_fd_pr__cap_mim_m3_1 l=3 w=3
X5582 N_B11 N_TOP sky130_fd_pr__cap_mim_m3_1 l=3 w=3
X5583 P_B11 P_TOP sky130_fd_pr__cap_mim_m3_1 l=3 w=3
X5584 N_B11 N_TOP sky130_fd_pr__cap_mim_m3_1 l=3 w=3
X5585 N_B6 N_TOP sky130_fd_pr__cap_mim_m3_1 l=3 w=3
X5586 P_B10 P_TOP sky130_fd_pr__cap_mim_m3_1 l=3 w=3
X5587 N_EDGE_BIAS N_EDGE_BIAS sky130_fd_pr__cap_mim_m3_1 l=3 w=3
X5588 N_B10 N_TOP sky130_fd_pr__cap_mim_m3_1 l=3 w=3
X5589 P_B10 P_TOP sky130_fd_pr__cap_mim_m3_1 l=3 w=3
X5590 N_B11 N_TOP sky130_fd_pr__cap_mim_m3_1 l=3 w=3
X5591 P_B9 P_TOP sky130_fd_pr__cap_mim_m3_1 l=3 w=3
X5592 P_B11 P_TOP sky130_fd_pr__cap_mim_m3_1 l=3 w=3
X5593 P_B7 P_TOP sky130_fd_pr__cap_mim_m3_1 l=3 w=3
X5594 P_B9 P_TOP sky130_fd_pr__cap_mim_m3_1 l=3 w=3
X5595 N_B11 N_TOP sky130_fd_pr__cap_mim_m3_1 l=3 w=3
X5596 N_B11 N_TOP sky130_fd_pr__cap_mim_m3_1 l=3 w=3
X5597 P_B10 P_TOP sky130_fd_pr__cap_mim_m3_1 l=3 w=3
X5598 N_B11 N_TOP sky130_fd_pr__cap_mim_m3_1 l=3 w=3
X5599 P_B11 P_TOP sky130_fd_pr__cap_mim_m3_1 l=3 w=3
X5600 P_B10 P_TOP sky130_fd_pr__cap_mim_m3_1 l=3 w=3
X5601 P_B8 P_TOP sky130_fd_pr__cap_mim_m3_1 l=3 w=3
X5602 N_B10 N_TOP sky130_fd_pr__cap_mim_m3_1 l=3 w=3
X5603 P_B10 P_TOP sky130_fd_pr__cap_mim_m3_1 l=3 w=3
X5604 N_EDGE_BIAS N_EDGE_BIAS sky130_fd_pr__cap_mim_m3_1 l=3 w=3
X5605 N_B10 N_TOP sky130_fd_pr__cap_mim_m3_1 l=3 w=3
X5606 P_B11 P_TOP sky130_fd_pr__cap_mim_m3_1 l=3 w=3
X5607 N_B8 N_TOP sky130_fd_pr__cap_mim_m3_1 l=3 w=3
X5608 P_B11 P_TOP sky130_fd_pr__cap_mim_m3_1 l=3 w=3
X5609 N_B11 N_TOP sky130_fd_pr__cap_mim_m3_1 l=3 w=3
X5610 P_B2 P_TOP sky130_fd_pr__cap_mim_m3_1 l=3 w=3
X5611 P_B8 P_TOP sky130_fd_pr__cap_mim_m3_1 l=3 w=3
X5612 N_B10 N_TOP sky130_fd_pr__cap_mim_m3_1 l=3 w=3
X5613 N_B11 N_TOP sky130_fd_pr__cap_mim_m3_1 l=3 w=3
X5614 P_B11 P_TOP sky130_fd_pr__cap_mim_m3_1 l=3 w=3
X5615 N_B9 N_TOP sky130_fd_pr__cap_mim_m3_1 l=3 w=3
X5616 P_B11 P_TOP sky130_fd_pr__cap_mim_m3_1 l=3 w=3
X5617 P_B9 P_TOP sky130_fd_pr__cap_mim_m3_1 l=3 w=3
X5618 N_B10 N_TOP sky130_fd_pr__cap_mim_m3_1 l=3 w=3
X5619 N_B11 N_TOP sky130_fd_pr__cap_mim_m3_1 l=3 w=3
X5620 N_B9 N_TOP sky130_fd_pr__cap_mim_m3_1 l=3 w=3
X5621 P_B9 P_TOP sky130_fd_pr__cap_mim_m3_1 l=3 w=3
X5622 P_B11 P_TOP sky130_fd_pr__cap_mim_m3_1 l=3 w=3
X5623 N_B10 N_TOP sky130_fd_pr__cap_mim_m3_1 l=3 w=3
X5624 P_B11 P_TOP sky130_fd_pr__cap_mim_m3_1 l=3 w=3
X5625 P_B5 P_TOP sky130_fd_pr__cap_mim_m3_1 l=3 w=3
X5626 P_B11 P_TOP sky130_fd_pr__cap_mim_m3_1 l=3 w=3
X5627 N_B10 N_TOP sky130_fd_pr__cap_mim_m3_1 l=3 w=3
X5628 N_B9 N_TOP sky130_fd_pr__cap_mim_m3_1 l=3 w=3
X5629 P_B11 P_TOP sky130_fd_pr__cap_mim_m3_1 l=3 w=3
X5630 P_B9 P_TOP sky130_fd_pr__cap_mim_m3_1 l=3 w=3
X5631 N_B11 N_TOP sky130_fd_pr__cap_mim_m3_1 l=3 w=3
X5632 N_B10 N_TOP sky130_fd_pr__cap_mim_m3_1 l=3 w=3
X5633 P_B10 P_TOP sky130_fd_pr__cap_mim_m3_1 l=3 w=3
X5634 P_B11 P_TOP sky130_fd_pr__cap_mim_m3_1 l=3 w=3
X5635 P_EDGE_BIAS P_EDGE_BIAS sky130_fd_pr__cap_mim_m3_1 l=3 w=3
X5636 P_B11 P_TOP sky130_fd_pr__cap_mim_m3_1 l=3 w=3
X5637 P_B11 P_TOP sky130_fd_pr__cap_mim_m3_1 l=3 w=3
X5638 N_B11 N_TOP sky130_fd_pr__cap_mim_m3_1 l=3 w=3
X5639 P_B9 P_TOP sky130_fd_pr__cap_mim_m3_1 l=3 w=3
X5640 P_B7 P_TOP sky130_fd_pr__cap_mim_m3_1 l=3 w=3
X5641 P_EDGE_BIAS P_EDGE_BIAS sky130_fd_pr__cap_mim_m3_1 l=3 w=3
X5642 N_B11 N_TOP sky130_fd_pr__cap_mim_m3_1 l=3 w=3
X5643 P_B11 P_TOP sky130_fd_pr__cap_mim_m3_1 l=3 w=3
X5644 N_B10 N_TOP sky130_fd_pr__cap_mim_m3_1 l=3 w=3
X5645 N_B11 N_TOP sky130_fd_pr__cap_mim_m3_1 l=3 w=3
X5646 P_B11 P_TOP sky130_fd_pr__cap_mim_m3_1 l=3 w=3
X5647 N_B10 N_TOP sky130_fd_pr__cap_mim_m3_1 l=3 w=3
X5648 P_B6 P_TOP sky130_fd_pr__cap_mim_m3_1 l=3 w=3
X5649 P_B11 P_TOP sky130_fd_pr__cap_mim_m3_1 l=3 w=3
X5650 N_B11 N_TOP sky130_fd_pr__cap_mim_m3_1 l=3 w=3
X5651 N_B9 N_TOP sky130_fd_pr__cap_mim_m3_1 l=3 w=3
X5652 P_B9 P_TOP sky130_fd_pr__cap_mim_m3_1 l=3 w=3
X5653 N_B11 N_TOP sky130_fd_pr__cap_mim_m3_1 l=3 w=3
X5654 P_B10 P_TOP sky130_fd_pr__cap_mim_m3_1 l=3 w=3
X5655 N_B11 N_TOP sky130_fd_pr__cap_mim_m3_1 l=3 w=3
X5656 P_B7 P_TOP sky130_fd_pr__cap_mim_m3_1 l=3 w=3
X5657 P_B10 P_TOP sky130_fd_pr__cap_mim_m3_1 l=3 w=3
X5658 N_B10 N_TOP sky130_fd_pr__cap_mim_m3_1 l=3 w=3
X5659 P_B11 P_TOP sky130_fd_pr__cap_mim_m3_1 l=3 w=3
X5660 N_B11 N_TOP sky130_fd_pr__cap_mim_m3_1 l=3 w=3
X5661 P_B11 P_TOP sky130_fd_pr__cap_mim_m3_1 l=3 w=3
X5662 P_B10 P_TOP sky130_fd_pr__cap_mim_m3_1 l=3 w=3
X5663 N_B11 N_TOP sky130_fd_pr__cap_mim_m3_1 l=3 w=3
X5664 N_B9 N_TOP sky130_fd_pr__cap_mim_m3_1 l=3 w=3
X5665 P_B9 P_TOP sky130_fd_pr__cap_mim_m3_1 l=3 w=3
X5666 N_B9 N_TOP sky130_fd_pr__cap_mim_m3_1 l=3 w=3
X5667 N_B8 N_TOP sky130_fd_pr__cap_mim_m3_1 l=3 w=3
X5668 P_B8 P_TOP sky130_fd_pr__cap_mim_m3_1 l=3 w=3
X5669 N_B10 N_TOP sky130_fd_pr__cap_mim_m3_1 l=3 w=3
X5670 P_B10 P_TOP sky130_fd_pr__cap_mim_m3_1 l=3 w=3
X5671 N_B11 N_TOP sky130_fd_pr__cap_mim_m3_1 l=3 w=3
X5672 N_B8 N_TOP sky130_fd_pr__cap_mim_m3_1 l=3 w=3
X5673 P_B11 P_TOP sky130_fd_pr__cap_mim_m3_1 l=3 w=3
X5674 N_B11 N_TOP sky130_fd_pr__cap_mim_m3_1 l=3 w=3
X5675 N_B10 N_TOP sky130_fd_pr__cap_mim_m3_1 l=3 w=3
X5676 P_B10 P_TOP sky130_fd_pr__cap_mim_m3_1 l=3 w=3
X5677 N_B9 N_TOP sky130_fd_pr__cap_mim_m3_1 l=3 w=3
X5678 N_B11 N_TOP sky130_fd_pr__cap_mim_m3_1 l=3 w=3
X5679 N_B11 N_TOP sky130_fd_pr__cap_mim_m3_1 l=3 w=3
X5680 P_B11 P_TOP sky130_fd_pr__cap_mim_m3_1 l=3 w=3
X5681 P_B11 P_TOP sky130_fd_pr__cap_mim_m3_1 l=3 w=3
X5682 N_B7 N_TOP sky130_fd_pr__cap_mim_m3_1 l=3 w=3
X5683 P_B11 P_TOP sky130_fd_pr__cap_mim_m3_1 l=3 w=3
X5684 P_B10 P_TOP sky130_fd_pr__cap_mim_m3_1 l=3 w=3
X5685 P_B11 P_TOP sky130_fd_pr__cap_mim_m3_1 l=3 w=3
X5686 N_B10 N_TOP sky130_fd_pr__cap_mim_m3_1 l=3 w=3
X5687 N_B11 N_TOP sky130_fd_pr__cap_mim_m3_1 l=3 w=3
X5688 N_B8 N_TOP sky130_fd_pr__cap_mim_m3_1 l=3 w=3
X5689 N_B10 N_TOP sky130_fd_pr__cap_mim_m3_1 l=3 w=3
X5690 N_B10 N_TOP sky130_fd_pr__cap_mim_m3_1 l=3 w=3
X5691 P_B10 P_TOP sky130_fd_pr__cap_mim_m3_1 l=3 w=3
X5692 P_B11 P_TOP sky130_fd_pr__cap_mim_m3_1 l=3 w=3
X5693 P_B10 P_TOP sky130_fd_pr__cap_mim_m3_1 l=3 w=3
X5694 N_B11 N_TOP sky130_fd_pr__cap_mim_m3_1 l=3 w=3
X5695 P_B11 P_TOP sky130_fd_pr__cap_mim_m3_1 l=3 w=3
X5696 N_B11 N_TOP sky130_fd_pr__cap_mim_m3_1 l=3 w=3
X5697 P_B10 P_TOP sky130_fd_pr__cap_mim_m3_1 l=3 w=3
X5698 P_B11 P_TOP sky130_fd_pr__cap_mim_m3_1 l=3 w=3
X5699 N_B11 N_TOP sky130_fd_pr__cap_mim_m3_1 l=3 w=3
X5700 N_B9 N_TOP sky130_fd_pr__cap_mim_m3_1 l=3 w=3
X5701 N_B10 N_TOP sky130_fd_pr__cap_mim_m3_1 l=3 w=3
X5702 P_B9 P_TOP sky130_fd_pr__cap_mim_m3_1 l=3 w=3
X5703 P_EDGE_BIAS P_EDGE_BIAS sky130_fd_pr__cap_mim_m3_1 l=3 w=3
X5704 P_B11 P_TOP sky130_fd_pr__cap_mim_m3_1 l=3 w=3
X5705 N_B11 N_TOP sky130_fd_pr__cap_mim_m3_1 l=3 w=3
X5706 N_B10 N_TOP sky130_fd_pr__cap_mim_m3_1 l=3 w=3
X5707 N_B11 N_TOP sky130_fd_pr__cap_mim_m3_1 l=3 w=3
X5708 N_B5 N_TOP sky130_fd_pr__cap_mim_m3_1 l=3 w=3
X5709 P_B6 P_TOP sky130_fd_pr__cap_mim_m3_1 l=3 w=3
X5710 N_B11 N_TOP sky130_fd_pr__cap_mim_m3_1 l=3 w=3
X5711 P_B8 P_TOP sky130_fd_pr__cap_mim_m3_1 l=3 w=3
X5712 P_B10 P_TOP sky130_fd_pr__cap_mim_m3_1 l=3 w=3
X5713 P_B11 P_TOP sky130_fd_pr__cap_mim_m3_1 l=3 w=3
X5714 P_B9 P_TOP sky130_fd_pr__cap_mim_m3_1 l=3 w=3
X5715 P_B11 P_TOP sky130_fd_pr__cap_mim_m3_1 l=3 w=3
X5716 P_B11 P_TOP sky130_fd_pr__cap_mim_m3_1 l=3 w=3
X5717 P_B7 P_TOP sky130_fd_pr__cap_mim_m3_1 l=3 w=3
X5718 N_B11 N_TOP sky130_fd_pr__cap_mim_m3_1 l=3 w=3
X5719 P_B11 P_TOP sky130_fd_pr__cap_mim_m3_1 l=3 w=3
X5720 N_B11 N_TOP sky130_fd_pr__cap_mim_m3_1 l=3 w=3
X5721 P_B8 P_TOP sky130_fd_pr__cap_mim_m3_1 l=3 w=3
X5722 P_B10 P_TOP sky130_fd_pr__cap_mim_m3_1 l=3 w=3
X5723 P_B11 P_TOP sky130_fd_pr__cap_mim_m3_1 l=3 w=3
X5724 N_B10 N_TOP sky130_fd_pr__cap_mim_m3_1 l=3 w=3
X5725 N_EDGE_BIAS N_EDGE_BIAS sky130_fd_pr__cap_mim_m3_1 l=3 w=3
X5726 P_B8 P_TOP sky130_fd_pr__cap_mim_m3_1 l=3 w=3
X5727 P_B10 P_TOP sky130_fd_pr__cap_mim_m3_1 l=3 w=3
X5728 N_B5 N_TOP sky130_fd_pr__cap_mim_m3_1 l=3 w=3
X5729 N_B11 N_TOP sky130_fd_pr__cap_mim_m3_1 l=3 w=3
X5730 P_B5 P_TOP sky130_fd_pr__cap_mim_m3_1 l=3 w=3
X5731 P_B11 P_TOP sky130_fd_pr__cap_mim_m3_1 l=3 w=3
X5732 N_B10 N_TOP sky130_fd_pr__cap_mim_m3_1 l=3 w=3
X5733 P_B9 P_TOP sky130_fd_pr__cap_mim_m3_1 l=3 w=3
X5734 P_B11 P_TOP sky130_fd_pr__cap_mim_m3_1 l=3 w=3
X5735 N_B11 N_TOP sky130_fd_pr__cap_mim_m3_1 l=3 w=3
X5736 P_EDGE_BIAS P_EDGE_BIAS sky130_fd_pr__cap_mim_m3_1 l=3 w=3
X5737 P_B9 P_TOP sky130_fd_pr__cap_mim_m3_1 l=3 w=3
X5738 P_B9 P_TOP sky130_fd_pr__cap_mim_m3_1 l=3 w=3
X5739 N_B10 N_TOP sky130_fd_pr__cap_mim_m3_1 l=3 w=3
X5740 P_B9 P_TOP sky130_fd_pr__cap_mim_m3_1 l=3 w=3
X5741 N_B7 N_TOP sky130_fd_pr__cap_mim_m3_1 l=3 w=3
X5742 P_B11 P_TOP sky130_fd_pr__cap_mim_m3_1 l=3 w=3
X5743 P_B3 P_TOP sky130_fd_pr__cap_mim_m3_1 l=3 w=3
X5744 N_B10 N_TOP sky130_fd_pr__cap_mim_m3_1 l=3 w=3
X5745 P_B11 P_TOP sky130_fd_pr__cap_mim_m3_1 l=3 w=3
X5746 P_B11 P_TOP sky130_fd_pr__cap_mim_m3_1 l=3 w=3
X5747 N_B11 N_TOP sky130_fd_pr__cap_mim_m3_1 l=3 w=3
X5748 N_B9 N_TOP sky130_fd_pr__cap_mim_m3_1 l=3 w=3
X5749 P_B9 P_TOP sky130_fd_pr__cap_mim_m3_1 l=3 w=3
X5750 P_B11 P_TOP sky130_fd_pr__cap_mim_m3_1 l=3 w=3
X5751 N_B10 N_TOP sky130_fd_pr__cap_mim_m3_1 l=3 w=3
X5752 P_B11 P_TOP sky130_fd_pr__cap_mim_m3_1 l=3 w=3
X5753 P_B10 P_TOP sky130_fd_pr__cap_mim_m3_1 l=3 w=3
X5754 P_B11 P_TOP sky130_fd_pr__cap_mim_m3_1 l=3 w=3
X5755 P_B11 P_TOP sky130_fd_pr__cap_mim_m3_1 l=3 w=3
X5756 P_B11 P_TOP sky130_fd_pr__cap_mim_m3_1 l=3 w=3
X5757 P_EDGE_BIAS P_EDGE_BIAS sky130_fd_pr__cap_mim_m3_1 l=3 w=3
X5758 P_B9 P_TOP sky130_fd_pr__cap_mim_m3_1 l=3 w=3
X5759 N_B10 N_TOP sky130_fd_pr__cap_mim_m3_1 l=3 w=3
X5760 P_B10 P_TOP sky130_fd_pr__cap_mim_m3_1 l=3 w=3
X5761 P_B11 P_TOP sky130_fd_pr__cap_mim_m3_1 l=3 w=3
X5762 N_B10 N_TOP sky130_fd_pr__cap_mim_m3_1 l=3 w=3
X5763 P_B10 P_TOP sky130_fd_pr__cap_mim_m3_1 l=3 w=3
X5764 P_B10 P_TOP sky130_fd_pr__cap_mim_m3_1 l=3 w=3
X5765 P_B11 P_TOP sky130_fd_pr__cap_mim_m3_1 l=3 w=3
X5766 P_B9 P_TOP sky130_fd_pr__cap_mim_m3_1 l=3 w=3
X5767 N_B11 N_TOP sky130_fd_pr__cap_mim_m3_1 l=3 w=3
X5768 N_EDGE_BIAS N_EDGE_BIAS sky130_fd_pr__cap_mim_m3_1 l=3 w=3
X5769 P_B10 P_TOP sky130_fd_pr__cap_mim_m3_1 l=3 w=3
X5770 N_B11 N_TOP sky130_fd_pr__cap_mim_m3_1 l=3 w=3
X5771 P_B10 P_TOP sky130_fd_pr__cap_mim_m3_1 l=3 w=3
X5772 P_B7 P_TOP sky130_fd_pr__cap_mim_m3_1 l=3 w=3
X5773 P_B10 P_TOP sky130_fd_pr__cap_mim_m3_1 l=3 w=3
X5774 P_B10 P_TOP sky130_fd_pr__cap_mim_m3_1 l=3 w=3
X5775 P_B11 P_TOP sky130_fd_pr__cap_mim_m3_1 l=3 w=3
X5776 N_B9 N_TOP sky130_fd_pr__cap_mim_m3_1 l=3 w=3
X5777 P_B9 P_TOP sky130_fd_pr__cap_mim_m3_1 l=3 w=3
X5778 N_B9 N_TOP sky130_fd_pr__cap_mim_m3_1 l=3 w=3
X5779 N_B10 N_TOP sky130_fd_pr__cap_mim_m3_1 l=3 w=3
X5780 N_B8 N_TOP sky130_fd_pr__cap_mim_m3_1 l=3 w=3
X5781 P_B8 P_TOP sky130_fd_pr__cap_mim_m3_1 l=3 w=3
X5782 N_B10 N_TOP sky130_fd_pr__cap_mim_m3_1 l=3 w=3
X5783 P_B10 P_TOP sky130_fd_pr__cap_mim_m3_1 l=3 w=3
X5784 N_B11 N_TOP sky130_fd_pr__cap_mim_m3_1 l=3 w=3
X5785 P_B10 P_TOP sky130_fd_pr__cap_mim_m3_1 l=3 w=3
X5786 P_B11 P_TOP sky130_fd_pr__cap_mim_m3_1 l=3 w=3
X5787 P_B10 P_TOP sky130_fd_pr__cap_mim_m3_1 l=3 w=3
X5788 N_B9 N_TOP sky130_fd_pr__cap_mim_m3_1 l=3 w=3
X5789 P_B11 P_TOP sky130_fd_pr__cap_mim_m3_1 l=3 w=3
X5790 N_B11 N_TOP sky130_fd_pr__cap_mim_m3_1 l=3 w=3
X5791 P_B10 P_TOP sky130_fd_pr__cap_mim_m3_1 l=3 w=3
X5792 N_B8 N_TOP sky130_fd_pr__cap_mim_m3_1 l=3 w=3
X5793 N_B10 N_TOP sky130_fd_pr__cap_mim_m3_1 l=3 w=3
X5794 P_B10 P_TOP sky130_fd_pr__cap_mim_m3_1 l=3 w=3
X5795 N_B11 N_TOP sky130_fd_pr__cap_mim_m3_1 l=3 w=3
X5796 N_B11 N_TOP sky130_fd_pr__cap_mim_m3_1 l=3 w=3
X5797 N_B8 N_TOP sky130_fd_pr__cap_mim_m3_1 l=3 w=3
X5798 N_B10 N_TOP sky130_fd_pr__cap_mim_m3_1 l=3 w=3
X5799 P_B10 P_TOP sky130_fd_pr__cap_mim_m3_1 l=3 w=3
X5800 P_B10 P_TOP sky130_fd_pr__cap_mim_m3_1 l=3 w=3
X5801 P_B11 P_TOP sky130_fd_pr__cap_mim_m3_1 l=3 w=3
X5802 N_B11 N_TOP sky130_fd_pr__cap_mim_m3_1 l=3 w=3
X5803 P_B11 P_TOP sky130_fd_pr__cap_mim_m3_1 l=3 w=3
X5804 P_B11 P_TOP sky130_fd_pr__cap_mim_m3_1 l=3 w=3
X5805 P_B11 P_TOP sky130_fd_pr__cap_mim_m3_1 l=3 w=3
X5806 P_B10 P_TOP sky130_fd_pr__cap_mim_m3_1 l=3 w=3
X5807 P_B11 P_TOP sky130_fd_pr__cap_mim_m3_1 l=3 w=3
X5808 N_B11 N_TOP sky130_fd_pr__cap_mim_m3_1 l=3 w=3
X5809 P_B11 P_TOP sky130_fd_pr__cap_mim_m3_1 l=3 w=3
X5810 N_B9 N_TOP sky130_fd_pr__cap_mim_m3_1 l=3 w=3
X5811 P_B11 P_TOP sky130_fd_pr__cap_mim_m3_1 l=3 w=3
X5812 N_B10 N_TOP sky130_fd_pr__cap_mim_m3_1 l=3 w=3
X5813 P_EDGE_BIAS P_EDGE_BIAS sky130_fd_pr__cap_mim_m3_1 l=3 w=3
X5814 N_B1 N_TOP sky130_fd_pr__cap_mim_m3_1 l=3 w=3
X5815 P_B8 P_TOP sky130_fd_pr__cap_mim_m3_1 l=3 w=3
X5816 N_B11 N_TOP sky130_fd_pr__cap_mim_m3_1 l=3 w=3
X5817 P_B11 P_TOP sky130_fd_pr__cap_mim_m3_1 l=3 w=3
X5818 N_B11 N_TOP sky130_fd_pr__cap_mim_m3_1 l=3 w=3
X5819 P_B11 P_TOP sky130_fd_pr__cap_mim_m3_1 l=3 w=3
X5820 N_B6 N_TOP sky130_fd_pr__cap_mim_m3_1 l=3 w=3
X5821 N_B11 N_TOP sky130_fd_pr__cap_mim_m3_1 l=3 w=3
X5822 P_EDGE_BIAS P_EDGE_BIAS sky130_fd_pr__cap_mim_m3_1 l=3 w=3
X5823 P_B10 P_TOP sky130_fd_pr__cap_mim_m3_1 l=3 w=3
X5824 N_B11 N_TOP sky130_fd_pr__cap_mim_m3_1 l=3 w=3
X5825 N_B9 N_TOP sky130_fd_pr__cap_mim_m3_1 l=3 w=3
X5826 P_B7 P_TOP sky130_fd_pr__cap_mim_m3_1 l=3 w=3
X5827 P_B9 P_TOP sky130_fd_pr__cap_mim_m3_1 l=3 w=3
X5828 N_B11 N_TOP sky130_fd_pr__cap_mim_m3_1 l=3 w=3
X5829 P_B11 P_TOP sky130_fd_pr__cap_mim_m3_1 l=3 w=3
X5830 P_B11 P_TOP sky130_fd_pr__cap_mim_m3_1 l=3 w=3
X5831 N_B11 N_TOP sky130_fd_pr__cap_mim_m3_1 l=3 w=3
X5832 N_B11 N_TOP sky130_fd_pr__cap_mim_m3_1 l=3 w=3
X5833 P_B7 P_TOP sky130_fd_pr__cap_mim_m3_1 l=3 w=3
X5834 N_B11 N_TOP sky130_fd_pr__cap_mim_m3_1 l=3 w=3
X5835 P_B11 P_TOP sky130_fd_pr__cap_mim_m3_1 l=3 w=3
X5836 P_B8 P_TOP sky130_fd_pr__cap_mim_m3_1 l=3 w=3
X5837 P_B10 P_TOP sky130_fd_pr__cap_mim_m3_1 l=3 w=3
X5838 N_B11 N_TOP sky130_fd_pr__cap_mim_m3_1 l=3 w=3
X5839 N_B8 N_TOP sky130_fd_pr__cap_mim_m3_1 l=3 w=3
X5840 P_B11 P_TOP sky130_fd_pr__cap_mim_m3_1 l=3 w=3
X5841 P_B8 P_TOP sky130_fd_pr__cap_mim_m3_1 l=3 w=3
X5842 N_B10 N_TOP sky130_fd_pr__cap_mim_m3_1 l=3 w=3
X5843 P_B10 P_TOP sky130_fd_pr__cap_mim_m3_1 l=3 w=3
X5844 N_B3 N_TOP sky130_fd_pr__cap_mim_m3_1 l=3 w=3
X5845 P_B6 P_TOP sky130_fd_pr__cap_mim_m3_1 l=3 w=3
X5846 N_B11 N_TOP sky130_fd_pr__cap_mim_m3_1 l=3 w=3
X5847 P_B11 P_TOP sky130_fd_pr__cap_mim_m3_1 l=3 w=3
X5848 P_B11 P_TOP sky130_fd_pr__cap_mim_m3_1 l=3 w=3
X5849 P_B9 P_TOP sky130_fd_pr__cap_mim_m3_1 l=3 w=3
X5850 P_B11 P_TOP sky130_fd_pr__cap_mim_m3_1 l=3 w=3
X5851 N_B9 N_TOP sky130_fd_pr__cap_mim_m3_1 l=3 w=3
X5852 P_B11 P_TOP sky130_fd_pr__cap_mim_m3_1 l=3 w=3
X5853 P_B9 P_TOP sky130_fd_pr__cap_mim_m3_1 l=3 w=3
X5854 N_B10 N_TOP sky130_fd_pr__cap_mim_m3_1 l=3 w=3
X5855 P_B11 P_TOP sky130_fd_pr__cap_mim_m3_1 l=3 w=3
X5856 N_B10 N_TOP sky130_fd_pr__cap_mim_m3_1 l=3 w=3
X5857 N_B11 N_TOP sky130_fd_pr__cap_mim_m3_1 l=3 w=3
X5858 N_B10 N_TOP sky130_fd_pr__cap_mim_m3_1 l=3 w=3
X5859 N_B11 N_TOP sky130_fd_pr__cap_mim_m3_1 l=3 w=3
X5860 N_B10 N_TOP sky130_fd_pr__cap_mim_m3_1 l=3 w=3
X5861 P_B11 P_TOP sky130_fd_pr__cap_mim_m3_1 l=3 w=3
X5862 P_B10 P_TOP sky130_fd_pr__cap_mim_m3_1 l=3 w=3
X5863 N_B9 N_TOP sky130_fd_pr__cap_mim_m3_1 l=3 w=3
X5864 P_B11 P_TOP sky130_fd_pr__cap_mim_m3_1 l=3 w=3
X5865 N_B11 N_TOP sky130_fd_pr__cap_mim_m3_1 l=3 w=3
X5866 N_EDGE_BIAS N_EDGE_BIAS sky130_fd_pr__cap_mim_m3_1 l=3 w=3
X5867 N_B11 N_TOP sky130_fd_pr__cap_mim_m3_1 l=3 w=3
X5868 P_EDGE_BIAS P_EDGE_BIAS sky130_fd_pr__cap_mim_m3_1 l=3 w=3
X5869 P_B11 P_TOP sky130_fd_pr__cap_mim_m3_1 l=3 w=3
X5870 P_B9 P_TOP sky130_fd_pr__cap_mim_m3_1 l=3 w=3
X5871 N_B11 N_TOP sky130_fd_pr__cap_mim_m3_1 l=3 w=3
X5872 N_B10 N_TOP sky130_fd_pr__cap_mim_m3_1 l=3 w=3
X5873 P_B10 P_TOP sky130_fd_pr__cap_mim_m3_1 l=3 w=3
X5874 N_B10 N_TOP sky130_fd_pr__cap_mim_m3_1 l=3 w=3
X5875 P_B10 P_TOP sky130_fd_pr__cap_mim_m3_1 l=3 w=3
X5876 P_B11 P_TOP sky130_fd_pr__cap_mim_m3_1 l=3 w=3
X5877 N_B11 N_TOP sky130_fd_pr__cap_mim_m3_1 l=3 w=3
X5878 P_B11 P_TOP sky130_fd_pr__cap_mim_m3_1 l=3 w=3
X5879 N_B10 N_TOP sky130_fd_pr__cap_mim_m3_1 l=3 w=3
X5880 N_B11 N_TOP sky130_fd_pr__cap_mim_m3_1 l=3 w=3
X5881 P_B11 P_TOP sky130_fd_pr__cap_mim_m3_1 l=3 w=3
X5882 P_B9 P_TOP sky130_fd_pr__cap_mim_m3_1 l=3 w=3
X5883 P_B11 P_TOP sky130_fd_pr__cap_mim_m3_1 l=3 w=3
X5884 N_B10 N_TOP sky130_fd_pr__cap_mim_m3_1 l=3 w=3
X5885 P_B10 P_TOP sky130_fd_pr__cap_mim_m3_1 l=3 w=3
X5886 P_B11 P_TOP sky130_fd_pr__cap_mim_m3_1 l=3 w=3
X5887 P_B9 P_TOP sky130_fd_pr__cap_mim_m3_1 l=3 w=3
X5888 P_B7 P_TOP sky130_fd_pr__cap_mim_m3_1 l=3 w=3
X5889 P_B10 P_TOP sky130_fd_pr__cap_mim_m3_1 l=3 w=3
X5890 N_B10 N_TOP sky130_fd_pr__cap_mim_m3_1 l=3 w=3
X5891 P_B7 P_TOP sky130_fd_pr__cap_mim_m3_1 l=3 w=3
X5892 N_B11 N_TOP sky130_fd_pr__cap_mim_m3_1 l=3 w=3
X5893 P_B10 P_TOP sky130_fd_pr__cap_mim_m3_1 l=3 w=3
X5894 N_B11 N_TOP sky130_fd_pr__cap_mim_m3_1 l=3 w=3
X5895 P_B9 P_TOP sky130_fd_pr__cap_mim_m3_1 l=3 w=3
X5896 P_B11 P_TOP sky130_fd_pr__cap_mim_m3_1 l=3 w=3
X5897 N_B9 N_TOP sky130_fd_pr__cap_mim_m3_1 l=3 w=3
X5898 N_B11 N_TOP sky130_fd_pr__cap_mim_m3_1 l=3 w=3
X5899 P_B10 P_TOP sky130_fd_pr__cap_mim_m3_1 l=3 w=3
X5900 N_B11 N_TOP sky130_fd_pr__cap_mim_m3_1 l=3 w=3
X5901 N_B8 N_TOP sky130_fd_pr__cap_mim_m3_1 l=3 w=3
X5902 N_B10 N_TOP sky130_fd_pr__cap_mim_m3_1 l=3 w=3
X5903 P_B11 P_TOP sky130_fd_pr__cap_mim_m3_1 l=3 w=3
X5904 P_B8 P_TOP sky130_fd_pr__cap_mim_m3_1 l=3 w=3
X5905 P_B10 P_TOP sky130_fd_pr__cap_mim_m3_1 l=3 w=3
X5906 P_B10 P_TOP sky130_fd_pr__cap_mim_m3_1 l=3 w=3
X5907 P_B11 P_TOP sky130_fd_pr__cap_mim_m3_1 l=3 w=3
X5908 N_B11 N_TOP sky130_fd_pr__cap_mim_m3_1 l=3 w=3
X5909 N_B11 N_TOP sky130_fd_pr__cap_mim_m3_1 l=3 w=3
X5910 P_B11 P_TOP sky130_fd_pr__cap_mim_m3_1 l=3 w=3
X5911 N_B9 N_TOP sky130_fd_pr__cap_mim_m3_1 l=3 w=3
X5912 N_B11 N_TOP sky130_fd_pr__cap_mim_m3_1 l=3 w=3
X5913 N_B11 N_TOP sky130_fd_pr__cap_mim_m3_1 l=3 w=3
X5914 N_B8 N_TOP sky130_fd_pr__cap_mim_m3_1 l=3 w=3
X5915 P_B8 P_TOP sky130_fd_pr__cap_mim_m3_1 l=3 w=3
X5916 N_B10 N_TOP sky130_fd_pr__cap_mim_m3_1 l=3 w=3
X5917 P_B10 P_TOP sky130_fd_pr__cap_mim_m3_1 l=3 w=3
X5918 N_B11 N_TOP sky130_fd_pr__cap_mim_m3_1 l=3 w=3
X5919 P_B11 P_TOP sky130_fd_pr__cap_mim_m3_1 l=3 w=3
X5920 N_B11 N_TOP sky130_fd_pr__cap_mim_m3_1 l=3 w=3
X5921 P_B11 P_TOP sky130_fd_pr__cap_mim_m3_1 l=3 w=3
X5922 N_B10 N_TOP sky130_fd_pr__cap_mim_m3_1 l=3 w=3
X5923 N_B8 N_TOP sky130_fd_pr__cap_mim_m3_1 l=3 w=3
X5924 P_B10 P_TOP sky130_fd_pr__cap_mim_m3_1 l=3 w=3
X5925 P_B11 P_TOP sky130_fd_pr__cap_mim_m3_1 l=3 w=3
X5926 N_EDGE_BIAS N_EDGE_BIAS sky130_fd_pr__cap_mim_m3_1 l=3 w=3
X5927 P_B11 P_TOP sky130_fd_pr__cap_mim_m3_1 l=3 w=3
X5928 N_B11 N_TOP sky130_fd_pr__cap_mim_m3_1 l=3 w=3
X5929 N_B9 N_TOP sky130_fd_pr__cap_mim_m3_1 l=3 w=3
X5930 N_B11 N_TOP sky130_fd_pr__cap_mim_m3_1 l=3 w=3
X5931 N_B9 N_TOP sky130_fd_pr__cap_mim_m3_1 l=3 w=3
X5932 N_B9 N_TOP sky130_fd_pr__cap_mim_m3_1 l=3 w=3
X5933 P_B9 P_TOP sky130_fd_pr__cap_mim_m3_1 l=3 w=3
X5934 P_B11 P_TOP sky130_fd_pr__cap_mim_m3_1 l=3 w=3
X5935 N_B11 N_TOP sky130_fd_pr__cap_mim_m3_1 l=3 w=3
X5936 N_B10 N_TOP sky130_fd_pr__cap_mim_m3_1 l=3 w=3
X5937 N_B5 N_TOP sky130_fd_pr__cap_mim_m3_1 l=3 w=3
X5938 P_B8 P_TOP sky130_fd_pr__cap_mim_m3_1 l=3 w=3
X5939 P_B11 P_TOP sky130_fd_pr__cap_mim_m3_1 l=3 w=3
X5940 N_B11 N_TOP sky130_fd_pr__cap_mim_m3_1 l=3 w=3
X5941 N_B6 N_TOP sky130_fd_pr__cap_mim_m3_1 l=3 w=3
X5942 P_B10 P_TOP sky130_fd_pr__cap_mim_m3_1 l=3 w=3
X5943 N_B11 N_TOP sky130_fd_pr__cap_mim_m3_1 l=3 w=3
X5944 N_B9 N_TOP sky130_fd_pr__cap_mim_m3_1 l=3 w=3
X5945 P_B9 P_TOP sky130_fd_pr__cap_mim_m3_1 l=3 w=3
X5946 P_B10 P_TOP sky130_fd_pr__cap_mim_m3_1 l=3 w=3
X5947 P_B11 P_TOP sky130_fd_pr__cap_mim_m3_1 l=3 w=3
X5948 N_EDGE_BIAS N_EDGE_BIAS sky130_fd_pr__cap_mim_m3_1 l=3 w=3
X5949 P_B7 P_TOP sky130_fd_pr__cap_mim_m3_1 l=3 w=3
X5950 N_B11 N_TOP sky130_fd_pr__cap_mim_m3_1 l=3 w=3
X5951 N_B11 N_TOP sky130_fd_pr__cap_mim_m3_1 l=3 w=3
X5952 N_B9 N_TOP sky130_fd_pr__cap_mim_m3_1 l=3 w=3
X5953 P_B11 P_TOP sky130_fd_pr__cap_mim_m3_1 l=3 w=3
X5954 N_B10 N_TOP sky130_fd_pr__cap_mim_m3_1 l=3 w=3
X5955 P_B10 P_TOP sky130_fd_pr__cap_mim_m3_1 l=3 w=3
X5956 N_EDGE_BIAS N_EDGE_BIAS sky130_fd_pr__cap_mim_m3_1 l=3 w=3
X5957 P_B8 P_TOP sky130_fd_pr__cap_mim_m3_1 l=3 w=3
X5958 N_B10 N_TOP sky130_fd_pr__cap_mim_m3_1 l=3 w=3
X5959 P_B11 P_TOP sky130_fd_pr__cap_mim_m3_1 l=3 w=3
X5960 N_B11 N_TOP sky130_fd_pr__cap_mim_m3_1 l=3 w=3
X5961 P_B4 P_TOP sky130_fd_pr__cap_mim_m3_1 l=3 w=3
X5962 P_B8 P_TOP sky130_fd_pr__cap_mim_m3_1 l=3 w=3
X5963 N_B10 N_TOP sky130_fd_pr__cap_mim_m3_1 l=3 w=3
X5964 P_B10 P_TOP sky130_fd_pr__cap_mim_m3_1 l=3 w=3
X5965 P_B6 P_TOP sky130_fd_pr__cap_mim_m3_1 l=3 w=3
X5966 N_B9 N_TOP sky130_fd_pr__cap_mim_m3_1 l=3 w=3
X5967 P_B11 P_TOP sky130_fd_pr__cap_mim_m3_1 l=3 w=3
X5968 P_B9 P_TOP sky130_fd_pr__cap_mim_m3_1 l=3 w=3
X5969 P_B11 P_TOP sky130_fd_pr__cap_mim_m3_1 l=3 w=3
X5970 P_B9 P_TOP sky130_fd_pr__cap_mim_m3_1 l=3 w=3
X5971 N_B10 N_TOP sky130_fd_pr__cap_mim_m3_1 l=3 w=3
X5972 P_B9 P_TOP sky130_fd_pr__cap_mim_m3_1 l=3 w=3
X5973 N_B10 N_TOP sky130_fd_pr__cap_mim_m3_1 l=3 w=3
X5974 N_B10 N_TOP sky130_fd_pr__cap_mim_m3_1 l=3 w=3
X5975 P_B4 P_TOP sky130_fd_pr__cap_mim_m3_1 l=3 w=3
X5976 N_B10 N_TOP sky130_fd_pr__cap_mim_m3_1 l=3 w=3
X5977 P_B10 P_TOP sky130_fd_pr__cap_mim_m3_1 l=3 w=3
X5978 P_B9 P_TOP sky130_fd_pr__cap_mim_m3_1 l=3 w=3
X5979 P_B11 P_TOP sky130_fd_pr__cap_mim_m3_1 l=3 w=3
X5980 N_B11 N_TOP sky130_fd_pr__cap_mim_m3_1 l=3 w=3
X5981 P_B11 P_TOP sky130_fd_pr__cap_mim_m3_1 l=3 w=3
X5982 N_B10 N_TOP sky130_fd_pr__cap_mim_m3_1 l=3 w=3
X5983 P_B10 P_TOP sky130_fd_pr__cap_mim_m3_1 l=3 w=3
X5984 P_B11 P_TOP sky130_fd_pr__cap_mim_m3_1 l=3 w=3
X5985 N_B10 N_TOP sky130_fd_pr__cap_mim_m3_1 l=3 w=3
X5986 P_B11 P_TOP sky130_fd_pr__cap_mim_m3_1 l=3 w=3
X5987 N_B11 N_TOP sky130_fd_pr__cap_mim_m3_1 l=3 w=3
X5988 N_B10 N_TOP sky130_fd_pr__cap_mim_m3_1 l=3 w=3
X5989 P_B11 P_TOP sky130_fd_pr__cap_mim_m3_1 l=3 w=3
X5990 N_B10 N_TOP sky130_fd_pr__cap_mim_m3_1 l=3 w=3
X5991 P_B11 P_TOP sky130_fd_pr__cap_mim_m3_1 l=3 w=3
X5992 N_B11 N_TOP sky130_fd_pr__cap_mim_m3_1 l=3 w=3
X5993 N_B10 N_TOP sky130_fd_pr__cap_mim_m3_1 l=3 w=3
X5994 P_B11 P_TOP sky130_fd_pr__cap_mim_m3_1 l=3 w=3
X5995 N_B11 N_TOP sky130_fd_pr__cap_mim_m3_1 l=3 w=3
X5996 P_EDGE_BIAS P_EDGE_BIAS sky130_fd_pr__cap_mim_m3_1 l=3 w=3
X5997 P_B9 P_TOP sky130_fd_pr__cap_mim_m3_1 l=3 w=3
X5998 P_B11 P_TOP sky130_fd_pr__cap_mim_m3_1 l=3 w=3
X5999 N_B10 N_TOP sky130_fd_pr__cap_mim_m3_1 l=3 w=3
X6000 P_B10 P_TOP sky130_fd_pr__cap_mim_m3_1 l=3 w=3
X6001 P_B11 P_TOP sky130_fd_pr__cap_mim_m3_1 l=3 w=3
X6002 P_B11 P_TOP sky130_fd_pr__cap_mim_m3_1 l=3 w=3
X6003 N_B11 N_TOP sky130_fd_pr__cap_mim_m3_1 l=3 w=3
X6004 P_B7 P_TOP sky130_fd_pr__cap_mim_m3_1 l=3 w=3
X6005 P_B10 P_TOP sky130_fd_pr__cap_mim_m3_1 l=3 w=3
X6006 N_B10 N_TOP sky130_fd_pr__cap_mim_m3_1 l=3 w=3
X6007 N_B11 N_TOP sky130_fd_pr__cap_mim_m3_1 l=3 w=3
X6008 P_B9 P_TOP sky130_fd_pr__cap_mim_m3_1 l=3 w=3
X6009 N_B9 N_TOP sky130_fd_pr__cap_mim_m3_1 l=3 w=3
X6010 P_B9 P_TOP sky130_fd_pr__cap_mim_m3_1 l=3 w=3
X6011 P_B11 P_TOP sky130_fd_pr__cap_mim_m3_1 l=3 w=3
X6012 N_B9 N_TOP sky130_fd_pr__cap_mim_m3_1 l=3 w=3
X6013 N_B8 N_TOP sky130_fd_pr__cap_mim_m3_1 l=3 w=3
X6014 N_EDGE_BIAS N_EDGE_BIAS sky130_fd_pr__cap_mim_m3_1 l=3 w=3
X6015 P_B8 P_TOP sky130_fd_pr__cap_mim_m3_1 l=3 w=3
X6016 N_B10 N_TOP sky130_fd_pr__cap_mim_m3_1 l=3 w=3
X6017 P_B10 P_TOP sky130_fd_pr__cap_mim_m3_1 l=3 w=3
X6018 N_B11 N_TOP sky130_fd_pr__cap_mim_m3_1 l=3 w=3
X6019 P_B8 P_TOP sky130_fd_pr__cap_mim_m3_1 l=3 w=3
X6020 P_B11 P_TOP sky130_fd_pr__cap_mim_m3_1 l=3 w=3
X6021 P_B10 P_TOP sky130_fd_pr__cap_mim_m3_1 l=3 w=3
X6022 N_B9 N_TOP sky130_fd_pr__cap_mim_m3_1 l=3 w=3
X6023 P_B11 P_TOP sky130_fd_pr__cap_mim_m3_1 l=3 w=3
X6024 N_B7 N_TOP sky130_fd_pr__cap_mim_m3_1 l=3 w=3
X6025 N_B11 N_TOP sky130_fd_pr__cap_mim_m3_1 l=3 w=3
X6026 N_B11 N_TOP sky130_fd_pr__cap_mim_m3_1 l=3 w=3
X6027 N_B9 N_TOP sky130_fd_pr__cap_mim_m3_1 l=3 w=3
X6028 P_B10 P_TOP sky130_fd_pr__cap_mim_m3_1 l=3 w=3
X6029 N_B10 N_TOP sky130_fd_pr__cap_mim_m3_1 l=3 w=3
X6030 P_B10 P_TOP sky130_fd_pr__cap_mim_m3_1 l=3 w=3
X6031 N_B11 N_TOP sky130_fd_pr__cap_mim_m3_1 l=3 w=3
X6032 P_B11 P_TOP sky130_fd_pr__cap_mim_m3_1 l=3 w=3
X6033 N_B8 N_TOP sky130_fd_pr__cap_mim_m3_1 l=3 w=3
X6034 P_B8 P_TOP sky130_fd_pr__cap_mim_m3_1 l=3 w=3
X6035 N_EDGE_BIAS N_EDGE_BIAS sky130_fd_pr__cap_mim_m3_1 l=3 w=3
X6036 P_B10 P_TOP sky130_fd_pr__cap_mim_m3_1 l=3 w=3
X6037 P_B10 P_TOP sky130_fd_pr__cap_mim_m3_1 l=3 w=3
X6038 P_B11 P_TOP sky130_fd_pr__cap_mim_m3_1 l=3 w=3
X6039 N_B11 N_TOP sky130_fd_pr__cap_mim_m3_1 l=3 w=3
X6040 P_B11 P_TOP sky130_fd_pr__cap_mim_m3_1 l=3 w=3
X6041 N_B11 N_TOP sky130_fd_pr__cap_mim_m3_1 l=3 w=3
X6042 N_B8 N_TOP sky130_fd_pr__cap_mim_m3_1 l=3 w=3
X6043 P_B10 P_TOP sky130_fd_pr__cap_mim_m3_1 l=3 w=3
X6044 P_B11 P_TOP sky130_fd_pr__cap_mim_m3_1 l=3 w=3
X6045 N_B11 N_TOP sky130_fd_pr__cap_mim_m3_1 l=3 w=3
X6046 N_B11 N_TOP sky130_fd_pr__cap_mim_m3_1 l=3 w=3
X6047 N_B9 N_TOP sky130_fd_pr__cap_mim_m3_1 l=3 w=3
X6048 P_B9 P_TOP sky130_fd_pr__cap_mim_m3_1 l=3 w=3
X6049 P_B9 P_TOP sky130_fd_pr__cap_mim_m3_1 l=3 w=3
X6050 N_B11 N_TOP sky130_fd_pr__cap_mim_m3_1 l=3 w=3
X6051 N_B9 N_TOP sky130_fd_pr__cap_mim_m3_1 l=3 w=3
X6052 P_B11 P_TOP sky130_fd_pr__cap_mim_m3_1 l=3 w=3
X6053 N_B11 N_TOP sky130_fd_pr__cap_mim_m3_1 l=3 w=3
X6054 N_B10 N_TOP sky130_fd_pr__cap_mim_m3_1 l=3 w=3
X6055 N_B6 N_TOP sky130_fd_pr__cap_mim_m3_1 l=3 w=3
X6056 P_B6 P_TOP sky130_fd_pr__cap_mim_m3_1 l=3 w=3
X6057 N_B11 N_TOP sky130_fd_pr__cap_mim_m3_1 l=3 w=3
X6058 P_B10 P_TOP sky130_fd_pr__cap_mim_m3_1 l=3 w=3
X6059 P_B11 P_TOP sky130_fd_pr__cap_mim_m3_1 l=3 w=3
X6060 P_B11 P_TOP sky130_fd_pr__cap_mim_m3_1 l=3 w=3
X6061 P_B10 P_TOP sky130_fd_pr__cap_mim_m3_1 l=3 w=3
X6062 N_B11 N_TOP sky130_fd_pr__cap_mim_m3_1 l=3 w=3
X6063 N_B10 N_TOP sky130_fd_pr__cap_mim_m3_1 l=3 w=3
X6064 P_B9 P_TOP sky130_fd_pr__cap_mim_m3_1 l=3 w=3
X6065 P_B11 P_TOP sky130_fd_pr__cap_mim_m3_1 l=3 w=3
X6066 P_B11 P_TOP sky130_fd_pr__cap_mim_m3_1 l=3 w=3
X6067 P_B11 P_TOP sky130_fd_pr__cap_mim_m3_1 l=3 w=3
X6068 P_B11 P_TOP sky130_fd_pr__cap_mim_m3_1 l=3 w=3
X6069 P_B7 P_TOP sky130_fd_pr__cap_mim_m3_1 l=3 w=3
X6070 N_B8 N_TOP sky130_fd_pr__cap_mim_m3_1 l=3 w=3
X6071 N_B11 N_TOP sky130_fd_pr__cap_mim_m3_1 l=3 w=3
X6072 P_B10 P_TOP sky130_fd_pr__cap_mim_m3_1 l=3 w=3
X6073 N_B10 N_TOP sky130_fd_pr__cap_mim_m3_1 l=3 w=3
X6074 P_B10 P_TOP sky130_fd_pr__cap_mim_m3_1 l=3 w=3
X6075 N_EDGE_BIAS N_EDGE_BIAS sky130_fd_pr__cap_mim_m3_1 l=3 w=3
X6076 P_B11 P_TOP sky130_fd_pr__cap_mim_m3_1 l=3 w=3
X6077 P_B8 P_TOP sky130_fd_pr__cap_mim_m3_1 l=3 w=3
X6078 N_B10 N_TOP sky130_fd_pr__cap_mim_m3_1 l=3 w=3
X6079 P_B11 P_TOP sky130_fd_pr__cap_mim_m3_1 l=3 w=3
X6080 P_B10 P_TOP sky130_fd_pr__cap_mim_m3_1 l=3 w=3
X6081 N_B4 N_TOP sky130_fd_pr__cap_mim_m3_1 l=3 w=3
X6082 P_B5 P_TOP sky130_fd_pr__cap_mim_m3_1 l=3 w=3
X6083 P_B11 P_TOP sky130_fd_pr__cap_mim_m3_1 l=3 w=3
X6084 N_B11 N_TOP sky130_fd_pr__cap_mim_m3_1 l=3 w=3
X6085 N_B11 N_TOP sky130_fd_pr__cap_mim_m3_1 l=3 w=3
X6086 N_B11 N_TOP sky130_fd_pr__cap_mim_m3_1 l=3 w=3
X6087 P_B10 P_TOP sky130_fd_pr__cap_mim_m3_1 l=3 w=3
X6088 N_B11 N_TOP sky130_fd_pr__cap_mim_m3_1 l=3 w=3
X6089 P_B11 P_TOP sky130_fd_pr__cap_mim_m3_1 l=3 w=3
X6090 P_B11 P_TOP sky130_fd_pr__cap_mim_m3_1 l=3 w=3
X6091 P_B9 P_TOP sky130_fd_pr__cap_mim_m3_1 l=3 w=3
X6092 P_B9 P_TOP sky130_fd_pr__cap_mim_m3_1 l=3 w=3
X6093 P_B10 P_TOP sky130_fd_pr__cap_mim_m3_1 l=3 w=3
X6094 N_B10 N_TOP sky130_fd_pr__cap_mim_m3_1 l=3 w=3
X6095 N_B11 N_TOP sky130_fd_pr__cap_mim_m3_1 l=3 w=3
X6096 N_B11 N_TOP sky130_fd_pr__cap_mim_m3_1 l=3 w=3
X6097 P_B9 P_TOP sky130_fd_pr__cap_mim_m3_1 l=3 w=3
X6098 N_B7 N_TOP sky130_fd_pr__cap_mim_m3_1 l=3 w=3
X6099 N_B10 N_TOP sky130_fd_pr__cap_mim_m3_1 l=3 w=3
X6100 P_B11 P_TOP sky130_fd_pr__cap_mim_m3_1 l=3 w=3
X6101 N_B10 N_TOP sky130_fd_pr__cap_mim_m3_1 l=3 w=3
X6102 P_B10 P_TOP sky130_fd_pr__cap_mim_m3_1 l=3 w=3
X6103 P_B11 P_TOP sky130_fd_pr__cap_mim_m3_1 l=3 w=3
X6104 P_B9 P_TOP sky130_fd_pr__cap_mim_m3_1 l=3 w=3
X6105 P_B11 P_TOP sky130_fd_pr__cap_mim_m3_1 l=3 w=3
X6106 P_B11 P_TOP sky130_fd_pr__cap_mim_m3_1 l=3 w=3
X6107 N_B11 N_TOP sky130_fd_pr__cap_mim_m3_1 l=3 w=3
X6108 N_B10 N_TOP sky130_fd_pr__cap_mim_m3_1 l=3 w=3
X6109 P_B10 P_TOP sky130_fd_pr__cap_mim_m3_1 l=3 w=3
X6110 P_B11 P_TOP sky130_fd_pr__cap_mim_m3_1 l=3 w=3
X6111 N_B10 N_TOP sky130_fd_pr__cap_mim_m3_1 l=3 w=3
X6112 P_B11 P_TOP sky130_fd_pr__cap_mim_m3_1 l=3 w=3
X6113 P_B11 P_TOP sky130_fd_pr__cap_mim_m3_1 l=3 w=3
X6114 P_B9 P_TOP sky130_fd_pr__cap_mim_m3_1 l=3 w=3
X6115 N_B10 N_TOP sky130_fd_pr__cap_mim_m3_1 l=3 w=3
X6116 P_B10 P_TOP sky130_fd_pr__cap_mim_m3_1 l=3 w=3
X6117 N_B11 N_TOP sky130_fd_pr__cap_mim_m3_1 l=3 w=3
X6118 N_B11 N_TOP sky130_fd_pr__cap_mim_m3_1 l=3 w=3
X6119 P_B10 P_TOP sky130_fd_pr__cap_mim_m3_1 l=3 w=3
X6120 P_B11 P_TOP sky130_fd_pr__cap_mim_m3_1 l=3 w=3
X6121 N_B10 N_TOP sky130_fd_pr__cap_mim_m3_1 l=3 w=3
X6122 P_B10 P_TOP sky130_fd_pr__cap_mim_m3_1 l=3 w=3
X6123 P_B11 P_TOP sky130_fd_pr__cap_mim_m3_1 l=3 w=3
X6124 P_B11 P_TOP sky130_fd_pr__cap_mim_m3_1 l=3 w=3
X6125 P_B9 P_TOP sky130_fd_pr__cap_mim_m3_1 l=3 w=3
X6126 P_B11 P_TOP sky130_fd_pr__cap_mim_m3_1 l=3 w=3
X6127 N_B11 N_TOP sky130_fd_pr__cap_mim_m3_1 l=3 w=3
X6128 N_B11 N_TOP sky130_fd_pr__cap_mim_m3_1 l=3 w=3
X6129 P_B9 P_TOP sky130_fd_pr__cap_mim_m3_1 l=3 w=3
X6130 N_B11 N_TOP sky130_fd_pr__cap_mim_m3_1 l=3 w=3
X6131 P_B10 P_TOP sky130_fd_pr__cap_mim_m3_1 l=3 w=3
X6132 N_B11 N_TOP sky130_fd_pr__cap_mim_m3_1 l=3 w=3
X6133 N_B10 N_TOP sky130_fd_pr__cap_mim_m3_1 l=3 w=3
X6134 P_EDGE_BIAS P_EDGE_BIAS sky130_fd_pr__cap_mim_m3_1 l=3 w=3
X6135 P_B7 P_TOP sky130_fd_pr__cap_mim_m3_1 l=3 w=3
X6136 P_B11 P_TOP sky130_fd_pr__cap_mim_m3_1 l=3 w=3
X6137 N_B9 N_TOP sky130_fd_pr__cap_mim_m3_1 l=3 w=3
X6138 P_B9 P_TOP sky130_fd_pr__cap_mim_m3_1 l=3 w=3
X6139 P_B8 P_TOP sky130_fd_pr__cap_mim_m3_1 l=3 w=3
X6140 N_B9 N_TOP sky130_fd_pr__cap_mim_m3_1 l=3 w=3
X6141 N_B11 N_TOP sky130_fd_pr__cap_mim_m3_1 l=3 w=3
X6142 P_B11 P_TOP sky130_fd_pr__cap_mim_m3_1 l=3 w=3
X6143 P_B9 P_TOP sky130_fd_pr__cap_mim_m3_1 l=3 w=3
X6144 N_B8 N_TOP sky130_fd_pr__cap_mim_m3_1 l=3 w=3
X6145 P_B10 P_TOP sky130_fd_pr__cap_mim_m3_1 l=3 w=3
X6146 N_B8 N_TOP sky130_fd_pr__cap_mim_m3_1 l=3 w=3
X6147 P_B8 P_TOP sky130_fd_pr__cap_mim_m3_1 l=3 w=3
X6148 P_B10 P_TOP sky130_fd_pr__cap_mim_m3_1 l=3 w=3
X6149 N_B11 N_TOP sky130_fd_pr__cap_mim_m3_1 l=3 w=3
X6150 P_B11 P_TOP sky130_fd_pr__cap_mim_m3_1 l=3 w=3
X6151 P_B11 P_TOP sky130_fd_pr__cap_mim_m3_1 l=3 w=3
X6152 P_B10 P_TOP sky130_fd_pr__cap_mim_m3_1 l=3 w=3
X6153 N_B9 N_TOP sky130_fd_pr__cap_mim_m3_1 l=3 w=3
X6154 P_B9 P_TOP sky130_fd_pr__cap_mim_m3_1 l=3 w=3
X6155 N_B11 N_TOP sky130_fd_pr__cap_mim_m3_1 l=3 w=3
X6156 P_B11 P_TOP sky130_fd_pr__cap_mim_m3_1 l=3 w=3
X6157 N_B11 N_TOP sky130_fd_pr__cap_mim_m3_1 l=3 w=3
X6158 N_B7 N_TOP sky130_fd_pr__cap_mim_m3_1 l=3 w=3
X6159 N_B8 N_TOP sky130_fd_pr__cap_mim_m3_1 l=3 w=3
X6160 P_B8 P_TOP sky130_fd_pr__cap_mim_m3_1 l=3 w=3
X6161 N_B10 N_TOP sky130_fd_pr__cap_mim_m3_1 l=3 w=3
X6162 P_B10 P_TOP sky130_fd_pr__cap_mim_m3_1 l=3 w=3
X6163 N_B11 N_TOP sky130_fd_pr__cap_mim_m3_1 l=3 w=3
X6164 N_B11 N_TOP sky130_fd_pr__cap_mim_m3_1 l=3 w=3
X6165 P_B11 P_TOP sky130_fd_pr__cap_mim_m3_1 l=3 w=3
X6166 P_B11 P_TOP sky130_fd_pr__cap_mim_m3_1 l=3 w=3
X6167 N_EDGE_BIAS N_EDGE_BIAS sky130_fd_pr__cap_mim_m3_1 l=3 w=3
X6168 P_B10 P_TOP sky130_fd_pr__cap_mim_m3_1 l=3 w=3
X6169 N_B8 N_TOP sky130_fd_pr__cap_mim_m3_1 l=3 w=3
X6170 P_B10 P_TOP sky130_fd_pr__cap_mim_m3_1 l=3 w=3
X6171 N_B11 N_TOP sky130_fd_pr__cap_mim_m3_1 l=3 w=3
X6172 P_EDGE_BIAS P_EDGE_BIAS sky130_fd_pr__cap_mim_m3_1 l=3 w=3
X6173 N_B11 N_TOP sky130_fd_pr__cap_mim_m3_1 l=3 w=3
X6174 P_B11 P_TOP sky130_fd_pr__cap_mim_m3_1 l=3 w=3
X6175 N_B6 N_TOP sky130_fd_pr__cap_mim_m3_1 l=3 w=3
X6176 N_B8 N_TOP sky130_fd_pr__cap_mim_m3_1 l=3 w=3
X6177 N_B11 N_TOP sky130_fd_pr__cap_mim_m3_1 l=3 w=3
X6178 P_B11 P_TOP sky130_fd_pr__cap_mim_m3_1 l=3 w=3
X6179 P_B10 P_TOP sky130_fd_pr__cap_mim_m3_1 l=3 w=3
X6180 N_B9 N_TOP sky130_fd_pr__cap_mim_m3_1 l=3 w=3
X6181 P_B11 P_TOP sky130_fd_pr__cap_mim_m3_1 l=3 w=3
X6182 N_B11 N_TOP sky130_fd_pr__cap_mim_m3_1 l=3 w=3
X6183 N_B11 N_TOP sky130_fd_pr__cap_mim_m3_1 l=3 w=3
X6184 P_B11 P_TOP sky130_fd_pr__cap_mim_m3_1 l=3 w=3
X6185 N_B9 N_TOP sky130_fd_pr__cap_mim_m3_1 l=3 w=3
X6186 N_B9 N_TOP sky130_fd_pr__cap_mim_m3_1 l=3 w=3
X6187 N_B11 N_TOP sky130_fd_pr__cap_mim_m3_1 l=3 w=3
X6188 P_B10 P_TOP sky130_fd_pr__cap_mim_m3_1 l=3 w=3
X6189 P_B8 P_TOP sky130_fd_pr__cap_mim_m3_1 l=3 w=3
X6190 P_B11 P_TOP sky130_fd_pr__cap_mim_m3_1 l=3 w=3
X6191 N_B11 N_TOP sky130_fd_pr__cap_mim_m3_1 l=3 w=3
X6192 P_B11 P_TOP sky130_fd_pr__cap_mim_m3_1 l=3 w=3
X6193 N_B6 N_TOP sky130_fd_pr__cap_mim_m3_1 l=3 w=3
X6194 N_EDGE_BIAS N_EDGE_BIAS sky130_fd_pr__cap_mim_m3_1 l=3 w=3
X6195 P_B10 P_TOP sky130_fd_pr__cap_mim_m3_1 l=3 w=3
X6196 N_B11 N_TOP sky130_fd_pr__cap_mim_m3_1 l=3 w=3
X6197 N_B9 N_TOP sky130_fd_pr__cap_mim_m3_1 l=3 w=3
X6198 N_B11 N_TOP sky130_fd_pr__cap_mim_m3_1 l=3 w=3
X6199 P_B7 P_TOP sky130_fd_pr__cap_mim_m3_1 l=3 w=3
X6200 N_B11 N_TOP sky130_fd_pr__cap_mim_m3_1 l=3 w=3
X6201 P_B11 P_TOP sky130_fd_pr__cap_mim_m3_1 l=3 w=3
X6202 P_B11 P_TOP sky130_fd_pr__cap_mim_m3_1 l=3 w=3
X6203 P_EDGE_BIAS P_EDGE_BIAS sky130_fd_pr__cap_mim_m3_1 l=3 w=3
X6204 N_B11 N_TOP sky130_fd_pr__cap_mim_m3_1 l=3 w=3
X6205 N_B11 N_TOP sky130_fd_pr__cap_mim_m3_1 l=3 w=3
X6206 N_B11 N_TOP sky130_fd_pr__cap_mim_m3_1 l=3 w=3
X6207 P_B10 P_TOP sky130_fd_pr__cap_mim_m3_1 l=3 w=3
X6208 P_B10 P_TOP sky130_fd_pr__cap_mim_m3_1 l=3 w=3
X6209 N_B11 N_TOP sky130_fd_pr__cap_mim_m3_1 l=3 w=3
X6210 P_B10 P_TOP sky130_fd_pr__cap_mim_m3_1 l=3 w=3
X6211 P_B3 P_TOP sky130_fd_pr__cap_mim_m3_1 l=3 w=3
X6212 P_B11 P_TOP sky130_fd_pr__cap_mim_m3_1 l=3 w=3
X6213 P_B8 P_TOP sky130_fd_pr__cap_mim_m3_1 l=3 w=3
X6214 N_B10 N_TOP sky130_fd_pr__cap_mim_m3_1 l=3 w=3
X6215 N_EDGE_BIAS N_EDGE_BIAS sky130_fd_pr__cap_mim_m3_1 l=3 w=3
X6216 P_B10 P_TOP sky130_fd_pr__cap_mim_m3_1 l=3 w=3
X6217 P_B6 P_TOP sky130_fd_pr__cap_mim_m3_1 l=3 w=3
X6218 N_B11 N_TOP sky130_fd_pr__cap_mim_m3_1 l=3 w=3
X6219 P_B11 P_TOP sky130_fd_pr__cap_mim_m3_1 l=3 w=3
X6220 P_B11 P_TOP sky130_fd_pr__cap_mim_m3_1 l=3 w=3
X6221 P_B9 P_TOP sky130_fd_pr__cap_mim_m3_1 l=3 w=3
X6222 N_B10 N_TOP sky130_fd_pr__cap_mim_m3_1 l=3 w=3
X6223 P_B10 P_TOP sky130_fd_pr__cap_mim_m3_1 l=3 w=3
X6224 N_B7 N_TOP sky130_fd_pr__cap_mim_m3_1 l=3 w=3
X6225 N_B10 N_TOP sky130_fd_pr__cap_mim_m3_1 l=3 w=3
X6226 N_B10 N_TOP sky130_fd_pr__cap_mim_m3_1 l=3 w=3
X6227 P_B10 P_TOP sky130_fd_pr__cap_mim_m3_1 l=3 w=3
X6228 P_EDGE_BIAS P_EDGE_BIAS sky130_fd_pr__cap_mim_m3_1 l=3 w=3
X6229 N_B11 N_TOP sky130_fd_pr__cap_mim_m3_1 l=3 w=3
X6230 N_EDGE_BIAS N_EDGE_BIAS sky130_fd_pr__cap_mim_m3_1 l=3 w=3
X6231 P_B11 P_TOP sky130_fd_pr__cap_mim_m3_1 l=3 w=3
X6232 P_B10 P_TOP sky130_fd_pr__cap_mim_m3_1 l=3 w=3
X6233 P_B11 P_TOP sky130_fd_pr__cap_mim_m3_1 l=3 w=3
X6234 N_B8 N_TOP sky130_fd_pr__cap_mim_m3_1 l=3 w=3
X6235 N_B10 N_TOP sky130_fd_pr__cap_mim_m3_1 l=3 w=3
X6236 P_B11 P_TOP sky130_fd_pr__cap_mim_m3_1 l=3 w=3
X6237 N_B10 N_TOP sky130_fd_pr__cap_mim_m3_1 l=3 w=3
X6238 P_B9 P_TOP sky130_fd_pr__cap_mim_m3_1 l=3 w=3
X6239 P_B11 P_TOP sky130_fd_pr__cap_mim_m3_1 l=3 w=3
X6240 N_B11 N_TOP sky130_fd_pr__cap_mim_m3_1 l=3 w=3
X6241 N_B10 N_TOP sky130_fd_pr__cap_mim_m3_1 l=3 w=3
X6242 P_EDGE_BIAS P_EDGE_BIAS sky130_fd_pr__cap_mim_m3_1 l=3 w=3
X6243 P_B11 P_TOP sky130_fd_pr__cap_mim_m3_1 l=3 w=3
X6244 N_B10 N_TOP sky130_fd_pr__cap_mim_m3_1 l=3 w=3
X6245 N_B10 N_TOP sky130_fd_pr__cap_mim_m3_1 l=3 w=3
X6246 P_B11 P_TOP sky130_fd_pr__cap_mim_m3_1 l=3 w=3
X6247 P_EDGE_BIAS P_EDGE_BIAS sky130_fd_pr__cap_mim_m3_1 l=3 w=3
X6248 P_B9 P_TOP sky130_fd_pr__cap_mim_m3_1 l=3 w=3
X6249 P_B11 P_TOP sky130_fd_pr__cap_mim_m3_1 l=3 w=3
X6250 N_B11 N_TOP sky130_fd_pr__cap_mim_m3_1 l=3 w=3
X6251 N_B10 N_TOP sky130_fd_pr__cap_mim_m3_1 l=3 w=3
X6252 N_B10 N_TOP sky130_fd_pr__cap_mim_m3_1 l=3 w=3
X6253 P_B7 P_TOP sky130_fd_pr__cap_mim_m3_1 l=3 w=3
X6254 P_B10 P_TOP sky130_fd_pr__cap_mim_m3_1 l=3 w=3
X6255 N_B11 N_TOP sky130_fd_pr__cap_mim_m3_1 l=3 w=3
X6256 N_B10 N_TOP sky130_fd_pr__cap_mim_m3_1 l=3 w=3
X6257 P_B11 P_TOP sky130_fd_pr__cap_mim_m3_1 l=3 w=3
X6258 N_B11 N_TOP sky130_fd_pr__cap_mim_m3_1 l=3 w=3
X6259 P_B9 P_TOP sky130_fd_pr__cap_mim_m3_1 l=3 w=3
X6260 P_B11 P_TOP sky130_fd_pr__cap_mim_m3_1 l=3 w=3
X6261 N_B9 N_TOP sky130_fd_pr__cap_mim_m3_1 l=3 w=3
X6262 P_B9 P_TOP sky130_fd_pr__cap_mim_m3_1 l=3 w=3
X6263 P_B8 P_TOP sky130_fd_pr__cap_mim_m3_1 l=3 w=3
X6264 P_B9 P_TOP sky130_fd_pr__cap_mim_m3_1 l=3 w=3
X6265 N_B11 N_TOP sky130_fd_pr__cap_mim_m3_1 l=3 w=3
X6266 P_B8 P_TOP sky130_fd_pr__cap_mim_m3_1 l=3 w=3
X6267 P_B10 P_TOP sky130_fd_pr__cap_mim_m3_1 l=3 w=3
X6268 P_B11 P_TOP sky130_fd_pr__cap_mim_m3_1 l=3 w=3
X6269 P_B8 P_TOP sky130_fd_pr__cap_mim_m3_1 l=3 w=3
X6270 P_B10 P_TOP sky130_fd_pr__cap_mim_m3_1 l=3 w=3
X6271 N_B10 N_TOP sky130_fd_pr__cap_mim_m3_1 l=3 w=3
X6272 N_B11 N_TOP sky130_fd_pr__cap_mim_m3_1 l=3 w=3
X6273 P_B11 P_TOP sky130_fd_pr__cap_mim_m3_1 l=3 w=3
X6274 N_B9 N_TOP sky130_fd_pr__cap_mim_m3_1 l=3 w=3
X6275 N_B11 N_TOP sky130_fd_pr__cap_mim_m3_1 l=3 w=3
X6276 P_B9 P_TOP sky130_fd_pr__cap_mim_m3_1 l=3 w=3
X6277 P_B11 P_TOP sky130_fd_pr__cap_mim_m3_1 l=3 w=3
X6278 N_B7 N_TOP sky130_fd_pr__cap_mim_m3_1 l=3 w=3
X6279 N_B11 N_TOP sky130_fd_pr__cap_mim_m3_1 l=3 w=3
X6280 P_B11 P_TOP sky130_fd_pr__cap_mim_m3_1 l=3 w=3
X6281 N_B8 N_TOP sky130_fd_pr__cap_mim_m3_1 l=3 w=3
X6282 P_B8 P_TOP sky130_fd_pr__cap_mim_m3_1 l=3 w=3
X6283 N_B10 N_TOP sky130_fd_pr__cap_mim_m3_1 l=3 w=3
X6284 P_B10 P_TOP sky130_fd_pr__cap_mim_m3_1 l=3 w=3
X6285 N_EDGE_BIAS N_EDGE_BIAS sky130_fd_pr__cap_mim_m3_1 l=3 w=3
X6286 P_B11 P_TOP sky130_fd_pr__cap_mim_m3_1 l=3 w=3
X6287 N_B11 N_TOP sky130_fd_pr__cap_mim_m3_1 l=3 w=3
X6288 P_B11 P_TOP sky130_fd_pr__cap_mim_m3_1 l=3 w=3
X6289 N_B8 N_TOP sky130_fd_pr__cap_mim_m3_1 l=3 w=3
X6290 P_B11 P_TOP sky130_fd_pr__cap_mim_m3_1 l=3 w=3
X6291 N_B11 N_TOP sky130_fd_pr__cap_mim_m3_1 l=3 w=3
X6292 P_B8 P_TOP sky130_fd_pr__cap_mim_m3_1 l=3 w=3
X6293 N_B10 N_TOP sky130_fd_pr__cap_mim_m3_1 l=3 w=3
X6294 N_B6 N_TOP sky130_fd_pr__cap_mim_m3_1 l=3 w=3
X6295 N_B11 N_TOP sky130_fd_pr__cap_mim_m3_1 l=3 w=3
X6296 N_B9 N_TOP sky130_fd_pr__cap_mim_m3_1 l=3 w=3
X6297 P_B11 P_TOP sky130_fd_pr__cap_mim_m3_1 l=3 w=3
X6298 N_B11 N_TOP sky130_fd_pr__cap_mim_m3_1 l=3 w=3
X6299 N_B9 N_TOP sky130_fd_pr__cap_mim_m3_1 l=3 w=3
X6300 N_B9 N_TOP sky130_fd_pr__cap_mim_m3_1 l=3 w=3
X6301 P_B11 P_TOP sky130_fd_pr__cap_mim_m3_1 l=3 w=3
X6302 N_B10 N_TOP sky130_fd_pr__cap_mim_m3_1 l=3 w=3
X6303 N_B5 N_TOP sky130_fd_pr__cap_mim_m3_1 l=3 w=3
X6304 P_B6 P_TOP sky130_fd_pr__cap_mim_m3_1 l=3 w=3
X6305 P_B11 P_TOP sky130_fd_pr__cap_mim_m3_1 l=3 w=3
X6306 P_B11 P_TOP sky130_fd_pr__cap_mim_m3_1 l=3 w=3
X6307 N_B11 N_TOP sky130_fd_pr__cap_mim_m3_1 l=3 w=3
X6308 P_B11 P_TOP sky130_fd_pr__cap_mim_m3_1 l=3 w=3
X6309 P_B10 P_TOP sky130_fd_pr__cap_mim_m3_1 l=3 w=3
X6310 P_EDGE_BIAS P_EDGE_BIAS sky130_fd_pr__cap_mim_m3_1 l=3 w=3
X6311 N_B11 N_TOP sky130_fd_pr__cap_mim_m3_1 l=3 w=3
X6312 N_B9 N_TOP sky130_fd_pr__cap_mim_m3_1 l=3 w=3
X6313 P_B9 P_TOP sky130_fd_pr__cap_mim_m3_1 l=3 w=3
X6314 P_EDGE_BIAS P_EDGE_BIAS sky130_fd_pr__cap_mim_m3_1 l=3 w=3
X6315 P_B7 P_TOP sky130_fd_pr__cap_mim_m3_1 l=3 w=3
X6316 P_B11 P_TOP sky130_fd_pr__cap_mim_m3_1 l=3 w=3
X6317 N_B11 N_TOP sky130_fd_pr__cap_mim_m3_1 l=3 w=3
X6318 P_B11 P_TOP sky130_fd_pr__cap_mim_m3_1 l=3 w=3
X6319 N_B11 N_TOP sky130_fd_pr__cap_mim_m3_1 l=3 w=3
X6320 N_B11 N_TOP sky130_fd_pr__cap_mim_m3_1 l=3 w=3
X6321 N_B9 N_TOP sky130_fd_pr__cap_mim_m3_1 l=3 w=3
X6322 N_B10 N_TOP sky130_fd_pr__cap_mim_m3_1 l=3 w=3
X6323 P_B10 P_TOP sky130_fd_pr__cap_mim_m3_1 l=3 w=3
X6324 N_EDGE_BIAS N_EDGE_BIAS sky130_fd_pr__cap_mim_m3_1 l=3 w=3
X6325 N_B11 N_TOP sky130_fd_pr__cap_mim_m3_1 l=3 w=3
X6326 N_B10 N_TOP sky130_fd_pr__cap_mim_m3_1 l=3 w=3
X6327 P_B10 P_TOP sky130_fd_pr__cap_mim_m3_1 l=3 w=3
X6328 P_B10 P_TOP sky130_fd_pr__cap_mim_m3_1 l=3 w=3
X6329 P_B11 P_TOP sky130_fd_pr__cap_mim_m3_1 l=3 w=3
X6330 P_B5 P_TOP sky130_fd_pr__cap_mim_m3_1 l=3 w=3
X6331 P_B8 P_TOP sky130_fd_pr__cap_mim_m3_1 l=3 w=3
X6332 N_B11 N_TOP sky130_fd_pr__cap_mim_m3_1 l=3 w=3
X6333 P_B11 P_TOP sky130_fd_pr__cap_mim_m3_1 l=3 w=3
X6334 N_EDGE_BIAS N_EDGE_BIAS sky130_fd_pr__cap_mim_m3_1 l=3 w=3
X6335 P_B10 P_TOP sky130_fd_pr__cap_mim_m3_1 l=3 w=3
X6336 P_B6 P_TOP sky130_fd_pr__cap_mim_m3_1 l=3 w=3
X6337 N_B9 N_TOP sky130_fd_pr__cap_mim_m3_1 l=3 w=3
X6338 N_B11 N_TOP sky130_fd_pr__cap_mim_m3_1 l=3 w=3
X6339 P_B9 P_TOP sky130_fd_pr__cap_mim_m3_1 l=3 w=3
X6340 P_B10 P_TOP sky130_fd_pr__cap_mim_m3_1 l=3 w=3
X6341 N_B10 N_TOP sky130_fd_pr__cap_mim_m3_1 l=3 w=3
X6342 P_B9 P_TOP sky130_fd_pr__cap_mim_m3_1 l=3 w=3
X6343 N_B11 N_TOP sky130_fd_pr__cap_mim_m3_1 l=3 w=3
X6344 N_B10 N_TOP sky130_fd_pr__cap_mim_m3_1 l=3 w=3
X6345 N_EDGE_BIAS N_EDGE_BIAS sky130_fd_pr__cap_mim_m3_1 l=3 w=3
X6346 P_B10 P_TOP sky130_fd_pr__cap_mim_m3_1 l=3 w=3
X6347 N_B7 N_TOP sky130_fd_pr__cap_mim_m3_1 l=3 w=3
X6348 N_B10 N_TOP sky130_fd_pr__cap_mim_m3_1 l=3 w=3
X6349 P_B10 P_TOP sky130_fd_pr__cap_mim_m3_1 l=3 w=3
X6350 N_B11 N_TOP sky130_fd_pr__cap_mim_m3_1 l=3 w=3
X6351 N_B11 N_TOP sky130_fd_pr__cap_mim_m3_1 l=3 w=3
X6352 P_B9 P_TOP sky130_fd_pr__cap_mim_m3_1 l=3 w=3
X6353 P_B11 P_TOP sky130_fd_pr__cap_mim_m3_1 l=3 w=3
X6354 P_B11 P_TOP sky130_fd_pr__cap_mim_m3_1 l=3 w=3
X6355 P_B11 P_TOP sky130_fd_pr__cap_mim_m3_1 l=3 w=3
X6356 N_B10 N_TOP sky130_fd_pr__cap_mim_m3_1 l=3 w=3
X6357 P_B10 P_TOP sky130_fd_pr__cap_mim_m3_1 l=3 w=3
X6358 N_B10 N_TOP sky130_fd_pr__cap_mim_m3_1 l=3 w=3
X6359 N_B11 N_TOP sky130_fd_pr__cap_mim_m3_1 l=3 w=3
X6360 N_B8 N_TOP sky130_fd_pr__cap_mim_m3_1 l=3 w=3
X6361 P_B11 P_TOP sky130_fd_pr__cap_mim_m3_1 l=3 w=3
X6362 N_B10 N_TOP sky130_fd_pr__cap_mim_m3_1 l=3 w=3
X6363 N_B11 N_TOP sky130_fd_pr__cap_mim_m3_1 l=3 w=3
X6364 N_B10 N_TOP sky130_fd_pr__cap_mim_m3_1 l=3 w=3
X6365 P_B11 P_TOP sky130_fd_pr__cap_mim_m3_1 l=3 w=3
X6366 N_B10 N_TOP sky130_fd_pr__cap_mim_m3_1 l=3 w=3
X6367 P_B11 P_TOP sky130_fd_pr__cap_mim_m3_1 l=3 w=3
X6368 P_B10 P_TOP sky130_fd_pr__cap_mim_m3_1 l=3 w=3
X6369 P_B11 P_TOP sky130_fd_pr__cap_mim_m3_1 l=3 w=3
X6370 N_B11 N_TOP sky130_fd_pr__cap_mim_m3_1 l=3 w=3
X6371 P_B11 P_TOP sky130_fd_pr__cap_mim_m3_1 l=3 w=3
X6372 N_B8 N_TOP sky130_fd_pr__cap_mim_m3_1 l=3 w=3
X6373 P_B11 P_TOP sky130_fd_pr__cap_mim_m3_1 l=3 w=3
X6374 P_EDGE_BIAS P_EDGE_BIAS sky130_fd_pr__cap_mim_m3_1 l=3 w=3
X6375 P_B9 P_TOP sky130_fd_pr__cap_mim_m3_1 l=3 w=3
X6376 N_B10 N_TOP sky130_fd_pr__cap_mim_m3_1 l=3 w=3
X6377 N_B10 N_TOP sky130_fd_pr__cap_mim_m3_1 l=3 w=3
X6378 P_B7 P_TOP sky130_fd_pr__cap_mim_m3_1 l=3 w=3
X6379 P_EDGE_BIAS P_EDGE_BIAS sky130_fd_pr__cap_mim_m3_1 l=3 w=3
X6380 P_B11 P_TOP sky130_fd_pr__cap_mim_m3_1 l=3 w=3
X6381 N_B10 N_TOP sky130_fd_pr__cap_mim_m3_1 l=3 w=3
X6382 P_B11 P_TOP sky130_fd_pr__cap_mim_m3_1 l=3 w=3
X6383 N_B11 N_TOP sky130_fd_pr__cap_mim_m3_1 l=3 w=3
X6384 P_B9 P_TOP sky130_fd_pr__cap_mim_m3_1 l=3 w=3
X6385 N_B9 N_TOP sky130_fd_pr__cap_mim_m3_1 l=3 w=3
X6386 P_B9 P_TOP sky130_fd_pr__cap_mim_m3_1 l=3 w=3
X6387 P_B11 P_TOP sky130_fd_pr__cap_mim_m3_1 l=3 w=3
X6388 P_B11 P_TOP sky130_fd_pr__cap_mim_m3_1 l=3 w=3
X6389 N_B8 N_TOP sky130_fd_pr__cap_mim_m3_1 l=3 w=3
X6390 N_B10 N_TOP sky130_fd_pr__cap_mim_m3_1 l=3 w=3
X6391 P_B9 P_TOP sky130_fd_pr__cap_mim_m3_1 l=3 w=3
X6392 P_B8 P_TOP sky130_fd_pr__cap_mim_m3_1 l=3 w=3
X6393 P_B8 P_TOP sky130_fd_pr__cap_mim_m3_1 l=3 w=3
X6394 P_B10 P_TOP sky130_fd_pr__cap_mim_m3_1 l=3 w=3
X6395 P_B11 P_TOP sky130_fd_pr__cap_mim_m3_1 l=3 w=3
X6396 P_B8 P_TOP sky130_fd_pr__cap_mim_m3_1 l=3 w=3
X6397 N_B10 N_TOP sky130_fd_pr__cap_mim_m3_1 l=3 w=3
X6398 P_B10 P_TOP sky130_fd_pr__cap_mim_m3_1 l=3 w=3
X6399 N_B9 N_TOP sky130_fd_pr__cap_mim_m3_1 l=3 w=3
X6400 P_B9 P_TOP sky130_fd_pr__cap_mim_m3_1 l=3 w=3
X6401 P_B11 P_TOP sky130_fd_pr__cap_mim_m3_1 l=3 w=3
X6402 N_B11 N_TOP sky130_fd_pr__cap_mim_m3_1 l=3 w=3
X6403 N_B7 N_TOP sky130_fd_pr__cap_mim_m3_1 l=3 w=3
X6404 P_B7 P_TOP sky130_fd_pr__cap_mim_m3_1 l=3 w=3
X6405 N_EDGE_BIAS N_EDGE_BIAS sky130_fd_pr__cap_mim_m3_1 l=3 w=3
X6406 P_B10 P_TOP sky130_fd_pr__cap_mim_m3_1 l=3 w=3
X6407 N_B11 N_TOP sky130_fd_pr__cap_mim_m3_1 l=3 w=3
X6408 P_B11 P_TOP sky130_fd_pr__cap_mim_m3_1 l=3 w=3
X6409 N_B8 N_TOP sky130_fd_pr__cap_mim_m3_1 l=3 w=3
X6410 P_B8 P_TOP sky130_fd_pr__cap_mim_m3_1 l=3 w=3
X6411 N_B10 N_TOP sky130_fd_pr__cap_mim_m3_1 l=3 w=3
X6412 P_B10 P_TOP sky130_fd_pr__cap_mim_m3_1 l=3 w=3
X6413 N_B8 N_TOP sky130_fd_pr__cap_mim_m3_1 l=3 w=3
X6414 P_B10 P_TOP sky130_fd_pr__cap_mim_m3_1 l=3 w=3
X6415 P_B11 P_TOP sky130_fd_pr__cap_mim_m3_1 l=3 w=3
X6416 N_B11 N_TOP sky130_fd_pr__cap_mim_m3_1 l=3 w=3
X6417 P_B11 P_TOP sky130_fd_pr__cap_mim_m3_1 l=3 w=3
X6418 N_B11 N_TOP sky130_fd_pr__cap_mim_m3_1 l=3 w=3
X6419 N_B6 N_TOP sky130_fd_pr__cap_mim_m3_1 l=3 w=3
X6420 N_B8 N_TOP sky130_fd_pr__cap_mim_m3_1 l=3 w=3
X6421 P_B11 P_TOP sky130_fd_pr__cap_mim_m3_1 l=3 w=3
X6422 N_B10 N_TOP sky130_fd_pr__cap_mim_m3_1 l=3 w=3
X6423 N_B11 N_TOP sky130_fd_pr__cap_mim_m3_1 l=3 w=3
X6424 N_B9 N_TOP sky130_fd_pr__cap_mim_m3_1 l=3 w=3
X6425 P_B9 P_TOP sky130_fd_pr__cap_mim_m3_1 l=3 w=3
X6426 N_B11 N_TOP sky130_fd_pr__cap_mim_m3_1 l=3 w=3
X6427 N_B9 N_TOP sky130_fd_pr__cap_mim_m3_1 l=3 w=3
X6428 P_B11 P_TOP sky130_fd_pr__cap_mim_m3_1 l=3 w=3
X6429 N_B11 N_TOP sky130_fd_pr__cap_mim_m3_1 l=3 w=3
X6430 N_B10 N_TOP sky130_fd_pr__cap_mim_m3_1 l=3 w=3
X6431 P_B11 P_TOP sky130_fd_pr__cap_mim_m3_1 l=3 w=3
X6432 N_B6 N_TOP sky130_fd_pr__cap_mim_m3_1 l=3 w=3
X6433 P_B11 P_TOP sky130_fd_pr__cap_mim_m3_1 l=3 w=3
X6434 P_B6 P_TOP sky130_fd_pr__cap_mim_m3_1 l=3 w=3
X6435 P_EDGE_BIAS P_EDGE_BIAS sky130_fd_pr__cap_mim_m3_1 l=3 w=3
X6436 P_B10 P_TOP sky130_fd_pr__cap_mim_m3_1 l=3 w=3
X6437 N_B10 N_TOP sky130_fd_pr__cap_mim_m3_1 l=3 w=3
X6438 P_B11 P_TOP sky130_fd_pr__cap_mim_m3_1 l=3 w=3
X6439 P_EDGE_BIAS P_EDGE_BIAS sky130_fd_pr__cap_mim_m3_1 l=3 w=3
X6440 N_B9 N_TOP sky130_fd_pr__cap_mim_m3_1 l=3 w=3
X6441 N_B11 N_TOP sky130_fd_pr__cap_mim_m3_1 l=3 w=3
X6442 N_B10 N_TOP sky130_fd_pr__cap_mim_m3_1 l=3 w=3
X6443 P_B11 P_TOP sky130_fd_pr__cap_mim_m3_1 l=3 w=3
X6444 N_B11 N_TOP sky130_fd_pr__cap_mim_m3_1 l=3 w=3
X6445 P_EDGE_BIAS P_EDGE_BIAS sky130_fd_pr__cap_mim_m3_1 l=3 w=3
X6446 P_B9 P_TOP sky130_fd_pr__cap_mim_m3_1 l=3 w=3
X6447 P_B11 P_TOP sky130_fd_pr__cap_mim_m3_1 l=3 w=3
X6448 P_B11 P_TOP sky130_fd_pr__cap_mim_m3_1 l=3 w=3
X6449 N_B11 N_TOP sky130_fd_pr__cap_mim_m3_1 l=3 w=3
X6450 N_B9 N_TOP sky130_fd_pr__cap_mim_m3_1 l=3 w=3
X6451 P_B10 P_TOP sky130_fd_pr__cap_mim_m3_1 l=3 w=3
X6452 P_B10 P_TOP sky130_fd_pr__cap_mim_m3_1 l=3 w=3
X6453 P_B10 P_TOP sky130_fd_pr__cap_mim_m3_1 l=3 w=3
X6454 N_B11 N_TOP sky130_fd_pr__cap_mim_m3_1 l=3 w=3
X6455 N_EDGE_BIAS N_EDGE_BIAS sky130_fd_pr__cap_mim_m3_1 l=3 w=3
X6456 P_B10 P_TOP sky130_fd_pr__cap_mim_m3_1 l=3 w=3
X6457 P_B6 P_TOP sky130_fd_pr__cap_mim_m3_1 l=3 w=3
X6458 P_B11 P_TOP sky130_fd_pr__cap_mim_m3_1 l=3 w=3
X6459 N_B11 N_TOP sky130_fd_pr__cap_mim_m3_1 l=3 w=3
X6460 P_B10 P_TOP sky130_fd_pr__cap_mim_m3_1 l=3 w=3
X6461 N_B11 N_TOP sky130_fd_pr__cap_mim_m3_1 l=3 w=3
X6462 N_B9 N_TOP sky130_fd_pr__cap_mim_m3_1 l=3 w=3
X6463 N_B11 N_TOP sky130_fd_pr__cap_mim_m3_1 l=3 w=3
X6464 P_B11 P_TOP sky130_fd_pr__cap_mim_m3_1 l=3 w=3
X6465 P_B9 P_TOP sky130_fd_pr__cap_mim_m3_1 l=3 w=3
X6466 P_B10 P_TOP sky130_fd_pr__cap_mim_m3_1 l=3 w=3
X6467 N_B10 N_TOP sky130_fd_pr__cap_mim_m3_1 l=3 w=3
X6468 N_B11 N_TOP sky130_fd_pr__cap_mim_m3_1 l=3 w=3
X6469 N_B7 N_TOP sky130_fd_pr__cap_mim_m3_1 l=3 w=3
X6470 P_B7 P_TOP sky130_fd_pr__cap_mim_m3_1 l=3 w=3
X6471 N_B10 N_TOP sky130_fd_pr__cap_mim_m3_1 l=3 w=3
X6472 N_B10 N_TOP sky130_fd_pr__cap_mim_m3_1 l=3 w=3
X6473 P_B10 P_TOP sky130_fd_pr__cap_mim_m3_1 l=3 w=3
X6474 N_B9 N_TOP sky130_fd_pr__cap_mim_m3_1 l=3 w=3
X6475 N_B11 N_TOP sky130_fd_pr__cap_mim_m3_1 l=3 w=3
X6476 P_B11 P_TOP sky130_fd_pr__cap_mim_m3_1 l=3 w=3
X6477 P_B10 P_TOP sky130_fd_pr__cap_mim_m3_1 l=3 w=3
X6478 P_B9 P_TOP sky130_fd_pr__cap_mim_m3_1 l=3 w=3
X6479 P_B11 P_TOP sky130_fd_pr__cap_mim_m3_1 l=3 w=3
X6480 N_B11 N_TOP sky130_fd_pr__cap_mim_m3_1 l=3 w=3
X6481 P_B10 P_TOP sky130_fd_pr__cap_mim_m3_1 l=3 w=3
X6482 N_B8 N_TOP sky130_fd_pr__cap_mim_m3_1 l=3 w=3
X6483 N_B10 N_TOP sky130_fd_pr__cap_mim_m3_1 l=3 w=3
X6484 P_B9 P_TOP sky130_fd_pr__cap_mim_m3_1 l=3 w=3
X6485 N_B10 N_TOP sky130_fd_pr__cap_mim_m3_1 l=3 w=3
X6486 P_B10 P_TOP sky130_fd_pr__cap_mim_m3_1 l=3 w=3
X6487 N_B11 N_TOP sky130_fd_pr__cap_mim_m3_1 l=3 w=3
X6488 P_B11 P_TOP sky130_fd_pr__cap_mim_m3_1 l=3 w=3
X6489 P_B11 P_TOP sky130_fd_pr__cap_mim_m3_1 l=3 w=3
X6490 N_B10 N_TOP sky130_fd_pr__cap_mim_m3_1 l=3 w=3
X6491 P_B10 P_TOP sky130_fd_pr__cap_mim_m3_1 l=3 w=3
X6492 P_B11 P_TOP sky130_fd_pr__cap_mim_m3_1 l=3 w=3
X6493 N_B11 N_TOP sky130_fd_pr__cap_mim_m3_1 l=3 w=3
X6494 P_B11 P_TOP sky130_fd_pr__cap_mim_m3_1 l=3 w=3
X6495 P_B9 P_TOP sky130_fd_pr__cap_mim_m3_1 l=3 w=3
X6496 P_B11 P_TOP sky130_fd_pr__cap_mim_m3_1 l=3 w=3
X6497 P_EDGE_BIAS P_EDGE_BIAS sky130_fd_pr__cap_mim_m3_1 l=3 w=3
X6498 P_B11 P_TOP sky130_fd_pr__cap_mim_m3_1 l=3 w=3
X6499 N_B10 N_TOP sky130_fd_pr__cap_mim_m3_1 l=3 w=3
X6500 N_B11 N_TOP sky130_fd_pr__cap_mim_m3_1 l=3 w=3
X6501 N_B11 N_TOP sky130_fd_pr__cap_mim_m3_1 l=3 w=3
X6502 N_B10 N_TOP sky130_fd_pr__cap_mim_m3_1 l=3 w=3
X6503 P_EDGE_BIAS P_EDGE_BIAS sky130_fd_pr__cap_mim_m3_1 l=3 w=3
X6504 P_B11 P_TOP sky130_fd_pr__cap_mim_m3_1 l=3 w=3
X6505 P_B9 P_TOP sky130_fd_pr__cap_mim_m3_1 l=3 w=3
X6506 P_B11 P_TOP sky130_fd_pr__cap_mim_m3_1 l=3 w=3
X6507 N_B9 N_TOP sky130_fd_pr__cap_mim_m3_1 l=3 w=3
X6508 P_B9 P_TOP sky130_fd_pr__cap_mim_m3_1 l=3 w=3
X6509 P_B11 P_TOP sky130_fd_pr__cap_mim_m3_1 l=3 w=3
X6510 P_B8 P_TOP sky130_fd_pr__cap_mim_m3_1 l=3 w=3
X6511 P_B9 P_TOP sky130_fd_pr__cap_mim_m3_1 l=3 w=3
X6512 N_B11 N_TOP sky130_fd_pr__cap_mim_m3_1 l=3 w=3
X6513 N_B11 N_TOP sky130_fd_pr__cap_mim_m3_1 l=3 w=3
X6514 N_B3 N_TOP sky130_fd_pr__cap_mim_m3_1 l=3 w=3
X6515 P_B11 P_TOP sky130_fd_pr__cap_mim_m3_1 l=3 w=3
X6516 N_B11 N_TOP sky130_fd_pr__cap_mim_m3_1 l=3 w=3
X6517 P_B8 P_TOP sky130_fd_pr__cap_mim_m3_1 l=3 w=3
X6518 P_B10 P_TOP sky130_fd_pr__cap_mim_m3_1 l=3 w=3
X6519 N_B10 N_TOP sky130_fd_pr__cap_mim_m3_1 l=3 w=3
X6520 N_B11 N_TOP sky130_fd_pr__cap_mim_m3_1 l=3 w=3
X6521 P_B11 P_TOP sky130_fd_pr__cap_mim_m3_1 l=3 w=3
X6522 N_B9 N_TOP sky130_fd_pr__cap_mim_m3_1 l=3 w=3
X6523 P_B11 P_TOP sky130_fd_pr__cap_mim_m3_1 l=3 w=3
X6524 P_B9 P_TOP sky130_fd_pr__cap_mim_m3_1 l=3 w=3
X6525 N_B11 N_TOP sky130_fd_pr__cap_mim_m3_1 l=3 w=3
X6526 N_B7 N_TOP sky130_fd_pr__cap_mim_m3_1 l=3 w=3
X6527 N_B10 N_TOP sky130_fd_pr__cap_mim_m3_1 l=3 w=3
X6528 N_B11 N_TOP sky130_fd_pr__cap_mim_m3_1 l=3 w=3
X6529 P_B8 P_TOP sky130_fd_pr__cap_mim_m3_1 l=3 w=3
X6530 N_B10 N_TOP sky130_fd_pr__cap_mim_m3_1 l=3 w=3
X6531 P_B10 P_TOP sky130_fd_pr__cap_mim_m3_1 l=3 w=3
X6532 N_B11 N_TOP sky130_fd_pr__cap_mim_m3_1 l=3 w=3
X6533 N_B11 N_TOP sky130_fd_pr__cap_mim_m3_1 l=3 w=3
X6534 P_B11 P_TOP sky130_fd_pr__cap_mim_m3_1 l=3 w=3
X6535 P_B11 P_TOP sky130_fd_pr__cap_mim_m3_1 l=3 w=3
X6536 N_B10 N_TOP sky130_fd_pr__cap_mim_m3_1 l=3 w=3
X6537 P_B11 P_TOP sky130_fd_pr__cap_mim_m3_1 l=3 w=3
X6538 P_B10 P_TOP sky130_fd_pr__cap_mim_m3_1 l=3 w=3
X6539 P_B11 P_TOP sky130_fd_pr__cap_mim_m3_1 l=3 w=3
X6540 N_B8 N_TOP sky130_fd_pr__cap_mim_m3_1 l=3 w=3
X6541 P_B10 P_TOP sky130_fd_pr__cap_mim_m3_1 l=3 w=3
X6542 P_B11 P_TOP sky130_fd_pr__cap_mim_m3_1 l=3 w=3
X6543 N_B10 N_TOP sky130_fd_pr__cap_mim_m3_1 l=3 w=3
X6544 N_B6 N_TOP sky130_fd_pr__cap_mim_m3_1 l=3 w=3
X6545 N_B8 N_TOP sky130_fd_pr__cap_mim_m3_1 l=3 w=3
X6546 N_B11 N_TOP sky130_fd_pr__cap_mim_m3_1 l=3 w=3
X6547 N_B11 N_TOP sky130_fd_pr__cap_mim_m3_1 l=3 w=3
X6548 P_B11 P_TOP sky130_fd_pr__cap_mim_m3_1 l=3 w=3
X6549 N_B9 N_TOP sky130_fd_pr__cap_mim_m3_1 l=3 w=3
X6550 N_B9 N_TOP sky130_fd_pr__cap_mim_m3_1 l=3 w=3
X6551 N_B10 N_TOP sky130_fd_pr__cap_mim_m3_1 l=3 w=3
X6552 P_B10 P_TOP sky130_fd_pr__cap_mim_m3_1 l=3 w=3
X6553 N_B11 N_TOP sky130_fd_pr__cap_mim_m3_1 l=3 w=3
X6554 N_B9 N_TOP sky130_fd_pr__cap_mim_m3_1 l=3 w=3
X6555 P_B11 P_TOP sky130_fd_pr__cap_mim_m3_1 l=3 w=3
X6556 P_EDGE_BIAS P_EDGE_BIAS sky130_fd_pr__cap_mim_m3_1 l=3 w=3
X6557 N_B11 N_TOP sky130_fd_pr__cap_mim_m3_1 l=3 w=3
X6558 P_B11 P_TOP sky130_fd_pr__cap_mim_m3_1 l=3 w=3
X6559 N_B6 N_TOP sky130_fd_pr__cap_mim_m3_1 l=3 w=3
X6560 P_B11 P_TOP sky130_fd_pr__cap_mim_m3_1 l=3 w=3
X6561 P_DUMMY P_TOP sky130_fd_pr__cap_mim_m3_1 l=3 w=3
X6562 P_B10 P_TOP sky130_fd_pr__cap_mim_m3_1 l=3 w=3
X6563 N_B11 N_TOP sky130_fd_pr__cap_mim_m3_1 l=3 w=3
X6564 N_B11 N_TOP sky130_fd_pr__cap_mim_m3_1 l=3 w=3
X6565 N_B9 N_TOP sky130_fd_pr__cap_mim_m3_1 l=3 w=3
X6566 N_B11 N_TOP sky130_fd_pr__cap_mim_m3_1 l=3 w=3
X6567 P_B11 P_TOP sky130_fd_pr__cap_mim_m3_1 l=3 w=3
X6568 N_B10 N_TOP sky130_fd_pr__cap_mim_m3_1 l=3 w=3
X6569 P_B11 P_TOP sky130_fd_pr__cap_mim_m3_1 l=3 w=3
X6570 N_B11 N_TOP sky130_fd_pr__cap_mim_m3_1 l=3 w=3
X6571 N_B11 N_TOP sky130_fd_pr__cap_mim_m3_1 l=3 w=3
X6572 N_B11 N_TOP sky130_fd_pr__cap_mim_m3_1 l=3 w=3
X6573 P_B9 P_TOP sky130_fd_pr__cap_mim_m3_1 l=3 w=3
X6574 P_B11 P_TOP sky130_fd_pr__cap_mim_m3_1 l=3 w=3
X6575 P_B10 P_TOP sky130_fd_pr__cap_mim_m3_1 l=3 w=3
X6576 P_B11 P_TOP sky130_fd_pr__cap_mim_m3_1 l=3 w=3
X6577 N_B11 N_TOP sky130_fd_pr__cap_mim_m3_1 l=3 w=3
X6578 P_B10 P_TOP sky130_fd_pr__cap_mim_m3_1 l=3 w=3
X6579 P_B10 P_TOP sky130_fd_pr__cap_mim_m3_1 l=3 w=3
X6580 P_B11 P_TOP sky130_fd_pr__cap_mim_m3_1 l=3 w=3
X6581 N_B10 N_TOP sky130_fd_pr__cap_mim_m3_1 l=3 w=3
X6582 P_B8 P_TOP sky130_fd_pr__cap_mim_m3_1 l=3 w=3
X6583 P_B11 P_TOP sky130_fd_pr__cap_mim_m3_1 l=3 w=3
X6584 P_B10 P_TOP sky130_fd_pr__cap_mim_m3_1 l=3 w=3
X6585 P_B6 P_TOP sky130_fd_pr__cap_mim_m3_1 l=3 w=3
X6586 N_B11 N_TOP sky130_fd_pr__cap_mim_m3_1 l=3 w=3
X6587 P_B11 P_TOP sky130_fd_pr__cap_mim_m3_1 l=3 w=3
X6588 N_B9 N_TOP sky130_fd_pr__cap_mim_m3_1 l=3 w=3
X6589 P_B9 P_TOP sky130_fd_pr__cap_mim_m3_1 l=3 w=3
X6590 N_B10 N_TOP sky130_fd_pr__cap_mim_m3_1 l=3 w=3
X6591 P_B10 P_TOP sky130_fd_pr__cap_mim_m3_1 l=3 w=3
X6592 P_B10 P_TOP sky130_fd_pr__cap_mim_m3_1 l=3 w=3
X6593 N_B7 N_TOP sky130_fd_pr__cap_mim_m3_1 l=3 w=3
X6594 P_B11 P_TOP sky130_fd_pr__cap_mim_m3_1 l=3 w=3
X6595 N_B11 N_TOP sky130_fd_pr__cap_mim_m3_1 l=3 w=3
X6596 P_B10 P_TOP sky130_fd_pr__cap_mim_m3_1 l=3 w=3
X6597 P_EDGE_BIAS P_EDGE_BIAS sky130_fd_pr__cap_mim_m3_1 l=3 w=3
X6598 N_B11 N_TOP sky130_fd_pr__cap_mim_m3_1 l=3 w=3
X6599 N_B11 N_TOP sky130_fd_pr__cap_mim_m3_1 l=3 w=3
X6600 N_B9 N_TOP sky130_fd_pr__cap_mim_m3_1 l=3 w=3
X6601 N_B9 N_TOP sky130_fd_pr__cap_mim_m3_1 l=3 w=3
X6602 P_B11 P_TOP sky130_fd_pr__cap_mim_m3_1 l=3 w=3
X6603 P_B10 P_TOP sky130_fd_pr__cap_mim_m3_1 l=3 w=3
X6604 N_B8 N_TOP sky130_fd_pr__cap_mim_m3_1 l=3 w=3
X6605 N_B10 N_TOP sky130_fd_pr__cap_mim_m3_1 l=3 w=3
X6606 P_B11 P_TOP sky130_fd_pr__cap_mim_m3_1 l=3 w=3
X6607 N_B11 N_TOP sky130_fd_pr__cap_mim_m3_1 l=3 w=3
X6608 N_B10 N_TOP sky130_fd_pr__cap_mim_m3_1 l=3 w=3
X6609 N_B9 N_TOP sky130_fd_pr__cap_mim_m3_1 l=3 w=3
X6610 N_B11 N_TOP sky130_fd_pr__cap_mim_m3_1 l=3 w=3
X6611 P_B11 P_TOP sky130_fd_pr__cap_mim_m3_1 l=3 w=3
X6612 P_EDGE_BIAS P_EDGE_BIAS sky130_fd_pr__cap_mim_m3_1 l=3 w=3
X6613 P_B11 P_TOP sky130_fd_pr__cap_mim_m3_1 l=3 w=3
X6614 N_B11 N_TOP sky130_fd_pr__cap_mim_m3_1 l=3 w=3
X6615 N_B10 N_TOP sky130_fd_pr__cap_mim_m3_1 l=3 w=3
X6616 P_B11 P_TOP sky130_fd_pr__cap_mim_m3_1 l=3 w=3
X6617 N_B10 N_TOP sky130_fd_pr__cap_mim_m3_1 l=3 w=3
X6618 P_B9 P_TOP sky130_fd_pr__cap_mim_m3_1 l=3 w=3
X6619 P_EDGE_BIAS P_EDGE_BIAS sky130_fd_pr__cap_mim_m3_1 l=3 w=3
X6620 P_B11 P_TOP sky130_fd_pr__cap_mim_m3_1 l=3 w=3
X6621 N_B10 N_TOP sky130_fd_pr__cap_mim_m3_1 l=3 w=3
X6622 P_B11 P_TOP sky130_fd_pr__cap_mim_m3_1 l=3 w=3
X6623 N_B10 N_TOP sky130_fd_pr__cap_mim_m3_1 l=3 w=3
X6624 N_B11 N_TOP sky130_fd_pr__cap_mim_m3_1 l=3 w=3
X6625 N_B11 N_TOP sky130_fd_pr__cap_mim_m3_1 l=3 w=3
X6626 P_B10 P_TOP sky130_fd_pr__cap_mim_m3_1 l=3 w=3
X6627 N_B10 N_TOP sky130_fd_pr__cap_mim_m3_1 l=3 w=3
X6628 P_B11 P_TOP sky130_fd_pr__cap_mim_m3_1 l=3 w=3
X6629 N_B11 N_TOP sky130_fd_pr__cap_mim_m3_1 l=3 w=3
X6630 N_B11 N_TOP sky130_fd_pr__cap_mim_m3_1 l=3 w=3
X6631 P_B9 P_TOP sky130_fd_pr__cap_mim_m3_1 l=3 w=3
X6632 P_B9 P_TOP sky130_fd_pr__cap_mim_m3_1 l=3 w=3
X6633 P_B11 P_TOP sky130_fd_pr__cap_mim_m3_1 l=3 w=3
X6634 N_EDGE_BIAS N_EDGE_BIAS sky130_fd_pr__cap_mim_m3_1 l=3 w=3
X6635 P_B9 P_TOP sky130_fd_pr__cap_mim_m3_1 l=3 w=3
X6636 N_EDGE_BIAS N_EDGE_BIAS sky130_fd_pr__cap_mim_m3_1 l=3 w=3
X6637 P_B8 P_TOP sky130_fd_pr__cap_mim_m3_1 l=3 w=3
X6638 P_B9 P_TOP sky130_fd_pr__cap_mim_m3_1 l=3 w=3
X6639 N_B11 N_TOP sky130_fd_pr__cap_mim_m3_1 l=3 w=3
X6640 N_B11 N_TOP sky130_fd_pr__cap_mim_m3_1 l=3 w=3
X6641 N_B11 N_TOP sky130_fd_pr__cap_mim_m3_1 l=3 w=3
X6642 N_B5 N_TOP sky130_fd_pr__cap_mim_m3_1 l=3 w=3
X6643 P_B10 P_TOP sky130_fd_pr__cap_mim_m3_1 l=3 w=3
X6644 P_B10 P_TOP sky130_fd_pr__cap_mim_m3_1 l=3 w=3
X6645 P_B8 P_TOP sky130_fd_pr__cap_mim_m3_1 l=3 w=3
X6646 P_B10 P_TOP sky130_fd_pr__cap_mim_m3_1 l=3 w=3
X6647 N_B10 N_TOP sky130_fd_pr__cap_mim_m3_1 l=3 w=3
X6648 P_B11 P_TOP sky130_fd_pr__cap_mim_m3_1 l=3 w=3
X6649 N_B9 N_TOP sky130_fd_pr__cap_mim_m3_1 l=3 w=3
X6650 N_B11 N_TOP sky130_fd_pr__cap_mim_m3_1 l=3 w=3
X6651 P_B7 P_TOP sky130_fd_pr__cap_mim_m3_1 l=3 w=3
X6652 P_B9 P_TOP sky130_fd_pr__cap_mim_m3_1 l=3 w=3
X6653 N_B11 N_TOP sky130_fd_pr__cap_mim_m3_1 l=3 w=3
X6654 P_B11 P_TOP sky130_fd_pr__cap_mim_m3_1 l=3 w=3
X6655 N_B11 N_TOP sky130_fd_pr__cap_mim_m3_1 l=3 w=3
X6656 P_B10 P_TOP sky130_fd_pr__cap_mim_m3_1 l=3 w=3
X6657 P_B11 P_TOP sky130_fd_pr__cap_mim_m3_1 l=3 w=3
X6658 N_B8 N_TOP sky130_fd_pr__cap_mim_m3_1 l=3 w=3
X6659 P_B8 P_TOP sky130_fd_pr__cap_mim_m3_1 l=3 w=3
X6660 P_B10 P_TOP sky130_fd_pr__cap_mim_m3_1 l=3 w=3
X6661 N_B10 N_TOP sky130_fd_pr__cap_mim_m3_1 l=3 w=3
X6662 P_B11 P_TOP sky130_fd_pr__cap_mim_m3_1 l=3 w=3
X6663 N_B10 N_TOP sky130_fd_pr__cap_mim_m3_1 l=3 w=3
X6664 N_EDGE_BIAS N_EDGE_BIAS sky130_fd_pr__cap_mim_m3_1 l=3 w=3
X6665 P_B11 P_TOP sky130_fd_pr__cap_mim_m3_1 l=3 w=3
X6666 P_B11 P_TOP sky130_fd_pr__cap_mim_m3_1 l=3 w=3
X6667 N_B11 N_TOP sky130_fd_pr__cap_mim_m3_1 l=3 w=3
X6668 N_B8 N_TOP sky130_fd_pr__cap_mim_m3_1 l=3 w=3
X6669 P_B8 P_TOP sky130_fd_pr__cap_mim_m3_1 l=3 w=3
X6670 N_B10 N_TOP sky130_fd_pr__cap_mim_m3_1 l=3 w=3
X6671 N_B5 N_TOP sky130_fd_pr__cap_mim_m3_1 l=3 w=3
X6672 N_B11 N_TOP sky130_fd_pr__cap_mim_m3_1 l=3 w=3
X6673 N_B9 N_TOP sky130_fd_pr__cap_mim_m3_1 l=3 w=3
X6674 P_B9 P_TOP sky130_fd_pr__cap_mim_m3_1 l=3 w=3
X6675 P_B11 P_TOP sky130_fd_pr__cap_mim_m3_1 l=3 w=3
X6676 N_B11 N_TOP sky130_fd_pr__cap_mim_m3_1 l=3 w=3
X6677 N_B9 N_TOP sky130_fd_pr__cap_mim_m3_1 l=3 w=3
X6678 P_B11 P_TOP sky130_fd_pr__cap_mim_m3_1 l=3 w=3
X6679 P_B9 P_TOP sky130_fd_pr__cap_mim_m3_1 l=3 w=3
X6680 P_B6 P_TOP sky130_fd_pr__cap_mim_m3_1 l=3 w=3
X6681 P_EDGE_BIAS P_EDGE_BIAS sky130_fd_pr__cap_mim_m3_1 l=3 w=3
X6682 P_B11 P_TOP sky130_fd_pr__cap_mim_m3_1 l=3 w=3
X6683 N_B11 N_TOP sky130_fd_pr__cap_mim_m3_1 l=3 w=3
X6684 P_B8 P_TOP sky130_fd_pr__cap_mim_m3_1 l=3 w=3
X6685 N_B9 N_TOP sky130_fd_pr__cap_mim_m3_1 l=3 w=3
X6686 P_EDGE_BIAS P_EDGE_BIAS sky130_fd_pr__cap_mim_m3_1 l=3 w=3
X6687 P_B11 P_TOP sky130_fd_pr__cap_mim_m3_1 l=3 w=3
X6688 N_B11 N_TOP sky130_fd_pr__cap_mim_m3_1 l=3 w=3
X6689 N_B10 N_TOP sky130_fd_pr__cap_mim_m3_1 l=3 w=3
X6690 N_B9 N_TOP sky130_fd_pr__cap_mim_m3_1 l=3 w=3
X6691 N_B11 N_TOP sky130_fd_pr__cap_mim_m3_1 l=3 w=3
X6692 P_B11 P_TOP sky130_fd_pr__cap_mim_m3_1 l=3 w=3
X6693 P_B11 P_TOP sky130_fd_pr__cap_mim_m3_1 l=3 w=3
X6694 N_B10 N_TOP sky130_fd_pr__cap_mim_m3_1 l=3 w=3
X6695 P_B7 P_TOP sky130_fd_pr__cap_mim_m3_1 l=3 w=3
X6696 P_B11 P_TOP sky130_fd_pr__cap_mim_m3_1 l=3 w=3
X6697 P_B11 P_TOP sky130_fd_pr__cap_mim_m3_1 l=3 w=3
X6698 N_B11 N_TOP sky130_fd_pr__cap_mim_m3_1 l=3 w=3
X6699 N_B9 N_TOP sky130_fd_pr__cap_mim_m3_1 l=3 w=3
X6700 P_B9 P_TOP sky130_fd_pr__cap_mim_m3_1 l=3 w=3
X6701 P_EDGE_BIAS P_EDGE_BIAS sky130_fd_pr__cap_mim_m3_1 l=3 w=3
X6702 P_B10 P_TOP sky130_fd_pr__cap_mim_m3_1 l=3 w=3
X6703 N_B11 N_TOP sky130_fd_pr__cap_mim_m3_1 l=3 w=3
X6704 N_B11 N_TOP sky130_fd_pr__cap_mim_m3_1 l=3 w=3
X6705 N_B11 N_TOP sky130_fd_pr__cap_mim_m3_1 l=3 w=3
X6706 P_B10 P_TOP sky130_fd_pr__cap_mim_m3_1 l=3 w=3
X6707 N_B10 N_TOP sky130_fd_pr__cap_mim_m3_1 l=3 w=3
X6708 P_B6 P_TOP sky130_fd_pr__cap_mim_m3_1 l=3 w=3
X6709 P_B11 P_TOP sky130_fd_pr__cap_mim_m3_1 l=3 w=3
X6710 N_B11 N_TOP sky130_fd_pr__cap_mim_m3_1 l=3 w=3
X6711 N_B11 N_TOP sky130_fd_pr__cap_mim_m3_1 l=3 w=3
X6712 P_B11 P_TOP sky130_fd_pr__cap_mim_m3_1 l=3 w=3
X6713 P_B10 P_TOP sky130_fd_pr__cap_mim_m3_1 l=3 w=3
X6714 N_B9 N_TOP sky130_fd_pr__cap_mim_m3_1 l=3 w=3
X6715 N_B11 N_TOP sky130_fd_pr__cap_mim_m3_1 l=3 w=3
X6716 P_B9 P_TOP sky130_fd_pr__cap_mim_m3_1 l=3 w=3
X6717 P_B10 P_TOP sky130_fd_pr__cap_mim_m3_1 l=3 w=3
X6718 P_B7 P_TOP sky130_fd_pr__cap_mim_m3_1 l=3 w=3
X6719 N_B10 N_TOP sky130_fd_pr__cap_mim_m3_1 l=3 w=3
X6720 P_B10 P_TOP sky130_fd_pr__cap_mim_m3_1 l=3 w=3
X6721 N_B11 N_TOP sky130_fd_pr__cap_mim_m3_1 l=3 w=3
X6722 N_B7 N_TOP sky130_fd_pr__cap_mim_m3_1 l=3 w=3
X6723 N_B10 N_TOP sky130_fd_pr__cap_mim_m3_1 l=3 w=3
X6724 P_B10 P_TOP sky130_fd_pr__cap_mim_m3_1 l=3 w=3
X6725 N_B9 N_TOP sky130_fd_pr__cap_mim_m3_1 l=3 w=3
X6726 N_B11 N_TOP sky130_fd_pr__cap_mim_m3_1 l=3 w=3
X6727 N_B11 N_TOP sky130_fd_pr__cap_mim_m3_1 l=3 w=3
X6728 N_B9 N_TOP sky130_fd_pr__cap_mim_m3_1 l=3 w=3
X6729 P_B11 P_TOP sky130_fd_pr__cap_mim_m3_1 l=3 w=3
X6730 N_B8 N_TOP sky130_fd_pr__cap_mim_m3_1 l=3 w=3
X6731 P_B11 P_TOP sky130_fd_pr__cap_mim_m3_1 l=3 w=3
X6732 P_B10 P_TOP sky130_fd_pr__cap_mim_m3_1 l=3 w=3
X6733 N_B10 N_TOP sky130_fd_pr__cap_mim_m3_1 l=3 w=3
X6734 P_B11 P_TOP sky130_fd_pr__cap_mim_m3_1 l=3 w=3
X6735 N_B8 N_TOP sky130_fd_pr__cap_mim_m3_1 l=3 w=3
X6736 N_B10 N_TOP sky130_fd_pr__cap_mim_m3_1 l=3 w=3
X6737 N_B10 N_TOP sky130_fd_pr__cap_mim_m3_1 l=3 w=3
X6738 P_B10 P_TOP sky130_fd_pr__cap_mim_m3_1 l=3 w=3
X6739 P_B11 P_TOP sky130_fd_pr__cap_mim_m3_1 l=3 w=3
X6740 N_B11 N_TOP sky130_fd_pr__cap_mim_m3_1 l=3 w=3
X6741 P_B11 P_TOP sky130_fd_pr__cap_mim_m3_1 l=3 w=3
X6742 P_B11 P_TOP sky130_fd_pr__cap_mim_m3_1 l=3 w=3
X6743 P_B10 P_TOP sky130_fd_pr__cap_mim_m3_1 l=3 w=3
X6744 P_B11 P_TOP sky130_fd_pr__cap_mim_m3_1 l=3 w=3
X6745 N_B11 N_TOP sky130_fd_pr__cap_mim_m3_1 l=3 w=3
X6746 N_B8 N_TOP sky130_fd_pr__cap_mim_m3_1 l=3 w=3
X6747 N_B10 N_TOP sky130_fd_pr__cap_mim_m3_1 l=3 w=3
X6748 N_B10 N_TOP sky130_fd_pr__cap_mim_m3_1 l=3 w=3
X6749 P_EDGE_BIAS P_EDGE_BIAS sky130_fd_pr__cap_mim_m3_1 l=3 w=3
X6750 P_B10 P_TOP sky130_fd_pr__cap_mim_m3_1 l=3 w=3
X6751 P_B11 P_TOP sky130_fd_pr__cap_mim_m3_1 l=3 w=3
X6752 N_B11 N_TOP sky130_fd_pr__cap_mim_m3_1 l=3 w=3
X6753 N_B10 N_TOP sky130_fd_pr__cap_mim_m3_1 l=3 w=3
X6754 N_B10 N_TOP sky130_fd_pr__cap_mim_m3_1 l=3 w=3
X6755 N_B11 N_TOP sky130_fd_pr__cap_mim_m3_1 l=3 w=3
X6756 N_B11 N_TOP sky130_fd_pr__cap_mim_m3_1 l=3 w=3
X6757 P_B7 P_TOP sky130_fd_pr__cap_mim_m3_1 l=3 w=3
X6758 P_B11 P_TOP sky130_fd_pr__cap_mim_m3_1 l=3 w=3
X6759 P_B11 P_TOP sky130_fd_pr__cap_mim_m3_1 l=3 w=3
X6760 N_B10 N_TOP sky130_fd_pr__cap_mim_m3_1 l=3 w=3
X6761 P_B9 P_TOP sky130_fd_pr__cap_mim_m3_1 l=3 w=3
X6762 P_B9 P_TOP sky130_fd_pr__cap_mim_m3_1 l=3 w=3
X6763 P_B11 P_TOP sky130_fd_pr__cap_mim_m3_1 l=3 w=3
X6764 P_B11 P_TOP sky130_fd_pr__cap_mim_m3_1 l=3 w=3
X6765 P_B11 P_TOP sky130_fd_pr__cap_mim_m3_1 l=3 w=3
X6766 N_B10 N_TOP sky130_fd_pr__cap_mim_m3_1 l=3 w=3
X6767 P_B9 P_TOP sky130_fd_pr__cap_mim_m3_1 l=3 w=3
X6768 P_B8 P_TOP sky130_fd_pr__cap_mim_m3_1 l=3 w=3
X6769 N_B11 N_TOP sky130_fd_pr__cap_mim_m3_1 l=3 w=3
X6770 N_B11 N_TOP sky130_fd_pr__cap_mim_m3_1 l=3 w=3
X6771 P_B8 P_TOP sky130_fd_pr__cap_mim_m3_1 l=3 w=3
X6772 P_B10 P_TOP sky130_fd_pr__cap_mim_m3_1 l=3 w=3
X6773 N_DUMMY N_TOP sky130_fd_pr__cap_mim_m3_1 l=3 w=3
X6774 N_B10 N_TOP sky130_fd_pr__cap_mim_m3_1 l=3 w=3
X6775 P_B11 P_TOP sky130_fd_pr__cap_mim_m3_1 l=3 w=3
X6776 P_B9 P_TOP sky130_fd_pr__cap_mim_m3_1 l=3 w=3
X6777 N_B11 N_TOP sky130_fd_pr__cap_mim_m3_1 l=3 w=3
X6778 N_B7 N_TOP sky130_fd_pr__cap_mim_m3_1 l=3 w=3
X6779 P_B7 P_TOP sky130_fd_pr__cap_mim_m3_1 l=3 w=3
X6780 N_B11 N_TOP sky130_fd_pr__cap_mim_m3_1 l=3 w=3
X6781 P_B11 P_TOP sky130_fd_pr__cap_mim_m3_1 l=3 w=3
X6782 P_B8 P_TOP sky130_fd_pr__cap_mim_m3_1 l=3 w=3
X6783 N_B11 N_TOP sky130_fd_pr__cap_mim_m3_1 l=3 w=3
X6784 P_B10 P_TOP sky130_fd_pr__cap_mim_m3_1 l=3 w=3
X6785 N_B11 N_TOP sky130_fd_pr__cap_mim_m3_1 l=3 w=3
X6786 P_B11 P_TOP sky130_fd_pr__cap_mim_m3_1 l=3 w=3
X6787 P_EDGE_BIAS P_EDGE_BIAS sky130_fd_pr__cap_mim_m3_1 l=3 w=3
X6788 P_B8 P_TOP sky130_fd_pr__cap_mim_m3_1 l=3 w=3
X6789 N_B10 N_TOP sky130_fd_pr__cap_mim_m3_1 l=3 w=3
X6790 N_B11 N_TOP sky130_fd_pr__cap_mim_m3_1 l=3 w=3
X6791 P_B10 P_TOP sky130_fd_pr__cap_mim_m3_1 l=3 w=3
X6792 N_B11 N_TOP sky130_fd_pr__cap_mim_m3_1 l=3 w=3
X6793 P_B11 P_TOP sky130_fd_pr__cap_mim_m3_1 l=3 w=3
X6794 N_B11 N_TOP sky130_fd_pr__cap_mim_m3_1 l=3 w=3
X6795 N_B6 N_TOP sky130_fd_pr__cap_mim_m3_1 l=3 w=3
X6796 N_B8 N_TOP sky130_fd_pr__cap_mim_m3_1 l=3 w=3
X6797 P_B11 P_TOP sky130_fd_pr__cap_mim_m3_1 l=3 w=3
X6798 N_B10 N_TOP sky130_fd_pr__cap_mim_m3_1 l=3 w=3
X6799 N_B4 N_TOP sky130_fd_pr__cap_mim_m3_1 l=3 w=3
X6800 N_B11 N_TOP sky130_fd_pr__cap_mim_m3_1 l=3 w=3
X6801 P_B11 P_TOP sky130_fd_pr__cap_mim_m3_1 l=3 w=3
X6802 N_B9 N_TOP sky130_fd_pr__cap_mim_m3_1 l=3 w=3
X6803 P_B9 P_TOP sky130_fd_pr__cap_mim_m3_1 l=3 w=3
X6804 P_B11 P_TOP sky130_fd_pr__cap_mim_m3_1 l=3 w=3
X6805 N_B9 N_TOP sky130_fd_pr__cap_mim_m3_1 l=3 w=3
X6806 P_B11 P_TOP sky130_fd_pr__cap_mim_m3_1 l=3 w=3
X6807 P_B9 P_TOP sky130_fd_pr__cap_mim_m3_1 l=3 w=3
X6808 P_B11 P_TOP sky130_fd_pr__cap_mim_m3_1 l=3 w=3
X6809 P_B11 P_TOP sky130_fd_pr__cap_mim_m3_1 l=3 w=3
X6810 P_EDGE_BIAS P_EDGE_BIAS sky130_fd_pr__cap_mim_m3_1 l=3 w=3
X6811 P_B11 P_TOP sky130_fd_pr__cap_mim_m3_1 l=3 w=3
X6812 N_B10 N_TOP sky130_fd_pr__cap_mim_m3_1 l=3 w=3
X6813 N_B11 N_TOP sky130_fd_pr__cap_mim_m3_1 l=3 w=3
X6814 N_B9 N_TOP sky130_fd_pr__cap_mim_m3_1 l=3 w=3
X6815 P_B11 P_TOP sky130_fd_pr__cap_mim_m3_1 l=3 w=3
X6816 N_B11 N_TOP sky130_fd_pr__cap_mim_m3_1 l=3 w=3
X6817 N_B10 N_TOP sky130_fd_pr__cap_mim_m3_1 l=3 w=3
X6818 P_B10 P_TOP sky130_fd_pr__cap_mim_m3_1 l=3 w=3
X6819 P_B11 P_TOP sky130_fd_pr__cap_mim_m3_1 l=3 w=3
X6820 P_B9 P_TOP sky130_fd_pr__cap_mim_m3_1 l=3 w=3
X6821 P_B11 P_TOP sky130_fd_pr__cap_mim_m3_1 l=3 w=3
X6822 P_B11 P_TOP sky130_fd_pr__cap_mim_m3_1 l=3 w=3
X6823 N_B11 N_TOP sky130_fd_pr__cap_mim_m3_1 l=3 w=3
X6824 P_B10 P_TOP sky130_fd_pr__cap_mim_m3_1 l=3 w=3
X6825 N_B11 N_TOP sky130_fd_pr__cap_mim_m3_1 l=3 w=3
X6826 P_B11 P_TOP sky130_fd_pr__cap_mim_m3_1 l=3 w=3
X6827 P_B10 P_TOP sky130_fd_pr__cap_mim_m3_1 l=3 w=3
X6828 N_B11 N_TOP sky130_fd_pr__cap_mim_m3_1 l=3 w=3
X6829 P_B10 P_TOP sky130_fd_pr__cap_mim_m3_1 l=3 w=3
X6830 N_EDGE_BIAS N_EDGE_BIAS sky130_fd_pr__cap_mim_m3_1 l=3 w=3
X6831 P_B10 P_TOP sky130_fd_pr__cap_mim_m3_1 l=3 w=3
X6832 P_B6 P_TOP sky130_fd_pr__cap_mim_m3_1 l=3 w=3
X6833 P_B11 P_TOP sky130_fd_pr__cap_mim_m3_1 l=3 w=3
X6834 N_B11 N_TOP sky130_fd_pr__cap_mim_m3_1 l=3 w=3
X6835 N_B9 N_TOP sky130_fd_pr__cap_mim_m3_1 l=3 w=3
X6836 N_B9 N_TOP sky130_fd_pr__cap_mim_m3_1 l=3 w=3
X6837 N_B10 N_TOP sky130_fd_pr__cap_mim_m3_1 l=3 w=3
X6838 P_B10 P_TOP sky130_fd_pr__cap_mim_m3_1 l=3 w=3
X6839 N_B7 N_TOP sky130_fd_pr__cap_mim_m3_1 l=3 w=3
X6840 P_B7 P_TOP sky130_fd_pr__cap_mim_m3_1 l=3 w=3
X6841 N_B10 N_TOP sky130_fd_pr__cap_mim_m3_1 l=3 w=3
X6842 P_B10 P_TOP sky130_fd_pr__cap_mim_m3_1 l=3 w=3
X6843 P_B10 P_TOP sky130_fd_pr__cap_mim_m3_1 l=3 w=3
X6844 N_B11 N_TOP sky130_fd_pr__cap_mim_m3_1 l=3 w=3
X6845 P_B10 P_TOP sky130_fd_pr__cap_mim_m3_1 l=3 w=3
X6846 N_B9 N_TOP sky130_fd_pr__cap_mim_m3_1 l=3 w=3
X6847 N_B9 N_TOP sky130_fd_pr__cap_mim_m3_1 l=3 w=3
X6848 N_B11 N_TOP sky130_fd_pr__cap_mim_m3_1 l=3 w=3
X6849 P_B10 P_TOP sky130_fd_pr__cap_mim_m3_1 l=3 w=3
X6850 N_B8 N_TOP sky130_fd_pr__cap_mim_m3_1 l=3 w=3
X6851 N_B10 N_TOP sky130_fd_pr__cap_mim_m3_1 l=3 w=3
X6852 P_B10 P_TOP sky130_fd_pr__cap_mim_m3_1 l=3 w=3
X6853 N_B11 N_TOP sky130_fd_pr__cap_mim_m3_1 l=3 w=3
X6854 N_B8 N_TOP sky130_fd_pr__cap_mim_m3_1 l=3 w=3
X6855 P_EDGE_BIAS P_EDGE_BIAS sky130_fd_pr__cap_mim_m3_1 l=3 w=3
X6856 N_B10 N_TOP sky130_fd_pr__cap_mim_m3_1 l=3 w=3
X6857 P_B10 P_TOP sky130_fd_pr__cap_mim_m3_1 l=3 w=3
X6858 P_B11 P_TOP sky130_fd_pr__cap_mim_m3_1 l=3 w=3
X6859 N_B11 N_TOP sky130_fd_pr__cap_mim_m3_1 l=3 w=3
X6860 P_B11 P_TOP sky130_fd_pr__cap_mim_m3_1 l=3 w=3
X6861 P_B11 P_TOP sky130_fd_pr__cap_mim_m3_1 l=3 w=3
X6862 P_B11 P_TOP sky130_fd_pr__cap_mim_m3_1 l=3 w=3
X6863 P_B11 P_TOP sky130_fd_pr__cap_mim_m3_1 l=3 w=3
X6864 P_B10 P_TOP sky130_fd_pr__cap_mim_m3_1 l=3 w=3
X6865 P_B11 P_TOP sky130_fd_pr__cap_mim_m3_1 l=3 w=3
X6866 N_B10 N_TOP sky130_fd_pr__cap_mim_m3_1 l=3 w=3
X6867 N_B11 N_TOP sky130_fd_pr__cap_mim_m3_1 l=3 w=3
X6868 N_B8 N_TOP sky130_fd_pr__cap_mim_m3_1 l=3 w=3
X6869 P_B11 P_TOP sky130_fd_pr__cap_mim_m3_1 l=3 w=3
X6870 N_B10 N_TOP sky130_fd_pr__cap_mim_m3_1 l=3 w=3
X6871 N_B10 N_TOP sky130_fd_pr__cap_mim_m3_1 l=3 w=3
X6872 P_B10 P_TOP sky130_fd_pr__cap_mim_m3_1 l=3 w=3
X6873 P_B11 P_TOP sky130_fd_pr__cap_mim_m3_1 l=3 w=3
X6874 N_B11 N_TOP sky130_fd_pr__cap_mim_m3_1 l=3 w=3
X6875 N_B11 N_TOP sky130_fd_pr__cap_mim_m3_1 l=3 w=3
X6876 P_B11 P_TOP sky130_fd_pr__cap_mim_m3_1 l=3 w=3
X6877 N_B11 N_TOP sky130_fd_pr__cap_mim_m3_1 l=3 w=3
X6878 P_B10 P_TOP sky130_fd_pr__cap_mim_m3_1 l=3 w=3
X6879 P_B11 P_TOP sky130_fd_pr__cap_mim_m3_1 l=3 w=3
X6880 N_B11 N_TOP sky130_fd_pr__cap_mim_m3_1 l=3 w=3
X6881 N_B9 N_TOP sky130_fd_pr__cap_mim_m3_1 l=3 w=3
X6882 P_B11 P_TOP sky130_fd_pr__cap_mim_m3_1 l=3 w=3
X6883 P_B9 P_TOP sky130_fd_pr__cap_mim_m3_1 l=3 w=3
X6884 P_EDGE_BIAS P_EDGE_BIAS sky130_fd_pr__cap_mim_m3_1 l=3 w=3
X6885 P_B8 P_TOP sky130_fd_pr__cap_mim_m3_1 l=3 w=3
X6886 P_B9 P_TOP sky130_fd_pr__cap_mim_m3_1 l=3 w=3
X6887 P_B11 P_TOP sky130_fd_pr__cap_mim_m3_1 l=3 w=3
X6888 N_B11 N_TOP sky130_fd_pr__cap_mim_m3_1 l=3 w=3
X6889 N_B11 N_TOP sky130_fd_pr__cap_mim_m3_1 l=3 w=3
X6890 N_B4 N_TOP sky130_fd_pr__cap_mim_m3_1 l=3 w=3
X6891 P_B8 P_TOP sky130_fd_pr__cap_mim_m3_1 l=3 w=3
X6892 N_B11 N_TOP sky130_fd_pr__cap_mim_m3_1 l=3 w=3
X6893 P_B8 P_TOP sky130_fd_pr__cap_mim_m3_1 l=3 w=3
X6894 P_B10 P_TOP sky130_fd_pr__cap_mim_m3_1 l=3 w=3
X6895 N_B11 N_TOP sky130_fd_pr__cap_mim_m3_1 l=3 w=3
X6896 P_B11 P_TOP sky130_fd_pr__cap_mim_m3_1 l=3 w=3
X6897 N_B9 N_TOP sky130_fd_pr__cap_mim_m3_1 l=3 w=3
X6898 P_B11 P_TOP sky130_fd_pr__cap_mim_m3_1 l=3 w=3
X6899 P_B9 P_TOP sky130_fd_pr__cap_mim_m3_1 l=3 w=3
X6900 N_B11 N_TOP sky130_fd_pr__cap_mim_m3_1 l=3 w=3
X6901 N_EDGE_BIAS N_EDGE_BIAS sky130_fd_pr__cap_mim_m3_1 l=3 w=3
X6902 N_B7 N_TOP sky130_fd_pr__cap_mim_m3_1 l=3 w=3
X6903 N_B11 N_TOP sky130_fd_pr__cap_mim_m3_1 l=3 w=3
X6904 P_B11 P_TOP sky130_fd_pr__cap_mim_m3_1 l=3 w=3
X6905 N_EDGE_BIAS N_EDGE_BIAS sky130_fd_pr__cap_mim_m3_1 l=3 w=3
X6906 P_B7 P_TOP sky130_fd_pr__cap_mim_m3_1 l=3 w=3
X6907 P_B11 P_TOP sky130_fd_pr__cap_mim_m3_1 l=3 w=3
X6908 P_B8 P_TOP sky130_fd_pr__cap_mim_m3_1 l=3 w=3
X6909 P_B10 P_TOP sky130_fd_pr__cap_mim_m3_1 l=3 w=3
X6910 P_B11 P_TOP sky130_fd_pr__cap_mim_m3_1 l=3 w=3
X6911 N_B10 N_TOP sky130_fd_pr__cap_mim_m3_1 l=3 w=3
X6912 N_B8 N_TOP sky130_fd_pr__cap_mim_m3_1 l=3 w=3
X6913 P_B8 P_TOP sky130_fd_pr__cap_mim_m3_1 l=3 w=3
X6914 P_B11 P_TOP sky130_fd_pr__cap_mim_m3_1 l=3 w=3
X6915 N_B10 N_TOP sky130_fd_pr__cap_mim_m3_1 l=3 w=3
X6916 N_B5 N_TOP sky130_fd_pr__cap_mim_m3_1 l=3 w=3
X6917 P_B11 P_TOP sky130_fd_pr__cap_mim_m3_1 l=3 w=3
X6918 N_B11 N_TOP sky130_fd_pr__cap_mim_m3_1 l=3 w=3
X6919 P_B4 P_TOP sky130_fd_pr__cap_mim_m3_1 l=3 w=3
X6920 N_B10 N_TOP sky130_fd_pr__cap_mim_m3_1 l=3 w=3
X6921 N_B11 N_TOP sky130_fd_pr__cap_mim_m3_1 l=3 w=3
X6922 P_B11 P_TOP sky130_fd_pr__cap_mim_m3_1 l=3 w=3
X6923 N_B9 N_TOP sky130_fd_pr__cap_mim_m3_1 l=3 w=3
X6924 P_B9 P_TOP sky130_fd_pr__cap_mim_m3_1 l=3 w=3
X6925 N_B9 N_TOP sky130_fd_pr__cap_mim_m3_1 l=3 w=3
X6926 P_B11 P_TOP sky130_fd_pr__cap_mim_m3_1 l=3 w=3
X6927 N_B10 N_TOP sky130_fd_pr__cap_mim_m3_1 l=3 w=3
X6928 N_EDGE_BIAS N_EDGE_BIAS sky130_fd_pr__cap_mim_m3_1 l=3 w=3
X6929 P_EDGE_BIAS P_EDGE_BIAS sky130_fd_pr__cap_mim_m3_1 l=3 w=3
X6930 P_B11 P_TOP sky130_fd_pr__cap_mim_m3_1 l=3 w=3
X6931 N_B10 N_TOP sky130_fd_pr__cap_mim_m3_1 l=3 w=3
X6932 P_B10 P_TOP sky130_fd_pr__cap_mim_m3_1 l=3 w=3
X6933 N_B11 N_TOP sky130_fd_pr__cap_mim_m3_1 l=3 w=3
X6934 N_B10 N_TOP sky130_fd_pr__cap_mim_m3_1 l=3 w=3
X6935 N_B9 N_TOP sky130_fd_pr__cap_mim_m3_1 l=3 w=3
X6936 P_B11 P_TOP sky130_fd_pr__cap_mim_m3_1 l=3 w=3
X6937 N_B11 N_TOP sky130_fd_pr__cap_mim_m3_1 l=3 w=3
X6938 N_B10 N_TOP sky130_fd_pr__cap_mim_m3_1 l=3 w=3
X6939 P_B11 P_TOP sky130_fd_pr__cap_mim_m3_1 l=3 w=3
X6940 P_B11 P_TOP sky130_fd_pr__cap_mim_m3_1 l=3 w=3
X6941 P_B9 P_TOP sky130_fd_pr__cap_mim_m3_1 l=3 w=3
X6942 P_B11 P_TOP sky130_fd_pr__cap_mim_m3_1 l=3 w=3
X6943 N_B10 N_TOP sky130_fd_pr__cap_mim_m3_1 l=3 w=3
X6944 P_B10 P_TOP sky130_fd_pr__cap_mim_m3_1 l=3 w=3
X6945 P_B11 P_TOP sky130_fd_pr__cap_mim_m3_1 l=3 w=3
X6946 P_B8 P_TOP sky130_fd_pr__cap_mim_m3_1 l=3 w=3
X6947 N_B11 N_TOP sky130_fd_pr__cap_mim_m3_1 l=3 w=3
X6948 P_B10 P_TOP sky130_fd_pr__cap_mim_m3_1 l=3 w=3
X6949 P_B11 P_TOP sky130_fd_pr__cap_mim_m3_1 l=3 w=3
X6950 N_B10 N_TOP sky130_fd_pr__cap_mim_m3_1 l=3 w=3
X6951 N_B11 N_TOP sky130_fd_pr__cap_mim_m3_1 l=3 w=3
X6952 P_B10 P_TOP sky130_fd_pr__cap_mim_m3_1 l=3 w=3
X6953 N_B11 N_TOP sky130_fd_pr__cap_mim_m3_1 l=3 w=3
X6954 P_B9 P_TOP sky130_fd_pr__cap_mim_m3_1 l=3 w=3
X6955 P_B11 P_TOP sky130_fd_pr__cap_mim_m3_1 l=3 w=3
X6956 P_B10 P_TOP sky130_fd_pr__cap_mim_m3_1 l=3 w=3
X6957 N_B11 N_TOP sky130_fd_pr__cap_mim_m3_1 l=3 w=3
X6958 P_B10 P_TOP sky130_fd_pr__cap_mim_m3_1 l=3 w=3
X6959 N_B11 N_TOP sky130_fd_pr__cap_mim_m3_1 l=3 w=3
X6960 P_B10 P_TOP sky130_fd_pr__cap_mim_m3_1 l=3 w=3
X6961 N_B7 N_TOP sky130_fd_pr__cap_mim_m3_1 l=3 w=3
X6962 P_B7 P_TOP sky130_fd_pr__cap_mim_m3_1 l=3 w=3
X6963 N_B11 N_TOP sky130_fd_pr__cap_mim_m3_1 l=3 w=3
X6964 P_B11 P_TOP sky130_fd_pr__cap_mim_m3_1 l=3 w=3
X6965 P_B10 P_TOP sky130_fd_pr__cap_mim_m3_1 l=3 w=3
X6966 P_B10 P_TOP sky130_fd_pr__cap_mim_m3_1 l=3 w=3
X6967 P_EDGE_BIAS P_EDGE_BIAS sky130_fd_pr__cap_mim_m3_1 l=3 w=3
X6968 N_B11 N_TOP sky130_fd_pr__cap_mim_m3_1 l=3 w=3
X6969 N_B11 N_TOP sky130_fd_pr__cap_mim_m3_1 l=3 w=3
X6970 N_B11 N_TOP sky130_fd_pr__cap_mim_m3_1 l=3 w=3
X6971 N_B9 N_TOP sky130_fd_pr__cap_mim_m3_1 l=3 w=3
X6972 N_B11 N_TOP sky130_fd_pr__cap_mim_m3_1 l=3 w=3
X6973 N_B9 N_TOP sky130_fd_pr__cap_mim_m3_1 l=3 w=3
X6974 P_B11 P_TOP sky130_fd_pr__cap_mim_m3_1 l=3 w=3
X6975 N_B8 N_TOP sky130_fd_pr__cap_mim_m3_1 l=3 w=3
X6976 P_B8 P_TOP sky130_fd_pr__cap_mim_m3_1 l=3 w=3
X6977 N_B10 N_TOP sky130_fd_pr__cap_mim_m3_1 l=3 w=3
X6978 P_B10 P_TOP sky130_fd_pr__cap_mim_m3_1 l=3 w=3
X6979 P_B11 P_TOP sky130_fd_pr__cap_mim_m3_1 l=3 w=3
X6980 N_B11 N_TOP sky130_fd_pr__cap_mim_m3_1 l=3 w=3
X6981 N_B10 N_TOP sky130_fd_pr__cap_mim_m3_1 l=3 w=3
X6982 P_B11 P_TOP sky130_fd_pr__cap_mim_m3_1 l=3 w=3
X6983 N_B9 N_TOP sky130_fd_pr__cap_mim_m3_1 l=3 w=3
X6984 N_EDGE_BIAS N_EDGE_BIAS sky130_fd_pr__cap_mim_m3_1 l=3 w=3
X6985 P_EDGE_BIAS P_EDGE_BIAS sky130_fd_pr__cap_mim_m3_1 l=3 w=3
X6986 P_B11 P_TOP sky130_fd_pr__cap_mim_m3_1 l=3 w=3
X6987 N_B11 N_TOP sky130_fd_pr__cap_mim_m3_1 l=3 w=3
X6988 N_B8 N_TOP sky130_fd_pr__cap_mim_m3_1 l=3 w=3
X6989 N_B10 N_TOP sky130_fd_pr__cap_mim_m3_1 l=3 w=3
X6990 P_B10 P_TOP sky130_fd_pr__cap_mim_m3_1 l=3 w=3
X6991 N_B11 N_TOP sky130_fd_pr__cap_mim_m3_1 l=3 w=3
X6992 N_B8 N_TOP sky130_fd_pr__cap_mim_m3_1 l=3 w=3
X6993 P_B9 P_TOP sky130_fd_pr__cap_mim_m3_1 l=3 w=3
X6994 P_B11 P_TOP sky130_fd_pr__cap_mim_m3_1 l=3 w=3
X6995 N_B11 N_TOP sky130_fd_pr__cap_mim_m3_1 l=3 w=3
X6996 N_B10 N_TOP sky130_fd_pr__cap_mim_m3_1 l=3 w=3
X6997 N_B10 N_TOP sky130_fd_pr__cap_mim_m3_1 l=3 w=3
X6998 P_B11 P_TOP sky130_fd_pr__cap_mim_m3_1 l=3 w=3
X6999 P_B10 P_TOP sky130_fd_pr__cap_mim_m3_1 l=3 w=3
X7000 N_B11 N_TOP sky130_fd_pr__cap_mim_m3_1 l=3 w=3
X7001 P_B11 P_TOP sky130_fd_pr__cap_mim_m3_1 l=3 w=3
X7002 N_B10 N_TOP sky130_fd_pr__cap_mim_m3_1 l=3 w=3
X7003 P_B11 P_TOP sky130_fd_pr__cap_mim_m3_1 l=3 w=3
X7004 N_B11 N_TOP sky130_fd_pr__cap_mim_m3_1 l=3 w=3
X7005 N_B9 N_TOP sky130_fd_pr__cap_mim_m3_1 l=3 w=3
X7006 P_B9 P_TOP sky130_fd_pr__cap_mim_m3_1 l=3 w=3
X7007 P_B11 P_TOP sky130_fd_pr__cap_mim_m3_1 l=3 w=3
X7008 P_B11 P_TOP sky130_fd_pr__cap_mim_m3_1 l=3 w=3
X7009 N_B11 N_TOP sky130_fd_pr__cap_mim_m3_1 l=3 w=3
X7010 N_B10 N_TOP sky130_fd_pr__cap_mim_m3_1 l=3 w=3
X7011 P_B10 P_TOP sky130_fd_pr__cap_mim_m3_1 l=3 w=3
X7012 P_B9 P_TOP sky130_fd_pr__cap_mim_m3_1 l=3 w=3
X7013 P_B8 P_TOP sky130_fd_pr__cap_mim_m3_1 l=3 w=3
X7014 N_B11 N_TOP sky130_fd_pr__cap_mim_m3_1 l=3 w=3
X7015 N_B11 N_TOP sky130_fd_pr__cap_mim_m3_1 l=3 w=3
X7016 N_B5 N_TOP sky130_fd_pr__cap_mim_m3_1 l=3 w=3
X7017 P_B10 P_TOP sky130_fd_pr__cap_mim_m3_1 l=3 w=3
X7018 N_B10 N_TOP sky130_fd_pr__cap_mim_m3_1 l=3 w=3
X7019 P_B9 P_TOP sky130_fd_pr__cap_mim_m3_1 l=3 w=3
X7020 N_B11 N_TOP sky130_fd_pr__cap_mim_m3_1 l=3 w=3
X7021 P_B7 P_TOP sky130_fd_pr__cap_mim_m3_1 l=3 w=3
X7022 P_B9 P_TOP sky130_fd_pr__cap_mim_m3_1 l=3 w=3
X7023 N_B11 N_TOP sky130_fd_pr__cap_mim_m3_1 l=3 w=3
X7024 P_B11 P_TOP sky130_fd_pr__cap_mim_m3_1 l=3 w=3
X7025 N_B11 N_TOP sky130_fd_pr__cap_mim_m3_1 l=3 w=3
X7026 P_B11 P_TOP sky130_fd_pr__cap_mim_m3_1 l=3 w=3
X7027 P_B11 P_TOP sky130_fd_pr__cap_mim_m3_1 l=3 w=3
X7028 P_B7 P_TOP sky130_fd_pr__cap_mim_m3_1 l=3 w=3
X7029 N_B9 N_TOP sky130_fd_pr__cap_mim_m3_1 l=3 w=3
X7030 P_B11 P_TOP sky130_fd_pr__cap_mim_m3_1 l=3 w=3
X7031 P_B8 P_TOP sky130_fd_pr__cap_mim_m3_1 l=3 w=3
X7032 N_B10 N_TOP sky130_fd_pr__cap_mim_m3_1 l=3 w=3
X7033 P_B10 P_TOP sky130_fd_pr__cap_mim_m3_1 l=3 w=3
X7034 P_B11 P_TOP sky130_fd_pr__cap_mim_m3_1 l=3 w=3
X7035 N_B10 N_TOP sky130_fd_pr__cap_mim_m3_1 l=3 w=3
X7036 N_B10 N_TOP sky130_fd_pr__cap_mim_m3_1 l=3 w=3
X7037 N_B11 N_TOP sky130_fd_pr__cap_mim_m3_1 l=3 w=3
X7038 N_B8 N_TOP sky130_fd_pr__cap_mim_m3_1 l=3 w=3
X7039 P_B8 P_TOP sky130_fd_pr__cap_mim_m3_1 l=3 w=3
X7040 P_B11 P_TOP sky130_fd_pr__cap_mim_m3_1 l=3 w=3
X7041 N_B10 N_TOP sky130_fd_pr__cap_mim_m3_1 l=3 w=3
X7042 P_B10 P_TOP sky130_fd_pr__cap_mim_m3_1 l=3 w=3
X7043 N_B4 N_TOP sky130_fd_pr__cap_mim_m3_1 l=3 w=3
X7044 N_EDGE_BIAS N_EDGE_BIAS sky130_fd_pr__cap_mim_m3_1 l=3 w=3
X7045 P_B11 P_TOP sky130_fd_pr__cap_mim_m3_1 l=3 w=3
X7046 P_B5 P_TOP sky130_fd_pr__cap_mim_m3_1 l=3 w=3
X7047 P_B9 P_TOP sky130_fd_pr__cap_mim_m3_1 l=3 w=3
X7048 P_B11 P_TOP sky130_fd_pr__cap_mim_m3_1 l=3 w=3
X7049 N_B11 N_TOP sky130_fd_pr__cap_mim_m3_1 l=3 w=3
X7050 P_B11 P_TOP sky130_fd_pr__cap_mim_m3_1 l=3 w=3
X7051 N_B9 N_TOP sky130_fd_pr__cap_mim_m3_1 l=3 w=3
X7052 P_B9 P_TOP sky130_fd_pr__cap_mim_m3_1 l=3 w=3
X7053 N_B10 N_TOP sky130_fd_pr__cap_mim_m3_1 l=3 w=3
X7054 P_B6 P_TOP sky130_fd_pr__cap_mim_m3_1 l=3 w=3
X7055 P_B11 P_TOP sky130_fd_pr__cap_mim_m3_1 l=3 w=3
X7056 N_B11 N_TOP sky130_fd_pr__cap_mim_m3_1 l=3 w=3
X7057 N_B10 N_TOP sky130_fd_pr__cap_mim_m3_1 l=3 w=3
X7058 P_B11 P_TOP sky130_fd_pr__cap_mim_m3_1 l=3 w=3
X7059 N_B10 N_TOP sky130_fd_pr__cap_mim_m3_1 l=3 w=3
X7060 P_B11 P_TOP sky130_fd_pr__cap_mim_m3_1 l=3 w=3
X7061 N_B11 N_TOP sky130_fd_pr__cap_mim_m3_1 l=3 w=3
X7062 N_B10 N_TOP sky130_fd_pr__cap_mim_m3_1 l=3 w=3
X7063 N_B9 N_TOP sky130_fd_pr__cap_mim_m3_1 l=3 w=3
X7064 N_B11 N_TOP sky130_fd_pr__cap_mim_m3_1 l=3 w=3
X7065 N_B10 N_TOP sky130_fd_pr__cap_mim_m3_1 l=3 w=3
X7066 P_B11 P_TOP sky130_fd_pr__cap_mim_m3_1 l=3 w=3
X7067 P_B11 P_TOP sky130_fd_pr__cap_mim_m3_1 l=3 w=3
X7068 N_B11 N_TOP sky130_fd_pr__cap_mim_m3_1 l=3 w=3
X7069 P_B11 P_TOP sky130_fd_pr__cap_mim_m3_1 l=3 w=3
X7070 P_B9 P_TOP sky130_fd_pr__cap_mim_m3_1 l=3 w=3
X7071 P_B10 P_TOP sky130_fd_pr__cap_mim_m3_1 l=3 w=3
X7072 N_B10 N_TOP sky130_fd_pr__cap_mim_m3_1 l=3 w=3
X7073 P_B11 P_TOP sky130_fd_pr__cap_mim_m3_1 l=3 w=3
X7074 N_B11 N_TOP sky130_fd_pr__cap_mim_m3_1 l=3 w=3
X7075 P_B11 P_TOP sky130_fd_pr__cap_mim_m3_1 l=3 w=3
X7076 N_B11 N_TOP sky130_fd_pr__cap_mim_m3_1 l=3 w=3
X7077 P_B10 P_TOP sky130_fd_pr__cap_mim_m3_1 l=3 w=3
X7078 N_B10 N_TOP sky130_fd_pr__cap_mim_m3_1 l=3 w=3
X7079 N_B11 N_TOP sky130_fd_pr__cap_mim_m3_1 l=3 w=3
X7080 N_B9 N_TOP sky130_fd_pr__cap_mim_m3_1 l=3 w=3
X7081 P_B11 P_TOP sky130_fd_pr__cap_mim_m3_1 l=3 w=3
X7082 N_B11 N_TOP sky130_fd_pr__cap_mim_m3_1 l=3 w=3
X7083 P_B9 P_TOP sky130_fd_pr__cap_mim_m3_1 l=3 w=3
X7084 P_B10 P_TOP sky130_fd_pr__cap_mim_m3_1 l=3 w=3
X7085 P_B7 P_TOP sky130_fd_pr__cap_mim_m3_1 l=3 w=3
X7086 N_B10 N_TOP sky130_fd_pr__cap_mim_m3_1 l=3 w=3
X7087 P_B10 P_TOP sky130_fd_pr__cap_mim_m3_1 l=3 w=3
X7088 N_B10 N_TOP sky130_fd_pr__cap_mim_m3_1 l=3 w=3
X7089 P_B7 P_TOP sky130_fd_pr__cap_mim_m3_1 l=3 w=3
X7090 P_B11 P_TOP sky130_fd_pr__cap_mim_m3_1 l=3 w=3
X7091 N_EDGE_BIAS N_EDGE_BIAS sky130_fd_pr__cap_mim_m3_1 l=3 w=3
X7092 P_B10 P_TOP sky130_fd_pr__cap_mim_m3_1 l=3 w=3
X7093 N_B9 N_TOP sky130_fd_pr__cap_mim_m3_1 l=3 w=3
X7094 P_B11 P_TOP sky130_fd_pr__cap_mim_m3_1 l=3 w=3
X7095 N_B11 N_TOP sky130_fd_pr__cap_mim_m3_1 l=3 w=3
X7096 N_B9 N_TOP sky130_fd_pr__cap_mim_m3_1 l=3 w=3
X7097 N_B8 N_TOP sky130_fd_pr__cap_mim_m3_1 l=3 w=3
X7098 N_B9 N_TOP sky130_fd_pr__cap_mim_m3_1 l=3 w=3
X7099 P_B10 P_TOP sky130_fd_pr__cap_mim_m3_1 l=3 w=3
X7100 N_B10 N_TOP sky130_fd_pr__cap_mim_m3_1 l=3 w=3
X7101 P_B10 P_TOP sky130_fd_pr__cap_mim_m3_1 l=3 w=3
X7102 N_B8 N_TOP sky130_fd_pr__cap_mim_m3_1 l=3 w=3
X7103 P_B8 P_TOP sky130_fd_pr__cap_mim_m3_1 l=3 w=3
X7104 N_EDGE_BIAS N_EDGE_BIAS sky130_fd_pr__cap_mim_m3_1 l=3 w=3
X7105 P_B10 P_TOP sky130_fd_pr__cap_mim_m3_1 l=3 w=3
X7106 P_B11 P_TOP sky130_fd_pr__cap_mim_m3_1 l=3 w=3
X7107 N_B11 N_TOP sky130_fd_pr__cap_mim_m3_1 l=3 w=3
X7108 P_B11 P_TOP sky130_fd_pr__cap_mim_m3_1 l=3 w=3
X7109 P_B11 P_TOP sky130_fd_pr__cap_mim_m3_1 l=3 w=3
X7110 N_B9 N_TOP sky130_fd_pr__cap_mim_m3_1 l=3 w=3
X7111 N_B11 N_TOP sky130_fd_pr__cap_mim_m3_1 l=3 w=3
X7112 P_B10 P_TOP sky130_fd_pr__cap_mim_m3_1 l=3 w=3
X7113 P_B11 P_TOP sky130_fd_pr__cap_mim_m3_1 l=3 w=3
X7114 N_B10 N_TOP sky130_fd_pr__cap_mim_m3_1 l=3 w=3
X7115 N_B11 N_TOP sky130_fd_pr__cap_mim_m3_1 l=3 w=3
X7116 N_B8 N_TOP sky130_fd_pr__cap_mim_m3_1 l=3 w=3
X7117 P_B8 P_TOP sky130_fd_pr__cap_mim_m3_1 l=3 w=3
X7118 N_B10 N_TOP sky130_fd_pr__cap_mim_m3_1 l=3 w=3
X7119 N_B11 N_TOP sky130_fd_pr__cap_mim_m3_1 l=3 w=3
X7120 P_B10 P_TOP sky130_fd_pr__cap_mim_m3_1 l=3 w=3
X7121 P_B11 P_TOP sky130_fd_pr__cap_mim_m3_1 l=3 w=3
X7122 N_B11 N_TOP sky130_fd_pr__cap_mim_m3_1 l=3 w=3
X7123 N_B10 N_TOP sky130_fd_pr__cap_mim_m3_1 l=3 w=3
X7124 P_EDGE_BIAS P_EDGE_BIAS sky130_fd_pr__cap_mim_m3_1 l=3 w=3
X7125 N_B8 N_TOP sky130_fd_pr__cap_mim_m3_1 l=3 w=3
X7126 N_B11 N_TOP sky130_fd_pr__cap_mim_m3_1 l=3 w=3
X7127 P_B11 P_TOP sky130_fd_pr__cap_mim_m3_1 l=3 w=3
X7128 P_B11 P_TOP sky130_fd_pr__cap_mim_m3_1 l=3 w=3
X7129 P_B11 P_TOP sky130_fd_pr__cap_mim_m3_1 l=3 w=3
X7130 N_B10 N_TOP sky130_fd_pr__cap_mim_m3_1 l=3 w=3
X7131 P_B11 P_TOP sky130_fd_pr__cap_mim_m3_1 l=3 w=3
X7132 N_B11 N_TOP sky130_fd_pr__cap_mim_m3_1 l=3 w=3
X7133 P_B9 P_TOP sky130_fd_pr__cap_mim_m3_1 l=3 w=3
X7134 N_B9 N_TOP sky130_fd_pr__cap_mim_m3_1 l=3 w=3
X7135 P_B9 P_TOP sky130_fd_pr__cap_mim_m3_1 l=3 w=3
X7136 P_B11 P_TOP sky130_fd_pr__cap_mim_m3_1 l=3 w=3
X7137 N_B10 N_TOP sky130_fd_pr__cap_mim_m3_1 l=3 w=3
X7138 N_B4 N_TOP sky130_fd_pr__cap_mim_m3_1 l=3 w=3
X7139 P_B8 P_TOP sky130_fd_pr__cap_mim_m3_1 l=3 w=3
X7140 N_B8 N_TOP sky130_fd_pr__cap_mim_m3_1 l=3 w=3
X7141 P_B11 P_TOP sky130_fd_pr__cap_mim_m3_1 l=3 w=3
X7142 N_B11 N_TOP sky130_fd_pr__cap_mim_m3_1 l=3 w=3
X7143 N_B10 N_TOP sky130_fd_pr__cap_mim_m3_1 l=3 w=3
X7144 P_B10 P_TOP sky130_fd_pr__cap_mim_m3_1 l=3 w=3
X7145 P_B11 P_TOP sky130_fd_pr__cap_mim_m3_1 l=3 w=3
X7146 P_B9 P_TOP sky130_fd_pr__cap_mim_m3_1 l=3 w=3
X7147 P_EDGE_BIAS P_EDGE_BIAS sky130_fd_pr__cap_mim_m3_1 l=3 w=3
X7148 N_B7 N_TOP sky130_fd_pr__cap_mim_m3_1 l=3 w=3
X7149 P_B7 P_TOP sky130_fd_pr__cap_mim_m3_1 l=3 w=3
X7150 N_B11 N_TOP sky130_fd_pr__cap_mim_m3_1 l=3 w=3
X7151 P_B11 P_TOP sky130_fd_pr__cap_mim_m3_1 l=3 w=3
X7152 N_B11 N_TOP sky130_fd_pr__cap_mim_m3_1 l=3 w=3
X7153 N_B11 N_TOP sky130_fd_pr__cap_mim_m3_1 l=3 w=3
X7154 P_B11 P_TOP sky130_fd_pr__cap_mim_m3_1 l=3 w=3
X7155 N_B11 N_TOP sky130_fd_pr__cap_mim_m3_1 l=3 w=3
X7156 P_B11 P_TOP sky130_fd_pr__cap_mim_m3_1 l=3 w=3
X7157 P_B8 P_TOP sky130_fd_pr__cap_mim_m3_1 l=3 w=3
X7158 N_B10 N_TOP sky130_fd_pr__cap_mim_m3_1 l=3 w=3
X7159 P_B10 P_TOP sky130_fd_pr__cap_mim_m3_1 l=3 w=3
X7160 N_EDGE_BIAS N_EDGE_BIAS sky130_fd_pr__cap_mim_m3_1 l=3 w=3
X7161 N_B11 N_TOP sky130_fd_pr__cap_mim_m3_1 l=3 w=3
X7162 N_B10 N_TOP sky130_fd_pr__cap_mim_m3_1 l=3 w=3
X7163 P_B11 P_TOP sky130_fd_pr__cap_mim_m3_1 l=3 w=3
X7164 N_B11 N_TOP sky130_fd_pr__cap_mim_m3_1 l=3 w=3
X7165 N_B6 N_TOP sky130_fd_pr__cap_mim_m3_1 l=3 w=3
X7166 P_B3 P_TOP sky130_fd_pr__cap_mim_m3_1 l=3 w=3
X7167 N_B8 N_TOP sky130_fd_pr__cap_mim_m3_1 l=3 w=3
X7168 P_B11 P_TOP sky130_fd_pr__cap_mim_m3_1 l=3 w=3
X7169 N_B10 N_TOP sky130_fd_pr__cap_mim_m3_1 l=3 w=3
X7170 P_B10 P_TOP sky130_fd_pr__cap_mim_m3_1 l=3 w=3
X7171 N_EDGE_BIAS N_EDGE_BIAS sky130_fd_pr__cap_mim_m3_1 l=3 w=3
X7172 P_B11 P_TOP sky130_fd_pr__cap_mim_m3_1 l=3 w=3
X7173 P_B9 P_TOP sky130_fd_pr__cap_mim_m3_1 l=3 w=3
X7174 P_B11 P_TOP sky130_fd_pr__cap_mim_m3_1 l=3 w=3
X7175 N_B10 N_TOP sky130_fd_pr__cap_mim_m3_1 l=3 w=3
X7176 N_B11 N_TOP sky130_fd_pr__cap_mim_m3_1 l=3 w=3
X7177 N_B9 N_TOP sky130_fd_pr__cap_mim_m3_1 l=3 w=3
X7178 P_B9 P_TOP sky130_fd_pr__cap_mim_m3_1 l=3 w=3
X7179 P_B11 P_TOP sky130_fd_pr__cap_mim_m3_1 l=3 w=3
X7180 N_B10 N_TOP sky130_fd_pr__cap_mim_m3_1 l=3 w=3
X7181 N_B10 N_TOP sky130_fd_pr__cap_mim_m3_1 l=3 w=3
X7182 P_B11 P_TOP sky130_fd_pr__cap_mim_m3_1 l=3 w=3
X7183 P_B5 P_TOP sky130_fd_pr__cap_mim_m3_1 l=3 w=3
X7184 P_B11 P_TOP sky130_fd_pr__cap_mim_m3_1 l=3 w=3
X7185 N_B10 N_TOP sky130_fd_pr__cap_mim_m3_1 l=3 w=3
X7186 P_B10 P_TOP sky130_fd_pr__cap_mim_m3_1 l=3 w=3
X7187 N_EDGE_BIAS N_EDGE_BIAS sky130_fd_pr__cap_mim_m3_1 l=3 w=3
X7188 P_B9 P_TOP sky130_fd_pr__cap_mim_m3_1 l=3 w=3
X7189 P_B11 P_TOP sky130_fd_pr__cap_mim_m3_1 l=3 w=3
X7190 N_B11 N_TOP sky130_fd_pr__cap_mim_m3_1 l=3 w=3
X7191 N_B10 N_TOP sky130_fd_pr__cap_mim_m3_1 l=3 w=3
X7192 P_B10 P_TOP sky130_fd_pr__cap_mim_m3_1 l=3 w=3
X7193 P_B11 P_TOP sky130_fd_pr__cap_mim_m3_1 l=3 w=3
X7194 P_B11 P_TOP sky130_fd_pr__cap_mim_m3_1 l=3 w=3
X7195 P_B9 P_TOP sky130_fd_pr__cap_mim_m3_1 l=3 w=3
X7196 P_B11 P_TOP sky130_fd_pr__cap_mim_m3_1 l=3 w=3
X7197 N_B11 N_TOP sky130_fd_pr__cap_mim_m3_1 l=3 w=3
X7198 P_B11 P_TOP sky130_fd_pr__cap_mim_m3_1 l=3 w=3
X7199 P_B9 P_TOP sky130_fd_pr__cap_mim_m3_1 l=3 w=3
X7200 N_B11 N_TOP sky130_fd_pr__cap_mim_m3_1 l=3 w=3
X7201 N_B11 N_TOP sky130_fd_pr__cap_mim_m3_1 l=3 w=3
X7202 P_B10 P_TOP sky130_fd_pr__cap_mim_m3_1 l=3 w=3
X7203 P_B11 P_TOP sky130_fd_pr__cap_mim_m3_1 l=3 w=3
X7204 N_B11 N_TOP sky130_fd_pr__cap_mim_m3_1 l=3 w=3
X7205 N_B10 N_TOP sky130_fd_pr__cap_mim_m3_1 l=3 w=3
X7206 N_B10 N_TOP sky130_fd_pr__cap_mim_m3_1 l=3 w=3
X7207 P_B11 P_TOP sky130_fd_pr__cap_mim_m3_1 l=3 w=3
X7208 N_B11 N_TOP sky130_fd_pr__cap_mim_m3_1 l=3 w=3
X7209 N_B9 N_TOP sky130_fd_pr__cap_mim_m3_1 l=3 w=3
X7210 P_B9 P_TOP sky130_fd_pr__cap_mim_m3_1 l=3 w=3
X7211 N_B11 N_TOP sky130_fd_pr__cap_mim_m3_1 l=3 w=3
X7212 P_B11 P_TOP sky130_fd_pr__cap_mim_m3_1 l=3 w=3
X7213 P_B11 P_TOP sky130_fd_pr__cap_mim_m3_1 l=3 w=3
X7214 P_B10 P_TOP sky130_fd_pr__cap_mim_m3_1 l=3 w=3
X7215 P_B10 P_TOP sky130_fd_pr__cap_mim_m3_1 l=3 w=3
X7216 N_B7 N_TOP sky130_fd_pr__cap_mim_m3_1 l=3 w=3
X7217 P_B7 P_TOP sky130_fd_pr__cap_mim_m3_1 l=3 w=3
X7218 P_B10 P_TOP sky130_fd_pr__cap_mim_m3_1 l=3 w=3
X7219 P_B11 P_TOP sky130_fd_pr__cap_mim_m3_1 l=3 w=3
X7220 N_B11 N_TOP sky130_fd_pr__cap_mim_m3_1 l=3 w=3
X7221 P_B10 P_TOP sky130_fd_pr__cap_mim_m3_1 l=3 w=3
X7222 N_B9 N_TOP sky130_fd_pr__cap_mim_m3_1 l=3 w=3
X7223 N_B9 N_TOP sky130_fd_pr__cap_mim_m3_1 l=3 w=3
X7224 N_B11 N_TOP sky130_fd_pr__cap_mim_m3_1 l=3 w=3
X7225 P_B9 P_TOP sky130_fd_pr__cap_mim_m3_1 l=3 w=3
X7226 P_B11 P_TOP sky130_fd_pr__cap_mim_m3_1 l=3 w=3
X7227 N_B9 N_TOP sky130_fd_pr__cap_mim_m3_1 l=3 w=3
X7228 N_B8 N_TOP sky130_fd_pr__cap_mim_m3_1 l=3 w=3
X7229 N_B8 N_TOP sky130_fd_pr__cap_mim_m3_1 l=3 w=3
X7230 P_B8 P_TOP sky130_fd_pr__cap_mim_m3_1 l=3 w=3
X7231 N_B10 N_TOP sky130_fd_pr__cap_mim_m3_1 l=3 w=3
X7232 P_B10 P_TOP sky130_fd_pr__cap_mim_m3_1 l=3 w=3
X7233 N_B11 N_TOP sky130_fd_pr__cap_mim_m3_1 l=3 w=3
X7234 P_B11 P_TOP sky130_fd_pr__cap_mim_m3_1 l=3 w=3
X7235 N_EDGE_BIAS N_EDGE_BIAS sky130_fd_pr__cap_mim_m3_1 l=3 w=3
X7236 P_B10 P_TOP sky130_fd_pr__cap_mim_m3_1 l=3 w=3
X7237 N_B9 N_TOP sky130_fd_pr__cap_mim_m3_1 l=3 w=3
X7238 N_B11 N_TOP sky130_fd_pr__cap_mim_m3_1 l=3 w=3
X7239 N_B11 N_TOP sky130_fd_pr__cap_mim_m3_1 l=3 w=3
X7240 N_B11 N_TOP sky130_fd_pr__cap_mim_m3_1 l=3 w=3
X7241 P_B11 P_TOP sky130_fd_pr__cap_mim_m3_1 l=3 w=3
X7242 P_B11 P_TOP sky130_fd_pr__cap_mim_m3_1 l=3 w=3
X7243 N_B7 N_TOP sky130_fd_pr__cap_mim_m3_1 l=3 w=3
X7244 N_B9 N_TOP sky130_fd_pr__cap_mim_m3_1 l=3 w=3
X7245 N_B11 N_TOP sky130_fd_pr__cap_mim_m3_1 l=3 w=3
X7246 P_B11 P_TOP sky130_fd_pr__cap_mim_m3_1 l=3 w=3
X7247 P_B10 P_TOP sky130_fd_pr__cap_mim_m3_1 l=3 w=3
X7248 N_B8 N_TOP sky130_fd_pr__cap_mim_m3_1 l=3 w=3
X7249 P_B11 P_TOP sky130_fd_pr__cap_mim_m3_1 l=3 w=3
X7250 N_B10 N_TOP sky130_fd_pr__cap_mim_m3_1 l=3 w=3
X7251 N_B11 N_TOP sky130_fd_pr__cap_mim_m3_1 l=3 w=3
X7252 P_B11 P_TOP sky130_fd_pr__cap_mim_m3_1 l=3 w=3
X7253 N_B8 N_TOP sky130_fd_pr__cap_mim_m3_1 l=3 w=3
X7254 N_B10 N_TOP sky130_fd_pr__cap_mim_m3_1 l=3 w=3
X7255 P_B10 P_TOP sky130_fd_pr__cap_mim_m3_1 l=3 w=3
X7256 P_B11 P_TOP sky130_fd_pr__cap_mim_m3_1 l=3 w=3
X7257 P_B10 P_TOP sky130_fd_pr__cap_mim_m3_1 l=3 w=3
X7258 N_B11 N_TOP sky130_fd_pr__cap_mim_m3_1 l=3 w=3
X7259 P_B11 P_TOP sky130_fd_pr__cap_mim_m3_1 l=3 w=3
X7260 N_B8 N_TOP sky130_fd_pr__cap_mim_m3_1 l=3 w=3
X7261 N_B11 N_TOP sky130_fd_pr__cap_mim_m3_1 l=3 w=3
X7262 P_B10 P_TOP sky130_fd_pr__cap_mim_m3_1 l=3 w=3
X7263 P_B11 P_TOP sky130_fd_pr__cap_mim_m3_1 l=3 w=3
X7264 N_B11 N_TOP sky130_fd_pr__cap_mim_m3_1 l=3 w=3
X7265 N_B9 N_TOP sky130_fd_pr__cap_mim_m3_1 l=3 w=3
X7266 N_B11 N_TOP sky130_fd_pr__cap_mim_m3_1 l=3 w=3
X7267 P_B9 P_TOP sky130_fd_pr__cap_mim_m3_1 l=3 w=3
X7268 P_B8 P_TOP sky130_fd_pr__cap_mim_m3_1 l=3 w=3
X7269 P_B11 P_TOP sky130_fd_pr__cap_mim_m3_1 l=3 w=3
X7270 N_B11 N_TOP sky130_fd_pr__cap_mim_m3_1 l=3 w=3
X7271 N_B11 N_TOP sky130_fd_pr__cap_mim_m3_1 l=3 w=3
X7272 N_B11 N_TOP sky130_fd_pr__cap_mim_m3_1 l=3 w=3
X7273 N_B5 N_TOP sky130_fd_pr__cap_mim_m3_1 l=3 w=3
X7274 P_B10 P_TOP sky130_fd_pr__cap_mim_m3_1 l=3 w=3
X7275 P_B11 P_TOP sky130_fd_pr__cap_mim_m3_1 l=3 w=3
X7276 N_B11 N_TOP sky130_fd_pr__cap_mim_m3_1 l=3 w=3
X7277 P_B10 P_TOP sky130_fd_pr__cap_mim_m3_1 l=3 w=3
X7278 P_B11 P_TOP sky130_fd_pr__cap_mim_m3_1 l=3 w=3
X7279 P_B7 P_TOP sky130_fd_pr__cap_mim_m3_1 l=3 w=3
X7280 P_B9 P_TOP sky130_fd_pr__cap_mim_m3_1 l=3 w=3
X7281 N_B11 N_TOP sky130_fd_pr__cap_mim_m3_1 l=3 w=3
X7282 P_B11 P_TOP sky130_fd_pr__cap_mim_m3_1 l=3 w=3
X7283 P_B11 P_TOP sky130_fd_pr__cap_mim_m3_1 l=3 w=3
X7284 P_B7 P_TOP sky130_fd_pr__cap_mim_m3_1 l=3 w=3
X7285 N_B11 N_TOP sky130_fd_pr__cap_mim_m3_1 l=3 w=3
X7286 N_B11 N_TOP sky130_fd_pr__cap_mim_m3_1 l=3 w=3
X7287 P_B10 P_TOP sky130_fd_pr__cap_mim_m3_1 l=3 w=3
X7288 P_B11 P_TOP sky130_fd_pr__cap_mim_m3_1 l=3 w=3
X7289 P_B10 P_TOP sky130_fd_pr__cap_mim_m3_1 l=3 w=3
X7290 N_B10 N_TOP sky130_fd_pr__cap_mim_m3_1 l=3 w=3
X7291 N_B0 N_TOP sky130_fd_pr__cap_mim_m3_1 l=3 w=3
X7292 P_B10 P_TOP sky130_fd_pr__cap_mim_m3_1 l=3 w=3
X7293 P_B8 P_TOP sky130_fd_pr__cap_mim_m3_1 l=3 w=3
X7294 N_B10 N_TOP sky130_fd_pr__cap_mim_m3_1 l=3 w=3
X7295 N_B10 N_TOP sky130_fd_pr__cap_mim_m3_1 l=3 w=3
X7296 P_B10 P_TOP sky130_fd_pr__cap_mim_m3_1 l=3 w=3
X7297 N_B5 N_TOP sky130_fd_pr__cap_mim_m3_1 l=3 w=3
X7298 P_B11 P_TOP sky130_fd_pr__cap_mim_m3_1 l=3 w=3
X7299 N_B11 N_TOP sky130_fd_pr__cap_mim_m3_1 l=3 w=3
X7300 P_B5 P_TOP sky130_fd_pr__cap_mim_m3_1 l=3 w=3
X7301 N_EDGE_BIAS N_EDGE_BIAS sky130_fd_pr__cap_mim_m3_1 l=3 w=3
X7302 P_B11 P_TOP sky130_fd_pr__cap_mim_m3_1 l=3 w=3
X7303 P_B9 P_TOP sky130_fd_pr__cap_mim_m3_1 l=3 w=3
X7304 N_B10 N_TOP sky130_fd_pr__cap_mim_m3_1 l=3 w=3
X7305 P_B10 P_TOP sky130_fd_pr__cap_mim_m3_1 l=3 w=3
X7306 N_B7 N_TOP sky130_fd_pr__cap_mim_m3_1 l=3 w=3
X7307 N_B10 N_TOP sky130_fd_pr__cap_mim_m3_1 l=3 w=3
X7308 P_B11 P_TOP sky130_fd_pr__cap_mim_m3_1 l=3 w=3
X7309 N_B10 N_TOP sky130_fd_pr__cap_mim_m3_1 l=3 w=3
X7310 P_EDGE_BIAS P_EDGE_BIAS sky130_fd_pr__cap_mim_m3_1 l=3 w=3
X7311 N_B10 N_TOP sky130_fd_pr__cap_mim_m3_1 l=3 w=3
X7312 P_B11 P_TOP sky130_fd_pr__cap_mim_m3_1 l=3 w=3
X7313 N_B9 N_TOP sky130_fd_pr__cap_mim_m3_1 l=3 w=3
X7314 P_B11 P_TOP sky130_fd_pr__cap_mim_m3_1 l=3 w=3
X7315 N_B10 N_TOP sky130_fd_pr__cap_mim_m3_1 l=3 w=3
X7316 P_B11 P_TOP sky130_fd_pr__cap_mim_m3_1 l=3 w=3
X7317 N_B10 N_TOP sky130_fd_pr__cap_mim_m3_1 l=3 w=3
X7318 P_B11 P_TOP sky130_fd_pr__cap_mim_m3_1 l=3 w=3
X7319 P_B9 P_TOP sky130_fd_pr__cap_mim_m3_1 l=3 w=3
X7320 P_B11 P_TOP sky130_fd_pr__cap_mim_m3_1 l=3 w=3
X7321 P_EDGE_BIAS P_EDGE_BIAS sky130_fd_pr__cap_mim_m3_1 l=3 w=3
X7322 P_EDGE_BIAS P_EDGE_BIAS sky130_fd_pr__cap_mim_m3_1 l=3 w=3
X7323 N_B10 N_TOP sky130_fd_pr__cap_mim_m3_1 l=3 w=3
X7324 N_B11 N_TOP sky130_fd_pr__cap_mim_m3_1 l=3 w=3
X7325 P_B10 P_TOP sky130_fd_pr__cap_mim_m3_1 l=3 w=3
X7326 P_B11 P_TOP sky130_fd_pr__cap_mim_m3_1 l=3 w=3
X7327 N_B10 N_TOP sky130_fd_pr__cap_mim_m3_1 l=3 w=3
X7328 N_B11 N_TOP sky130_fd_pr__cap_mim_m3_1 l=3 w=3
X7329 N_B11 N_TOP sky130_fd_pr__cap_mim_m3_1 l=3 w=3
X7330 P_B9 P_TOP sky130_fd_pr__cap_mim_m3_1 l=3 w=3
X7331 P_B11 P_TOP sky130_fd_pr__cap_mim_m3_1 l=3 w=3
X7332 P_B9 P_TOP sky130_fd_pr__cap_mim_m3_1 l=3 w=3
X7333 N_B10 N_TOP sky130_fd_pr__cap_mim_m3_1 l=3 w=3
X7334 N_EDGE_BIAS N_EDGE_BIAS sky130_fd_pr__cap_mim_m3_1 l=3 w=3
X7335 P_B7 P_TOP sky130_fd_pr__cap_mim_m3_1 l=3 w=3
X7336 P_B10 P_TOP sky130_fd_pr__cap_mim_m3_1 l=3 w=3
X7337 N_B11 N_TOP sky130_fd_pr__cap_mim_m3_1 l=3 w=3
X7338 P_B10 P_TOP sky130_fd_pr__cap_mim_m3_1 l=3 w=3
X7339 N_EDGE_BIAS N_EDGE_BIAS sky130_fd_pr__cap_mim_m3_1 l=3 w=3
X7340 P_B7 P_TOP sky130_fd_pr__cap_mim_m3_1 l=3 w=3
X7341 N_B11 N_TOP sky130_fd_pr__cap_mim_m3_1 l=3 w=3
X7342 P_B10 P_TOP sky130_fd_pr__cap_mim_m3_1 l=3 w=3
X7343 P_B11 P_TOP sky130_fd_pr__cap_mim_m3_1 l=3 w=3
X7344 N_B11 N_TOP sky130_fd_pr__cap_mim_m3_1 l=3 w=3
X7345 N_B9 N_TOP sky130_fd_pr__cap_mim_m3_1 l=3 w=3
X7346 N_EDGE_BIAS N_EDGE_BIAS sky130_fd_pr__cap_mim_m3_1 l=3 w=3
X7347 P_B9 P_TOP sky130_fd_pr__cap_mim_m3_1 l=3 w=3
X7348 N_B9 N_TOP sky130_fd_pr__cap_mim_m3_1 l=3 w=3
X7349 P_B9 P_TOP sky130_fd_pr__cap_mim_m3_1 l=3 w=3
X7350 N_B8 N_TOP sky130_fd_pr__cap_mim_m3_1 l=3 w=3
X7351 P_B11 P_TOP sky130_fd_pr__cap_mim_m3_1 l=3 w=3
X7352 N_B8 N_TOP sky130_fd_pr__cap_mim_m3_1 l=3 w=3
X7353 P_B8 P_TOP sky130_fd_pr__cap_mim_m3_1 l=3 w=3
X7354 N_B10 N_TOP sky130_fd_pr__cap_mim_m3_1 l=3 w=3
X7355 P_B10 P_TOP sky130_fd_pr__cap_mim_m3_1 l=3 w=3
X7356 P_B11 P_TOP sky130_fd_pr__cap_mim_m3_1 l=3 w=3
X7357 P_B11 P_TOP sky130_fd_pr__cap_mim_m3_1 l=3 w=3
X7358 N_B11 N_TOP sky130_fd_pr__cap_mim_m3_1 l=3 w=3
X7359 N_B9 N_TOP sky130_fd_pr__cap_mim_m3_1 l=3 w=3
X7360 P_B9 P_TOP sky130_fd_pr__cap_mim_m3_1 l=3 w=3
X7361 N_B7 N_TOP sky130_fd_pr__cap_mim_m3_1 l=3 w=3
X7362 N_B11 N_TOP sky130_fd_pr__cap_mim_m3_1 l=3 w=3
X7363 N_B8 N_TOP sky130_fd_pr__cap_mim_m3_1 l=3 w=3
X7364 N_B10 N_TOP sky130_fd_pr__cap_mim_m3_1 l=3 w=3
X7365 P_B10 P_TOP sky130_fd_pr__cap_mim_m3_1 l=3 w=3
X7366 N_B11 N_TOP sky130_fd_pr__cap_mim_m3_1 l=3 w=3
X7367 N_B8 N_TOP sky130_fd_pr__cap_mim_m3_1 l=3 w=3
X7368 P_B11 P_TOP sky130_fd_pr__cap_mim_m3_1 l=3 w=3
X7369 N_B10 N_TOP sky130_fd_pr__cap_mim_m3_1 l=3 w=3
X7370 P_B11 P_TOP sky130_fd_pr__cap_mim_m3_1 l=3 w=3
X7371 P_B10 P_TOP sky130_fd_pr__cap_mim_m3_1 l=3 w=3
X7372 P_B11 P_TOP sky130_fd_pr__cap_mim_m3_1 l=3 w=3
X7373 N_B11 N_TOP sky130_fd_pr__cap_mim_m3_1 l=3 w=3
X7374 P_B11 P_TOP sky130_fd_pr__cap_mim_m3_1 l=3 w=3
X7375 N_B6 N_TOP sky130_fd_pr__cap_mim_m3_1 l=3 w=3
X7376 P_B11 P_TOP sky130_fd_pr__cap_mim_m3_1 l=3 w=3
X7377 P_EDGE_BIAS P_EDGE_BIAS sky130_fd_pr__cap_mim_m3_1 l=3 w=3
X7378 N_B11 N_TOP sky130_fd_pr__cap_mim_m3_1 l=3 w=3
X7379 N_B9 N_TOP sky130_fd_pr__cap_mim_m3_1 l=3 w=3
X7380 P_B9 P_TOP sky130_fd_pr__cap_mim_m3_1 l=3 w=3
X7381 N_B10 N_TOP sky130_fd_pr__cap_mim_m3_1 l=3 w=3
X7382 N_B2 N_TOP sky130_fd_pr__cap_mim_m3_1 l=3 w=3
X7383 P_B8 P_TOP sky130_fd_pr__cap_mim_m3_1 l=3 w=3
X7384 N_B11 N_TOP sky130_fd_pr__cap_mim_m3_1 l=3 w=3
X7385 P_B11 P_TOP sky130_fd_pr__cap_mim_m3_1 l=3 w=3
X7386 P_B11 P_TOP sky130_fd_pr__cap_mim_m3_1 l=3 w=3
X7387 N_B11 N_TOP sky130_fd_pr__cap_mim_m3_1 l=3 w=3
X7388 N_B6 N_TOP sky130_fd_pr__cap_mim_m3_1 l=3 w=3
X7389 N_B11 N_TOP sky130_fd_pr__cap_mim_m3_1 l=3 w=3
X7390 P_B10 P_TOP sky130_fd_pr__cap_mim_m3_1 l=3 w=3
X7391 N_B10 N_TOP sky130_fd_pr__cap_mim_m3_1 l=3 w=3
X7392 N_B11 N_TOP sky130_fd_pr__cap_mim_m3_1 l=3 w=3
X7393 N_B9 N_TOP sky130_fd_pr__cap_mim_m3_1 l=3 w=3
X7394 P_B7 P_TOP sky130_fd_pr__cap_mim_m3_1 l=3 w=3
X7395 P_B9 P_TOP sky130_fd_pr__cap_mim_m3_1 l=3 w=3
X7396 N_B11 N_TOP sky130_fd_pr__cap_mim_m3_1 l=3 w=3
X7397 P_B11 P_TOP sky130_fd_pr__cap_mim_m3_1 l=3 w=3
X7398 P_B11 P_TOP sky130_fd_pr__cap_mim_m3_1 l=3 w=3
X7399 N_B11 N_TOP sky130_fd_pr__cap_mim_m3_1 l=3 w=3
X7400 N_EDGE_BIAS N_EDGE_BIAS sky130_fd_pr__cap_mim_m3_1 l=3 w=3
X7401 P_B11 P_TOP sky130_fd_pr__cap_mim_m3_1 l=3 w=3
X7402 N_EDGE_BIAS N_EDGE_BIAS sky130_fd_pr__cap_mim_m3_1 l=3 w=3
X7403 P_B7 P_TOP sky130_fd_pr__cap_mim_m3_1 l=3 w=3
X7404 N_B9 N_TOP sky130_fd_pr__cap_mim_m3_1 l=3 w=3
X7405 N_B11 N_TOP sky130_fd_pr__cap_mim_m3_1 l=3 w=3
X7406 P_B8 P_TOP sky130_fd_pr__cap_mim_m3_1 l=3 w=3
X7407 P_B10 P_TOP sky130_fd_pr__cap_mim_m3_1 l=3 w=3
X7408 N_B10 N_TOP sky130_fd_pr__cap_mim_m3_1 l=3 w=3
X7409 N_EDGE_BIAS N_EDGE_BIAS sky130_fd_pr__cap_mim_m3_1 l=3 w=3
X7410 N_B10 N_TOP sky130_fd_pr__cap_mim_m3_1 l=3 w=3
X7411 P_B10 P_TOP sky130_fd_pr__cap_mim_m3_1 l=3 w=3
X7412 P_B8 P_TOP sky130_fd_pr__cap_mim_m3_1 l=3 w=3
X7413 P_B11 P_TOP sky130_fd_pr__cap_mim_m3_1 l=3 w=3
X7414 N_B10 N_TOP sky130_fd_pr__cap_mim_m3_1 l=3 w=3
X7415 P_B10 P_TOP sky130_fd_pr__cap_mim_m3_1 l=3 w=3
X7416 N_B3 N_TOP sky130_fd_pr__cap_mim_m3_1 l=3 w=3
X7417 P_B6 P_TOP sky130_fd_pr__cap_mim_m3_1 l=3 w=3
X7418 N_B11 N_TOP sky130_fd_pr__cap_mim_m3_1 l=3 w=3
X7419 P_B9 P_TOP sky130_fd_pr__cap_mim_m3_1 l=3 w=3
X7420 P_B11 P_TOP sky130_fd_pr__cap_mim_m3_1 l=3 w=3
X7421 P_B11 P_TOP sky130_fd_pr__cap_mim_m3_1 l=3 w=3
X7422 N_B11 N_TOP sky130_fd_pr__cap_mim_m3_1 l=3 w=3
X7423 N_B10 N_TOP sky130_fd_pr__cap_mim_m3_1 l=3 w=3
X7424 N_B9 N_TOP sky130_fd_pr__cap_mim_m3_1 l=3 w=3
X7425 P_B11 P_TOP sky130_fd_pr__cap_mim_m3_1 l=3 w=3
X7426 P_B9 P_TOP sky130_fd_pr__cap_mim_m3_1 l=3 w=3
X7427 N_B10 N_TOP sky130_fd_pr__cap_mim_m3_1 l=3 w=3
X7428 N_B10 N_TOP sky130_fd_pr__cap_mim_m3_1 l=3 w=3
X7429 N_B11 N_TOP sky130_fd_pr__cap_mim_m3_1 l=3 w=3
X7430 P_B11 P_TOP sky130_fd_pr__cap_mim_m3_1 l=3 w=3
X7431 N_B7 N_TOP sky130_fd_pr__cap_mim_m3_1 l=3 w=3
X7432 P_B11 P_TOP sky130_fd_pr__cap_mim_m3_1 l=3 w=3
X7433 N_B11 N_TOP sky130_fd_pr__cap_mim_m3_1 l=3 w=3
X7434 N_B10 N_TOP sky130_fd_pr__cap_mim_m3_1 l=3 w=3
X7435 N_B10 N_TOP sky130_fd_pr__cap_mim_m3_1 l=3 w=3
X7436 P_B11 P_TOP sky130_fd_pr__cap_mim_m3_1 l=3 w=3
X7437 N_B11 N_TOP sky130_fd_pr__cap_mim_m3_1 l=3 w=3
X7438 N_B10 N_TOP sky130_fd_pr__cap_mim_m3_1 l=3 w=3
X7439 N_B9 N_TOP sky130_fd_pr__cap_mim_m3_1 l=3 w=3
X7440 P_B10 P_TOP sky130_fd_pr__cap_mim_m3_1 l=3 w=3
X7441 P_B11 P_TOP sky130_fd_pr__cap_mim_m3_1 l=3 w=3
X7442 N_B11 N_TOP sky130_fd_pr__cap_mim_m3_1 l=3 w=3
X7443 P_B11 P_TOP sky130_fd_pr__cap_mim_m3_1 l=3 w=3
X7444 N_B8 N_TOP sky130_fd_pr__cap_mim_m3_1 l=3 w=3
X7445 P_EDGE_BIAS P_EDGE_BIAS sky130_fd_pr__cap_mim_m3_1 l=3 w=3
X7446 P_B9 P_TOP sky130_fd_pr__cap_mim_m3_1 l=3 w=3
X7447 N_B10 N_TOP sky130_fd_pr__cap_mim_m3_1 l=3 w=3
X7448 N_B10 N_TOP sky130_fd_pr__cap_mim_m3_1 l=3 w=3
X7449 N_B11 N_TOP sky130_fd_pr__cap_mim_m3_1 l=3 w=3
X7450 P_EDGE_BIAS P_EDGE_BIAS sky130_fd_pr__cap_mim_m3_1 l=3 w=3
X7451 P_B11 P_TOP sky130_fd_pr__cap_mim_m3_1 l=3 w=3
X7452 P_B11 P_TOP sky130_fd_pr__cap_mim_m3_1 l=3 w=3
X7453 N_B10 N_TOP sky130_fd_pr__cap_mim_m3_1 l=3 w=3
X7454 N_B11 N_TOP sky130_fd_pr__cap_mim_m3_1 l=3 w=3
X7455 P_B11 P_TOP sky130_fd_pr__cap_mim_m3_1 l=3 w=3
X7456 N_B9 N_TOP sky130_fd_pr__cap_mim_m3_1 l=3 w=3
X7457 P_B11 P_TOP sky130_fd_pr__cap_mim_m3_1 l=3 w=3
X7458 P_B9 P_TOP sky130_fd_pr__cap_mim_m3_1 l=3 w=3
X7459 P_B11 P_TOP sky130_fd_pr__cap_mim_m3_1 l=3 w=3
X7460 N_B10 N_TOP sky130_fd_pr__cap_mim_m3_1 l=3 w=3
X7461 P_B11 P_TOP sky130_fd_pr__cap_mim_m3_1 l=3 w=3
X7462 P_B7 P_TOP sky130_fd_pr__cap_mim_m3_1 l=3 w=3
X7463 P_B10 P_TOP sky130_fd_pr__cap_mim_m3_1 l=3 w=3
X7464 N_B10 N_TOP sky130_fd_pr__cap_mim_m3_1 l=3 w=3
X7465 P_B7 P_TOP sky130_fd_pr__cap_mim_m3_1 l=3 w=3
X7466 N_B11 N_TOP sky130_fd_pr__cap_mim_m3_1 l=3 w=3
X7467 P_B11 P_TOP sky130_fd_pr__cap_mim_m3_1 l=3 w=3
X7468 P_B10 P_TOP sky130_fd_pr__cap_mim_m3_1 l=3 w=3
X7469 N_B9 N_TOP sky130_fd_pr__cap_mim_m3_1 l=3 w=3
X7470 P_B11 P_TOP sky130_fd_pr__cap_mim_m3_1 l=3 w=3
X7471 N_B11 N_TOP sky130_fd_pr__cap_mim_m3_1 l=3 w=3
X7472 P_B9 P_TOP sky130_fd_pr__cap_mim_m3_1 l=3 w=3
X7473 N_B9 N_TOP sky130_fd_pr__cap_mim_m3_1 l=3 w=3
X7474 P_B9 P_TOP sky130_fd_pr__cap_mim_m3_1 l=3 w=3
X7475 N_B8 N_TOP sky130_fd_pr__cap_mim_m3_1 l=3 w=3
X7476 P_B8 P_TOP sky130_fd_pr__cap_mim_m3_1 l=3 w=3
X7477 N_EDGE_BIAS N_EDGE_BIAS sky130_fd_pr__cap_mim_m3_1 l=3 w=3
X7478 P_B10 P_TOP sky130_fd_pr__cap_mim_m3_1 l=3 w=3
X7479 N_B8 N_TOP sky130_fd_pr__cap_mim_m3_1 l=3 w=3
X7480 P_B8 P_TOP sky130_fd_pr__cap_mim_m3_1 l=3 w=3
X7481 N_B10 N_TOP sky130_fd_pr__cap_mim_m3_1 l=3 w=3
X7482 P_B10 P_TOP sky130_fd_pr__cap_mim_m3_1 l=3 w=3
X7483 N_B9 N_TOP sky130_fd_pr__cap_mim_m3_1 l=3 w=3
X7484 P_B11 P_TOP sky130_fd_pr__cap_mim_m3_1 l=3 w=3
X7485 N_B11 N_TOP sky130_fd_pr__cap_mim_m3_1 l=3 w=3
X7486 N_B11 N_TOP sky130_fd_pr__cap_mim_m3_1 l=3 w=3
X7487 P_B11 P_TOP sky130_fd_pr__cap_mim_m3_1 l=3 w=3
X7488 N_B7 N_TOP sky130_fd_pr__cap_mim_m3_1 l=3 w=3
X7489 N_B9 N_TOP sky130_fd_pr__cap_mim_m3_1 l=3 w=3
X7490 N_B11 N_TOP sky130_fd_pr__cap_mim_m3_1 l=3 w=3
X7491 P_B11 P_TOP sky130_fd_pr__cap_mim_m3_1 l=3 w=3
X7492 N_B11 N_TOP sky130_fd_pr__cap_mim_m3_1 l=3 w=3
X7493 N_B8 N_TOP sky130_fd_pr__cap_mim_m3_1 l=3 w=3
X7494 P_B8 P_TOP sky130_fd_pr__cap_mim_m3_1 l=3 w=3
X7495 N_B10 N_TOP sky130_fd_pr__cap_mim_m3_1 l=3 w=3
X7496 N_B11 N_TOP sky130_fd_pr__cap_mim_m3_1 l=3 w=3
X7497 P_B10 P_TOP sky130_fd_pr__cap_mim_m3_1 l=3 w=3
X7498 P_B11 P_TOP sky130_fd_pr__cap_mim_m3_1 l=3 w=3
X7499 N_B11 N_TOP sky130_fd_pr__cap_mim_m3_1 l=3 w=3
X7500 P_B11 P_TOP sky130_fd_pr__cap_mim_m3_1 l=3 w=3
X7501 N_B10 N_TOP sky130_fd_pr__cap_mim_m3_1 l=3 w=3
X7502 N_B8 N_TOP sky130_fd_pr__cap_mim_m3_1 l=3 w=3
X7503 P_B10 P_TOP sky130_fd_pr__cap_mim_m3_1 l=3 w=3
X7504 P_B11 P_TOP sky130_fd_pr__cap_mim_m3_1 l=3 w=3
X7505 N_B10 N_TOP sky130_fd_pr__cap_mim_m3_1 l=3 w=3
X7506 P_B11 P_TOP sky130_fd_pr__cap_mim_m3_1 l=3 w=3
X7507 P_B11 P_TOP sky130_fd_pr__cap_mim_m3_1 l=3 w=3
X7508 P_EDGE_BIAS P_EDGE_BIAS sky130_fd_pr__cap_mim_m3_1 l=3 w=3
X7509 N_B9 N_TOP sky130_fd_pr__cap_mim_m3_1 l=3 w=3
X7510 N_B11 N_TOP sky130_fd_pr__cap_mim_m3_1 l=3 w=3
X7511 N_B9 N_TOP sky130_fd_pr__cap_mim_m3_1 l=3 w=3
X7512 P_B11 P_TOP sky130_fd_pr__cap_mim_m3_1 l=3 w=3
X7513 N_B11 N_TOP sky130_fd_pr__cap_mim_m3_1 l=3 w=3
X7514 N_B10 N_TOP sky130_fd_pr__cap_mim_m3_1 l=3 w=3
X7515 N_B5 N_TOP sky130_fd_pr__cap_mim_m3_1 l=3 w=3
X7516 P_EDGE_BIAS P_EDGE_BIAS sky130_fd_pr__cap_mim_m3_1 l=3 w=3
X7517 P_B11 P_TOP sky130_fd_pr__cap_mim_m3_1 l=3 w=3
X7518 P_B11 P_TOP sky130_fd_pr__cap_mim_m3_1 l=3 w=3
X7519 N_B11 N_TOP sky130_fd_pr__cap_mim_m3_1 l=3 w=3
X7520 N_EDGE_BIAS N_EDGE_BIAS sky130_fd_pr__cap_mim_m3_1 l=3 w=3
X7521 P_B10 P_TOP sky130_fd_pr__cap_mim_m3_1 l=3 w=3
X7522 P_B10 P_TOP sky130_fd_pr__cap_mim_m3_1 l=3 w=3
X7523 N_B11 N_TOP sky130_fd_pr__cap_mim_m3_1 l=3 w=3
X7524 N_B11 N_TOP sky130_fd_pr__cap_mim_m3_1 l=3 w=3
X7525 N_EDGE_BIAS N_EDGE_BIAS sky130_fd_pr__cap_mim_m3_1 l=3 w=3
X7526 P_B7 P_TOP sky130_fd_pr__cap_mim_m3_1 l=3 w=3
X7527 N_B11 N_TOP sky130_fd_pr__cap_mim_m3_1 l=3 w=3
X7528 P_B11 P_TOP sky130_fd_pr__cap_mim_m3_1 l=3 w=3
X7529 P_B11 P_TOP sky130_fd_pr__cap_mim_m3_1 l=3 w=3
X7530 N_B11 N_TOP sky130_fd_pr__cap_mim_m3_1 l=3 w=3
X7531 N_B11 N_TOP sky130_fd_pr__cap_mim_m3_1 l=3 w=3
X7532 N_B9 N_TOP sky130_fd_pr__cap_mim_m3_1 l=3 w=3
X7533 N_B11 N_TOP sky130_fd_pr__cap_mim_m3_1 l=3 w=3
X7534 P_B11 P_TOP sky130_fd_pr__cap_mim_m3_1 l=3 w=3
X7535 N_B10 N_TOP sky130_fd_pr__cap_mim_m3_1 l=3 w=3
X7536 P_B10 P_TOP sky130_fd_pr__cap_mim_m3_1 l=3 w=3
X7537 N_EDGE_BIAS N_EDGE_BIAS sky130_fd_pr__cap_mim_m3_1 l=3 w=3
X7538 N_B10 N_TOP sky130_fd_pr__cap_mim_m3_1 l=3 w=3
X7539 P_B4 P_TOP sky130_fd_pr__cap_mim_m3_1 l=3 w=3
X7540 P_B11 P_TOP sky130_fd_pr__cap_mim_m3_1 l=3 w=3
X7541 N_B11 N_TOP sky130_fd_pr__cap_mim_m3_1 l=3 w=3
X7542 N_EDGE_BIAS N_EDGE_BIAS sky130_fd_pr__cap_mim_m3_1 l=3 w=3
X7543 N_B10 N_TOP sky130_fd_pr__cap_mim_m3_1 l=3 w=3
X7544 P_B10 P_TOP sky130_fd_pr__cap_mim_m3_1 l=3 w=3
X7545 N_B11 N_TOP sky130_fd_pr__cap_mim_m3_1 l=3 w=3
X7546 N_B9 N_TOP sky130_fd_pr__cap_mim_m3_1 l=3 w=3
X7547 P_B11 P_TOP sky130_fd_pr__cap_mim_m3_1 l=3 w=3
X7548 P_B9 P_TOP sky130_fd_pr__cap_mim_m3_1 l=3 w=3
X7549 P_B9 P_TOP sky130_fd_pr__cap_mim_m3_1 l=3 w=3
X7550 P_B11 P_TOP sky130_fd_pr__cap_mim_m3_1 l=3 w=3
X7551 N_B10 N_TOP sky130_fd_pr__cap_mim_m3_1 l=3 w=3
X7552 P_B9 P_TOP sky130_fd_pr__cap_mim_m3_1 l=3 w=3
X7553 N_B7 N_TOP sky130_fd_pr__cap_mim_m3_1 l=3 w=3
X7554 N_B10 N_TOP sky130_fd_pr__cap_mim_m3_1 l=3 w=3
X7555 N_B10 N_TOP sky130_fd_pr__cap_mim_m3_1 l=3 w=3
X7556 N_B10 N_TOP sky130_fd_pr__cap_mim_m3_1 l=3 w=3
X7557 P_B10 P_TOP sky130_fd_pr__cap_mim_m3_1 l=3 w=3
X7558 N_B11 N_TOP sky130_fd_pr__cap_mim_m3_1 l=3 w=3
X7559 P_B9 P_TOP sky130_fd_pr__cap_mim_m3_1 l=3 w=3
X7560 P_B11 P_TOP sky130_fd_pr__cap_mim_m3_1 l=3 w=3
X7561 N_B11 N_TOP sky130_fd_pr__cap_mim_m3_1 l=3 w=3
X7562 P_B11 P_TOP sky130_fd_pr__cap_mim_m3_1 l=3 w=3
X7563 N_B10 N_TOP sky130_fd_pr__cap_mim_m3_1 l=3 w=3
X7564 P_B10 P_TOP sky130_fd_pr__cap_mim_m3_1 l=3 w=3
X7565 P_B9 P_TOP sky130_fd_pr__cap_mim_m3_1 l=3 w=3
X7566 P_B11 P_TOP sky130_fd_pr__cap_mim_m3_1 l=3 w=3
X7567 N_B10 N_TOP sky130_fd_pr__cap_mim_m3_1 l=3 w=3
X7568 N_B11 N_TOP sky130_fd_pr__cap_mim_m3_1 l=3 w=3
X7569 N_B11 N_TOP sky130_fd_pr__cap_mim_m3_1 l=3 w=3
X7570 P_B11 P_TOP sky130_fd_pr__cap_mim_m3_1 l=3 w=3
X7571 N_B10 N_TOP sky130_fd_pr__cap_mim_m3_1 l=3 w=3
X7572 P_B11 P_TOP sky130_fd_pr__cap_mim_m3_1 l=3 w=3
X7573 P_B11 P_TOP sky130_fd_pr__cap_mim_m3_1 l=3 w=3
X7574 P_B9 P_TOP sky130_fd_pr__cap_mim_m3_1 l=3 w=3
X7575 P_B11 P_TOP sky130_fd_pr__cap_mim_m3_1 l=3 w=3
X7576 P_EDGE_BIAS P_EDGE_BIAS sky130_fd_pr__cap_mim_m3_1 l=3 w=3
X7577 P_B9 P_TOP sky130_fd_pr__cap_mim_m3_1 l=3 w=3
X7578 N_B11 N_TOP sky130_fd_pr__cap_mim_m3_1 l=3 w=3
X7579 P_B11 P_TOP sky130_fd_pr__cap_mim_m3_1 l=3 w=3
X7580 P_B10 P_TOP sky130_fd_pr__cap_mim_m3_1 l=3 w=3
X7581 P_B11 P_TOP sky130_fd_pr__cap_mim_m3_1 l=3 w=3
X7582 N_B11 N_TOP sky130_fd_pr__cap_mim_m3_1 l=3 w=3
X7583 P_B7 P_TOP sky130_fd_pr__cap_mim_m3_1 l=3 w=3
X7584 P_B10 P_TOP sky130_fd_pr__cap_mim_m3_1 l=3 w=3
X7585 N_B11 N_TOP sky130_fd_pr__cap_mim_m3_1 l=3 w=3
X7586 N_B11 N_TOP sky130_fd_pr__cap_mim_m3_1 l=3 w=3
X7587 N_B9 N_TOP sky130_fd_pr__cap_mim_m3_1 l=3 w=3
X7588 P_B9 P_TOP sky130_fd_pr__cap_mim_m3_1 l=3 w=3
X7589 N_B9 N_TOP sky130_fd_pr__cap_mim_m3_1 l=3 w=3
X7590 N_B11 N_TOP sky130_fd_pr__cap_mim_m3_1 l=3 w=3
X7591 P_B11 P_TOP sky130_fd_pr__cap_mim_m3_1 l=3 w=3
X7592 P_B9 P_TOP sky130_fd_pr__cap_mim_m3_1 l=3 w=3
X7593 P_B11 P_TOP sky130_fd_pr__cap_mim_m3_1 l=3 w=3
X7594 N_EDGE_BIAS N_EDGE_BIAS sky130_fd_pr__cap_mim_m3_1 l=3 w=3
X7595 N_B8 N_TOP sky130_fd_pr__cap_mim_m3_1 l=3 w=3
X7596 N_EDGE_BIAS N_EDGE_BIAS sky130_fd_pr__cap_mim_m3_1 l=3 w=3
X7597 P_B8 P_TOP sky130_fd_pr__cap_mim_m3_1 l=3 w=3
X7598 N_B10 N_TOP sky130_fd_pr__cap_mim_m3_1 l=3 w=3
X7599 P_B10 P_TOP sky130_fd_pr__cap_mim_m3_1 l=3 w=3
X7600 N_B11 N_TOP sky130_fd_pr__cap_mim_m3_1 l=3 w=3
X7601 N_B10 N_TOP sky130_fd_pr__cap_mim_m3_1 l=3 w=3
X7602 P_B11 P_TOP sky130_fd_pr__cap_mim_m3_1 l=3 w=3
X7603 P_B10 P_TOP sky130_fd_pr__cap_mim_m3_1 l=3 w=3
X7604 N_B9 N_TOP sky130_fd_pr__cap_mim_m3_1 l=3 w=3
X7605 P_B11 P_TOP sky130_fd_pr__cap_mim_m3_1 l=3 w=3
X7606 N_B7 N_TOP sky130_fd_pr__cap_mim_m3_1 l=3 w=3
X7607 N_B9 N_TOP sky130_fd_pr__cap_mim_m3_1 l=3 w=3
X7608 N_B11 N_TOP sky130_fd_pr__cap_mim_m3_1 l=3 w=3
X7609 N_B10 N_TOP sky130_fd_pr__cap_mim_m3_1 l=3 w=3
X7610 N_B11 N_TOP sky130_fd_pr__cap_mim_m3_1 l=3 w=3
X7611 P_B10 P_TOP sky130_fd_pr__cap_mim_m3_1 l=3 w=3
X7612 P_B11 P_TOP sky130_fd_pr__cap_mim_m3_1 l=3 w=3
X7613 N_B8 N_TOP sky130_fd_pr__cap_mim_m3_1 l=3 w=3
X7614 N_B10 N_TOP sky130_fd_pr__cap_mim_m3_1 l=3 w=3
X7615 P_B10 P_TOP sky130_fd_pr__cap_mim_m3_1 l=3 w=3
X7616 P_B11 P_TOP sky130_fd_pr__cap_mim_m3_1 l=3 w=3
X7617 P_EDGE_BIAS P_EDGE_BIAS sky130_fd_pr__cap_mim_m3_1 l=3 w=3
X7618 P_B10 P_TOP sky130_fd_pr__cap_mim_m3_1 l=3 w=3
X7619 N_B11 N_TOP sky130_fd_pr__cap_mim_m3_1 l=3 w=3
X7620 P_B11 P_TOP sky130_fd_pr__cap_mim_m3_1 l=3 w=3
X7621 N_B8 N_TOP sky130_fd_pr__cap_mim_m3_1 l=3 w=3
X7622 P_B11 P_TOP sky130_fd_pr__cap_mim_m3_1 l=3 w=3
X7623 N_B11 N_TOP sky130_fd_pr__cap_mim_m3_1 l=3 w=3
X7624 P_B11 P_TOP sky130_fd_pr__cap_mim_m3_1 l=3 w=3
X7625 N_B11 N_TOP sky130_fd_pr__cap_mim_m3_1 l=3 w=3
X7626 N_B11 N_TOP sky130_fd_pr__cap_mim_m3_1 l=3 w=3
X7627 N_B9 N_TOP sky130_fd_pr__cap_mim_m3_1 l=3 w=3
X7628 N_B11 N_TOP sky130_fd_pr__cap_mim_m3_1 l=3 w=3
X7629 N_B9 N_TOP sky130_fd_pr__cap_mim_m3_1 l=3 w=3
X7630 P_B11 P_TOP sky130_fd_pr__cap_mim_m3_1 l=3 w=3
X7631 N_B11 N_TOP sky130_fd_pr__cap_mim_m3_1 l=3 w=3
X7632 N_B11 N_TOP sky130_fd_pr__cap_mim_m3_1 l=3 w=3
X7633 N_B6 N_TOP sky130_fd_pr__cap_mim_m3_1 l=3 w=3
X7634 P_B11 P_TOP sky130_fd_pr__cap_mim_m3_1 l=3 w=3
X7635 N_B11 N_TOP sky130_fd_pr__cap_mim_m3_1 l=3 w=3
X7636 P_B10 P_TOP sky130_fd_pr__cap_mim_m3_1 l=3 w=3
X7637 P_B11 P_TOP sky130_fd_pr__cap_mim_m3_1 l=3 w=3
X7638 N_EDGE_BIAS N_EDGE_BIAS sky130_fd_pr__cap_mim_m3_1 l=3 w=3
X7639 N_B11 N_TOP sky130_fd_pr__cap_mim_m3_1 l=3 w=3
X7640 P_B10 P_TOP sky130_fd_pr__cap_mim_m3_1 l=3 w=3
X7641 N_B10 N_TOP sky130_fd_pr__cap_mim_m3_1 l=3 w=3
X7642 P_B9 P_TOP sky130_fd_pr__cap_mim_m3_1 l=3 w=3
X7643 P_B11 P_TOP sky130_fd_pr__cap_mim_m3_1 l=3 w=3
X7644 N_B11 N_TOP sky130_fd_pr__cap_mim_m3_1 l=3 w=3
X7645 P_B11 P_TOP sky130_fd_pr__cap_mim_m3_1 l=3 w=3
X7646 P_B11 P_TOP sky130_fd_pr__cap_mim_m3_1 l=3 w=3
X7647 P_B11 P_TOP sky130_fd_pr__cap_mim_m3_1 l=3 w=3
X7648 P_B7 P_TOP sky130_fd_pr__cap_mim_m3_1 l=3 w=3
X7649 N_EDGE_BIAS N_EDGE_BIAS sky130_fd_pr__cap_mim_m3_1 l=3 w=3
X7650 P_B11 P_TOP sky130_fd_pr__cap_mim_m3_1 l=3 w=3
X7651 N_B11 N_TOP sky130_fd_pr__cap_mim_m3_1 l=3 w=3
X7652 N_B9 N_TOP sky130_fd_pr__cap_mim_m3_1 l=3 w=3
X7653 P_B10 P_TOP sky130_fd_pr__cap_mim_m3_1 l=3 w=3
X7654 N_B10 N_TOP sky130_fd_pr__cap_mim_m3_1 l=3 w=3
X7655 P_B10 P_TOP sky130_fd_pr__cap_mim_m3_1 l=3 w=3
X7656 P_B10 P_TOP sky130_fd_pr__cap_mim_m3_1 l=3 w=3
X7657 P_B11 P_TOP sky130_fd_pr__cap_mim_m3_1 l=3 w=3
X7658 P_B8 P_TOP sky130_fd_pr__cap_mim_m3_1 l=3 w=3
X7659 N_B11 N_TOP sky130_fd_pr__cap_mim_m3_1 l=3 w=3
X7660 P_B11 P_TOP sky130_fd_pr__cap_mim_m3_1 l=3 w=3
X7661 P_B10 P_TOP sky130_fd_pr__cap_mim_m3_1 l=3 w=3
X7662 N_B4 N_TOP sky130_fd_pr__cap_mim_m3_1 l=3 w=3
X7663 P_B11 P_TOP sky130_fd_pr__cap_mim_m3_1 l=3 w=3
X7664 P_B5 P_TOP sky130_fd_pr__cap_mim_m3_1 l=3 w=3
X7665 N_B11 N_TOP sky130_fd_pr__cap_mim_m3_1 l=3 w=3
X7666 N_B11 N_TOP sky130_fd_pr__cap_mim_m3_1 l=3 w=3
X7667 N_B11 N_TOP sky130_fd_pr__cap_mim_m3_1 l=3 w=3
X7668 N_B11 N_TOP sky130_fd_pr__cap_mim_m3_1 l=3 w=3
X7669 N_B9 N_TOP sky130_fd_pr__cap_mim_m3_1 l=3 w=3
X7670 P_B11 P_TOP sky130_fd_pr__cap_mim_m3_1 l=3 w=3
X7671 P_B9 P_TOP sky130_fd_pr__cap_mim_m3_1 l=3 w=3
X7672 P_B10 P_TOP sky130_fd_pr__cap_mim_m3_1 l=3 w=3
X7673 N_B10 N_TOP sky130_fd_pr__cap_mim_m3_1 l=3 w=3
X7674 N_B11 N_TOP sky130_fd_pr__cap_mim_m3_1 l=3 w=3
X7675 N_B7 N_TOP sky130_fd_pr__cap_mim_m3_1 l=3 w=3
X7676 N_B10 N_TOP sky130_fd_pr__cap_mim_m3_1 l=3 w=3
X7677 P_EDGE_BIAS P_EDGE_BIAS sky130_fd_pr__cap_mim_m3_1 l=3 w=3
X7678 N_B10 N_TOP sky130_fd_pr__cap_mim_m3_1 l=3 w=3
X7679 N_B9 N_TOP sky130_fd_pr__cap_mim_m3_1 l=3 w=3
X7680 P_B11 P_TOP sky130_fd_pr__cap_mim_m3_1 l=3 w=3
X7681 P_EDGE_BIAS P_EDGE_BIAS sky130_fd_pr__cap_mim_m3_1 l=3 w=3
X7682 P_B11 P_TOP sky130_fd_pr__cap_mim_m3_1 l=3 w=3
X7683 P_B11 P_TOP sky130_fd_pr__cap_mim_m3_1 l=3 w=3
X7684 N_B11 N_TOP sky130_fd_pr__cap_mim_m3_1 l=3 w=3
X7685 N_B10 N_TOP sky130_fd_pr__cap_mim_m3_1 l=3 w=3
X7686 N_B10 N_TOP sky130_fd_pr__cap_mim_m3_1 l=3 w=3
X7687 P_B9 P_TOP sky130_fd_pr__cap_mim_m3_1 l=3 w=3
X7688 P_EDGE_BIAS P_EDGE_BIAS sky130_fd_pr__cap_mim_m3_1 l=3 w=3
X7689 P_B11 P_TOP sky130_fd_pr__cap_mim_m3_1 l=3 w=3
X7690 N_B10 N_TOP sky130_fd_pr__cap_mim_m3_1 l=3 w=3
X7691 N_B11 N_TOP sky130_fd_pr__cap_mim_m3_1 l=3 w=3
X7692 P_B11 P_TOP sky130_fd_pr__cap_mim_m3_1 l=3 w=3
X7693 N_B11 N_TOP sky130_fd_pr__cap_mim_m3_1 l=3 w=3
X7694 N_B11 N_TOP sky130_fd_pr__cap_mim_m3_1 l=3 w=3
X7695 P_B10 P_TOP sky130_fd_pr__cap_mim_m3_1 l=3 w=3
X7696 P_B11 P_TOP sky130_fd_pr__cap_mim_m3_1 l=3 w=3
X7697 N_B10 N_TOP sky130_fd_pr__cap_mim_m3_1 l=3 w=3
X7698 P_B11 P_TOP sky130_fd_pr__cap_mim_m3_1 l=3 w=3
X7699 N_B11 N_TOP sky130_fd_pr__cap_mim_m3_1 l=3 w=3
X7700 N_B11 N_TOP sky130_fd_pr__cap_mim_m3_1 l=3 w=3
X7701 P_B9 P_TOP sky130_fd_pr__cap_mim_m3_1 l=3 w=3
X7702 P_B11 P_TOP sky130_fd_pr__cap_mim_m3_1 l=3 w=3
X7703 P_B11 P_TOP sky130_fd_pr__cap_mim_m3_1 l=3 w=3
X7704 N_B11 N_TOP sky130_fd_pr__cap_mim_m3_1 l=3 w=3
X7705 N_EDGE_BIAS N_EDGE_BIAS sky130_fd_pr__cap_mim_m3_1 l=3 w=3
X7706 P_B9 P_TOP sky130_fd_pr__cap_mim_m3_1 l=3 w=3
X7707 N_B10 N_TOP sky130_fd_pr__cap_mim_m3_1 l=3 w=3
X7708 N_B11 N_TOP sky130_fd_pr__cap_mim_m3_1 l=3 w=3
X7709 N_B11 N_TOP sky130_fd_pr__cap_mim_m3_1 l=3 w=3
X7710 P_B10 P_TOP sky130_fd_pr__cap_mim_m3_1 l=3 w=3
X7711 N_B11 N_TOP sky130_fd_pr__cap_mim_m3_1 l=3 w=3
X7712 N_B10 N_TOP sky130_fd_pr__cap_mim_m3_1 l=3 w=3
X7713 P_B9 P_TOP sky130_fd_pr__cap_mim_m3_1 l=3 w=3
X7714 P_B7 P_TOP sky130_fd_pr__cap_mim_m3_1 l=3 w=3
X7715 P_B11 P_TOP sky130_fd_pr__cap_mim_m3_1 l=3 w=3
X7716 N_B11 N_TOP sky130_fd_pr__cap_mim_m3_1 l=3 w=3
X7717 P_B11 P_TOP sky130_fd_pr__cap_mim_m3_1 l=3 w=3
X7718 N_B9 N_TOP sky130_fd_pr__cap_mim_m3_1 l=3 w=3
X7719 P_B9 P_TOP sky130_fd_pr__cap_mim_m3_1 l=3 w=3
X7720 P_B8 P_TOP sky130_fd_pr__cap_mim_m3_1 l=3 w=3
X7721 N_B9 N_TOP sky130_fd_pr__cap_mim_m3_1 l=3 w=3
X7722 P_B9 P_TOP sky130_fd_pr__cap_mim_m3_1 l=3 w=3
X7723 N_B11 N_TOP sky130_fd_pr__cap_mim_m3_1 l=3 w=3
X7724 N_B11 N_TOP sky130_fd_pr__cap_mim_m3_1 l=3 w=3
X7725 P_B11 P_TOP sky130_fd_pr__cap_mim_m3_1 l=3 w=3
X7726 P_B11 P_TOP sky130_fd_pr__cap_mim_m3_1 l=3 w=3
X7727 P_B10 P_TOP sky130_fd_pr__cap_mim_m3_1 l=3 w=3
X7728 N_B8 N_TOP sky130_fd_pr__cap_mim_m3_1 l=3 w=3
X7729 P_B8 P_TOP sky130_fd_pr__cap_mim_m3_1 l=3 w=3
X7730 N_B10 N_TOP sky130_fd_pr__cap_mim_m3_1 l=3 w=3
X7731 P_B10 P_TOP sky130_fd_pr__cap_mim_m3_1 l=3 w=3
X7732 P_B11 P_TOP sky130_fd_pr__cap_mim_m3_1 l=3 w=3
X7733 P_B11 P_TOP sky130_fd_pr__cap_mim_m3_1 l=3 w=3
X7734 P_B11 P_TOP sky130_fd_pr__cap_mim_m3_1 l=3 w=3
X7735 P_B11 P_TOP sky130_fd_pr__cap_mim_m3_1 l=3 w=3
X7736 N_B11 N_TOP sky130_fd_pr__cap_mim_m3_1 l=3 w=3
X7737 N_B9 N_TOP sky130_fd_pr__cap_mim_m3_1 l=3 w=3
X7738 P_B9 P_TOP sky130_fd_pr__cap_mim_m3_1 l=3 w=3
X7739 N_B11 N_TOP sky130_fd_pr__cap_mim_m3_1 l=3 w=3
X7740 N_B7 N_TOP sky130_fd_pr__cap_mim_m3_1 l=3 w=3
X7741 N_B8 N_TOP sky130_fd_pr__cap_mim_m3_1 l=3 w=3
X7742 P_B8 P_TOP sky130_fd_pr__cap_mim_m3_1 l=3 w=3
X7743 N_B10 N_TOP sky130_fd_pr__cap_mim_m3_1 l=3 w=3
X7744 P_B10 P_TOP sky130_fd_pr__cap_mim_m3_1 l=3 w=3
X7745 N_B11 N_TOP sky130_fd_pr__cap_mim_m3_1 l=3 w=3
X7746 P_B11 P_TOP sky130_fd_pr__cap_mim_m3_1 l=3 w=3
X7747 P_EDGE_BIAS P_EDGE_BIAS sky130_fd_pr__cap_mim_m3_1 l=3 w=3
X7748 P_B11 P_TOP sky130_fd_pr__cap_mim_m3_1 l=3 w=3
X7749 N_B8 N_TOP sky130_fd_pr__cap_mim_m3_1 l=3 w=3
X7750 P_B10 P_TOP sky130_fd_pr__cap_mim_m3_1 l=3 w=3
X7751 N_B11 N_TOP sky130_fd_pr__cap_mim_m3_1 l=3 w=3
X7752 N_B11 N_TOP sky130_fd_pr__cap_mim_m3_1 l=3 w=3
X7753 N_B6 N_TOP sky130_fd_pr__cap_mim_m3_1 l=3 w=3
X7754 P_B8 P_TOP sky130_fd_pr__cap_mim_m3_1 l=3 w=3
X7755 P_EDGE_BIAS P_EDGE_BIAS sky130_fd_pr__cap_mim_m3_1 l=3 w=3
X7756 N_B9 N_TOP sky130_fd_pr__cap_mim_m3_1 l=3 w=3
X7757 P_B11 P_TOP sky130_fd_pr__cap_mim_m3_1 l=3 w=3
X7758 N_B11 N_TOP sky130_fd_pr__cap_mim_m3_1 l=3 w=3
X7759 N_B9 N_TOP sky130_fd_pr__cap_mim_m3_1 l=3 w=3
X7760 N_B11 N_TOP sky130_fd_pr__cap_mim_m3_1 l=3 w=3
X7761 N_B9 N_TOP sky130_fd_pr__cap_mim_m3_1 l=3 w=3
X7762 P_B11 P_TOP sky130_fd_pr__cap_mim_m3_1 l=3 w=3
X7763 N_B9 N_TOP sky130_fd_pr__cap_mim_m3_1 l=3 w=3
X7764 P_B8 P_TOP sky130_fd_pr__cap_mim_m3_1 l=3 w=3
X7765 P_B11 P_TOP sky130_fd_pr__cap_mim_m3_1 l=3 w=3
X7766 P_B11 P_TOP sky130_fd_pr__cap_mim_m3_1 l=3 w=3
X7767 N_B11 N_TOP sky130_fd_pr__cap_mim_m3_1 l=3 w=3
X7768 P_B11 P_TOP sky130_fd_pr__cap_mim_m3_1 l=3 w=3
X7769 N_B6 N_TOP sky130_fd_pr__cap_mim_m3_1 l=3 w=3
X7770 N_EDGE_BIAS N_EDGE_BIAS sky130_fd_pr__cap_mim_m3_1 l=3 w=3
X7771 P_B10 P_TOP sky130_fd_pr__cap_mim_m3_1 l=3 w=3
X7772 N_EDGE_BIAS N_EDGE_BIAS sky130_fd_pr__cap_mim_m3_1 l=3 w=3
X7773 N_B11 N_TOP sky130_fd_pr__cap_mim_m3_1 l=3 w=3
X7774 N_B11 N_TOP sky130_fd_pr__cap_mim_m3_1 l=3 w=3
X7775 N_B9 N_TOP sky130_fd_pr__cap_mim_m3_1 l=3 w=3
X7776 P_EDGE_BIAS P_EDGE_BIAS sky130_fd_pr__cap_mim_m3_1 l=3 w=3
X7777 N_B10 N_TOP sky130_fd_pr__cap_mim_m3_1 l=3 w=3
X7778 P_B7 P_TOP sky130_fd_pr__cap_mim_m3_1 l=3 w=3
X7779 N_B11 N_TOP sky130_fd_pr__cap_mim_m3_1 l=3 w=3
X7780 P_B11 P_TOP sky130_fd_pr__cap_mim_m3_1 l=3 w=3
X7781 P_B11 P_TOP sky130_fd_pr__cap_mim_m3_1 l=3 w=3
X7782 N_B11 N_TOP sky130_fd_pr__cap_mim_m3_1 l=3 w=3
X7783 P_B11 P_TOP sky130_fd_pr__cap_mim_m3_1 l=3 w=3
X7784 N_B9 N_TOP sky130_fd_pr__cap_mim_m3_1 l=3 w=3
X7785 N_B11 N_TOP sky130_fd_pr__cap_mim_m3_1 l=3 w=3
X7786 P_B9 P_TOP sky130_fd_pr__cap_mim_m3_1 l=3 w=3
X7787 P_B10 P_TOP sky130_fd_pr__cap_mim_m3_1 l=3 w=3
X7788 N_B10 N_TOP sky130_fd_pr__cap_mim_m3_1 l=3 w=3
X7789 P_B10 P_TOP sky130_fd_pr__cap_mim_m3_1 l=3 w=3
X7790 N_B11 N_TOP sky130_fd_pr__cap_mim_m3_1 l=3 w=3
X7791 P_B4 P_TOP sky130_fd_pr__cap_mim_m3_1 l=3 w=3
X7792 P_B8 P_TOP sky130_fd_pr__cap_mim_m3_1 l=3 w=3
X7793 P_B11 P_TOP sky130_fd_pr__cap_mim_m3_1 l=3 w=3
X7794 N_B10 N_TOP sky130_fd_pr__cap_mim_m3_1 l=3 w=3
X7795 P_B10 P_TOP sky130_fd_pr__cap_mim_m3_1 l=3 w=3
X7796 N_EDGE_BIAS N_EDGE_BIAS sky130_fd_pr__cap_mim_m3_1 l=3 w=3
X7797 P_B6 P_TOP sky130_fd_pr__cap_mim_m3_1 l=3 w=3
X7798 N_B9 N_TOP sky130_fd_pr__cap_mim_m3_1 l=3 w=3
X7799 N_B11 N_TOP sky130_fd_pr__cap_mim_m3_1 l=3 w=3
X7800 N_B11 N_TOP sky130_fd_pr__cap_mim_m3_1 l=3 w=3
X7801 P_B11 P_TOP sky130_fd_pr__cap_mim_m3_1 l=3 w=3
X7802 P_B9 P_TOP sky130_fd_pr__cap_mim_m3_1 l=3 w=3
X7803 N_B10 N_TOP sky130_fd_pr__cap_mim_m3_1 l=3 w=3
X7804 N_B10 N_TOP sky130_fd_pr__cap_mim_m3_1 l=3 w=3
X7805 N_B7 N_TOP sky130_fd_pr__cap_mim_m3_1 l=3 w=3
X7806 N_B10 N_TOP sky130_fd_pr__cap_mim_m3_1 l=3 w=3
X7807 N_B10 N_TOP sky130_fd_pr__cap_mim_m3_1 l=3 w=3
X7808 P_B10 P_TOP sky130_fd_pr__cap_mim_m3_1 l=3 w=3
X7809 P_EDGE_BIAS P_EDGE_BIAS sky130_fd_pr__cap_mim_m3_1 l=3 w=3
X7810 P_B11 P_TOP sky130_fd_pr__cap_mim_m3_1 l=3 w=3
X7811 N_B9 N_TOP sky130_fd_pr__cap_mim_m3_1 l=3 w=3
X7812 P_B10 P_TOP sky130_fd_pr__cap_mim_m3_1 l=3 w=3
X7813 N_B8 N_TOP sky130_fd_pr__cap_mim_m3_1 l=3 w=3
X7814 P_B11 P_TOP sky130_fd_pr__cap_mim_m3_1 l=3 w=3
X7815 N_B10 N_TOP sky130_fd_pr__cap_mim_m3_1 l=3 w=3
X7816 N_B10 N_TOP sky130_fd_pr__cap_mim_m3_1 l=3 w=3
X7817 P_EDGE_BIAS P_EDGE_BIAS sky130_fd_pr__cap_mim_m3_1 l=3 w=3
X7818 P_B11 P_TOP sky130_fd_pr__cap_mim_m3_1 l=3 w=3
X7819 N_B11 N_TOP sky130_fd_pr__cap_mim_m3_1 l=3 w=3
X7820 N_B10 N_TOP sky130_fd_pr__cap_mim_m3_1 l=3 w=3
X7821 P_B11 P_TOP sky130_fd_pr__cap_mim_m3_1 l=3 w=3
X7822 N_B11 N_TOP sky130_fd_pr__cap_mim_m3_1 l=3 w=3
X7823 N_B11 N_TOP sky130_fd_pr__cap_mim_m3_1 l=3 w=3
X7824 P_B11 P_TOP sky130_fd_pr__cap_mim_m3_1 l=3 w=3
X7825 P_B11 P_TOP sky130_fd_pr__cap_mim_m3_1 l=3 w=3
X7826 P_B11 P_TOP sky130_fd_pr__cap_mim_m3_1 l=3 w=3
X7827 N_B10 N_TOP sky130_fd_pr__cap_mim_m3_1 l=3 w=3
X7828 N_B10 N_TOP sky130_fd_pr__cap_mim_m3_1 l=3 w=3
X7829 P_B11 P_TOP sky130_fd_pr__cap_mim_m3_1 l=3 w=3
X7830 P_B10 P_TOP sky130_fd_pr__cap_mim_m3_1 l=3 w=3
X7831 P_B9 P_TOP sky130_fd_pr__cap_mim_m3_1 l=3 w=3
X7832 P_B11 P_TOP sky130_fd_pr__cap_mim_m3_1 l=3 w=3
X7833 N_B10 N_TOP sky130_fd_pr__cap_mim_m3_1 l=3 w=3
X7834 N_B11 N_TOP sky130_fd_pr__cap_mim_m3_1 l=3 w=3
X7835 N_B10 N_TOP sky130_fd_pr__cap_mim_m3_1 l=3 w=3
X7836 P_B7 P_TOP sky130_fd_pr__cap_mim_m3_1 l=3 w=3
X7837 N_B11 N_TOP sky130_fd_pr__cap_mim_m3_1 l=3 w=3
X7838 P_B10 P_TOP sky130_fd_pr__cap_mim_m3_1 l=3 w=3
X7839 N_B10 N_TOP sky130_fd_pr__cap_mim_m3_1 l=3 w=3
X7840 N_B11 N_TOP sky130_fd_pr__cap_mim_m3_1 l=3 w=3
X7841 P_B11 P_TOP sky130_fd_pr__cap_mim_m3_1 l=3 w=3
X7842 N_B11 N_TOP sky130_fd_pr__cap_mim_m3_1 l=3 w=3
X7843 P_B9 P_TOP sky130_fd_pr__cap_mim_m3_1 l=3 w=3
X7844 P_B11 P_TOP sky130_fd_pr__cap_mim_m3_1 l=3 w=3
X7845 N_B9 N_TOP sky130_fd_pr__cap_mim_m3_1 l=3 w=3
X7846 P_B9 P_TOP sky130_fd_pr__cap_mim_m3_1 l=3 w=3
X7847 N_B8 N_TOP sky130_fd_pr__cap_mim_m3_1 l=3 w=3
X7848 P_EDGE_BIAS P_EDGE_BIAS sky130_fd_pr__cap_mim_m3_1 l=3 w=3
X7849 P_B8 P_TOP sky130_fd_pr__cap_mim_m3_1 l=3 w=3
X7850 N_B11 N_TOP sky130_fd_pr__cap_mim_m3_1 l=3 w=3
X7851 N_B11 N_TOP sky130_fd_pr__cap_mim_m3_1 l=3 w=3
X7852 P_B8 P_TOP sky130_fd_pr__cap_mim_m3_1 l=3 w=3
X7853 P_B10 P_TOP sky130_fd_pr__cap_mim_m3_1 l=3 w=3
X7854 P_EDGE_BIAS P_EDGE_BIAS sky130_fd_pr__cap_mim_m3_1 l=3 w=3
X7855 P_B8 P_TOP sky130_fd_pr__cap_mim_m3_1 l=3 w=3
X7856 N_B10 N_TOP sky130_fd_pr__cap_mim_m3_1 l=3 w=3
X7857 N_B11 N_TOP sky130_fd_pr__cap_mim_m3_1 l=3 w=3
X7858 N_B11 N_TOP sky130_fd_pr__cap_mim_m3_1 l=3 w=3
X7859 N_B11 N_TOP sky130_fd_pr__cap_mim_m3_1 l=3 w=3
X7860 P_B11 P_TOP sky130_fd_pr__cap_mim_m3_1 l=3 w=3
X7861 N_B7 N_TOP sky130_fd_pr__cap_mim_m3_1 l=3 w=3
X7862 N_B9 N_TOP sky130_fd_pr__cap_mim_m3_1 l=3 w=3
X7863 P_B11 P_TOP sky130_fd_pr__cap_mim_m3_1 l=3 w=3
X7864 N_B11 N_TOP sky130_fd_pr__cap_mim_m3_1 l=3 w=3
X7865 N_B11 N_TOP sky130_fd_pr__cap_mim_m3_1 l=3 w=3
X7866 N_B7 N_TOP sky130_fd_pr__cap_mim_m3_1 l=3 w=3
X7867 N_B11 N_TOP sky130_fd_pr__cap_mim_m3_1 l=3 w=3
X7868 P_B11 P_TOP sky130_fd_pr__cap_mim_m3_1 l=3 w=3
X7869 N_B8 N_TOP sky130_fd_pr__cap_mim_m3_1 l=3 w=3
X7870 P_B8 P_TOP sky130_fd_pr__cap_mim_m3_1 l=3 w=3
X7871 N_B10 N_TOP sky130_fd_pr__cap_mim_m3_1 l=3 w=3
X7872 P_B10 P_TOP sky130_fd_pr__cap_mim_m3_1 l=3 w=3
X7873 P_B11 P_TOP sky130_fd_pr__cap_mim_m3_1 l=3 w=3
X7874 P_B11 P_TOP sky130_fd_pr__cap_mim_m3_1 l=3 w=3
X7875 N_B8 N_TOP sky130_fd_pr__cap_mim_m3_1 l=3 w=3
X7876 P_B11 P_TOP sky130_fd_pr__cap_mim_m3_1 l=3 w=3
X7877 N_B11 N_TOP sky130_fd_pr__cap_mim_m3_1 l=3 w=3
X7878 N_B10 N_TOP sky130_fd_pr__cap_mim_m3_1 l=3 w=3
X7879 N_B6 N_TOP sky130_fd_pr__cap_mim_m3_1 l=3 w=3
X7880 N_B11 N_TOP sky130_fd_pr__cap_mim_m3_1 l=3 w=3
X7881 N_B11 N_TOP sky130_fd_pr__cap_mim_m3_1 l=3 w=3
X7882 N_B9 N_TOP sky130_fd_pr__cap_mim_m3_1 l=3 w=3
X7883 P_B11 P_TOP sky130_fd_pr__cap_mim_m3_1 l=3 w=3
X7884 N_B11 N_TOP sky130_fd_pr__cap_mim_m3_1 l=3 w=3
X7885 N_B9 N_TOP sky130_fd_pr__cap_mim_m3_1 l=3 w=3
X7886 P_B9 P_TOP sky130_fd_pr__cap_mim_m3_1 l=3 w=3
X7887 P_B11 P_TOP sky130_fd_pr__cap_mim_m3_1 l=3 w=3
X7888 P_B6 P_TOP sky130_fd_pr__cap_mim_m3_1 l=3 w=3
X7889 P_B11 P_TOP sky130_fd_pr__cap_mim_m3_1 l=3 w=3
X7890 P_B11 P_TOP sky130_fd_pr__cap_mim_m3_1 l=3 w=3
X7891 N_B11 N_TOP sky130_fd_pr__cap_mim_m3_1 l=3 w=3
X7892 P_B11 P_TOP sky130_fd_pr__cap_mim_m3_1 l=3 w=3
X7893 P_B11 P_TOP sky130_fd_pr__cap_mim_m3_1 l=3 w=3
X7894 P_B10 P_TOP sky130_fd_pr__cap_mim_m3_1 l=3 w=3
X7895 N_B11 N_TOP sky130_fd_pr__cap_mim_m3_1 l=3 w=3
X7896 N_B11 N_TOP sky130_fd_pr__cap_mim_m3_1 l=3 w=3
X7897 N_B11 N_TOP sky130_fd_pr__cap_mim_m3_1 l=3 w=3
X7898 P_B7 P_TOP sky130_fd_pr__cap_mim_m3_1 l=3 w=3
X7899 N_B11 N_TOP sky130_fd_pr__cap_mim_m3_1 l=3 w=3
X7900 P_B11 P_TOP sky130_fd_pr__cap_mim_m3_1 l=3 w=3
X7901 P_B11 P_TOP sky130_fd_pr__cap_mim_m3_1 l=3 w=3
X7902 N_B11 N_TOP sky130_fd_pr__cap_mim_m3_1 l=3 w=3
X7903 N_B9 N_TOP sky130_fd_pr__cap_mim_m3_1 l=3 w=3
X7904 N_B9 N_TOP sky130_fd_pr__cap_mim_m3_1 l=3 w=3
X7905 N_B10 N_TOP sky130_fd_pr__cap_mim_m3_1 l=3 w=3
X7906 P_B11 P_TOP sky130_fd_pr__cap_mim_m3_1 l=3 w=3
X7907 P_B10 P_TOP sky130_fd_pr__cap_mim_m3_1 l=3 w=3
X7908 N_B10 N_TOP sky130_fd_pr__cap_mim_m3_1 l=3 w=3
X7909 N_B11 N_TOP sky130_fd_pr__cap_mim_m3_1 l=3 w=3
X7910 P_B10 P_TOP sky130_fd_pr__cap_mim_m3_1 l=3 w=3
X7911 P_B10 P_TOP sky130_fd_pr__cap_mim_m3_1 l=3 w=3
X7912 P_B11 P_TOP sky130_fd_pr__cap_mim_m3_1 l=3 w=3
X7913 P_B5 P_TOP sky130_fd_pr__cap_mim_m3_1 l=3 w=3
X7914 P_B11 P_TOP sky130_fd_pr__cap_mim_m3_1 l=3 w=3
X7915 N_B10 N_TOP sky130_fd_pr__cap_mim_m3_1 l=3 w=3
X7916 P_B10 P_TOP sky130_fd_pr__cap_mim_m3_1 l=3 w=3
X7917 N_B11 N_TOP sky130_fd_pr__cap_mim_m3_1 l=3 w=3
X7918 N_B9 N_TOP sky130_fd_pr__cap_mim_m3_1 l=3 w=3
X7919 N_B10 N_TOP sky130_fd_pr__cap_mim_m3_1 l=3 w=3
X7920 P_B10 P_TOP sky130_fd_pr__cap_mim_m3_1 l=3 w=3
X7921 P_B9 P_TOP sky130_fd_pr__cap_mim_m3_1 l=3 w=3
X7922 N_B7 N_TOP sky130_fd_pr__cap_mim_m3_1 l=3 w=3
X7923 N_B10 N_TOP sky130_fd_pr__cap_mim_m3_1 l=3 w=3
X7924 P_B10 P_TOP sky130_fd_pr__cap_mim_m3_1 l=3 w=3
X7925 N_B7 N_TOP sky130_fd_pr__cap_mim_m3_1 l=3 w=3
X7926 P_EDGE_BIAS P_EDGE_BIAS sky130_fd_pr__cap_mim_m3_1 l=3 w=3
X7927 N_B10 N_TOP sky130_fd_pr__cap_mim_m3_1 l=3 w=3
X7928 P_B10 P_TOP sky130_fd_pr__cap_mim_m3_1 l=3 w=3
X7929 P_EDGE_BIAS P_EDGE_BIAS sky130_fd_pr__cap_mim_m3_1 l=3 w=3
X7930 N_B11 N_TOP sky130_fd_pr__cap_mim_m3_1 l=3 w=3
X7931 P_B11 P_TOP sky130_fd_pr__cap_mim_m3_1 l=3 w=3
X7932 N_B11 N_TOP sky130_fd_pr__cap_mim_m3_1 l=3 w=3
X7933 P_B11 P_TOP sky130_fd_pr__cap_mim_m3_1 l=3 w=3
X7934 P_B11 P_TOP sky130_fd_pr__cap_mim_m3_1 l=3 w=3
X7935 P_B10 P_TOP sky130_fd_pr__cap_mim_m3_1 l=3 w=3
X7936 N_B11 N_TOP sky130_fd_pr__cap_mim_m3_1 l=3 w=3
X7937 N_B10 N_TOP sky130_fd_pr__cap_mim_m3_1 l=3 w=3
X7938 N_B11 N_TOP sky130_fd_pr__cap_mim_m3_1 l=3 w=3
X7939 N_B8 N_TOP sky130_fd_pr__cap_mim_m3_1 l=3 w=3
X7940 P_B11 P_TOP sky130_fd_pr__cap_mim_m3_1 l=3 w=3
X7941 N_B10 N_TOP sky130_fd_pr__cap_mim_m3_1 l=3 w=3
X7942 N_B10 N_TOP sky130_fd_pr__cap_mim_m3_1 l=3 w=3
X7943 P_B11 P_TOP sky130_fd_pr__cap_mim_m3_1 l=3 w=3
X7944 N_B11 N_TOP sky130_fd_pr__cap_mim_m3_1 l=3 w=3
X7945 N_B11 N_TOP sky130_fd_pr__cap_mim_m3_1 l=3 w=3
X7946 P_B11 P_TOP sky130_fd_pr__cap_mim_m3_1 l=3 w=3
X7947 P_B11 P_TOP sky130_fd_pr__cap_mim_m3_1 l=3 w=3
X7948 P_B10 P_TOP sky130_fd_pr__cap_mim_m3_1 l=3 w=3
X7949 P_B11 P_TOP sky130_fd_pr__cap_mim_m3_1 l=3 w=3
X7950 P_B11 P_TOP sky130_fd_pr__cap_mim_m3_1 l=3 w=3
X7951 N_B11 N_TOP sky130_fd_pr__cap_mim_m3_1 l=3 w=3
X7952 N_B8 N_TOP sky130_fd_pr__cap_mim_m3_1 l=3 w=3
X7953 P_B11 P_TOP sky130_fd_pr__cap_mim_m3_1 l=3 w=3
X7954 N_B10 N_TOP sky130_fd_pr__cap_mim_m3_1 l=3 w=3
X7955 P_B11 P_TOP sky130_fd_pr__cap_mim_m3_1 l=3 w=3
X7956 P_B9 P_TOP sky130_fd_pr__cap_mim_m3_1 l=3 w=3
X7957 N_B11 N_TOP sky130_fd_pr__cap_mim_m3_1 l=3 w=3
X7958 P_B11 P_TOP sky130_fd_pr__cap_mim_m3_1 l=3 w=3
X7959 N_B11 N_TOP sky130_fd_pr__cap_mim_m3_1 l=3 w=3
X7960 N_B10 N_TOP sky130_fd_pr__cap_mim_m3_1 l=3 w=3
X7961 N_B11 N_TOP sky130_fd_pr__cap_mim_m3_1 l=3 w=3
X7962 P_B7 P_TOP sky130_fd_pr__cap_mim_m3_1 l=3 w=3
X7963 P_B11 P_TOP sky130_fd_pr__cap_mim_m3_1 l=3 w=3
X7964 P_B11 P_TOP sky130_fd_pr__cap_mim_m3_1 l=3 w=3
X7965 N_B10 N_TOP sky130_fd_pr__cap_mim_m3_1 l=3 w=3
X7966 P_B9 P_TOP sky130_fd_pr__cap_mim_m3_1 l=3 w=3
X7967 N_B9 N_TOP sky130_fd_pr__cap_mim_m3_1 l=3 w=3
X7968 P_B9 P_TOP sky130_fd_pr__cap_mim_m3_1 l=3 w=3
X7969 N_B11 N_TOP sky130_fd_pr__cap_mim_m3_1 l=3 w=3
X7970 P_B11 P_TOP sky130_fd_pr__cap_mim_m3_1 l=3 w=3
X7971 P_B11 P_TOP sky130_fd_pr__cap_mim_m3_1 l=3 w=3
X7972 N_B8 N_TOP sky130_fd_pr__cap_mim_m3_1 l=3 w=3
X7973 P_B8 P_TOP sky130_fd_pr__cap_mim_m3_1 l=3 w=3
X7974 N_B11 N_TOP sky130_fd_pr__cap_mim_m3_1 l=3 w=3
X7975 P_B8 P_TOP sky130_fd_pr__cap_mim_m3_1 l=3 w=3
X7976 P_B10 P_TOP sky130_fd_pr__cap_mim_m3_1 l=3 w=3
X7977 N_B10 N_TOP sky130_fd_pr__cap_mim_m3_1 l=3 w=3
X7978 N_B9 N_TOP sky130_fd_pr__cap_mim_m3_1 l=3 w=3
X7979 P_B9 P_TOP sky130_fd_pr__cap_mim_m3_1 l=3 w=3
X7980 P_B11 P_TOP sky130_fd_pr__cap_mim_m3_1 l=3 w=3
X7981 P_B10 P_TOP sky130_fd_pr__cap_mim_m3_1 l=3 w=3
X7982 N_B7 N_TOP sky130_fd_pr__cap_mim_m3_1 l=3 w=3
X7983 N_B11 N_TOP sky130_fd_pr__cap_mim_m3_1 l=3 w=3
X7984 P_B7 P_TOP sky130_fd_pr__cap_mim_m3_1 l=3 w=3
X7985 P_B11 P_TOP sky130_fd_pr__cap_mim_m3_1 l=3 w=3
X7986 P_EDGE_BIAS P_EDGE_BIAS sky130_fd_pr__cap_mim_m3_1 l=3 w=3
X7987 P_B10 P_TOP sky130_fd_pr__cap_mim_m3_1 l=3 w=3
X7988 N_B11 N_TOP sky130_fd_pr__cap_mim_m3_1 l=3 w=3
X7989 P_B11 P_TOP sky130_fd_pr__cap_mim_m3_1 l=3 w=3
X7990 N_B8 N_TOP sky130_fd_pr__cap_mim_m3_1 l=3 w=3
X7991 N_B10 N_TOP sky130_fd_pr__cap_mim_m3_1 l=3 w=3
X7992 P_EDGE_BIAS P_EDGE_BIAS sky130_fd_pr__cap_mim_m3_1 l=3 w=3
X7993 N_B8 N_TOP sky130_fd_pr__cap_mim_m3_1 l=3 w=3
X7994 P_B10 P_TOP sky130_fd_pr__cap_mim_m3_1 l=3 w=3
X7995 P_B11 P_TOP sky130_fd_pr__cap_mim_m3_1 l=3 w=3
X7996 N_B6 N_TOP sky130_fd_pr__cap_mim_m3_1 l=3 w=3
X7997 N_B11 N_TOP sky130_fd_pr__cap_mim_m3_1 l=3 w=3
X7998 N_B8 N_TOP sky130_fd_pr__cap_mim_m3_1 l=3 w=3
X7999 P_B11 P_TOP sky130_fd_pr__cap_mim_m3_1 l=3 w=3
X8000 P_B11 P_TOP sky130_fd_pr__cap_mim_m3_1 l=3 w=3
X8001 N_B10 N_TOP sky130_fd_pr__cap_mim_m3_1 l=3 w=3
X8002 N_B5 N_TOP sky130_fd_pr__cap_mim_m3_1 l=3 w=3
X8003 N_B11 N_TOP sky130_fd_pr__cap_mim_m3_1 l=3 w=3
X8004 N_B9 N_TOP sky130_fd_pr__cap_mim_m3_1 l=3 w=3
X8005 N_B9 N_TOP sky130_fd_pr__cap_mim_m3_1 l=3 w=3
X8006 N_B11 N_TOP sky130_fd_pr__cap_mim_m3_1 l=3 w=3
X8007 P_B11 P_TOP sky130_fd_pr__cap_mim_m3_1 l=3 w=3
X8008 N_B9 N_TOP sky130_fd_pr__cap_mim_m3_1 l=3 w=3
X8009 P_B11 P_TOP sky130_fd_pr__cap_mim_m3_1 l=3 w=3
X8010 P_B11 P_TOP sky130_fd_pr__cap_mim_m3_1 l=3 w=3
X8011 N_B6 N_TOP sky130_fd_pr__cap_mim_m3_1 l=3 w=3
X8012 P_B11 P_TOP sky130_fd_pr__cap_mim_m3_1 l=3 w=3
X8013 P_EDGE_BIAS P_EDGE_BIAS sky130_fd_pr__cap_mim_m3_1 l=3 w=3
X8014 P_B10 P_TOP sky130_fd_pr__cap_mim_m3_1 l=3 w=3
X8015 N_B10 N_TOP sky130_fd_pr__cap_mim_m3_1 l=3 w=3
X8016 P_B11 P_TOP sky130_fd_pr__cap_mim_m3_1 l=3 w=3
X8017 N_B9 N_TOP sky130_fd_pr__cap_mim_m3_1 l=3 w=3
X8018 P_B8 P_TOP sky130_fd_pr__cap_mim_m3_1 l=3 w=3
X8019 N_B11 N_TOP sky130_fd_pr__cap_mim_m3_1 l=3 w=3
X8020 N_B11 N_TOP sky130_fd_pr__cap_mim_m3_1 l=3 w=3
X8021 P_B11 P_TOP sky130_fd_pr__cap_mim_m3_1 l=3 w=3
X8022 N_B10 N_TOP sky130_fd_pr__cap_mim_m3_1 l=3 w=3
X8023 P_B11 P_TOP sky130_fd_pr__cap_mim_m3_1 l=3 w=3
X8024 P_B11 P_TOP sky130_fd_pr__cap_mim_m3_1 l=3 w=3
X8025 N_B11 N_TOP sky130_fd_pr__cap_mim_m3_1 l=3 w=3
X8026 P_B9 P_TOP sky130_fd_pr__cap_mim_m3_1 l=3 w=3
X8027 P_B10 P_TOP sky130_fd_pr__cap_mim_m3_1 l=3 w=3
X8028 N_B11 N_TOP sky130_fd_pr__cap_mim_m3_1 l=3 w=3
X8029 P_B10 P_TOP sky130_fd_pr__cap_mim_m3_1 l=3 w=3
X8030 N_B11 N_TOP sky130_fd_pr__cap_mim_m3_1 l=3 w=3
X8031 P_B10 P_TOP sky130_fd_pr__cap_mim_m3_1 l=3 w=3
X8032 P_B10 P_TOP sky130_fd_pr__cap_mim_m3_1 l=3 w=3
X8033 N_B11 N_TOP sky130_fd_pr__cap_mim_m3_1 l=3 w=3
X8034 N_B11 N_TOP sky130_fd_pr__cap_mim_m3_1 l=3 w=3
X8035 P_B10 P_TOP sky130_fd_pr__cap_mim_m3_1 l=3 w=3
X8036 P_EDGE_BIAS P_EDGE_BIAS sky130_fd_pr__cap_mim_m3_1 l=3 w=3
X8037 P_B10 P_TOP sky130_fd_pr__cap_mim_m3_1 l=3 w=3
X8038 P_B6 P_TOP sky130_fd_pr__cap_mim_m3_1 l=3 w=3
X8039 N_B11 N_TOP sky130_fd_pr__cap_mim_m3_1 l=3 w=3
X8040 P_B11 P_TOP sky130_fd_pr__cap_mim_m3_1 l=3 w=3
X8041 N_B11 N_TOP sky130_fd_pr__cap_mim_m3_1 l=3 w=3
X8042 N_B9 N_TOP sky130_fd_pr__cap_mim_m3_1 l=3 w=3
X8043 N_B11 N_TOP sky130_fd_pr__cap_mim_m3_1 l=3 w=3
X8044 P_B10 P_TOP sky130_fd_pr__cap_mim_m3_1 l=3 w=3
X8045 P_B11 P_TOP sky130_fd_pr__cap_mim_m3_1 l=3 w=3
X8046 N_B10 N_TOP sky130_fd_pr__cap_mim_m3_1 l=3 w=3
X8047 N_B7 N_TOP sky130_fd_pr__cap_mim_m3_1 l=3 w=3
X8048 P_B7 P_TOP sky130_fd_pr__cap_mim_m3_1 l=3 w=3
X8049 N_B10 N_TOP sky130_fd_pr__cap_mim_m3_1 l=3 w=3
X8050 P_B10 P_TOP sky130_fd_pr__cap_mim_m3_1 l=3 w=3
X8051 P_EDGE_BIAS P_EDGE_BIAS sky130_fd_pr__cap_mim_m3_1 l=3 w=3
X8052 N_B10 N_TOP sky130_fd_pr__cap_mim_m3_1 l=3 w=3
X8053 N_B9 N_TOP sky130_fd_pr__cap_mim_m3_1 l=3 w=3
X8054 N_B11 N_TOP sky130_fd_pr__cap_mim_m3_1 l=3 w=3
X8055 P_EDGE_BIAS P_EDGE_BIAS sky130_fd_pr__cap_mim_m3_1 l=3 w=3
X8056 N_B11 N_TOP sky130_fd_pr__cap_mim_m3_1 l=3 w=3
X8057 P_B11 P_TOP sky130_fd_pr__cap_mim_m3_1 l=3 w=3
X8058 N_B8 N_TOP sky130_fd_pr__cap_mim_m3_1 l=3 w=3
X8059 N_B10 N_TOP sky130_fd_pr__cap_mim_m3_1 l=3 w=3
X8060 P_B10 P_TOP sky130_fd_pr__cap_mim_m3_1 l=3 w=3
X8061 P_B9 P_TOP sky130_fd_pr__cap_mim_m3_1 l=3 w=3
X8062 N_B8 N_TOP sky130_fd_pr__cap_mim_m3_1 l=3 w=3
X8063 P_B11 P_TOP sky130_fd_pr__cap_mim_m3_1 l=3 w=3
X8064 N_B11 N_TOP sky130_fd_pr__cap_mim_m3_1 l=3 w=3
X8065 N_B10 N_TOP sky130_fd_pr__cap_mim_m3_1 l=3 w=3
X8066 N_B11 N_TOP sky130_fd_pr__cap_mim_m3_1 l=3 w=3
X8067 P_B11 P_TOP sky130_fd_pr__cap_mim_m3_1 l=3 w=3
X8068 P_B11 P_TOP sky130_fd_pr__cap_mim_m3_1 l=3 w=3
X8069 N_B10 N_TOP sky130_fd_pr__cap_mim_m3_1 l=3 w=3
X8070 P_B11 P_TOP sky130_fd_pr__cap_mim_m3_1 l=3 w=3
X8071 N_B11 N_TOP sky130_fd_pr__cap_mim_m3_1 l=3 w=3
X8072 P_B11 P_TOP sky130_fd_pr__cap_mim_m3_1 l=3 w=3
X8073 N_B8 N_TOP sky130_fd_pr__cap_mim_m3_1 l=3 w=3
X8074 P_B9 P_TOP sky130_fd_pr__cap_mim_m3_1 l=3 w=3
X8075 P_B11 P_TOP sky130_fd_pr__cap_mim_m3_1 l=3 w=3
X8076 P_B10 P_TOP sky130_fd_pr__cap_mim_m3_1 l=3 w=3
X8077 N_B10 N_TOP sky130_fd_pr__cap_mim_m3_1 l=3 w=3
X8078 N_B11 N_TOP sky130_fd_pr__cap_mim_m3_1 l=3 w=3
X8079 N_B10 N_TOP sky130_fd_pr__cap_mim_m3_1 l=3 w=3
X8080 P_B10 P_TOP sky130_fd_pr__cap_mim_m3_1 l=3 w=3
X8081 N_B11 N_TOP sky130_fd_pr__cap_mim_m3_1 l=3 w=3
X8082 N_B10 N_TOP sky130_fd_pr__cap_mim_m3_1 l=3 w=3
X8083 N_B11 N_TOP sky130_fd_pr__cap_mim_m3_1 l=3 w=3
X8084 P_B11 P_TOP sky130_fd_pr__cap_mim_m3_1 l=3 w=3
X8085 P_B11 P_TOP sky130_fd_pr__cap_mim_m3_1 l=3 w=3
X8086 P_B9 P_TOP sky130_fd_pr__cap_mim_m3_1 l=3 w=3
X8087 N_B9 N_TOP sky130_fd_pr__cap_mim_m3_1 l=3 w=3
X8088 P_B9 P_TOP sky130_fd_pr__cap_mim_m3_1 l=3 w=3
X8089 P_B8 P_TOP sky130_fd_pr__cap_mim_m3_1 l=3 w=3
X8090 P_B9 P_TOP sky130_fd_pr__cap_mim_m3_1 l=3 w=3
X8091 N_B11 N_TOP sky130_fd_pr__cap_mim_m3_1 l=3 w=3
X8092 N_B11 N_TOP sky130_fd_pr__cap_mim_m3_1 l=3 w=3
X8093 P_B11 P_TOP sky130_fd_pr__cap_mim_m3_1 l=3 w=3
X8094 P_B11 P_TOP sky130_fd_pr__cap_mim_m3_1 l=3 w=3
X8095 N_B3 N_TOP sky130_fd_pr__cap_mim_m3_1 l=3 w=3
X8096 P_B8 P_TOP sky130_fd_pr__cap_mim_m3_1 l=3 w=3
X8097 P_B11 P_TOP sky130_fd_pr__cap_mim_m3_1 l=3 w=3
X8098 P_B8 P_TOP sky130_fd_pr__cap_mim_m3_1 l=3 w=3
X8099 N_B10 N_TOP sky130_fd_pr__cap_mim_m3_1 l=3 w=3
X8100 P_B10 P_TOP sky130_fd_pr__cap_mim_m3_1 l=3 w=3
X8101 P_B11 P_TOP sky130_fd_pr__cap_mim_m3_1 l=3 w=3
X8102 N_EDGE_BIAS N_EDGE_BIAS sky130_fd_pr__cap_mim_m3_1 l=3 w=3
X8103 N_B10 N_TOP sky130_fd_pr__cap_mim_m3_1 l=3 w=3
X8104 N_B11 N_TOP sky130_fd_pr__cap_mim_m3_1 l=3 w=3
X8105 N_B9 N_TOP sky130_fd_pr__cap_mim_m3_1 l=3 w=3
X8106 P_B11 P_TOP sky130_fd_pr__cap_mim_m3_1 l=3 w=3
X8107 P_B9 P_TOP sky130_fd_pr__cap_mim_m3_1 l=3 w=3
X8108 N_EDGE_BIAS N_EDGE_BIAS sky130_fd_pr__cap_mim_m3_1 l=3 w=3
X8109 N_B7 N_TOP sky130_fd_pr__cap_mim_m3_1 l=3 w=3
X8110 P_B7 P_TOP sky130_fd_pr__cap_mim_m3_1 l=3 w=3
X8111 P_B8 P_TOP sky130_fd_pr__cap_mim_m3_1 l=3 w=3
X8112 P_B10 P_TOP sky130_fd_pr__cap_mim_m3_1 l=3 w=3
X8113 N_B11 N_TOP sky130_fd_pr__cap_mim_m3_1 l=3 w=3
X8114 P_B11 P_TOP sky130_fd_pr__cap_mim_m3_1 l=3 w=3
X8115 N_B10 N_TOP sky130_fd_pr__cap_mim_m3_1 l=3 w=3
X8116 N_B11 N_TOP sky130_fd_pr__cap_mim_m3_1 l=3 w=3
X8117 N_B8 N_TOP sky130_fd_pr__cap_mim_m3_1 l=3 w=3
X8118 P_EDGE_BIAS P_EDGE_BIAS sky130_fd_pr__cap_mim_m3_1 l=3 w=3
X8119 P_B11 P_TOP sky130_fd_pr__cap_mim_m3_1 l=3 w=3
X8120 N_B11 N_TOP sky130_fd_pr__cap_mim_m3_1 l=3 w=3
X8121 N_B10 N_TOP sky130_fd_pr__cap_mim_m3_1 l=3 w=3
X8122 N_B11 N_TOP sky130_fd_pr__cap_mim_m3_1 l=3 w=3
X8123 P_B11 P_TOP sky130_fd_pr__cap_mim_m3_1 l=3 w=3
X8124 N_B6 N_TOP sky130_fd_pr__cap_mim_m3_1 l=3 w=3
X8125 P_B1 P_TOP sky130_fd_pr__cap_mim_m3_1 l=3 w=3
X8126 N_B10 N_TOP sky130_fd_pr__cap_mim_m3_1 l=3 w=3
X8127 P_B11 P_TOP sky130_fd_pr__cap_mim_m3_1 l=3 w=3
X8128 N_B11 N_TOP sky130_fd_pr__cap_mim_m3_1 l=3 w=3
X8129 N_B11 N_TOP sky130_fd_pr__cap_mim_m3_1 l=3 w=3
X8130 N_B9 N_TOP sky130_fd_pr__cap_mim_m3_1 l=3 w=3
X8131 N_B9 N_TOP sky130_fd_pr__cap_mim_m3_1 l=3 w=3
X8132 N_B10 N_TOP sky130_fd_pr__cap_mim_m3_1 l=3 w=3
X8133 N_B11 N_TOP sky130_fd_pr__cap_mim_m3_1 l=3 w=3
X8134 N_B9 N_TOP sky130_fd_pr__cap_mim_m3_1 l=3 w=3
X8135 P_B10 P_TOP sky130_fd_pr__cap_mim_m3_1 l=3 w=3
X8136 P_B11 P_TOP sky130_fd_pr__cap_mim_m3_1 l=3 w=3
X8137 P_B11 P_TOP sky130_fd_pr__cap_mim_m3_1 l=3 w=3
X8138 N_B11 N_TOP sky130_fd_pr__cap_mim_m3_1 l=3 w=3
X8139 N_B6 N_TOP sky130_fd_pr__cap_mim_m3_1 l=3 w=3
X8140 P_B11 P_TOP sky130_fd_pr__cap_mim_m3_1 l=3 w=3
X8141 N_B10 N_TOP sky130_fd_pr__cap_mim_m3_1 l=3 w=3
X8142 P_B10 P_TOP sky130_fd_pr__cap_mim_m3_1 l=3 w=3
X8143 P_B11 P_TOP sky130_fd_pr__cap_mim_m3_1 l=3 w=3
X8144 N_B11 N_TOP sky130_fd_pr__cap_mim_m3_1 l=3 w=3
X8145 N_B11 N_TOP sky130_fd_pr__cap_mim_m3_1 l=3 w=3
X8146 N_B9 N_TOP sky130_fd_pr__cap_mim_m3_1 l=3 w=3
X8147 N_B11 N_TOP sky130_fd_pr__cap_mim_m3_1 l=3 w=3
X8148 N_B10 N_TOP sky130_fd_pr__cap_mim_m3_1 l=3 w=3
X8149 N_B11 N_TOP sky130_fd_pr__cap_mim_m3_1 l=3 w=3
X8150 P_B11 P_TOP sky130_fd_pr__cap_mim_m3_1 l=3 w=3
X8151 N_B11 N_TOP sky130_fd_pr__cap_mim_m3_1 l=3 w=3
X8152 N_B9 N_TOP sky130_fd_pr__cap_mim_m3_1 l=3 w=3
X8153 N_B11 N_TOP sky130_fd_pr__cap_mim_m3_1 l=3 w=3
X8154 P_B9 P_TOP sky130_fd_pr__cap_mim_m3_1 l=3 w=3
X8155 P_B11 P_TOP sky130_fd_pr__cap_mim_m3_1 l=3 w=3
X8156 P_B10 P_TOP sky130_fd_pr__cap_mim_m3_1 l=3 w=3
X8157 N_B10 N_TOP sky130_fd_pr__cap_mim_m3_1 l=3 w=3
X8158 P_B10 P_TOP sky130_fd_pr__cap_mim_m3_1 l=3 w=3
X8159 N_B11 N_TOP sky130_fd_pr__cap_mim_m3_1 l=3 w=3
X8160 N_B10 N_TOP sky130_fd_pr__cap_mim_m3_1 l=3 w=3
X8161 P_B11 P_TOP sky130_fd_pr__cap_mim_m3_1 l=3 w=3
X8162 P_B10 P_TOP sky130_fd_pr__cap_mim_m3_1 l=3 w=3
X8163 P_B6 P_TOP sky130_fd_pr__cap_mim_m3_1 l=3 w=3
X8164 N_B9 N_TOP sky130_fd_pr__cap_mim_m3_1 l=3 w=3
X8165 N_B11 N_TOP sky130_fd_pr__cap_mim_m3_1 l=3 w=3
X8166 P_B11 P_TOP sky130_fd_pr__cap_mim_m3_1 l=3 w=3
X8167 N_B9 N_TOP sky130_fd_pr__cap_mim_m3_1 l=3 w=3
X8168 P_B9 P_TOP sky130_fd_pr__cap_mim_m3_1 l=3 w=3
X8169 N_B10 N_TOP sky130_fd_pr__cap_mim_m3_1 l=3 w=3
X8170 P_B10 P_TOP sky130_fd_pr__cap_mim_m3_1 l=3 w=3
X8171 N_B10 N_TOP sky130_fd_pr__cap_mim_m3_1 l=3 w=3
X8172 N_B7 N_TOP sky130_fd_pr__cap_mim_m3_1 l=3 w=3
X8173 P_B7 P_TOP sky130_fd_pr__cap_mim_m3_1 l=3 w=3
X8174 N_EDGE_BIAS N_EDGE_BIAS sky130_fd_pr__cap_mim_m3_1 l=3 w=3
X8175 P_B10 P_TOP sky130_fd_pr__cap_mim_m3_1 l=3 w=3
X8176 P_EDGE_BIAS P_EDGE_BIAS sky130_fd_pr__cap_mim_m3_1 l=3 w=3
X8177 N_B11 N_TOP sky130_fd_pr__cap_mim_m3_1 l=3 w=3
X8178 P_B11 P_TOP sky130_fd_pr__cap_mim_m3_1 l=3 w=3
X8179 N_B9 N_TOP sky130_fd_pr__cap_mim_m3_1 l=3 w=3
X8180 N_B9 N_TOP sky130_fd_pr__cap_mim_m3_1 l=3 w=3
X8181 N_B11 N_TOP sky130_fd_pr__cap_mim_m3_1 l=3 w=3
X8182 P_B10 P_TOP sky130_fd_pr__cap_mim_m3_1 l=3 w=3
X8183 N_B10 N_TOP sky130_fd_pr__cap_mim_m3_1 l=3 w=3
X8184 N_B8 N_TOP sky130_fd_pr__cap_mim_m3_1 l=3 w=3
X8185 P_B8 P_TOP sky130_fd_pr__cap_mim_m3_1 l=3 w=3
X8186 N_B10 N_TOP sky130_fd_pr__cap_mim_m3_1 l=3 w=3
X8187 P_B11 P_TOP sky130_fd_pr__cap_mim_m3_1 l=3 w=3
X8188 N_B11 N_TOP sky130_fd_pr__cap_mim_m3_1 l=3 w=3
X8189 N_B10 N_TOP sky130_fd_pr__cap_mim_m3_1 l=3 w=3
X8190 N_B9 N_TOP sky130_fd_pr__cap_mim_m3_1 l=3 w=3
X8191 N_B11 N_TOP sky130_fd_pr__cap_mim_m3_1 l=3 w=3
X8192 P_B11 P_TOP sky130_fd_pr__cap_mim_m3_1 l=3 w=3
X8193 P_B11 P_TOP sky130_fd_pr__cap_mim_m3_1 l=3 w=3
X8194 P_B11 P_TOP sky130_fd_pr__cap_mim_m3_1 l=3 w=3
X8195 P_B11 P_TOP sky130_fd_pr__cap_mim_m3_1 l=3 w=3
X8196 N_B10 N_TOP sky130_fd_pr__cap_mim_m3_1 l=3 w=3
X8197 P_B11 P_TOP sky130_fd_pr__cap_mim_m3_1 l=3 w=3
X8198 N_B10 N_TOP sky130_fd_pr__cap_mim_m3_1 l=3 w=3
X8199 N_B11 N_TOP sky130_fd_pr__cap_mim_m3_1 l=3 w=3
X8200 P_EDGE_BIAS P_EDGE_BIAS sky130_fd_pr__cap_mim_m3_1 l=3 w=3
X8201 P_B9 P_TOP sky130_fd_pr__cap_mim_m3_1 l=3 w=3
X8202 P_B11 P_TOP sky130_fd_pr__cap_mim_m3_1 l=3 w=3
X8203 N_B10 N_TOP sky130_fd_pr__cap_mim_m3_1 l=3 w=3
X8204 P_B11 P_TOP sky130_fd_pr__cap_mim_m3_1 l=3 w=3
X8205 N_B10 N_TOP sky130_fd_pr__cap_mim_m3_1 l=3 w=3
X8206 N_B7 N_TOP sky130_fd_pr__cap_mim_m3_1 l=3 w=3
X8207 N_B11 N_TOP sky130_fd_pr__cap_mim_m3_1 l=3 w=3
X8208 N_B11 N_TOP sky130_fd_pr__cap_mim_m3_1 l=3 w=3
X8209 N_B10 N_TOP sky130_fd_pr__cap_mim_m3_1 l=3 w=3
X8210 N_B11 N_TOP sky130_fd_pr__cap_mim_m3_1 l=3 w=3
X8211 P_B11 P_TOP sky130_fd_pr__cap_mim_m3_1 l=3 w=3
X8212 P_B9 P_TOP sky130_fd_pr__cap_mim_m3_1 l=3 w=3
X8213 P_B9 P_TOP sky130_fd_pr__cap_mim_m3_1 l=3 w=3
X8214 P_B11 P_TOP sky130_fd_pr__cap_mim_m3_1 l=3 w=3
X8215 N_B11 N_TOP sky130_fd_pr__cap_mim_m3_1 l=3 w=3
X8216 P_B9 P_TOP sky130_fd_pr__cap_mim_m3_1 l=3 w=3
X8217 N_B8 N_TOP sky130_fd_pr__cap_mim_m3_1 l=3 w=3
X8218 N_EDGE_BIAS N_EDGE_BIAS sky130_fd_pr__cap_mim_m3_1 l=3 w=3
X8219 P_B8 P_TOP sky130_fd_pr__cap_mim_m3_1 l=3 w=3
X8220 N_B11 N_TOP sky130_fd_pr__cap_mim_m3_1 l=3 w=3
X8221 N_B11 N_TOP sky130_fd_pr__cap_mim_m3_1 l=3 w=3
X8222 N_B11 N_TOP sky130_fd_pr__cap_mim_m3_1 l=3 w=3
X8223 N_B11 N_TOP sky130_fd_pr__cap_mim_m3_1 l=3 w=3
X8224 P_B8 P_TOP sky130_fd_pr__cap_mim_m3_1 l=3 w=3
X8225 N_B10 N_TOP sky130_fd_pr__cap_mim_m3_1 l=3 w=3
X8226 P_B10 P_TOP sky130_fd_pr__cap_mim_m3_1 l=3 w=3
X8227 P_B11 P_TOP sky130_fd_pr__cap_mim_m3_1 l=3 w=3
X8228 N_B7 N_TOP sky130_fd_pr__cap_mim_m3_1 l=3 w=3
X8229 N_B9 N_TOP sky130_fd_pr__cap_mim_m3_1 l=3 w=3
X8230 P_B11 P_TOP sky130_fd_pr__cap_mim_m3_1 l=3 w=3
X8231 N_B11 N_TOP sky130_fd_pr__cap_mim_m3_1 l=3 w=3
X8232 P_B7 P_TOP sky130_fd_pr__cap_mim_m3_1 l=3 w=3
X8233 N_B11 N_TOP sky130_fd_pr__cap_mim_m3_1 l=3 w=3
X8234 N_EDGE_BIAS N_EDGE_BIAS sky130_fd_pr__cap_mim_m3_1 l=3 w=3
X8235 P_B11 P_TOP sky130_fd_pr__cap_mim_m3_1 l=3 w=3
X8236 N_B10 N_TOP sky130_fd_pr__cap_mim_m3_1 l=3 w=3
X8237 P_B8 P_TOP sky130_fd_pr__cap_mim_m3_1 l=3 w=3
X8238 N_B10 N_TOP sky130_fd_pr__cap_mim_m3_1 l=3 w=3
X8239 P_B11 P_TOP sky130_fd_pr__cap_mim_m3_1 l=3 w=3
X8240 N_B10 N_TOP sky130_fd_pr__cap_mim_m3_1 l=3 w=3
X8241 N_B10 N_TOP sky130_fd_pr__cap_mim_m3_1 l=3 w=3
X8242 N_EDGE_BIAS N_EDGE_BIAS sky130_fd_pr__cap_mim_m3_1 l=3 w=3
X8243 P_B11 P_TOP sky130_fd_pr__cap_mim_m3_1 l=3 w=3
X8244 N_B6 N_TOP sky130_fd_pr__cap_mim_m3_1 l=3 w=3
X8245 N_B8 N_TOP sky130_fd_pr__cap_mim_m3_1 l=3 w=3
X8246 P_B11 P_TOP sky130_fd_pr__cap_mim_m3_1 l=3 w=3
X8247 N_B11 N_TOP sky130_fd_pr__cap_mim_m3_1 l=3 w=3
X8248 N_B10 N_TOP sky130_fd_pr__cap_mim_m3_1 l=3 w=3
X8249 P_B10 P_TOP sky130_fd_pr__cap_mim_m3_1 l=3 w=3
X8250 N_B5 N_TOP sky130_fd_pr__cap_mim_m3_1 l=3 w=3
X8251 N_B11 N_TOP sky130_fd_pr__cap_mim_m3_1 l=3 w=3
X8252 P_B9 P_TOP sky130_fd_pr__cap_mim_m3_1 l=3 w=3
X8253 P_B11 P_TOP sky130_fd_pr__cap_mim_m3_1 l=3 w=3
X8254 N_B11 N_TOP sky130_fd_pr__cap_mim_m3_1 l=3 w=3
X8255 N_B9 N_TOP sky130_fd_pr__cap_mim_m3_1 l=3 w=3
X8256 P_B9 P_TOP sky130_fd_pr__cap_mim_m3_1 l=3 w=3
X8257 P_B11 P_TOP sky130_fd_pr__cap_mim_m3_1 l=3 w=3
X8258 N_B10 N_TOP sky130_fd_pr__cap_mim_m3_1 l=3 w=3
X8259 P_B6 P_TOP sky130_fd_pr__cap_mim_m3_1 l=3 w=3
X8260 P_B11 P_TOP sky130_fd_pr__cap_mim_m3_1 l=3 w=3
X8261 P_B11 P_TOP sky130_fd_pr__cap_mim_m3_1 l=3 w=3
X8262 N_B11 N_TOP sky130_fd_pr__cap_mim_m3_1 l=3 w=3
X8263 N_EDGE_BIAS N_EDGE_BIAS sky130_fd_pr__cap_mim_m3_1 l=3 w=3
X8264 P_B11 P_TOP sky130_fd_pr__cap_mim_m3_1 l=3 w=3
X8265 P_B11 P_TOP sky130_fd_pr__cap_mim_m3_1 l=3 w=3
X8266 N_B11 N_TOP sky130_fd_pr__cap_mim_m3_1 l=3 w=3
X8267 N_B10 N_TOP sky130_fd_pr__cap_mim_m3_1 l=3 w=3
X8268 P_B11 P_TOP sky130_fd_pr__cap_mim_m3_1 l=3 w=3
X8269 N_B10 N_TOP sky130_fd_pr__cap_mim_m3_1 l=3 w=3
X8270 P_B11 P_TOP sky130_fd_pr__cap_mim_m3_1 l=3 w=3
X8271 P_B11 P_TOP sky130_fd_pr__cap_mim_m3_1 l=3 w=3
X8272 N_B11 N_TOP sky130_fd_pr__cap_mim_m3_1 l=3 w=3
X8273 N_B9 N_TOP sky130_fd_pr__cap_mim_m3_1 l=3 w=3
X8274 P_B9 P_TOP sky130_fd_pr__cap_mim_m3_1 l=3 w=3
X8275 N_B11 N_TOP sky130_fd_pr__cap_mim_m3_1 l=3 w=3
X8276 P_B11 P_TOP sky130_fd_pr__cap_mim_m3_1 l=3 w=3
X8277 P_EDGE_BIAS P_EDGE_BIAS sky130_fd_pr__cap_mim_m3_1 l=3 w=3
X8278 P_B10 P_TOP sky130_fd_pr__cap_mim_m3_1 l=3 w=3
X8279 P_B10 P_TOP sky130_fd_pr__cap_mim_m3_1 l=3 w=3
X8280 N_B11 N_TOP sky130_fd_pr__cap_mim_m3_1 l=3 w=3
X8281 P_B10 P_TOP sky130_fd_pr__cap_mim_m3_1 l=3 w=3
X8282 P_B11 P_TOP sky130_fd_pr__cap_mim_m3_1 l=3 w=3
X8283 N_B11 N_TOP sky130_fd_pr__cap_mim_m3_1 l=3 w=3
X8284 N_B11 N_TOP sky130_fd_pr__cap_mim_m3_1 l=3 w=3
X8285 P_B10 P_TOP sky130_fd_pr__cap_mim_m3_1 l=3 w=3
X8286 P_B9 P_TOP sky130_fd_pr__cap_mim_m3_1 l=3 w=3
X8287 N_B11 N_TOP sky130_fd_pr__cap_mim_m3_1 l=3 w=3
X8288 N_B9 N_TOP sky130_fd_pr__cap_mim_m3_1 l=3 w=3
X8289 P_B9 P_TOP sky130_fd_pr__cap_mim_m3_1 l=3 w=3
X8290 P_B11 P_TOP sky130_fd_pr__cap_mim_m3_1 l=3 w=3
X8291 P_B10 P_TOP sky130_fd_pr__cap_mim_m3_1 l=3 w=3
X8292 N_B7 N_TOP sky130_fd_pr__cap_mim_m3_1 l=3 w=3
X8293 P_B7 P_TOP sky130_fd_pr__cap_mim_m3_1 l=3 w=3
X8294 N_B10 N_TOP sky130_fd_pr__cap_mim_m3_1 l=3 w=3
X8295 P_B10 P_TOP sky130_fd_pr__cap_mim_m3_1 l=3 w=3
X8296 N_EDGE_BIAS N_EDGE_BIAS sky130_fd_pr__cap_mim_m3_1 l=3 w=3
X8297 P_B10 P_TOP sky130_fd_pr__cap_mim_m3_1 l=3 w=3
X8298 N_B11 N_TOP sky130_fd_pr__cap_mim_m3_1 l=3 w=3
X8299 N_B9 N_TOP sky130_fd_pr__cap_mim_m3_1 l=3 w=3
X8300 P_B11 P_TOP sky130_fd_pr__cap_mim_m3_1 l=3 w=3
X8301 N_B11 N_TOP sky130_fd_pr__cap_mim_m3_1 l=3 w=3
X8302 P_B11 P_TOP sky130_fd_pr__cap_mim_m3_1 l=3 w=3
X8303 N_B9 N_TOP sky130_fd_pr__cap_mim_m3_1 l=3 w=3
X8304 N_B8 N_TOP sky130_fd_pr__cap_mim_m3_1 l=3 w=3
X8305 N_B9 N_TOP sky130_fd_pr__cap_mim_m3_1 l=3 w=3
X8306 P_B11 P_TOP sky130_fd_pr__cap_mim_m3_1 l=3 w=3
X8307 P_B10 P_TOP sky130_fd_pr__cap_mim_m3_1 l=3 w=3
X8308 N_B8 N_TOP sky130_fd_pr__cap_mim_m3_1 l=3 w=3
X8309 N_B10 N_TOP sky130_fd_pr__cap_mim_m3_1 l=3 w=3
X8310 N_B8 N_TOP sky130_fd_pr__cap_mim_m3_1 l=3 w=3
X8311 N_B10 N_TOP sky130_fd_pr__cap_mim_m3_1 l=3 w=3
X8312 P_B10 P_TOP sky130_fd_pr__cap_mim_m3_1 l=3 w=3
X8313 P_B11 P_TOP sky130_fd_pr__cap_mim_m3_1 l=3 w=3
X8314 N_B11 N_TOP sky130_fd_pr__cap_mim_m3_1 l=3 w=3
X8315 P_B11 P_TOP sky130_fd_pr__cap_mim_m3_1 l=3 w=3
X8316 P_B11 P_TOP sky130_fd_pr__cap_mim_m3_1 l=3 w=3
X8317 N_B11 N_TOP sky130_fd_pr__cap_mim_m3_1 l=3 w=3
X8318 N_B9 N_TOP sky130_fd_pr__cap_mim_m3_1 l=3 w=3
X8319 P_B10 P_TOP sky130_fd_pr__cap_mim_m3_1 l=3 w=3
X8320 P_B11 P_TOP sky130_fd_pr__cap_mim_m3_1 l=3 w=3
X8321 N_B11 N_TOP sky130_fd_pr__cap_mim_m3_1 l=3 w=3
X8322 N_B8 N_TOP sky130_fd_pr__cap_mim_m3_1 l=3 w=3
X8323 N_B10 N_TOP sky130_fd_pr__cap_mim_m3_1 l=3 w=3
X8324 N_B11 N_TOP sky130_fd_pr__cap_mim_m3_1 l=3 w=3
X8325 P_B10 P_TOP sky130_fd_pr__cap_mim_m3_1 l=3 w=3
X8326 P_B11 P_TOP sky130_fd_pr__cap_mim_m3_1 l=3 w=3
X8327 N_B11 N_TOP sky130_fd_pr__cap_mim_m3_1 l=3 w=3
X8328 N_B11 N_TOP sky130_fd_pr__cap_mim_m3_1 l=3 w=3
X8329 N_B11 N_TOP sky130_fd_pr__cap_mim_m3_1 l=3 w=3
X8330 P_B11 P_TOP sky130_fd_pr__cap_mim_m3_1 l=3 w=3
X8331 P_B11 P_TOP sky130_fd_pr__cap_mim_m3_1 l=3 w=3
X8332 N_B11 N_TOP sky130_fd_pr__cap_mim_m3_1 l=3 w=3
X8333 P_B11 P_TOP sky130_fd_pr__cap_mim_m3_1 l=3 w=3
X8334 P_B9 P_TOP sky130_fd_pr__cap_mim_m3_1 l=3 w=3
X8335 P_B8 P_TOP sky130_fd_pr__cap_mim_m3_1 l=3 w=3
X8336 P_B9 P_TOP sky130_fd_pr__cap_mim_m3_1 l=3 w=3
X8337 N_B11 N_TOP sky130_fd_pr__cap_mim_m3_1 l=3 w=3
X8338 P_B11 P_TOP sky130_fd_pr__cap_mim_m3_1 l=3 w=3
X8339 P_B11 P_TOP sky130_fd_pr__cap_mim_m3_1 l=3 w=3
X8340 P_B11 P_TOP sky130_fd_pr__cap_mim_m3_1 l=3 w=3
X8341 N_EDGE_BIAS N_EDGE_BIAS sky130_fd_pr__cap_mim_m3_1 l=3 w=3
X8342 P_B8 P_TOP sky130_fd_pr__cap_mim_m3_1 l=3 w=3
X8343 N_B11 N_TOP sky130_fd_pr__cap_mim_m3_1 l=3 w=3
X8344 N_B11 N_TOP sky130_fd_pr__cap_mim_m3_1 l=3 w=3
X8345 P_B10 P_TOP sky130_fd_pr__cap_mim_m3_1 l=3 w=3
X8346 P_B10 P_TOP sky130_fd_pr__cap_mim_m3_1 l=3 w=3
X8347 P_B10 P_TOP sky130_fd_pr__cap_mim_m3_1 l=3 w=3
X8348 N_B10 N_TOP sky130_fd_pr__cap_mim_m3_1 l=3 w=3
X8349 P_B11 P_TOP sky130_fd_pr__cap_mim_m3_1 l=3 w=3
X8350 N_B11 N_TOP sky130_fd_pr__cap_mim_m3_1 l=3 w=3
X8351 P_B9 P_TOP sky130_fd_pr__cap_mim_m3_1 l=3 w=3
X8352 P_B10 P_TOP sky130_fd_pr__cap_mim_m3_1 l=3 w=3
X8353 N_B7 N_TOP sky130_fd_pr__cap_mim_m3_1 l=3 w=3
X8354 N_B11 N_TOP sky130_fd_pr__cap_mim_m3_1 l=3 w=3
X8355 P_B7 P_TOP sky130_fd_pr__cap_mim_m3_1 l=3 w=3
X8356 N_B11 N_TOP sky130_fd_pr__cap_mim_m3_1 l=3 w=3
X8357 P_B11 P_TOP sky130_fd_pr__cap_mim_m3_1 l=3 w=3
X8358 N_B11 N_TOP sky130_fd_pr__cap_mim_m3_1 l=3 w=3
X8359 P_B10 P_TOP sky130_fd_pr__cap_mim_m3_1 l=3 w=3
X8360 P_B11 P_TOP sky130_fd_pr__cap_mim_m3_1 l=3 w=3
X8361 P_B10 P_TOP sky130_fd_pr__cap_mim_m3_1 l=3 w=3
X8362 P_B10 P_TOP sky130_fd_pr__cap_mim_m3_1 l=3 w=3
X8363 N_B10 N_TOP sky130_fd_pr__cap_mim_m3_1 l=3 w=3
X8364 N_B11 N_TOP sky130_fd_pr__cap_mim_m3_1 l=3 w=3
X8365 N_B10 N_TOP sky130_fd_pr__cap_mim_m3_1 l=3 w=3
X8366 P_B10 P_TOP sky130_fd_pr__cap_mim_m3_1 l=3 w=3
X8367 N_B11 N_TOP sky130_fd_pr__cap_mim_m3_1 l=3 w=3
X8368 P_B11 P_TOP sky130_fd_pr__cap_mim_m3_1 l=3 w=3
X8369 P_B11 P_TOP sky130_fd_pr__cap_mim_m3_1 l=3 w=3
X8370 N_B10 N_TOP sky130_fd_pr__cap_mim_m3_1 l=3 w=3
X8371 N_B6 N_TOP sky130_fd_pr__cap_mim_m3_1 l=3 w=3
X8372 N_B11 N_TOP sky130_fd_pr__cap_mim_m3_1 l=3 w=3
X8373 N_B8 N_TOP sky130_fd_pr__cap_mim_m3_1 l=3 w=3
X8374 P_B11 P_TOP sky130_fd_pr__cap_mim_m3_1 l=3 w=3
X8375 N_B10 N_TOP sky130_fd_pr__cap_mim_m3_1 l=3 w=3
X8376 N_B4 N_TOP sky130_fd_pr__cap_mim_m3_1 l=3 w=3
X8377 P_B11 P_TOP sky130_fd_pr__cap_mim_m3_1 l=3 w=3
X8378 N_B11 N_TOP sky130_fd_pr__cap_mim_m3_1 l=3 w=3
X8379 N_B9 N_TOP sky130_fd_pr__cap_mim_m3_1 l=3 w=3
X8380 P_B11 P_TOP sky130_fd_pr__cap_mim_m3_1 l=3 w=3
X8381 N_B9 N_TOP sky130_fd_pr__cap_mim_m3_1 l=3 w=3
X8382 P_B11 P_TOP sky130_fd_pr__cap_mim_m3_1 l=3 w=3
X8383 N_B10 N_TOP sky130_fd_pr__cap_mim_m3_1 l=3 w=3
X8384 P_B11 P_TOP sky130_fd_pr__cap_mim_m3_1 l=3 w=3
X8385 P_B9 P_TOP sky130_fd_pr__cap_mim_m3_1 l=3 w=3
X8386 P_B11 P_TOP sky130_fd_pr__cap_mim_m3_1 l=3 w=3
X8387 N_B11 N_TOP sky130_fd_pr__cap_mim_m3_1 l=3 w=3
X8388 N_B10 N_TOP sky130_fd_pr__cap_mim_m3_1 l=3 w=3
X8389 N_B9 N_TOP sky130_fd_pr__cap_mim_m3_1 l=3 w=3
X8390 N_B11 N_TOP sky130_fd_pr__cap_mim_m3_1 l=3 w=3
X8391 P_B11 P_TOP sky130_fd_pr__cap_mim_m3_1 l=3 w=3
X8392 N_B10 N_TOP sky130_fd_pr__cap_mim_m3_1 l=3 w=3
X8393 P_B11 P_TOP sky130_fd_pr__cap_mim_m3_1 l=3 w=3
X8394 P_B11 P_TOP sky130_fd_pr__cap_mim_m3_1 l=3 w=3
X8395 N_B11 N_TOP sky130_fd_pr__cap_mim_m3_1 l=3 w=3
X8396 P_B9 P_TOP sky130_fd_pr__cap_mim_m3_1 l=3 w=3
X8397 P_B9 P_TOP sky130_fd_pr__cap_mim_m3_1 l=3 w=3
X8398 N_B11 N_TOP sky130_fd_pr__cap_mim_m3_1 l=3 w=3
X8399 P_B10 P_TOP sky130_fd_pr__cap_mim_m3_1 l=3 w=3
X8400 N_B11 N_TOP sky130_fd_pr__cap_mim_m3_1 l=3 w=3
X8401 P_B10 P_TOP sky130_fd_pr__cap_mim_m3_1 l=3 w=3
X8402 N_EDGE_BIAS N_EDGE_BIAS sky130_fd_pr__cap_mim_m3_1 l=3 w=3
X8403 N_B11 N_TOP sky130_fd_pr__cap_mim_m3_1 l=3 w=3
X8404 N_B11 N_TOP sky130_fd_pr__cap_mim_m3_1 l=3 w=3
X8405 P_B11 P_TOP sky130_fd_pr__cap_mim_m3_1 l=3 w=3
X8406 P_B10 P_TOP sky130_fd_pr__cap_mim_m3_1 l=3 w=3
X8407 P_B6 P_TOP sky130_fd_pr__cap_mim_m3_1 l=3 w=3
X8408 P_B11 P_TOP sky130_fd_pr__cap_mim_m3_1 l=3 w=3
X8409 N_B11 N_TOP sky130_fd_pr__cap_mim_m3_1 l=3 w=3
X8410 P_B11 P_TOP sky130_fd_pr__cap_mim_m3_1 l=3 w=3
X8411 N_B9 N_TOP sky130_fd_pr__cap_mim_m3_1 l=3 w=3
X8412 N_EDGE_BIAS N_EDGE_BIAS sky130_fd_pr__cap_mim_m3_1 l=3 w=3
X8413 P_B9 P_TOP sky130_fd_pr__cap_mim_m3_1 l=3 w=3
X8414 P_B10 P_TOP sky130_fd_pr__cap_mim_m3_1 l=3 w=3
X8415 P_B11 P_TOP sky130_fd_pr__cap_mim_m3_1 l=3 w=3
X8416 N_B7 N_TOP sky130_fd_pr__cap_mim_m3_1 l=3 w=3
X8417 P_B7 P_TOP sky130_fd_pr__cap_mim_m3_1 l=3 w=3
X8418 N_B10 N_TOP sky130_fd_pr__cap_mim_m3_1 l=3 w=3
X8419 P_B10 P_TOP sky130_fd_pr__cap_mim_m3_1 l=3 w=3
X8420 P_B11 P_TOP sky130_fd_pr__cap_mim_m3_1 l=3 w=3
X8421 P_EDGE_BIAS P_EDGE_BIAS sky130_fd_pr__cap_mim_m3_1 l=3 w=3
X8422 N_B11 N_TOP sky130_fd_pr__cap_mim_m3_1 l=3 w=3
X8423 N_B9 N_TOP sky130_fd_pr__cap_mim_m3_1 l=3 w=3
X8424 N_B9 N_TOP sky130_fd_pr__cap_mim_m3_1 l=3 w=3
X8425 N_B11 N_TOP sky130_fd_pr__cap_mim_m3_1 l=3 w=3
X8426 P_B9 P_TOP sky130_fd_pr__cap_mim_m3_1 l=3 w=3
X8427 N_B9 N_TOP sky130_fd_pr__cap_mim_m3_1 l=3 w=3
X8428 N_B8 N_TOP sky130_fd_pr__cap_mim_m3_1 l=3 w=3
X8429 P_B11 P_TOP sky130_fd_pr__cap_mim_m3_1 l=3 w=3
X8430 P_B11 P_TOP sky130_fd_pr__cap_mim_m3_1 l=3 w=3
X8431 N_B8 N_TOP sky130_fd_pr__cap_mim_m3_1 l=3 w=3
X8432 N_B10 N_TOP sky130_fd_pr__cap_mim_m3_1 l=3 w=3
X8433 P_B10 P_TOP sky130_fd_pr__cap_mim_m3_1 l=3 w=3
X8434 N_B8 N_TOP sky130_fd_pr__cap_mim_m3_1 l=3 w=3
X8435 P_B11 P_TOP sky130_fd_pr__cap_mim_m3_1 l=3 w=3
X8436 P_B8 P_TOP sky130_fd_pr__cap_mim_m3_1 l=3 w=3
X8437 N_B10 N_TOP sky130_fd_pr__cap_mim_m3_1 l=3 w=3
X8438 P_B11 P_TOP sky130_fd_pr__cap_mim_m3_1 l=3 w=3
X8439 N_B11 N_TOP sky130_fd_pr__cap_mim_m3_1 l=3 w=3
X8440 P_B11 P_TOP sky130_fd_pr__cap_mim_m3_1 l=3 w=3
X8441 P_B11 P_TOP sky130_fd_pr__cap_mim_m3_1 l=3 w=3
X8442 N_B7 N_TOP sky130_fd_pr__cap_mim_m3_1 l=3 w=3
X8443 P_EDGE_BIAS P_EDGE_BIAS sky130_fd_pr__cap_mim_m3_1 l=3 w=3
X8444 P_B11 P_TOP sky130_fd_pr__cap_mim_m3_1 l=3 w=3
X8445 N_B10 N_TOP sky130_fd_pr__cap_mim_m3_1 l=3 w=3
X8446 N_B11 N_TOP sky130_fd_pr__cap_mim_m3_1 l=3 w=3
X8447 N_B8 N_TOP sky130_fd_pr__cap_mim_m3_1 l=3 w=3
X8448 N_B10 N_TOP sky130_fd_pr__cap_mim_m3_1 l=3 w=3
X8449 N_B11 N_TOP sky130_fd_pr__cap_mim_m3_1 l=3 w=3
X8450 N_B10 N_TOP sky130_fd_pr__cap_mim_m3_1 l=3 w=3
X8451 P_B10 P_TOP sky130_fd_pr__cap_mim_m3_1 l=3 w=3
X8452 P_B11 P_TOP sky130_fd_pr__cap_mim_m3_1 l=3 w=3
X8453 P_B11 P_TOP sky130_fd_pr__cap_mim_m3_1 l=3 w=3
X8454 N_B11 N_TOP sky130_fd_pr__cap_mim_m3_1 l=3 w=3
X8455 N_B11 N_TOP sky130_fd_pr__cap_mim_m3_1 l=3 w=3
X8456 N_B11 N_TOP sky130_fd_pr__cap_mim_m3_1 l=3 w=3
X8457 P_B11 P_TOP sky130_fd_pr__cap_mim_m3_1 l=3 w=3
X8458 N_B11 N_TOP sky130_fd_pr__cap_mim_m3_1 l=3 w=3
X8459 N_B9 N_TOP sky130_fd_pr__cap_mim_m3_1 l=3 w=3
X8460 P_EDGE_BIAS P_EDGE_BIAS sky130_fd_pr__cap_mim_m3_1 l=3 w=3
X8461 P_B9 P_TOP sky130_fd_pr__cap_mim_m3_1 l=3 w=3
X8462 P_B8 P_TOP sky130_fd_pr__cap_mim_m3_1 l=3 w=3
X8463 N_B11 N_TOP sky130_fd_pr__cap_mim_m3_1 l=3 w=3
X8464 P_EDGE_BIAS P_EDGE_BIAS sky130_fd_pr__cap_mim_m3_1 l=3 w=3
X8465 P_B9 P_TOP sky130_fd_pr__cap_mim_m3_1 l=3 w=3
X8466 P_B11 P_TOP sky130_fd_pr__cap_mim_m3_1 l=3 w=3
X8467 P_B11 P_TOP sky130_fd_pr__cap_mim_m3_1 l=3 w=3
X8468 N_EDGE_BIAS N_EDGE_BIAS sky130_fd_pr__cap_mim_m3_1 l=3 w=3
X8469 N_EDGE_BIAS N_EDGE_BIAS sky130_fd_pr__cap_mim_m3_1 l=3 w=3
X8470 N_B4 N_TOP sky130_fd_pr__cap_mim_m3_1 l=3 w=3
X8471 P_B8 P_TOP sky130_fd_pr__cap_mim_m3_1 l=3 w=3
X8472 N_B11 N_TOP sky130_fd_pr__cap_mim_m3_1 l=3 w=3
X8473 P_B11 P_TOP sky130_fd_pr__cap_mim_m3_1 l=3 w=3
X8474 P_B8 P_TOP sky130_fd_pr__cap_mim_m3_1 l=3 w=3
X8475 N_B10 N_TOP sky130_fd_pr__cap_mim_m3_1 l=3 w=3
X8476 P_B10 P_TOP sky130_fd_pr__cap_mim_m3_1 l=3 w=3
X8477 N_EDGE_BIAS N_EDGE_BIAS sky130_fd_pr__cap_mim_m3_1 l=3 w=3
X8478 N_B11 N_TOP sky130_fd_pr__cap_mim_m3_1 l=3 w=3
X8479 P_B11 P_TOP sky130_fd_pr__cap_mim_m3_1 l=3 w=3
X8480 P_B9 P_TOP sky130_fd_pr__cap_mim_m3_1 l=3 w=3
X8481 N_EDGE_BIAS N_EDGE_BIAS sky130_fd_pr__cap_mim_m3_1 l=3 w=3
X8482 N_B7 N_TOP sky130_fd_pr__cap_mim_m3_1 l=3 w=3
X8483 P_B7 P_TOP sky130_fd_pr__cap_mim_m3_1 l=3 w=3
X8484 N_B11 N_TOP sky130_fd_pr__cap_mim_m3_1 l=3 w=3
X8485 N_B11 N_TOP sky130_fd_pr__cap_mim_m3_1 l=3 w=3
X8486 P_B8 P_TOP sky130_fd_pr__cap_mim_m3_1 l=3 w=3
X8487 N_B10 N_TOP sky130_fd_pr__cap_mim_m3_1 l=3 w=3
X8488 N_B11 N_TOP sky130_fd_pr__cap_mim_m3_1 l=3 w=3
X8489 P_B10 P_TOP sky130_fd_pr__cap_mim_m3_1 l=3 w=3
X8490 N_B10 N_TOP sky130_fd_pr__cap_mim_m3_1 l=3 w=3
X8491 N_B10 N_TOP sky130_fd_pr__cap_mim_m3_1 l=3 w=3
X8492 P_B11 P_TOP sky130_fd_pr__cap_mim_m3_1 l=3 w=3
X8493 P_B8 P_TOP sky130_fd_pr__cap_mim_m3_1 l=3 w=3
X8494 N_B11 N_TOP sky130_fd_pr__cap_mim_m3_1 l=3 w=3
X8495 N_B10 N_TOP sky130_fd_pr__cap_mim_m3_1 l=3 w=3
X8496 N_B11 N_TOP sky130_fd_pr__cap_mim_m3_1 l=3 w=3
X8497 N_B5 N_TOP sky130_fd_pr__cap_mim_m3_1 l=3 w=3
X8498 P_B4 P_TOP sky130_fd_pr__cap_mim_m3_1 l=3 w=3
X8499 N_B10 N_TOP sky130_fd_pr__cap_mim_m3_1 l=3 w=3
X8500 P_B11 P_TOP sky130_fd_pr__cap_mim_m3_1 l=3 w=3
X8501 N_B11 N_TOP sky130_fd_pr__cap_mim_m3_1 l=3 w=3
X8502 N_B9 N_TOP sky130_fd_pr__cap_mim_m3_1 l=3 w=3
X8503 P_B9 P_TOP sky130_fd_pr__cap_mim_m3_1 l=3 w=3
X8504 N_B9 N_TOP sky130_fd_pr__cap_mim_m3_1 l=3 w=3
X8505 P_B11 P_TOP sky130_fd_pr__cap_mim_m3_1 l=3 w=3
X8506 N_B10 N_TOP sky130_fd_pr__cap_mim_m3_1 l=3 w=3
X8507 N_B7 N_TOP sky130_fd_pr__cap_mim_m3_1 l=3 w=3
X8508 P_B11 P_TOP sky130_fd_pr__cap_mim_m3_1 l=3 w=3
X8509 P_EDGE_BIAS P_EDGE_BIAS sky130_fd_pr__cap_mim_m3_1 l=3 w=3
X8510 N_B10 N_TOP sky130_fd_pr__cap_mim_m3_1 l=3 w=3
X8511 N_B11 N_TOP sky130_fd_pr__cap_mim_m3_1 l=3 w=3
X8512 N_B10 N_TOP sky130_fd_pr__cap_mim_m3_1 l=3 w=3
X8513 N_B9 N_TOP sky130_fd_pr__cap_mim_m3_1 l=3 w=3
X8514 P_B11 P_TOP sky130_fd_pr__cap_mim_m3_1 l=3 w=3
X8515 N_B11 N_TOP sky130_fd_pr__cap_mim_m3_1 l=3 w=3
X8516 N_B10 N_TOP sky130_fd_pr__cap_mim_m3_1 l=3 w=3
X8517 N_B11 N_TOP sky130_fd_pr__cap_mim_m3_1 l=3 w=3
X8518 P_B11 P_TOP sky130_fd_pr__cap_mim_m3_1 l=3 w=3
X8519 P_B11 P_TOP sky130_fd_pr__cap_mim_m3_1 l=3 w=3
X8520 N_B9 N_TOP sky130_fd_pr__cap_mim_m3_1 l=3 w=3
X8521 P_B9 P_TOP sky130_fd_pr__cap_mim_m3_1 l=3 w=3
X8522 P_B11 P_TOP sky130_fd_pr__cap_mim_m3_1 l=3 w=3
X8523 N_B10 N_TOP sky130_fd_pr__cap_mim_m3_1 l=3 w=3
X8524 P_B11 P_TOP sky130_fd_pr__cap_mim_m3_1 l=3 w=3
X8525 P_B10 P_TOP sky130_fd_pr__cap_mim_m3_1 l=3 w=3
X8526 P_B11 P_TOP sky130_fd_pr__cap_mim_m3_1 l=3 w=3
X8527 N_B11 N_TOP sky130_fd_pr__cap_mim_m3_1 l=3 w=3
X8528 N_B11 N_TOP sky130_fd_pr__cap_mim_m3_1 l=3 w=3
X8529 P_B11 P_TOP sky130_fd_pr__cap_mim_m3_1 l=3 w=3
X8530 N_B10 N_TOP sky130_fd_pr__cap_mim_m3_1 l=3 w=3
X8531 P_B10 P_TOP sky130_fd_pr__cap_mim_m3_1 l=3 w=3
X8532 N_B9 N_TOP sky130_fd_pr__cap_mim_m3_1 l=3 w=3
X8533 N_B11 N_TOP sky130_fd_pr__cap_mim_m3_1 l=3 w=3
X8534 P_B9 P_TOP sky130_fd_pr__cap_mim_m3_1 l=3 w=3
X8535 P_B11 P_TOP sky130_fd_pr__cap_mim_m3_1 l=3 w=3
X8536 N_EDGE_BIAS N_EDGE_BIAS sky130_fd_pr__cap_mim_m3_1 l=3 w=3
X8537 P_B10 P_TOP sky130_fd_pr__cap_mim_m3_1 l=3 w=3
X8538 N_B7 N_TOP sky130_fd_pr__cap_mim_m3_1 l=3 w=3
X8539 N_B11 N_TOP sky130_fd_pr__cap_mim_m3_1 l=3 w=3
X8540 P_B7 P_TOP sky130_fd_pr__cap_mim_m3_1 l=3 w=3
X8541 P_B10 P_TOP sky130_fd_pr__cap_mim_m3_1 l=3 w=3
X8542 P_EDGE_BIAS P_EDGE_BIAS sky130_fd_pr__cap_mim_m3_1 l=3 w=3
X8543 N_B11 N_TOP sky130_fd_pr__cap_mim_m3_1 l=3 w=3
X8544 N_B11 N_TOP sky130_fd_pr__cap_mim_m3_1 l=3 w=3
X8545 N_B9 N_TOP sky130_fd_pr__cap_mim_m3_1 l=3 w=3
X8546 N_B11 N_TOP sky130_fd_pr__cap_mim_m3_1 l=3 w=3
X8547 N_B9 N_TOP sky130_fd_pr__cap_mim_m3_1 l=3 w=3
X8548 P_B9 P_TOP sky130_fd_pr__cap_mim_m3_1 l=3 w=3
X8549 N_B8 N_TOP sky130_fd_pr__cap_mim_m3_1 l=3 w=3
X8550 N_B9 N_TOP sky130_fd_pr__cap_mim_m3_1 l=3 w=3
X8551 N_B11 N_TOP sky130_fd_pr__cap_mim_m3_1 l=3 w=3
X8552 P_B11 P_TOP sky130_fd_pr__cap_mim_m3_1 l=3 w=3
X8553 N_B11 N_TOP sky130_fd_pr__cap_mim_m3_1 l=3 w=3
X8554 N_B8 N_TOP sky130_fd_pr__cap_mim_m3_1 l=3 w=3
X8555 P_B8 P_TOP sky130_fd_pr__cap_mim_m3_1 l=3 w=3
X8556 N_B10 N_TOP sky130_fd_pr__cap_mim_m3_1 l=3 w=3
X8557 P_B11 P_TOP sky130_fd_pr__cap_mim_m3_1 l=3 w=3
X8558 N_B11 N_TOP sky130_fd_pr__cap_mim_m3_1 l=3 w=3
X8559 P_B11 P_TOP sky130_fd_pr__cap_mim_m3_1 l=3 w=3
X8560 N_B10 N_TOP sky130_fd_pr__cap_mim_m3_1 l=3 w=3
X8561 N_B9 N_TOP sky130_fd_pr__cap_mim_m3_1 l=3 w=3
X8562 P_B11 P_TOP sky130_fd_pr__cap_mim_m3_1 l=3 w=3
X8563 P_B11 P_TOP sky130_fd_pr__cap_mim_m3_1 l=3 w=3
X8564 N_B8 N_TOP sky130_fd_pr__cap_mim_m3_1 l=3 w=3
X8565 N_B10 N_TOP sky130_fd_pr__cap_mim_m3_1 l=3 w=3
X8566 N_B11 N_TOP sky130_fd_pr__cap_mim_m3_1 l=3 w=3
X8567 P_B11 P_TOP sky130_fd_pr__cap_mim_m3_1 l=3 w=3
X8568 P_B11 P_TOP sky130_fd_pr__cap_mim_m3_1 l=3 w=3
X8569 N_B11 N_TOP sky130_fd_pr__cap_mim_m3_1 l=3 w=3
X8570 N_B10 N_TOP sky130_fd_pr__cap_mim_m3_1 l=3 w=3
X8571 N_B10 N_TOP sky130_fd_pr__cap_mim_m3_1 l=3 w=3
X8572 P_B11 P_TOP sky130_fd_pr__cap_mim_m3_1 l=3 w=3
X8573 P_B11 P_TOP sky130_fd_pr__cap_mim_m3_1 l=3 w=3
X8574 P_B10 P_TOP sky130_fd_pr__cap_mim_m3_1 l=3 w=3
X8575 N_B11 N_TOP sky130_fd_pr__cap_mim_m3_1 l=3 w=3
X8576 P_B11 P_TOP sky130_fd_pr__cap_mim_m3_1 l=3 w=3
X8577 P_B11 P_TOP sky130_fd_pr__cap_mim_m3_1 l=3 w=3
X8578 N_B11 N_TOP sky130_fd_pr__cap_mim_m3_1 l=3 w=3
X8579 N_B11 N_TOP sky130_fd_pr__cap_mim_m3_1 l=3 w=3
X8580 P_B11 P_TOP sky130_fd_pr__cap_mim_m3_1 l=3 w=3
X8581 P_B11 P_TOP sky130_fd_pr__cap_mim_m3_1 l=3 w=3
X8582 N_B10 N_TOP sky130_fd_pr__cap_mim_m3_1 l=3 w=3
X8583 P_B9 P_TOP sky130_fd_pr__cap_mim_m3_1 l=3 w=3
X8584 P_B8 P_TOP sky130_fd_pr__cap_mim_m3_1 l=3 w=3
X8585 P_B11 P_TOP sky130_fd_pr__cap_mim_m3_1 l=3 w=3
X8586 N_B11 N_TOP sky130_fd_pr__cap_mim_m3_1 l=3 w=3
X8587 N_B11 N_TOP sky130_fd_pr__cap_mim_m3_1 l=3 w=3
X8588 N_B11 N_TOP sky130_fd_pr__cap_mim_m3_1 l=3 w=3
X8589 N_B11 N_TOP sky130_fd_pr__cap_mim_m3_1 l=3 w=3
X8590 N_B10 N_TOP sky130_fd_pr__cap_mim_m3_1 l=3 w=3
X8591 P_B10 P_TOP sky130_fd_pr__cap_mim_m3_1 l=3 w=3
X8592 P_B11 P_TOP sky130_fd_pr__cap_mim_m3_1 l=3 w=3
X8593 N_B11 N_TOP sky130_fd_pr__cap_mim_m3_1 l=3 w=3
X8594 P_B7 P_TOP sky130_fd_pr__cap_mim_m3_1 l=3 w=3
X8595 P_B11 P_TOP sky130_fd_pr__cap_mim_m3_1 l=3 w=3
X8596 N_B11 N_TOP sky130_fd_pr__cap_mim_m3_1 l=3 w=3
X8597 P_B11 P_TOP sky130_fd_pr__cap_mim_m3_1 l=3 w=3
X8598 N_B11 N_TOP sky130_fd_pr__cap_mim_m3_1 l=3 w=3
X8599 P_B11 P_TOP sky130_fd_pr__cap_mim_m3_1 l=3 w=3
X8600 N_B9 N_TOP sky130_fd_pr__cap_mim_m3_1 l=3 w=3
X8601 P_B11 P_TOP sky130_fd_pr__cap_mim_m3_1 l=3 w=3
X8602 P_B8 P_TOP sky130_fd_pr__cap_mim_m3_1 l=3 w=3
X8603 N_B10 N_TOP sky130_fd_pr__cap_mim_m3_1 l=3 w=3
X8604 N_B10 N_TOP sky130_fd_pr__cap_mim_m3_1 l=3 w=3
X8605 P_B11 P_TOP sky130_fd_pr__cap_mim_m3_1 l=3 w=3
X8606 N_B10 N_TOP sky130_fd_pr__cap_mim_m3_1 l=3 w=3
X8607 N_B8 N_TOP sky130_fd_pr__cap_mim_m3_1 l=3 w=3
X8608 N_B11 N_TOP sky130_fd_pr__cap_mim_m3_1 l=3 w=3
X8609 P_B11 P_TOP sky130_fd_pr__cap_mim_m3_1 l=3 w=3
X8610 N_B10 N_TOP sky130_fd_pr__cap_mim_m3_1 l=3 w=3
X8611 P_B10 P_TOP sky130_fd_pr__cap_mim_m3_1 l=3 w=3
X8612 N_B4 N_TOP sky130_fd_pr__cap_mim_m3_1 l=3 w=3
X8613 N_B11 N_TOP sky130_fd_pr__cap_mim_m3_1 l=3 w=3
X8614 N_B7 N_TOP sky130_fd_pr__cap_mim_m3_1 l=3 w=3
X8615 P_B9 P_TOP sky130_fd_pr__cap_mim_m3_1 l=3 w=3
X8616 P_B11 P_TOP sky130_fd_pr__cap_mim_m3_1 l=3 w=3
X8617 N_B11 N_TOP sky130_fd_pr__cap_mim_m3_1 l=3 w=3
X8618 P_B11 P_TOP sky130_fd_pr__cap_mim_m3_1 l=3 w=3
X8619 N_B9 N_TOP sky130_fd_pr__cap_mim_m3_1 l=3 w=3
X8620 P_B9 P_TOP sky130_fd_pr__cap_mim_m3_1 l=3 w=3
X8621 N_B10 N_TOP sky130_fd_pr__cap_mim_m3_1 l=3 w=3
X8622 P_B11 P_TOP sky130_fd_pr__cap_mim_m3_1 l=3 w=3
X8623 N_B11 N_TOP sky130_fd_pr__cap_mim_m3_1 l=3 w=3
X8624 N_B10 N_TOP sky130_fd_pr__cap_mim_m3_1 l=3 w=3
X8625 N_EDGE_BIAS N_EDGE_BIAS sky130_fd_pr__cap_mim_m3_1 l=3 w=3
X8626 P_B11 P_TOP sky130_fd_pr__cap_mim_m3_1 l=3 w=3
X8627 N_B11 N_TOP sky130_fd_pr__cap_mim_m3_1 l=3 w=3
X8628 N_B10 N_TOP sky130_fd_pr__cap_mim_m3_1 l=3 w=3
X8629 P_B11 P_TOP sky130_fd_pr__cap_mim_m3_1 l=3 w=3
X8630 P_B9 P_TOP sky130_fd_pr__cap_mim_m3_1 l=3 w=3
X8631 P_B11 P_TOP sky130_fd_pr__cap_mim_m3_1 l=3 w=3
X8632 P_B11 P_TOP sky130_fd_pr__cap_mim_m3_1 l=3 w=3
X8633 P_B9 P_TOP sky130_fd_pr__cap_mim_m3_1 l=3 w=3
X8634 N_B11 N_TOP sky130_fd_pr__cap_mim_m3_1 l=3 w=3
X8635 P_B11 P_TOP sky130_fd_pr__cap_mim_m3_1 l=3 w=3
X8636 P_B10 P_TOP sky130_fd_pr__cap_mim_m3_1 l=3 w=3
X8637 P_B11 P_TOP sky130_fd_pr__cap_mim_m3_1 l=3 w=3
X8638 N_B11 N_TOP sky130_fd_pr__cap_mim_m3_1 l=3 w=3
X8639 N_B11 N_TOP sky130_fd_pr__cap_mim_m3_1 l=3 w=3
X8640 P_B10 P_TOP sky130_fd_pr__cap_mim_m3_1 l=3 w=3
X8641 P_B11 P_TOP sky130_fd_pr__cap_mim_m3_1 l=3 w=3
X8642 N_B11 N_TOP sky130_fd_pr__cap_mim_m3_1 l=3 w=3
X8643 P_B9 P_TOP sky130_fd_pr__cap_mim_m3_1 l=3 w=3
X8644 N_B11 N_TOP sky130_fd_pr__cap_mim_m3_1 l=3 w=3
X8645 N_B9 N_TOP sky130_fd_pr__cap_mim_m3_1 l=3 w=3
X8646 P_B9 P_TOP sky130_fd_pr__cap_mim_m3_1 l=3 w=3
X8647 P_B11 P_TOP sky130_fd_pr__cap_mim_m3_1 l=3 w=3
X8648 P_B10 P_TOP sky130_fd_pr__cap_mim_m3_1 l=3 w=3
X8649 P_B7 P_TOP sky130_fd_pr__cap_mim_m3_1 l=3 w=3
X8650 N_B10 N_TOP sky130_fd_pr__cap_mim_m3_1 l=3 w=3
X8651 N_B11 N_TOP sky130_fd_pr__cap_mim_m3_1 l=3 w=3
X8652 P_B10 P_TOP sky130_fd_pr__cap_mim_m3_1 l=3 w=3
X8653 N_B11 N_TOP sky130_fd_pr__cap_mim_m3_1 l=3 w=3
X8654 N_EDGE_BIAS N_EDGE_BIAS sky130_fd_pr__cap_mim_m3_1 l=3 w=3
X8655 P_B10 P_TOP sky130_fd_pr__cap_mim_m3_1 l=3 w=3
X8656 N_B9 N_TOP sky130_fd_pr__cap_mim_m3_1 l=3 w=3
X8657 N_B9 N_TOP sky130_fd_pr__cap_mim_m3_1 l=3 w=3
X8658 P_B11 P_TOP sky130_fd_pr__cap_mim_m3_1 l=3 w=3
X8659 N_B11 N_TOP sky130_fd_pr__cap_mim_m3_1 l=3 w=3
X8660 N_B9 N_TOP sky130_fd_pr__cap_mim_m3_1 l=3 w=3
X8661 N_B8 N_TOP sky130_fd_pr__cap_mim_m3_1 l=3 w=3
X8662 N_B9 N_TOP sky130_fd_pr__cap_mim_m3_1 l=3 w=3
X8663 N_B10 N_TOP sky130_fd_pr__cap_mim_m3_1 l=3 w=3
X8664 P_B11 P_TOP sky130_fd_pr__cap_mim_m3_1 l=3 w=3
X8665 P_B10 P_TOP sky130_fd_pr__cap_mim_m3_1 l=3 w=3
X8666 N_B8 N_TOP sky130_fd_pr__cap_mim_m3_1 l=3 w=3
X8667 N_B10 N_TOP sky130_fd_pr__cap_mim_m3_1 l=3 w=3
X8668 N_B11 N_TOP sky130_fd_pr__cap_mim_m3_1 l=3 w=3
X8669 P_B10 P_TOP sky130_fd_pr__cap_mim_m3_1 l=3 w=3
X8670 P_EDGE_BIAS P_EDGE_BIAS sky130_fd_pr__cap_mim_m3_1 l=3 w=3
X8671 P_B11 P_TOP sky130_fd_pr__cap_mim_m3_1 l=3 w=3
X8672 N_B11 N_TOP sky130_fd_pr__cap_mim_m3_1 l=3 w=3
X8673 P_B11 P_TOP sky130_fd_pr__cap_mim_m3_1 l=3 w=3
X8674 N_B11 N_TOP sky130_fd_pr__cap_mim_m3_1 l=3 w=3
X8675 N_B9 N_TOP sky130_fd_pr__cap_mim_m3_1 l=3 w=3
X8676 P_B11 P_TOP sky130_fd_pr__cap_mim_m3_1 l=3 w=3
X8677 N_B10 N_TOP sky130_fd_pr__cap_mim_m3_1 l=3 w=3
X8678 N_B11 N_TOP sky130_fd_pr__cap_mim_m3_1 l=3 w=3
X8679 N_B8 N_TOP sky130_fd_pr__cap_mim_m3_1 l=3 w=3
X8680 N_B10 N_TOP sky130_fd_pr__cap_mim_m3_1 l=3 w=3
X8681 N_B11 N_TOP sky130_fd_pr__cap_mim_m3_1 l=3 w=3
X8682 P_B10 P_TOP sky130_fd_pr__cap_mim_m3_1 l=3 w=3
X8683 P_B11 P_TOP sky130_fd_pr__cap_mim_m3_1 l=3 w=3
X8684 N_B11 N_TOP sky130_fd_pr__cap_mim_m3_1 l=3 w=3
X8685 P_B11 P_TOP sky130_fd_pr__cap_mim_m3_1 l=3 w=3
X8686 N_B11 N_TOP sky130_fd_pr__cap_mim_m3_1 l=3 w=3
X8687 P_EDGE_BIAS P_EDGE_BIAS sky130_fd_pr__cap_mim_m3_1 l=3 w=3
X8688 N_B8 N_TOP sky130_fd_pr__cap_mim_m3_1 l=3 w=3
X8689 P_B10 P_TOP sky130_fd_pr__cap_mim_m3_1 l=3 w=3
X8690 P_B11 P_TOP sky130_fd_pr__cap_mim_m3_1 l=3 w=3
X8691 P_B11 P_TOP sky130_fd_pr__cap_mim_m3_1 l=3 w=3
X8692 N_B11 N_TOP sky130_fd_pr__cap_mim_m3_1 l=3 w=3
X8693 P_B11 P_TOP sky130_fd_pr__cap_mim_m3_1 l=3 w=3
X8694 N_EDGE_BIAS N_EDGE_BIAS sky130_fd_pr__cap_mim_m3_1 l=3 w=3
X8695 N_B9 N_TOP sky130_fd_pr__cap_mim_m3_1 l=3 w=3
X8696 P_B9 P_TOP sky130_fd_pr__cap_mim_m3_1 l=3 w=3
X8697 N_B11 N_TOP sky130_fd_pr__cap_mim_m3_1 l=3 w=3
X8698 P_B11 P_TOP sky130_fd_pr__cap_mim_m3_1 l=3 w=3
X8699 P_B11 P_TOP sky130_fd_pr__cap_mim_m3_1 l=3 w=3
X8700 N_B4 N_TOP sky130_fd_pr__cap_mim_m3_1 l=3 w=3
X8701 P_B8 P_TOP sky130_fd_pr__cap_mim_m3_1 l=3 w=3
X8702 N_EDGE_BIAS N_EDGE_BIAS sky130_fd_pr__cap_mim_m3_1 l=3 w=3
X8703 P_B11 P_TOP sky130_fd_pr__cap_mim_m3_1 l=3 w=3
X8704 N_B11 N_TOP sky130_fd_pr__cap_mim_m3_1 l=3 w=3
X8705 P_B10 P_TOP sky130_fd_pr__cap_mim_m3_1 l=3 w=3
X8706 P_B10 P_TOP sky130_fd_pr__cap_mim_m3_1 l=3 w=3
X8707 N_B10 N_TOP sky130_fd_pr__cap_mim_m3_1 l=3 w=3
X8708 P_B9 P_TOP sky130_fd_pr__cap_mim_m3_1 l=3 w=3
X8709 N_B11 N_TOP sky130_fd_pr__cap_mim_m3_1 l=3 w=3
X8710 P_B11 P_TOP sky130_fd_pr__cap_mim_m3_1 l=3 w=3
X8711 P_B10 P_TOP sky130_fd_pr__cap_mim_m3_1 l=3 w=3
C0 N_B2 N_B10 0.20117f
C1 N_B1 N_B8 0.20117f
C2 N_TOP N_B9 0.69832p
C3 P_B11 P_B9 11.7155f
C4 N_EDGE_BIAS N_B1 0.72592f
C5 N_B10 N_B3 0.21733f
C6 P_B6 P_B9 3.26534f
C7 N_B1 N_DUMMY 0.25854f
C8 N_B2 N_B1 23.9603f
C9 N_B10 N_B4 0.21733f
C10 P_TOP P_B8 0.34916p
C11 P_B11 P_B0 5.19786f
C12 P_B3 P_B1 1.06319f
C13 N_B6 N_B5 5.10246f
C14 N_TOP N_B0 2.93203f
C15 P_B6 P_B0 3.04519f
C16 P_B1 P_DUMMY 0.50634f
C17 N_TOP N_B8 0.34916p
C18 N_B1 N_B3 0.64015f
C19 P_B10 P_TOP 1.39663p
C20 N_B1 N_B4 0.63392f
C21 N_TOP N_EDGE_BIAS 32.7097f
C22 N_TOP N_DUMMY 2.92337f
C23 P_B3 P_DUMMY 0.64753f
C24 P_TOP P_EDGE_BIAS 32.7097f
C25 N_B11 N_B10 56.4869f
C26 N_TOP N_B2 5.72949f
C27 P_B2 P_TOP 5.73002f
C28 P_B5 P_TOP 41.447f
C29 P_TOP P_B7 0.17475p
C30 P_B4 P_TOP 21.0683f
C31 N_TOP N_B3 10.8704f
C32 P_B1 P_B8 0.20117f
C33 N_B11 N_B1 0.23134f
C34 N_TOP N_B4 21.0678f
C35 N_B6 N_B10 6.12572f
C36 P_B11 P_B6 11.8733f
C37 N_B9 N_B7 3.17486f
C38 P_B3 P_B8 0.21733f
C39 P_B10 P_B1 0.20117f
C40 P_B8 P_DUMMY 0.21733f
C41 N_B6 N_B1 1.8115f
C42 P_B1 P_EDGE_BIAS 0.72592f
C43 N_B10 N_B5 0.20117f
C44 N_B0 N_B7 0.20857f
C45 N_B11 N_TOP 2.78728p
C46 P_TOP P_B9 0.69832p
C47 P_B1 P_B2 24.6191f
C48 P_B5 P_B1 1.69766f
C49 P_B10 P_B3 0.21733f
C50 N_B8 N_B7 45.8633f
C51 P_B1 P_B7 0.28314f
C52 P_TOP P_B0 2.85793f
C53 P_B4 P_B1 1.27745f
C54 P_B10 P_DUMMY 0.21733f
C55 P_B3 P_EDGE_BIAS 0.78741f
C56 N_EDGE_BIAS N_B7 5.81562f
C57 N_B1 N_B5 0.63392f
C58 N_DUMMY N_B7 0.21733f
C59 P_DUMMY P_EDGE_BIAS 0.8132f
C60 N_B0 N_B9 0.20857f
C61 N_B2 N_B7 0.40806f
C62 P_B3 P_B2 23.6754f
C63 P_B3 P_B5 0.86713f
C64 N_TOP N_B6 84.34361f
C65 P_B3 P_B7 0.64979f
C66 P_B2 P_DUMMY 0.54505f
C67 P_B3 P_B4 14.7689f
C68 P_B5 P_DUMMY 14.8009f
C69 N_B8 N_B9 47.3732f
C70 P_DUMMY P_B7 0.21733f
C71 P_B4 P_DUMMY 1.1329f
C72 N_B7 N_B3 0.64979f
C73 N_EDGE_BIAS N_B9 15.3737f
C74 N_DUMMY N_B9 0.21733f
C75 N_B7 N_B4 1.10041f
C76 N_B2 N_B9 0.20117f
C77 N_TOP N_B5 41.4463f
C78 N_B0 N_B8 0.20857f
C79 P_B1 P_B9 0.20117f
C80 P_B10 P_B8 5.94575f
C81 P_B1 P_B0 20.0524f
C82 N_EDGE_BIAS N_B0 0.75452f
C83 N_DUMMY N_B0 5.56621f
C84 P_TOP P_B11 2.78715p
C85 P_B8 P_EDGE_BIAS 8.13832f
C86 N_B9 N_B3 0.21733f
C87 N_B2 N_B0 0.97095f
C88 P_TOP P_B6 84.5521f
C89 N_B9 N_B4 0.21733f
C90 P_B3 P_B9 0.21733f
C91 N_EDGE_BIAS N_B8 8.12192f
C92 P_B2 P_B8 0.20117f
C93 N_DUMMY N_B8 0.21733f
C94 P_B5 P_B8 0.22766f
C95 N_B1 N_B10 0.20117f
C96 N_B11 N_B7 11.5089f
C97 N_B2 N_B8 0.20117f
C98 P_DUMMY P_B9 0.21733f
C99 P_B8 P_B7 45.8633f
C100 P_B4 P_B8 0.21781f
C101 P_B3 P_B0 0.68619f
C102 N_EDGE_BIAS N_DUMMY 0.8132f
C103 N_B0 N_B3 1.20228f
C104 P_B10 P_EDGE_BIAS 30.8112f
C105 P_DUMMY P_B0 5.56621f
C106 N_EDGE_BIAS N_B2 0.72592f
C107 N_B0 N_B4 1.30275f
C108 N_B2 N_DUMMY 0.24382f
C109 P_B10 P_B2 0.20117f
C110 N_B8 N_B3 0.21733f
C111 P_B10 P_B5 0.20117f
C112 P_B10 P_B7 5.91729f
C113 P_B10 P_B4 0.21733f
C114 N_B8 N_B4 0.21781f
C115 N_B11 N_B9 11.7068f
C116 P_B2 P_EDGE_BIAS 0.72592f
C117 P_B5 P_EDGE_BIAS 0.72592f
C118 N_EDGE_BIAS N_B3 0.78741f
C119 N_B6 N_B7 39.9033f
C120 N_TOP N_B10 1.39663p
C121 N_DUMMY N_B3 0.23679f
C122 P_B7 P_EDGE_BIAS 5.86155f
C123 P_B4 P_EDGE_BIAS 0.78741f
C124 N_B2 N_B3 23.4689f
C125 N_EDGE_BIAS N_B4 0.78741f
C126 N_DUMMY N_B4 0.50628f
C127 P_B5 P_B2 0.84779f
C128 P_B1 P_B11 0.23134f
C129 N_B2 N_B4 0.63555f
C130 P_B2 P_B7 0.40806f
C131 P_B5 P_B7 2.02494f
C132 P_B4 P_B2 0.86557f
C133 P_B1 P_B6 0.21325f
C134 N_B11 N_B0 5.58773f
C135 P_B4 P_B5 20.7272f
C136 P_B8 P_B9 47.3732f
C137 P_B4 P_B7 1.10041f
C138 N_B7 N_B5 2.02494f
C139 N_TOP N_B1 3.27868f
C140 N_B6 N_B9 3.27116f
C141 P_B8 P_B0 0.21733f
C142 N_B11 N_B8 11.5564f
C143 N_B4 N_B3 14.5373f
C144 P_B3 P_B11 0.22164f
C145 P_B3 P_B6 0.22535f
C146 P_B10 P_B9 50.3041f
C147 N_B11 N_EDGE_BIAS 77.50249f
C148 P_B11 P_DUMMY 0.239f
C149 N_B11 N_DUMMY 0.22164f
C150 P_B6 P_DUMMY 0.22446f
C151 N_B11 N_B2 0.20548f
C152 N_B6 N_B0 0.21569f
C153 P_B9 P_EDGE_BIAS 15.3737f
C154 P_B10 P_B0 0.24629f
C155 N_B9 N_B5 0.22063f
C156 P_B2 P_B9 0.20117f
C157 N_B6 N_B8 1.85405f
C158 P_B0 P_EDGE_BIAS 0.75452f
C159 P_B5 P_B9 0.22063f
C160 N_B11 N_B3 0.22164f
C161 P_B9 P_B7 3.17486f
C162 P_B4 P_B9 0.21733f
C163 P_B2 P_B0 0.63311f
C164 N_B11 N_B4 0.22164f
C165 N_EDGE_BIAS N_B6 30.2696f
C166 P_B5 P_B0 0.42994f
C167 N_B6 N_DUMMY 0.76271f
C168 N_B0 N_B5 2.01443f
C169 P_B0 P_B7 0.21733f
C170 N_B6 N_B2 0.20995f
C171 P_B4 P_B0 0.42994f
C172 N_B8 N_B5 0.22766f
C173 P_B11 P_B8 11.5652f
C174 N_B10 N_B7 5.91729f
C175 P_B6 P_B8 1.85114f
C176 N_B6 N_B3 0.22535f
C177 N_EDGE_BIAS N_B5 0.72592f
C178 N_DUMMY N_B5 13.6281f
C179 N_B6 N_B4 0.22676f
C180 N_B2 N_B5 0.63392f
C181 P_B10 P_B11 56.4956f
C182 N_B1 N_B7 0.28314f
C183 P_B10 P_B6 6.1141f
C184 P_B1 P_TOP 3.30683f
C185 N_B9 N_B10 50.3041f
C186 P_B11 P_EDGE_BIAS 77.5884f
C187 P_B0 P_B9 0.21733f
C188 N_B5 N_B3 0.65171f
C189 P_B6 P_EDGE_BIAS 31.1733f
C190 N_B5 N_B4 20.5353f
C191 P_B2 P_B11 0.20548f
C192 P_B5 P_B11 0.20548f
C193 P_B2 P_B6 0.20995f
C194 P_B11 P_B7 11.5176f
C195 P_B5 P_B6 5.10252f
C196 N_B11 N_B6 11.8877f
C197 P_B3 P_TOP 10.871f
C198 N_B0 N_B10 0.23753f
C199 P_B4 P_B11 0.22164f
C200 P_B6 P_B7 39.9019f
C201 N_B1 N_B9 0.20117f
C202 P_B4 P_B6 0.22676f
C203 P_TOP P_DUMMY 2.74686f
C204 N_TOP N_B7 0.17475p
C205 N_B8 N_B10 5.94575f
C206 N_EDGE_BIAS N_B10 30.8112f
C207 N_B1 N_B0 20.4138f
C208 N_B11 N_B5 0.20548f
C209 N_DUMMY N_B10 0.21733f
C210 N_TOP VSUBS 2.87738p
C211 P_TOP VSUBS 2.87436p
.ends
