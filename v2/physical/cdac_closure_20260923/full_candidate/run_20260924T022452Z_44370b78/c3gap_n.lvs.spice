* NGSPICE file created from c3gap_n_flat.ext - technology: sky130A

.subckt c3gap_n_flat TOP B11 B10 B9 B8 B7 B6 B5 B4 B3 B2 B1 B0 DUMMY EDGE_BIAS
X0 B10 TOP sky130_fd_pr__cap_mim_m3_1 l=3 w=3
X1 B11 TOP sky130_fd_pr__cap_mim_m3_1 l=3 w=3
X2 B11 TOP sky130_fd_pr__cap_mim_m3_1 l=3 w=3
X3 B11 TOP sky130_fd_pr__cap_mim_m3_1 l=3 w=3
X4 B9 TOP sky130_fd_pr__cap_mim_m3_1 l=3 w=3
X5 B10 TOP sky130_fd_pr__cap_mim_m3_1 l=3 w=3
X6 B8 TOP sky130_fd_pr__cap_mim_m3_1 l=3 w=3
X7 B11 TOP sky130_fd_pr__cap_mim_m3_1 l=3 w=3
X8 B11 TOP sky130_fd_pr__cap_mim_m3_1 l=3 w=3
X9 B11 TOP sky130_fd_pr__cap_mim_m3_1 l=3 w=3
X10 B11 TOP sky130_fd_pr__cap_mim_m3_1 l=3 w=3
X11 B11 TOP sky130_fd_pr__cap_mim_m3_1 l=3 w=3
X12 B8 TOP sky130_fd_pr__cap_mim_m3_1 l=3 w=3
X13 B11 TOP sky130_fd_pr__cap_mim_m3_1 l=3 w=3
X14 B9 TOP sky130_fd_pr__cap_mim_m3_1 l=3 w=3
X15 B11 TOP sky130_fd_pr__cap_mim_m3_1 l=3 w=3
X16 B11 TOP sky130_fd_pr__cap_mim_m3_1 l=3 w=3
X17 B4 TOP sky130_fd_pr__cap_mim_m3_1 l=3 w=3
X18 B11 TOP sky130_fd_pr__cap_mim_m3_1 l=3 w=3
X19 B8 TOP sky130_fd_pr__cap_mim_m3_1 l=3 w=3
X20 EDGE_BIAS EDGE_BIAS sky130_fd_pr__cap_mim_m3_1 l=3 w=3
X21 B11 TOP sky130_fd_pr__cap_mim_m3_1 l=3 w=3
X22 EDGE_BIAS EDGE_BIAS sky130_fd_pr__cap_mim_m3_1 l=3 w=3
X23 B11 TOP sky130_fd_pr__cap_mim_m3_1 l=3 w=3
X24 B11 TOP sky130_fd_pr__cap_mim_m3_1 l=3 w=3
X25 B11 TOP sky130_fd_pr__cap_mim_m3_1 l=3 w=3
X26 B11 TOP sky130_fd_pr__cap_mim_m3_1 l=3 w=3
X27 B10 TOP sky130_fd_pr__cap_mim_m3_1 l=3 w=3
X28 B9 TOP sky130_fd_pr__cap_mim_m3_1 l=3 w=3
X29 B10 TOP sky130_fd_pr__cap_mim_m3_1 l=3 w=3
X30 B8 TOP sky130_fd_pr__cap_mim_m3_1 l=3 w=3
X31 B11 TOP sky130_fd_pr__cap_mim_m3_1 l=3 w=3
X32 B9 TOP sky130_fd_pr__cap_mim_m3_1 l=3 w=3
X33 B10 TOP sky130_fd_pr__cap_mim_m3_1 l=3 w=3
X34 B11 TOP sky130_fd_pr__cap_mim_m3_1 l=3 w=3
X35 B10 TOP sky130_fd_pr__cap_mim_m3_1 l=3 w=3
X36 EDGE_BIAS EDGE_BIAS sky130_fd_pr__cap_mim_m3_1 l=3 w=3
X37 B11 TOP sky130_fd_pr__cap_mim_m3_1 l=3 w=3
X38 B11 TOP sky130_fd_pr__cap_mim_m3_1 l=3 w=3
X39 B10 TOP sky130_fd_pr__cap_mim_m3_1 l=3 w=3
X40 EDGE_BIAS EDGE_BIAS sky130_fd_pr__cap_mim_m3_1 l=3 w=3
X41 B10 TOP sky130_fd_pr__cap_mim_m3_1 l=3 w=3
X42 B11 TOP sky130_fd_pr__cap_mim_m3_1 l=3 w=3
X43 B10 TOP sky130_fd_pr__cap_mim_m3_1 l=3 w=3
X44 B11 TOP sky130_fd_pr__cap_mim_m3_1 l=3 w=3
X45 B11 TOP sky130_fd_pr__cap_mim_m3_1 l=3 w=3
X46 B11 TOP sky130_fd_pr__cap_mim_m3_1 l=3 w=3
X47 B11 TOP sky130_fd_pr__cap_mim_m3_1 l=3 w=3
X48 B10 TOP sky130_fd_pr__cap_mim_m3_1 l=3 w=3
X49 EDGE_BIAS EDGE_BIAS sky130_fd_pr__cap_mim_m3_1 l=3 w=3
X50 B11 TOP sky130_fd_pr__cap_mim_m3_1 l=3 w=3
X51 B11 TOP sky130_fd_pr__cap_mim_m3_1 l=3 w=3
X52 B11 TOP sky130_fd_pr__cap_mim_m3_1 l=3 w=3
X53 B11 TOP sky130_fd_pr__cap_mim_m3_1 l=3 w=3
X54 B11 TOP sky130_fd_pr__cap_mim_m3_1 l=3 w=3
X55 B11 TOP sky130_fd_pr__cap_mim_m3_1 l=3 w=3
X56 B11 TOP sky130_fd_pr__cap_mim_m3_1 l=3 w=3
X57 B9 TOP sky130_fd_pr__cap_mim_m3_1 l=3 w=3
X58 B9 TOP sky130_fd_pr__cap_mim_m3_1 l=3 w=3
X59 B10 TOP sky130_fd_pr__cap_mim_m3_1 l=3 w=3
X60 B8 TOP sky130_fd_pr__cap_mim_m3_1 l=3 w=3
X61 B9 TOP sky130_fd_pr__cap_mim_m3_1 l=3 w=3
X62 B10 TOP sky130_fd_pr__cap_mim_m3_1 l=3 w=3
X63 B10 TOP sky130_fd_pr__cap_mim_m3_1 l=3 w=3
X64 B9 TOP sky130_fd_pr__cap_mim_m3_1 l=3 w=3
X65 B11 TOP sky130_fd_pr__cap_mim_m3_1 l=3 w=3
X66 B10 TOP sky130_fd_pr__cap_mim_m3_1 l=3 w=3
X67 B7 TOP sky130_fd_pr__cap_mim_m3_1 l=3 w=3
X68 B11 TOP sky130_fd_pr__cap_mim_m3_1 l=3 w=3
X69 EDGE_BIAS EDGE_BIAS sky130_fd_pr__cap_mim_m3_1 l=3 w=3
X70 B8 TOP sky130_fd_pr__cap_mim_m3_1 l=3 w=3
X71 B11 TOP sky130_fd_pr__cap_mim_m3_1 l=3 w=3
X72 B10 TOP sky130_fd_pr__cap_mim_m3_1 l=3 w=3
X73 B11 TOP sky130_fd_pr__cap_mim_m3_1 l=3 w=3
X74 B11 TOP sky130_fd_pr__cap_mim_m3_1 l=3 w=3
X75 B11 TOP sky130_fd_pr__cap_mim_m3_1 l=3 w=3
X76 B11 TOP sky130_fd_pr__cap_mim_m3_1 l=3 w=3
X77 B9 TOP sky130_fd_pr__cap_mim_m3_1 l=3 w=3
X78 B9 TOP sky130_fd_pr__cap_mim_m3_1 l=3 w=3
X79 B11 TOP sky130_fd_pr__cap_mim_m3_1 l=3 w=3
X80 B11 TOP sky130_fd_pr__cap_mim_m3_1 l=3 w=3
X81 B5 TOP sky130_fd_pr__cap_mim_m3_1 l=3 w=3
X82 B11 TOP sky130_fd_pr__cap_mim_m3_1 l=3 w=3
X83 B11 TOP sky130_fd_pr__cap_mim_m3_1 l=3 w=3
X84 B11 TOP sky130_fd_pr__cap_mim_m3_1 l=3 w=3
X85 B10 TOP sky130_fd_pr__cap_mim_m3_1 l=3 w=3
X86 B11 TOP sky130_fd_pr__cap_mim_m3_1 l=3 w=3
X87 B11 TOP sky130_fd_pr__cap_mim_m3_1 l=3 w=3
X88 B9 TOP sky130_fd_pr__cap_mim_m3_1 l=3 w=3
X89 B9 TOP sky130_fd_pr__cap_mim_m3_1 l=3 w=3
X90 B10 TOP sky130_fd_pr__cap_mim_m3_1 l=3 w=3
X91 B10 TOP sky130_fd_pr__cap_mim_m3_1 l=3 w=3
X92 B11 TOP sky130_fd_pr__cap_mim_m3_1 l=3 w=3
X93 B10 TOP sky130_fd_pr__cap_mim_m3_1 l=3 w=3
X94 B4 TOP sky130_fd_pr__cap_mim_m3_1 l=3 w=3
X95 EDGE_BIAS EDGE_BIAS sky130_fd_pr__cap_mim_m3_1 l=3 w=3
X96 B9 TOP sky130_fd_pr__cap_mim_m3_1 l=3 w=3
X97 B11 TOP sky130_fd_pr__cap_mim_m3_1 l=3 w=3
X98 B11 TOP sky130_fd_pr__cap_mim_m3_1 l=3 w=3
X99 B10 TOP sky130_fd_pr__cap_mim_m3_1 l=3 w=3
X100 B7 TOP sky130_fd_pr__cap_mim_m3_1 l=3 w=3
X101 B10 TOP sky130_fd_pr__cap_mim_m3_1 l=3 w=3
X102 B10 TOP sky130_fd_pr__cap_mim_m3_1 l=3 w=3
X103 B10 TOP sky130_fd_pr__cap_mim_m3_1 l=3 w=3
X104 B10 TOP sky130_fd_pr__cap_mim_m3_1 l=3 w=3
X105 B10 TOP sky130_fd_pr__cap_mim_m3_1 l=3 w=3
X106 B11 TOP sky130_fd_pr__cap_mim_m3_1 l=3 w=3
X107 B11 TOP sky130_fd_pr__cap_mim_m3_1 l=3 w=3
X108 B11 TOP sky130_fd_pr__cap_mim_m3_1 l=3 w=3
X109 B11 TOP sky130_fd_pr__cap_mim_m3_1 l=3 w=3
X110 B11 TOP sky130_fd_pr__cap_mim_m3_1 l=3 w=3
X111 B10 TOP sky130_fd_pr__cap_mim_m3_1 l=3 w=3
X112 B10 TOP sky130_fd_pr__cap_mim_m3_1 l=3 w=3
X113 B11 TOP sky130_fd_pr__cap_mim_m3_1 l=3 w=3
X114 B9 TOP sky130_fd_pr__cap_mim_m3_1 l=3 w=3
X115 EDGE_BIAS EDGE_BIAS sky130_fd_pr__cap_mim_m3_1 l=3 w=3
X116 B11 TOP sky130_fd_pr__cap_mim_m3_1 l=3 w=3
X117 B10 TOP sky130_fd_pr__cap_mim_m3_1 l=3 w=3
X118 B11 TOP sky130_fd_pr__cap_mim_m3_1 l=3 w=3
X119 B11 TOP sky130_fd_pr__cap_mim_m3_1 l=3 w=3
X120 B9 TOP sky130_fd_pr__cap_mim_m3_1 l=3 w=3
X121 B8 TOP sky130_fd_pr__cap_mim_m3_1 l=3 w=3
X122 B9 TOP sky130_fd_pr__cap_mim_m3_1 l=3 w=3
X123 B8 TOP sky130_fd_pr__cap_mim_m3_1 l=3 w=3
X124 B8 TOP sky130_fd_pr__cap_mim_m3_1 l=3 w=3
X125 B11 TOP sky130_fd_pr__cap_mim_m3_1 l=3 w=3
X126 B11 TOP sky130_fd_pr__cap_mim_m3_1 l=3 w=3
X127 EDGE_BIAS EDGE_BIAS sky130_fd_pr__cap_mim_m3_1 l=3 w=3
X128 B11 TOP sky130_fd_pr__cap_mim_m3_1 l=3 w=3
X129 B9 TOP sky130_fd_pr__cap_mim_m3_1 l=3 w=3
X130 B7 TOP sky130_fd_pr__cap_mim_m3_1 l=3 w=3
X131 B11 TOP sky130_fd_pr__cap_mim_m3_1 l=3 w=3
X132 B10 TOP sky130_fd_pr__cap_mim_m3_1 l=3 w=3
X133 B8 TOP sky130_fd_pr__cap_mim_m3_1 l=3 w=3
X134 B11 TOP sky130_fd_pr__cap_mim_m3_1 l=3 w=3
X135 B11 TOP sky130_fd_pr__cap_mim_m3_1 l=3 w=3
X136 B6 TOP sky130_fd_pr__cap_mim_m3_1 l=3 w=3
X137 B11 TOP sky130_fd_pr__cap_mim_m3_1 l=3 w=3
X138 B11 TOP sky130_fd_pr__cap_mim_m3_1 l=3 w=3
X139 EDGE_BIAS EDGE_BIAS sky130_fd_pr__cap_mim_m3_1 l=3 w=3
X140 B11 TOP sky130_fd_pr__cap_mim_m3_1 l=3 w=3
X141 B11 TOP sky130_fd_pr__cap_mim_m3_1 l=3 w=3
X142 B11 TOP sky130_fd_pr__cap_mim_m3_1 l=3 w=3
X143 B11 TOP sky130_fd_pr__cap_mim_m3_1 l=3 w=3
X144 B11 TOP sky130_fd_pr__cap_mim_m3_1 l=3 w=3
X145 B9 TOP sky130_fd_pr__cap_mim_m3_1 l=3 w=3
X146 B11 TOP sky130_fd_pr__cap_mim_m3_1 l=3 w=3
X147 B11 TOP sky130_fd_pr__cap_mim_m3_1 l=3 w=3
X148 B9 TOP sky130_fd_pr__cap_mim_m3_1 l=3 w=3
X149 B11 TOP sky130_fd_pr__cap_mim_m3_1 l=3 w=3
X150 B11 TOP sky130_fd_pr__cap_mim_m3_1 l=3 w=3
X151 B10 TOP sky130_fd_pr__cap_mim_m3_1 l=3 w=3
X152 B10 TOP sky130_fd_pr__cap_mim_m3_1 l=3 w=3
X153 B11 TOP sky130_fd_pr__cap_mim_m3_1 l=3 w=3
X154 EDGE_BIAS EDGE_BIAS sky130_fd_pr__cap_mim_m3_1 l=3 w=3
X155 B10 TOP sky130_fd_pr__cap_mim_m3_1 l=3 w=3
X156 B10 TOP sky130_fd_pr__cap_mim_m3_1 l=3 w=3
X157 B10 TOP sky130_fd_pr__cap_mim_m3_1 l=3 w=3
X158 B7 TOP sky130_fd_pr__cap_mim_m3_1 l=3 w=3
X159 B11 TOP sky130_fd_pr__cap_mim_m3_1 l=3 w=3
X160 EDGE_BIAS EDGE_BIAS sky130_fd_pr__cap_mim_m3_1 l=3 w=3
X161 B11 TOP sky130_fd_pr__cap_mim_m3_1 l=3 w=3
X162 B10 TOP sky130_fd_pr__cap_mim_m3_1 l=3 w=3
X163 B10 TOP sky130_fd_pr__cap_mim_m3_1 l=3 w=3
X164 B8 TOP sky130_fd_pr__cap_mim_m3_1 l=3 w=3
X165 B11 TOP sky130_fd_pr__cap_mim_m3_1 l=3 w=3
X166 B11 TOP sky130_fd_pr__cap_mim_m3_1 l=3 w=3
X167 B11 TOP sky130_fd_pr__cap_mim_m3_1 l=3 w=3
X168 B9 TOP sky130_fd_pr__cap_mim_m3_1 l=3 w=3
X169 EDGE_BIAS EDGE_BIAS sky130_fd_pr__cap_mim_m3_1 l=3 w=3
X170 B11 TOP sky130_fd_pr__cap_mim_m3_1 l=3 w=3
X171 B11 TOP sky130_fd_pr__cap_mim_m3_1 l=3 w=3
X172 B11 TOP sky130_fd_pr__cap_mim_m3_1 l=3 w=3
X173 B10 TOP sky130_fd_pr__cap_mim_m3_1 l=3 w=3
X174 B11 TOP sky130_fd_pr__cap_mim_m3_1 l=3 w=3
X175 B11 TOP sky130_fd_pr__cap_mim_m3_1 l=3 w=3
X176 B11 TOP sky130_fd_pr__cap_mim_m3_1 l=3 w=3
X177 B8 TOP sky130_fd_pr__cap_mim_m3_1 l=3 w=3
X178 B9 TOP sky130_fd_pr__cap_mim_m3_1 l=3 w=3
X179 B10 TOP sky130_fd_pr__cap_mim_m3_1 l=3 w=3
X180 B11 TOP sky130_fd_pr__cap_mim_m3_1 l=3 w=3
X181 B11 TOP sky130_fd_pr__cap_mim_m3_1 l=3 w=3
X182 EDGE_BIAS EDGE_BIAS sky130_fd_pr__cap_mim_m3_1 l=3 w=3
X183 B11 TOP sky130_fd_pr__cap_mim_m3_1 l=3 w=3
X184 B9 TOP sky130_fd_pr__cap_mim_m3_1 l=3 w=3
X185 B7 TOP sky130_fd_pr__cap_mim_m3_1 l=3 w=3
X186 B7 TOP sky130_fd_pr__cap_mim_m3_1 l=3 w=3
X187 B11 TOP sky130_fd_pr__cap_mim_m3_1 l=3 w=3
X188 B11 TOP sky130_fd_pr__cap_mim_m3_1 l=3 w=3
X189 B10 TOP sky130_fd_pr__cap_mim_m3_1 l=3 w=3
X190 B8 TOP sky130_fd_pr__cap_mim_m3_1 l=3 w=3
X191 B11 TOP sky130_fd_pr__cap_mim_m3_1 l=3 w=3
X192 B8 TOP sky130_fd_pr__cap_mim_m3_1 l=3 w=3
X193 B11 TOP sky130_fd_pr__cap_mim_m3_1 l=3 w=3
X194 B6 TOP sky130_fd_pr__cap_mim_m3_1 l=3 w=3
X195 B10 TOP sky130_fd_pr__cap_mim_m3_1 l=3 w=3
X196 B11 TOP sky130_fd_pr__cap_mim_m3_1 l=3 w=3
X197 B9 TOP sky130_fd_pr__cap_mim_m3_1 l=3 w=3
X198 B9 TOP sky130_fd_pr__cap_mim_m3_1 l=3 w=3
X199 B11 TOP sky130_fd_pr__cap_mim_m3_1 l=3 w=3
X200 B11 TOP sky130_fd_pr__cap_mim_m3_1 l=3 w=3
X201 B11 TOP sky130_fd_pr__cap_mim_m3_1 l=3 w=3
X202 B11 TOP sky130_fd_pr__cap_mim_m3_1 l=3 w=3
X203 B11 TOP sky130_fd_pr__cap_mim_m3_1 l=3 w=3
X204 B11 TOP sky130_fd_pr__cap_mim_m3_1 l=3 w=3
X205 B11 TOP sky130_fd_pr__cap_mim_m3_1 l=3 w=3
X206 B11 TOP sky130_fd_pr__cap_mim_m3_1 l=3 w=3
X207 B11 TOP sky130_fd_pr__cap_mim_m3_1 l=3 w=3
X208 B11 TOP sky130_fd_pr__cap_mim_m3_1 l=3 w=3
X209 B9 TOP sky130_fd_pr__cap_mim_m3_1 l=3 w=3
X210 B11 TOP sky130_fd_pr__cap_mim_m3_1 l=3 w=3
X211 B10 TOP sky130_fd_pr__cap_mim_m3_1 l=3 w=3
X212 B11 TOP sky130_fd_pr__cap_mim_m3_1 l=3 w=3
X213 B10 TOP sky130_fd_pr__cap_mim_m3_1 l=3 w=3
X214 B11 TOP sky130_fd_pr__cap_mim_m3_1 l=3 w=3
X215 B9 TOP sky130_fd_pr__cap_mim_m3_1 l=3 w=3
X216 B11 TOP sky130_fd_pr__cap_mim_m3_1 l=3 w=3
X217 B10 TOP sky130_fd_pr__cap_mim_m3_1 l=3 w=3
X218 B7 TOP sky130_fd_pr__cap_mim_m3_1 l=3 w=3
X219 EDGE_BIAS EDGE_BIAS sky130_fd_pr__cap_mim_m3_1 l=3 w=3
X220 B10 TOP sky130_fd_pr__cap_mim_m3_1 l=3 w=3
X221 B7 TOP sky130_fd_pr__cap_mim_m3_1 l=3 w=3
X222 B11 TOP sky130_fd_pr__cap_mim_m3_1 l=3 w=3
X223 B10 TOP sky130_fd_pr__cap_mim_m3_1 l=3 w=3
X224 B11 TOP sky130_fd_pr__cap_mim_m3_1 l=3 w=3
X225 B8 TOP sky130_fd_pr__cap_mim_m3_1 l=3 w=3
X226 B10 TOP sky130_fd_pr__cap_mim_m3_1 l=3 w=3
X227 B11 TOP sky130_fd_pr__cap_mim_m3_1 l=3 w=3
X228 B11 TOP sky130_fd_pr__cap_mim_m3_1 l=3 w=3
X229 B11 TOP sky130_fd_pr__cap_mim_m3_1 l=3 w=3
X230 B11 TOP sky130_fd_pr__cap_mim_m3_1 l=3 w=3
X231 B10 TOP sky130_fd_pr__cap_mim_m3_1 l=3 w=3
X232 B11 TOP sky130_fd_pr__cap_mim_m3_1 l=3 w=3
X233 B11 TOP sky130_fd_pr__cap_mim_m3_1 l=3 w=3
X234 B11 TOP sky130_fd_pr__cap_mim_m3_1 l=3 w=3
X235 B10 TOP sky130_fd_pr__cap_mim_m3_1 l=3 w=3
X236 B11 TOP sky130_fd_pr__cap_mim_m3_1 l=3 w=3
X237 B11 TOP sky130_fd_pr__cap_mim_m3_1 l=3 w=3
X238 B10 TOP sky130_fd_pr__cap_mim_m3_1 l=3 w=3
X239 B9 TOP sky130_fd_pr__cap_mim_m3_1 l=3 w=3
X240 B11 TOP sky130_fd_pr__cap_mim_m3_1 l=3 w=3
X241 EDGE_BIAS EDGE_BIAS sky130_fd_pr__cap_mim_m3_1 l=3 w=3
X242 B8 TOP sky130_fd_pr__cap_mim_m3_1 l=3 w=3
X243 EDGE_BIAS EDGE_BIAS sky130_fd_pr__cap_mim_m3_1 l=3 w=3
X244 B10 TOP sky130_fd_pr__cap_mim_m3_1 l=3 w=3
X245 B11 TOP sky130_fd_pr__cap_mim_m3_1 l=3 w=3
X246 B11 TOP sky130_fd_pr__cap_mim_m3_1 l=3 w=3
X247 B9 TOP sky130_fd_pr__cap_mim_m3_1 l=3 w=3
X248 B7 TOP sky130_fd_pr__cap_mim_m3_1 l=3 w=3
X249 B11 TOP sky130_fd_pr__cap_mim_m3_1 l=3 w=3
X250 B11 TOP sky130_fd_pr__cap_mim_m3_1 l=3 w=3
X251 B10 TOP sky130_fd_pr__cap_mim_m3_1 l=3 w=3
X252 B8 TOP sky130_fd_pr__cap_mim_m3_1 l=3 w=3
X253 B11 TOP sky130_fd_pr__cap_mim_m3_1 l=3 w=3
X254 B11 TOP sky130_fd_pr__cap_mim_m3_1 l=3 w=3
X255 B9 TOP sky130_fd_pr__cap_mim_m3_1 l=3 w=3
X256 B11 TOP sky130_fd_pr__cap_mim_m3_1 l=3 w=3
X257 B10 TOP sky130_fd_pr__cap_mim_m3_1 l=3 w=3
X258 B11 TOP sky130_fd_pr__cap_mim_m3_1 l=3 w=3
X259 B9 TOP sky130_fd_pr__cap_mim_m3_1 l=3 w=3
X260 B11 TOP sky130_fd_pr__cap_mim_m3_1 l=3 w=3
X261 B9 TOP sky130_fd_pr__cap_mim_m3_1 l=3 w=3
X262 B11 TOP sky130_fd_pr__cap_mim_m3_1 l=3 w=3
X263 B6 TOP sky130_fd_pr__cap_mim_m3_1 l=3 w=3
X264 B11 TOP sky130_fd_pr__cap_mim_m3_1 l=3 w=3
X265 B10 TOP sky130_fd_pr__cap_mim_m3_1 l=3 w=3
X266 B11 TOP sky130_fd_pr__cap_mim_m3_1 l=3 w=3
X267 B9 TOP sky130_fd_pr__cap_mim_m3_1 l=3 w=3
X268 B9 TOP sky130_fd_pr__cap_mim_m3_1 l=3 w=3
X269 B7 TOP sky130_fd_pr__cap_mim_m3_1 l=3 w=3
X270 B10 TOP sky130_fd_pr__cap_mim_m3_1 l=3 w=3
X271 B10 TOP sky130_fd_pr__cap_mim_m3_1 l=3 w=3
X272 B11 TOP sky130_fd_pr__cap_mim_m3_1 l=3 w=3
X273 B11 TOP sky130_fd_pr__cap_mim_m3_1 l=3 w=3
X274 EDGE_BIAS EDGE_BIAS sky130_fd_pr__cap_mim_m3_1 l=3 w=3
X275 B11 TOP sky130_fd_pr__cap_mim_m3_1 l=3 w=3
X276 B11 TOP sky130_fd_pr__cap_mim_m3_1 l=3 w=3
X277 B9 TOP sky130_fd_pr__cap_mim_m3_1 l=3 w=3
X278 B11 TOP sky130_fd_pr__cap_mim_m3_1 l=3 w=3
X279 B11 TOP sky130_fd_pr__cap_mim_m3_1 l=3 w=3
X280 B10 TOP sky130_fd_pr__cap_mim_m3_1 l=3 w=3
X281 B10 TOP sky130_fd_pr__cap_mim_m3_1 l=3 w=3
X282 B7 TOP sky130_fd_pr__cap_mim_m3_1 l=3 w=3
X283 B10 TOP sky130_fd_pr__cap_mim_m3_1 l=3 w=3
X284 B11 TOP sky130_fd_pr__cap_mim_m3_1 l=3 w=3
X285 B9 TOP sky130_fd_pr__cap_mim_m3_1 l=3 w=3
X286 B11 TOP sky130_fd_pr__cap_mim_m3_1 l=3 w=3
X287 B10 TOP sky130_fd_pr__cap_mim_m3_1 l=3 w=3
X288 B10 TOP sky130_fd_pr__cap_mim_m3_1 l=3 w=3
X289 B10 TOP sky130_fd_pr__cap_mim_m3_1 l=3 w=3
X290 B11 TOP sky130_fd_pr__cap_mim_m3_1 l=3 w=3
X291 B10 TOP sky130_fd_pr__cap_mim_m3_1 l=3 w=3
X292 B10 TOP sky130_fd_pr__cap_mim_m3_1 l=3 w=3
X293 B11 TOP sky130_fd_pr__cap_mim_m3_1 l=3 w=3
X294 B10 TOP sky130_fd_pr__cap_mim_m3_1 l=3 w=3
X295 B11 TOP sky130_fd_pr__cap_mim_m3_1 l=3 w=3
X296 B11 TOP sky130_fd_pr__cap_mim_m3_1 l=3 w=3
X297 B11 TOP sky130_fd_pr__cap_mim_m3_1 l=3 w=3
X298 B10 TOP sky130_fd_pr__cap_mim_m3_1 l=3 w=3
X299 B11 TOP sky130_fd_pr__cap_mim_m3_1 l=3 w=3
X300 B7 TOP sky130_fd_pr__cap_mim_m3_1 l=3 w=3
X301 B11 TOP sky130_fd_pr__cap_mim_m3_1 l=3 w=3
X302 B8 TOP sky130_fd_pr__cap_mim_m3_1 l=3 w=3
X303 B9 TOP sky130_fd_pr__cap_mim_m3_1 l=3 w=3
X304 B10 TOP sky130_fd_pr__cap_mim_m3_1 l=3 w=3
X305 EDGE_BIAS EDGE_BIAS sky130_fd_pr__cap_mim_m3_1 l=3 w=3
X306 B10 TOP sky130_fd_pr__cap_mim_m3_1 l=3 w=3
X307 B11 TOP sky130_fd_pr__cap_mim_m3_1 l=3 w=3
X308 B11 TOP sky130_fd_pr__cap_mim_m3_1 l=3 w=3
X309 B11 TOP sky130_fd_pr__cap_mim_m3_1 l=3 w=3
X310 B9 TOP sky130_fd_pr__cap_mim_m3_1 l=3 w=3
X311 B7 TOP sky130_fd_pr__cap_mim_m3_1 l=3 w=3
X312 B11 TOP sky130_fd_pr__cap_mim_m3_1 l=3 w=3
X313 B10 TOP sky130_fd_pr__cap_mim_m3_1 l=3 w=3
X314 B10 TOP sky130_fd_pr__cap_mim_m3_1 l=3 w=3
X315 B8 TOP sky130_fd_pr__cap_mim_m3_1 l=3 w=3
X316 B11 TOP sky130_fd_pr__cap_mim_m3_1 l=3 w=3
X317 B11 TOP sky130_fd_pr__cap_mim_m3_1 l=3 w=3
X318 B10 TOP sky130_fd_pr__cap_mim_m3_1 l=3 w=3
X319 B6 TOP sky130_fd_pr__cap_mim_m3_1 l=3 w=3
X320 B11 TOP sky130_fd_pr__cap_mim_m3_1 l=3 w=3
X321 B9 TOP sky130_fd_pr__cap_mim_m3_1 l=3 w=3
X322 B11 TOP sky130_fd_pr__cap_mim_m3_1 l=3 w=3
X323 B7 TOP sky130_fd_pr__cap_mim_m3_1 l=3 w=3
X324 B11 TOP sky130_fd_pr__cap_mim_m3_1 l=3 w=3
X325 EDGE_BIAS EDGE_BIAS sky130_fd_pr__cap_mim_m3_1 l=3 w=3
X326 B11 TOP sky130_fd_pr__cap_mim_m3_1 l=3 w=3
X327 B11 TOP sky130_fd_pr__cap_mim_m3_1 l=3 w=3
X328 B11 TOP sky130_fd_pr__cap_mim_m3_1 l=3 w=3
X329 B9 TOP sky130_fd_pr__cap_mim_m3_1 l=3 w=3
X330 B11 TOP sky130_fd_pr__cap_mim_m3_1 l=3 w=3
X331 B11 TOP sky130_fd_pr__cap_mim_m3_1 l=3 w=3
X332 B11 TOP sky130_fd_pr__cap_mim_m3_1 l=3 w=3
X333 B10 TOP sky130_fd_pr__cap_mim_m3_1 l=3 w=3
X334 B11 TOP sky130_fd_pr__cap_mim_m3_1 l=3 w=3
X335 B9 TOP sky130_fd_pr__cap_mim_m3_1 l=3 w=3
X336 B11 TOP sky130_fd_pr__cap_mim_m3_1 l=3 w=3
X337 B10 TOP sky130_fd_pr__cap_mim_m3_1 l=3 w=3
X338 B10 TOP sky130_fd_pr__cap_mim_m3_1 l=3 w=3
X339 B9 TOP sky130_fd_pr__cap_mim_m3_1 l=3 w=3
X340 EDGE_BIAS EDGE_BIAS sky130_fd_pr__cap_mim_m3_1 l=3 w=3
X341 B10 TOP sky130_fd_pr__cap_mim_m3_1 l=3 w=3
X342 B7 TOP sky130_fd_pr__cap_mim_m3_1 l=3 w=3
X343 B9 TOP sky130_fd_pr__cap_mim_m3_1 l=3 w=3
X344 B9 TOP sky130_fd_pr__cap_mim_m3_1 l=3 w=3
X345 B11 TOP sky130_fd_pr__cap_mim_m3_1 l=3 w=3
X346 B10 TOP sky130_fd_pr__cap_mim_m3_1 l=3 w=3
X347 B8 TOP sky130_fd_pr__cap_mim_m3_1 l=3 w=3
X348 B11 TOP sky130_fd_pr__cap_mim_m3_1 l=3 w=3
X349 B11 TOP sky130_fd_pr__cap_mim_m3_1 l=3 w=3
X350 B11 TOP sky130_fd_pr__cap_mim_m3_1 l=3 w=3
X351 B11 TOP sky130_fd_pr__cap_mim_m3_1 l=3 w=3
X352 B10 TOP sky130_fd_pr__cap_mim_m3_1 l=3 w=3
X353 B11 TOP sky130_fd_pr__cap_mim_m3_1 l=3 w=3
X354 B11 TOP sky130_fd_pr__cap_mim_m3_1 l=3 w=3
X355 B11 TOP sky130_fd_pr__cap_mim_m3_1 l=3 w=3
X356 B10 TOP sky130_fd_pr__cap_mim_m3_1 l=3 w=3
X357 B11 TOP sky130_fd_pr__cap_mim_m3_1 l=3 w=3
X358 B11 TOP sky130_fd_pr__cap_mim_m3_1 l=3 w=3
X359 B11 TOP sky130_fd_pr__cap_mim_m3_1 l=3 w=3
X360 B8 TOP sky130_fd_pr__cap_mim_m3_1 l=3 w=3
X361 EDGE_BIAS EDGE_BIAS sky130_fd_pr__cap_mim_m3_1 l=3 w=3
X362 B10 TOP sky130_fd_pr__cap_mim_m3_1 l=3 w=3
X363 B11 TOP sky130_fd_pr__cap_mim_m3_1 l=3 w=3
X364 B11 TOP sky130_fd_pr__cap_mim_m3_1 l=3 w=3
X365 B11 TOP sky130_fd_pr__cap_mim_m3_1 l=3 w=3
X366 B9 TOP sky130_fd_pr__cap_mim_m3_1 l=3 w=3
X367 B7 TOP sky130_fd_pr__cap_mim_m3_1 l=3 w=3
X368 B11 TOP sky130_fd_pr__cap_mim_m3_1 l=3 w=3
X369 B7 TOP sky130_fd_pr__cap_mim_m3_1 l=3 w=3
X370 B10 TOP sky130_fd_pr__cap_mim_m3_1 l=3 w=3
X371 B11 TOP sky130_fd_pr__cap_mim_m3_1 l=3 w=3
X372 B10 TOP sky130_fd_pr__cap_mim_m3_1 l=3 w=3
X373 B8 TOP sky130_fd_pr__cap_mim_m3_1 l=3 w=3
X374 B11 TOP sky130_fd_pr__cap_mim_m3_1 l=3 w=3
X375 B5 TOP sky130_fd_pr__cap_mim_m3_1 l=3 w=3
X376 B11 TOP sky130_fd_pr__cap_mim_m3_1 l=3 w=3
X377 B10 TOP sky130_fd_pr__cap_mim_m3_1 l=3 w=3
X378 B11 TOP sky130_fd_pr__cap_mim_m3_1 l=3 w=3
X379 B9 TOP sky130_fd_pr__cap_mim_m3_1 l=3 w=3
X380 B11 TOP sky130_fd_pr__cap_mim_m3_1 l=3 w=3
X381 EDGE_BIAS EDGE_BIAS sky130_fd_pr__cap_mim_m3_1 l=3 w=3
X382 B11 TOP sky130_fd_pr__cap_mim_m3_1 l=3 w=3
X383 B11 TOP sky130_fd_pr__cap_mim_m3_1 l=3 w=3
X384 B10 TOP sky130_fd_pr__cap_mim_m3_1 l=3 w=3
X385 EDGE_BIAS EDGE_BIAS sky130_fd_pr__cap_mim_m3_1 l=3 w=3
X386 B11 TOP sky130_fd_pr__cap_mim_m3_1 l=3 w=3
X387 B9 TOP sky130_fd_pr__cap_mim_m3_1 l=3 w=3
X388 EDGE_BIAS EDGE_BIAS sky130_fd_pr__cap_mim_m3_1 l=3 w=3
X389 B11 TOP sky130_fd_pr__cap_mim_m3_1 l=3 w=3
X390 B11 TOP sky130_fd_pr__cap_mim_m3_1 l=3 w=3
X391 EDGE_BIAS EDGE_BIAS sky130_fd_pr__cap_mim_m3_1 l=3 w=3
X392 B11 TOP sky130_fd_pr__cap_mim_m3_1 l=3 w=3
X393 B9 TOP sky130_fd_pr__cap_mim_m3_1 l=3 w=3
X394 B11 TOP sky130_fd_pr__cap_mim_m3_1 l=3 w=3
X395 B10 TOP sky130_fd_pr__cap_mim_m3_1 l=3 w=3
X396 B7 TOP sky130_fd_pr__cap_mim_m3_1 l=3 w=3
X397 B7 TOP sky130_fd_pr__cap_mim_m3_1 l=3 w=3
X398 B9 TOP sky130_fd_pr__cap_mim_m3_1 l=3 w=3
X399 B11 TOP sky130_fd_pr__cap_mim_m3_1 l=3 w=3
X400 B8 TOP sky130_fd_pr__cap_mim_m3_1 l=3 w=3
X401 B9 TOP sky130_fd_pr__cap_mim_m3_1 l=3 w=3
X402 B10 TOP sky130_fd_pr__cap_mim_m3_1 l=3 w=3
X403 B11 TOP sky130_fd_pr__cap_mim_m3_1 l=3 w=3
X404 B11 TOP sky130_fd_pr__cap_mim_m3_1 l=3 w=3
X405 B8 TOP sky130_fd_pr__cap_mim_m3_1 l=3 w=3
X406 B11 TOP sky130_fd_pr__cap_mim_m3_1 l=3 w=3
X407 B6 TOP sky130_fd_pr__cap_mim_m3_1 l=3 w=3
X408 B11 TOP sky130_fd_pr__cap_mim_m3_1 l=3 w=3
X409 B11 TOP sky130_fd_pr__cap_mim_m3_1 l=3 w=3
X410 B11 TOP sky130_fd_pr__cap_mim_m3_1 l=3 w=3
X411 B8 TOP sky130_fd_pr__cap_mim_m3_1 l=3 w=3
X412 B11 TOP sky130_fd_pr__cap_mim_m3_1 l=3 w=3
X413 B10 TOP sky130_fd_pr__cap_mim_m3_1 l=3 w=3
X414 B11 TOP sky130_fd_pr__cap_mim_m3_1 l=3 w=3
X415 B11 TOP sky130_fd_pr__cap_mim_m3_1 l=3 w=3
X416 B11 TOP sky130_fd_pr__cap_mim_m3_1 l=3 w=3
X417 B10 TOP sky130_fd_pr__cap_mim_m3_1 l=3 w=3
X418 B9 TOP sky130_fd_pr__cap_mim_m3_1 l=3 w=3
X419 B11 TOP sky130_fd_pr__cap_mim_m3_1 l=3 w=3
X420 B11 TOP sky130_fd_pr__cap_mim_m3_1 l=3 w=3
X421 EDGE_BIAS EDGE_BIAS sky130_fd_pr__cap_mim_m3_1 l=3 w=3
X422 B11 TOP sky130_fd_pr__cap_mim_m3_1 l=3 w=3
X423 B11 TOP sky130_fd_pr__cap_mim_m3_1 l=3 w=3
X424 B10 TOP sky130_fd_pr__cap_mim_m3_1 l=3 w=3
X425 B11 TOP sky130_fd_pr__cap_mim_m3_1 l=3 w=3
X426 B11 TOP sky130_fd_pr__cap_mim_m3_1 l=3 w=3
X427 B7 TOP sky130_fd_pr__cap_mim_m3_1 l=3 w=3
X428 B11 TOP sky130_fd_pr__cap_mim_m3_1 l=3 w=3
X429 B11 TOP sky130_fd_pr__cap_mim_m3_1 l=3 w=3
X430 B10 TOP sky130_fd_pr__cap_mim_m3_1 l=3 w=3
X431 B10 TOP sky130_fd_pr__cap_mim_m3_1 l=3 w=3
X432 B11 TOP sky130_fd_pr__cap_mim_m3_1 l=3 w=3
X433 B6 TOP sky130_fd_pr__cap_mim_m3_1 l=3 w=3
X434 B10 TOP sky130_fd_pr__cap_mim_m3_1 l=3 w=3
X435 B10 TOP sky130_fd_pr__cap_mim_m3_1 l=3 w=3
X436 B10 TOP sky130_fd_pr__cap_mim_m3_1 l=3 w=3
X437 B9 TOP sky130_fd_pr__cap_mim_m3_1 l=3 w=3
X438 B9 TOP sky130_fd_pr__cap_mim_m3_1 l=3 w=3
X439 B10 TOP sky130_fd_pr__cap_mim_m3_1 l=3 w=3
X440 B11 TOP sky130_fd_pr__cap_mim_m3_1 l=3 w=3
X441 B9 TOP sky130_fd_pr__cap_mim_m3_1 l=3 w=3
X442 B11 TOP sky130_fd_pr__cap_mim_m3_1 l=3 w=3
X443 B11 TOP sky130_fd_pr__cap_mim_m3_1 l=3 w=3
X444 B9 TOP sky130_fd_pr__cap_mim_m3_1 l=3 w=3
X445 B10 TOP sky130_fd_pr__cap_mim_m3_1 l=3 w=3
X446 B11 TOP sky130_fd_pr__cap_mim_m3_1 l=3 w=3
X447 EDGE_BIAS EDGE_BIAS sky130_fd_pr__cap_mim_m3_1 l=3 w=3
X448 B11 TOP sky130_fd_pr__cap_mim_m3_1 l=3 w=3
X449 B11 TOP sky130_fd_pr__cap_mim_m3_1 l=3 w=3
X450 B11 TOP sky130_fd_pr__cap_mim_m3_1 l=3 w=3
X451 B10 TOP sky130_fd_pr__cap_mim_m3_1 l=3 w=3
X452 B11 TOP sky130_fd_pr__cap_mim_m3_1 l=3 w=3
X453 B11 TOP sky130_fd_pr__cap_mim_m3_1 l=3 w=3
X454 B11 TOP sky130_fd_pr__cap_mim_m3_1 l=3 w=3
X455 B9 TOP sky130_fd_pr__cap_mim_m3_1 l=3 w=3
X456 B10 TOP sky130_fd_pr__cap_mim_m3_1 l=3 w=3
X457 B7 TOP sky130_fd_pr__cap_mim_m3_1 l=3 w=3
X458 B11 TOP sky130_fd_pr__cap_mim_m3_1 l=3 w=3
X459 B9 TOP sky130_fd_pr__cap_mim_m3_1 l=3 w=3
X460 B8 TOP sky130_fd_pr__cap_mim_m3_1 l=3 w=3
X461 EDGE_BIAS EDGE_BIAS sky130_fd_pr__cap_mim_m3_1 l=3 w=3
X462 B10 TOP sky130_fd_pr__cap_mim_m3_1 l=3 w=3
X463 B8 TOP sky130_fd_pr__cap_mim_m3_1 l=3 w=3
X464 B9 TOP sky130_fd_pr__cap_mim_m3_1 l=3 w=3
X465 B10 TOP sky130_fd_pr__cap_mim_m3_1 l=3 w=3
X466 B11 TOP sky130_fd_pr__cap_mim_m3_1 l=3 w=3
X467 B11 TOP sky130_fd_pr__cap_mim_m3_1 l=3 w=3
X468 B11 TOP sky130_fd_pr__cap_mim_m3_1 l=3 w=3
X469 B10 TOP sky130_fd_pr__cap_mim_m3_1 l=3 w=3
X470 B11 TOP sky130_fd_pr__cap_mim_m3_1 l=3 w=3
X471 B10 TOP sky130_fd_pr__cap_mim_m3_1 l=3 w=3
X472 B11 TOP sky130_fd_pr__cap_mim_m3_1 l=3 w=3
X473 B11 TOP sky130_fd_pr__cap_mim_m3_1 l=3 w=3
X474 B11 TOP sky130_fd_pr__cap_mim_m3_1 l=3 w=3
X475 B11 TOP sky130_fd_pr__cap_mim_m3_1 l=3 w=3
X476 B10 TOP sky130_fd_pr__cap_mim_m3_1 l=3 w=3
X477 B8 TOP sky130_fd_pr__cap_mim_m3_1 l=3 w=3
X478 B11 TOP sky130_fd_pr__cap_mim_m3_1 l=3 w=3
X479 B10 TOP sky130_fd_pr__cap_mim_m3_1 l=3 w=3
X480 B10 TOP sky130_fd_pr__cap_mim_m3_1 l=3 w=3
X481 B11 TOP sky130_fd_pr__cap_mim_m3_1 l=3 w=3
X482 B7 TOP sky130_fd_pr__cap_mim_m3_1 l=3 w=3
X483 B11 TOP sky130_fd_pr__cap_mim_m3_1 l=3 w=3
X484 B10 TOP sky130_fd_pr__cap_mim_m3_1 l=3 w=3
X485 B10 TOP sky130_fd_pr__cap_mim_m3_1 l=3 w=3
X486 B11 TOP sky130_fd_pr__cap_mim_m3_1 l=3 w=3
X487 B6 TOP sky130_fd_pr__cap_mim_m3_1 l=3 w=3
X488 B11 TOP sky130_fd_pr__cap_mim_m3_1 l=3 w=3
X489 B10 TOP sky130_fd_pr__cap_mim_m3_1 l=3 w=3
X490 B10 TOP sky130_fd_pr__cap_mim_m3_1 l=3 w=3
X491 B9 TOP sky130_fd_pr__cap_mim_m3_1 l=3 w=3
X492 B11 TOP sky130_fd_pr__cap_mim_m3_1 l=3 w=3
X493 B11 TOP sky130_fd_pr__cap_mim_m3_1 l=3 w=3
X494 EDGE_BIAS EDGE_BIAS sky130_fd_pr__cap_mim_m3_1 l=3 w=3
X495 B11 TOP sky130_fd_pr__cap_mim_m3_1 l=3 w=3
X496 B11 TOP sky130_fd_pr__cap_mim_m3_1 l=3 w=3
X497 B11 TOP sky130_fd_pr__cap_mim_m3_1 l=3 w=3
X498 EDGE_BIAS EDGE_BIAS sky130_fd_pr__cap_mim_m3_1 l=3 w=3
X499 B9 TOP sky130_fd_pr__cap_mim_m3_1 l=3 w=3
X500 B11 TOP sky130_fd_pr__cap_mim_m3_1 l=3 w=3
X501 B11 TOP sky130_fd_pr__cap_mim_m3_1 l=3 w=3
X502 B11 TOP sky130_fd_pr__cap_mim_m3_1 l=3 w=3
X503 B9 TOP sky130_fd_pr__cap_mim_m3_1 l=3 w=3
X504 B6 TOP sky130_fd_pr__cap_mim_m3_1 l=3 w=3
X505 B9 TOP sky130_fd_pr__cap_mim_m3_1 l=3 w=3
X506 B11 TOP sky130_fd_pr__cap_mim_m3_1 l=3 w=3
X507 B7 TOP sky130_fd_pr__cap_mim_m3_1 l=3 w=3
X508 B11 TOP sky130_fd_pr__cap_mim_m3_1 l=3 w=3
X509 EDGE_BIAS EDGE_BIAS sky130_fd_pr__cap_mim_m3_1 l=3 w=3
X510 B11 TOP sky130_fd_pr__cap_mim_m3_1 l=3 w=3
X511 B9 TOP sky130_fd_pr__cap_mim_m3_1 l=3 w=3
X512 B9 TOP sky130_fd_pr__cap_mim_m3_1 l=3 w=3
X513 B11 TOP sky130_fd_pr__cap_mim_m3_1 l=3 w=3
X514 B11 TOP sky130_fd_pr__cap_mim_m3_1 l=3 w=3
X515 B11 TOP sky130_fd_pr__cap_mim_m3_1 l=3 w=3
X516 B10 TOP sky130_fd_pr__cap_mim_m3_1 l=3 w=3
X517 B8 TOP sky130_fd_pr__cap_mim_m3_1 l=3 w=3
X518 B9 TOP sky130_fd_pr__cap_mim_m3_1 l=3 w=3
X519 B11 TOP sky130_fd_pr__cap_mim_m3_1 l=3 w=3
X520 B11 TOP sky130_fd_pr__cap_mim_m3_1 l=3 w=3
X521 B10 TOP sky130_fd_pr__cap_mim_m3_1 l=3 w=3
X522 B11 TOP sky130_fd_pr__cap_mim_m3_1 l=3 w=3
X523 B11 TOP sky130_fd_pr__cap_mim_m3_1 l=3 w=3
X524 B10 TOP sky130_fd_pr__cap_mim_m3_1 l=3 w=3
X525 B11 TOP sky130_fd_pr__cap_mim_m3_1 l=3 w=3
X526 EDGE_BIAS EDGE_BIAS sky130_fd_pr__cap_mim_m3_1 l=3 w=3
X527 B11 TOP sky130_fd_pr__cap_mim_m3_1 l=3 w=3
X528 B11 TOP sky130_fd_pr__cap_mim_m3_1 l=3 w=3
X529 B11 TOP sky130_fd_pr__cap_mim_m3_1 l=3 w=3
X530 B11 TOP sky130_fd_pr__cap_mim_m3_1 l=3 w=3
X531 B11 TOP sky130_fd_pr__cap_mim_m3_1 l=3 w=3
X532 B11 TOP sky130_fd_pr__cap_mim_m3_1 l=3 w=3
X533 B10 TOP sky130_fd_pr__cap_mim_m3_1 l=3 w=3
X534 B8 TOP sky130_fd_pr__cap_mim_m3_1 l=3 w=3
X535 B11 TOP sky130_fd_pr__cap_mim_m3_1 l=3 w=3
X536 B11 TOP sky130_fd_pr__cap_mim_m3_1 l=3 w=3
X537 B11 TOP sky130_fd_pr__cap_mim_m3_1 l=3 w=3
X538 B9 TOP sky130_fd_pr__cap_mim_m3_1 l=3 w=3
X539 B10 TOP sky130_fd_pr__cap_mim_m3_1 l=3 w=3
X540 B10 TOP sky130_fd_pr__cap_mim_m3_1 l=3 w=3
X541 B11 TOP sky130_fd_pr__cap_mim_m3_1 l=3 w=3
X542 B11 TOP sky130_fd_pr__cap_mim_m3_1 l=3 w=3
X543 B8 TOP sky130_fd_pr__cap_mim_m3_1 l=3 w=3
X544 B10 TOP sky130_fd_pr__cap_mim_m3_1 l=3 w=3
X545 B11 TOP sky130_fd_pr__cap_mim_m3_1 l=3 w=3
X546 B5 TOP sky130_fd_pr__cap_mim_m3_1 l=3 w=3
X547 B9 TOP sky130_fd_pr__cap_mim_m3_1 l=3 w=3
X548 EDGE_BIAS EDGE_BIAS sky130_fd_pr__cap_mim_m3_1 l=3 w=3
X549 B11 TOP sky130_fd_pr__cap_mim_m3_1 l=3 w=3
X550 B10 TOP sky130_fd_pr__cap_mim_m3_1 l=3 w=3
X551 B11 TOP sky130_fd_pr__cap_mim_m3_1 l=3 w=3
X552 EDGE_BIAS EDGE_BIAS sky130_fd_pr__cap_mim_m3_1 l=3 w=3
X553 B11 TOP sky130_fd_pr__cap_mim_m3_1 l=3 w=3
X554 B11 TOP sky130_fd_pr__cap_mim_m3_1 l=3 w=3
X555 B11 TOP sky130_fd_pr__cap_mim_m3_1 l=3 w=3
X556 B11 TOP sky130_fd_pr__cap_mim_m3_1 l=3 w=3
X557 B11 TOP sky130_fd_pr__cap_mim_m3_1 l=3 w=3
X558 B11 TOP sky130_fd_pr__cap_mim_m3_1 l=3 w=3
X559 B9 TOP sky130_fd_pr__cap_mim_m3_1 l=3 w=3
X560 B10 TOP sky130_fd_pr__cap_mim_m3_1 l=3 w=3
X561 B10 TOP sky130_fd_pr__cap_mim_m3_1 l=3 w=3
X562 B11 TOP sky130_fd_pr__cap_mim_m3_1 l=3 w=3
X563 B9 TOP sky130_fd_pr__cap_mim_m3_1 l=3 w=3
X564 B11 TOP sky130_fd_pr__cap_mim_m3_1 l=3 w=3
X565 B8 TOP sky130_fd_pr__cap_mim_m3_1 l=3 w=3
X566 B9 TOP sky130_fd_pr__cap_mim_m3_1 l=3 w=3
X567 B11 TOP sky130_fd_pr__cap_mim_m3_1 l=3 w=3
X568 B10 TOP sky130_fd_pr__cap_mim_m3_1 l=3 w=3
X569 B8 TOP sky130_fd_pr__cap_mim_m3_1 l=3 w=3
X570 B11 TOP sky130_fd_pr__cap_mim_m3_1 l=3 w=3
X571 B11 TOP sky130_fd_pr__cap_mim_m3_1 l=3 w=3
X572 B11 TOP sky130_fd_pr__cap_mim_m3_1 l=3 w=3
X573 B8 TOP sky130_fd_pr__cap_mim_m3_1 l=3 w=3
X574 B11 TOP sky130_fd_pr__cap_mim_m3_1 l=3 w=3
X575 B10 TOP sky130_fd_pr__cap_mim_m3_1 l=3 w=3
X576 B11 TOP sky130_fd_pr__cap_mim_m3_1 l=3 w=3
X577 B11 TOP sky130_fd_pr__cap_mim_m3_1 l=3 w=3
X578 B11 TOP sky130_fd_pr__cap_mim_m3_1 l=3 w=3
X579 B11 TOP sky130_fd_pr__cap_mim_m3_1 l=3 w=3
X580 B11 TOP sky130_fd_pr__cap_mim_m3_1 l=3 w=3
X581 B11 TOP sky130_fd_pr__cap_mim_m3_1 l=3 w=3
X582 B11 TOP sky130_fd_pr__cap_mim_m3_1 l=3 w=3
X583 B11 TOP sky130_fd_pr__cap_mim_m3_1 l=3 w=3
X584 B11 TOP sky130_fd_pr__cap_mim_m3_1 l=3 w=3
X585 B10 TOP sky130_fd_pr__cap_mim_m3_1 l=3 w=3
X586 B11 TOP sky130_fd_pr__cap_mim_m3_1 l=3 w=3
X587 B11 TOP sky130_fd_pr__cap_mim_m3_1 l=3 w=3
X588 B7 TOP sky130_fd_pr__cap_mim_m3_1 l=3 w=3
X589 B10 TOP sky130_fd_pr__cap_mim_m3_1 l=3 w=3
X590 EDGE_BIAS EDGE_BIAS sky130_fd_pr__cap_mim_m3_1 l=3 w=3
X591 B10 TOP sky130_fd_pr__cap_mim_m3_1 l=3 w=3
X592 B9 TOP sky130_fd_pr__cap_mim_m3_1 l=3 w=3
X593 B11 TOP sky130_fd_pr__cap_mim_m3_1 l=3 w=3
X594 B11 TOP sky130_fd_pr__cap_mim_m3_1 l=3 w=3
X595 B10 TOP sky130_fd_pr__cap_mim_m3_1 l=3 w=3
X596 B11 TOP sky130_fd_pr__cap_mim_m3_1 l=3 w=3
X597 B6 TOP sky130_fd_pr__cap_mim_m3_1 l=3 w=3
X598 B11 TOP sky130_fd_pr__cap_mim_m3_1 l=3 w=3
X599 B10 TOP sky130_fd_pr__cap_mim_m3_1 l=3 w=3
X600 B10 TOP sky130_fd_pr__cap_mim_m3_1 l=3 w=3
X601 B9 TOP sky130_fd_pr__cap_mim_m3_1 l=3 w=3
X602 EDGE_BIAS EDGE_BIAS sky130_fd_pr__cap_mim_m3_1 l=3 w=3
X603 B11 TOP sky130_fd_pr__cap_mim_m3_1 l=3 w=3
X604 B10 TOP sky130_fd_pr__cap_mim_m3_1 l=3 w=3
X605 B11 TOP sky130_fd_pr__cap_mim_m3_1 l=3 w=3
X606 B10 TOP sky130_fd_pr__cap_mim_m3_1 l=3 w=3
X607 B11 TOP sky130_fd_pr__cap_mim_m3_1 l=3 w=3
X608 B11 TOP sky130_fd_pr__cap_mim_m3_1 l=3 w=3
X609 B11 TOP sky130_fd_pr__cap_mim_m3_1 l=3 w=3
X610 B11 TOP sky130_fd_pr__cap_mim_m3_1 l=3 w=3
X611 B10 TOP sky130_fd_pr__cap_mim_m3_1 l=3 w=3
X612 B9 TOP sky130_fd_pr__cap_mim_m3_1 l=3 w=3
X613 B11 TOP sky130_fd_pr__cap_mim_m3_1 l=3 w=3
X614 B11 TOP sky130_fd_pr__cap_mim_m3_1 l=3 w=3
X615 B9 TOP sky130_fd_pr__cap_mim_m3_1 l=3 w=3
X616 B7 TOP sky130_fd_pr__cap_mim_m3_1 l=3 w=3
X617 B11 TOP sky130_fd_pr__cap_mim_m3_1 l=3 w=3
X618 B11 TOP sky130_fd_pr__cap_mim_m3_1 l=3 w=3
X619 EDGE_BIAS EDGE_BIAS sky130_fd_pr__cap_mim_m3_1 l=3 w=3
X620 B9 TOP sky130_fd_pr__cap_mim_m3_1 l=3 w=3
X621 B9 TOP sky130_fd_pr__cap_mim_m3_1 l=3 w=3
X622 B8 TOP sky130_fd_pr__cap_mim_m3_1 l=3 w=3
X623 B8 TOP sky130_fd_pr__cap_mim_m3_1 l=3 w=3
X624 B10 TOP sky130_fd_pr__cap_mim_m3_1 l=3 w=3
X625 B11 TOP sky130_fd_pr__cap_mim_m3_1 l=3 w=3
X626 B10 TOP sky130_fd_pr__cap_mim_m3_1 l=3 w=3
X627 B11 TOP sky130_fd_pr__cap_mim_m3_1 l=3 w=3
X628 B10 TOP sky130_fd_pr__cap_mim_m3_1 l=3 w=3
X629 B7 TOP sky130_fd_pr__cap_mim_m3_1 l=3 w=3
X630 B11 TOP sky130_fd_pr__cap_mim_m3_1 l=3 w=3
X631 B11 TOP sky130_fd_pr__cap_mim_m3_1 l=3 w=3
X632 B11 TOP sky130_fd_pr__cap_mim_m3_1 l=3 w=3
X633 EDGE_BIAS EDGE_BIAS sky130_fd_pr__cap_mim_m3_1 l=3 w=3
X634 B10 TOP sky130_fd_pr__cap_mim_m3_1 l=3 w=3
X635 B11 TOP sky130_fd_pr__cap_mim_m3_1 l=3 w=3
X636 B11 TOP sky130_fd_pr__cap_mim_m3_1 l=3 w=3
X637 B11 TOP sky130_fd_pr__cap_mim_m3_1 l=3 w=3
X638 B11 TOP sky130_fd_pr__cap_mim_m3_1 l=3 w=3
X639 B11 TOP sky130_fd_pr__cap_mim_m3_1 l=3 w=3
X640 B9 TOP sky130_fd_pr__cap_mim_m3_1 l=3 w=3
X641 B11 TOP sky130_fd_pr__cap_mim_m3_1 l=3 w=3
X642 B11 TOP sky130_fd_pr__cap_mim_m3_1 l=3 w=3
X643 B11 TOP sky130_fd_pr__cap_mim_m3_1 l=3 w=3
X644 B11 TOP sky130_fd_pr__cap_mim_m3_1 l=3 w=3
X645 EDGE_BIAS EDGE_BIAS sky130_fd_pr__cap_mim_m3_1 l=3 w=3
X646 B10 TOP sky130_fd_pr__cap_mim_m3_1 l=3 w=3
X647 B10 TOP sky130_fd_pr__cap_mim_m3_1 l=3 w=3
X648 EDGE_BIAS EDGE_BIAS sky130_fd_pr__cap_mim_m3_1 l=3 w=3
X649 B11 TOP sky130_fd_pr__cap_mim_m3_1 l=3 w=3
X650 B10 TOP sky130_fd_pr__cap_mim_m3_1 l=3 w=3
X651 B10 TOP sky130_fd_pr__cap_mim_m3_1 l=3 w=3
X652 B5 TOP sky130_fd_pr__cap_mim_m3_1 l=3 w=3
X653 B10 TOP sky130_fd_pr__cap_mim_m3_1 l=3 w=3
X654 B11 TOP sky130_fd_pr__cap_mim_m3_1 l=3 w=3
X655 B11 TOP sky130_fd_pr__cap_mim_m3_1 l=3 w=3
X656 B10 TOP sky130_fd_pr__cap_mim_m3_1 l=3 w=3
X657 B11 TOP sky130_fd_pr__cap_mim_m3_1 l=3 w=3
X658 EDGE_BIAS EDGE_BIAS sky130_fd_pr__cap_mim_m3_1 l=3 w=3
X659 B10 TOP sky130_fd_pr__cap_mim_m3_1 l=3 w=3
X660 B7 TOP sky130_fd_pr__cap_mim_m3_1 l=3 w=3
X661 EDGE_BIAS EDGE_BIAS sky130_fd_pr__cap_mim_m3_1 l=3 w=3
X662 B11 TOP sky130_fd_pr__cap_mim_m3_1 l=3 w=3
X663 B11 TOP sky130_fd_pr__cap_mim_m3_1 l=3 w=3
X664 B11 TOP sky130_fd_pr__cap_mim_m3_1 l=3 w=3
X665 B11 TOP sky130_fd_pr__cap_mim_m3_1 l=3 w=3
X666 B11 TOP sky130_fd_pr__cap_mim_m3_1 l=3 w=3
X667 B11 TOP sky130_fd_pr__cap_mim_m3_1 l=3 w=3
X668 B11 TOP sky130_fd_pr__cap_mim_m3_1 l=3 w=3
X669 B7 TOP sky130_fd_pr__cap_mim_m3_1 l=3 w=3
X670 B11 TOP sky130_fd_pr__cap_mim_m3_1 l=3 w=3
X671 B10 TOP sky130_fd_pr__cap_mim_m3_1 l=3 w=3
X672 B11 TOP sky130_fd_pr__cap_mim_m3_1 l=3 w=3
X673 EDGE_BIAS EDGE_BIAS sky130_fd_pr__cap_mim_m3_1 l=3 w=3
X674 B11 TOP sky130_fd_pr__cap_mim_m3_1 l=3 w=3
X675 B11 TOP sky130_fd_pr__cap_mim_m3_1 l=3 w=3
X676 B9 TOP sky130_fd_pr__cap_mim_m3_1 l=3 w=3
X677 B8 TOP sky130_fd_pr__cap_mim_m3_1 l=3 w=3
X678 B9 TOP sky130_fd_pr__cap_mim_m3_1 l=3 w=3
X679 B11 TOP sky130_fd_pr__cap_mim_m3_1 l=3 w=3
X680 B10 TOP sky130_fd_pr__cap_mim_m3_1 l=3 w=3
X681 B8 TOP sky130_fd_pr__cap_mim_m3_1 l=3 w=3
X682 B8 TOP sky130_fd_pr__cap_mim_m3_1 l=3 w=3
X683 B9 TOP sky130_fd_pr__cap_mim_m3_1 l=3 w=3
X684 B11 TOP sky130_fd_pr__cap_mim_m3_1 l=3 w=3
X685 B10 TOP sky130_fd_pr__cap_mim_m3_1 l=3 w=3
X686 B10 TOP sky130_fd_pr__cap_mim_m3_1 l=3 w=3
X687 B7 TOP sky130_fd_pr__cap_mim_m3_1 l=3 w=3
X688 B8 TOP sky130_fd_pr__cap_mim_m3_1 l=3 w=3
X689 B11 TOP sky130_fd_pr__cap_mim_m3_1 l=3 w=3
X690 B11 TOP sky130_fd_pr__cap_mim_m3_1 l=3 w=3
X691 B11 TOP sky130_fd_pr__cap_mim_m3_1 l=3 w=3
X692 EDGE_BIAS EDGE_BIAS sky130_fd_pr__cap_mim_m3_1 l=3 w=3
X693 B11 TOP sky130_fd_pr__cap_mim_m3_1 l=3 w=3
X694 B11 TOP sky130_fd_pr__cap_mim_m3_1 l=3 w=3
X695 B11 TOP sky130_fd_pr__cap_mim_m3_1 l=3 w=3
X696 B11 TOP sky130_fd_pr__cap_mim_m3_1 l=3 w=3
X697 B11 TOP sky130_fd_pr__cap_mim_m3_1 l=3 w=3
X698 B11 TOP sky130_fd_pr__cap_mim_m3_1 l=3 w=3
X699 B9 TOP sky130_fd_pr__cap_mim_m3_1 l=3 w=3
X700 B10 TOP sky130_fd_pr__cap_mim_m3_1 l=3 w=3
X701 B11 TOP sky130_fd_pr__cap_mim_m3_1 l=3 w=3
X702 B11 TOP sky130_fd_pr__cap_mim_m3_1 l=3 w=3
X703 B11 TOP sky130_fd_pr__cap_mim_m3_1 l=3 w=3
X704 B10 TOP sky130_fd_pr__cap_mim_m3_1 l=3 w=3
X705 B9 TOP sky130_fd_pr__cap_mim_m3_1 l=3 w=3
X706 B10 TOP sky130_fd_pr__cap_mim_m3_1 l=3 w=3
X707 B3 TOP sky130_fd_pr__cap_mim_m3_1 l=3 w=3
X708 B10 TOP sky130_fd_pr__cap_mim_m3_1 l=3 w=3
X709 B11 TOP sky130_fd_pr__cap_mim_m3_1 l=3 w=3
X710 B7 TOP sky130_fd_pr__cap_mim_m3_1 l=3 w=3
X711 B11 TOP sky130_fd_pr__cap_mim_m3_1 l=3 w=3
X712 B11 TOP sky130_fd_pr__cap_mim_m3_1 l=3 w=3
X713 EDGE_BIAS EDGE_BIAS sky130_fd_pr__cap_mim_m3_1 l=3 w=3
X714 B11 TOP sky130_fd_pr__cap_mim_m3_1 l=3 w=3
X715 B10 TOP sky130_fd_pr__cap_mim_m3_1 l=3 w=3
X716 B11 TOP sky130_fd_pr__cap_mim_m3_1 l=3 w=3
X717 B11 TOP sky130_fd_pr__cap_mim_m3_1 l=3 w=3
X718 B11 TOP sky130_fd_pr__cap_mim_m3_1 l=3 w=3
X719 B11 TOP sky130_fd_pr__cap_mim_m3_1 l=3 w=3
X720 B11 TOP sky130_fd_pr__cap_mim_m3_1 l=3 w=3
X721 B11 TOP sky130_fd_pr__cap_mim_m3_1 l=3 w=3
X722 B11 TOP sky130_fd_pr__cap_mim_m3_1 l=3 w=3
X723 B11 TOP sky130_fd_pr__cap_mim_m3_1 l=3 w=3
X724 B10 TOP sky130_fd_pr__cap_mim_m3_1 l=3 w=3
X725 B9 TOP sky130_fd_pr__cap_mim_m3_1 l=3 w=3
X726 EDGE_BIAS EDGE_BIAS sky130_fd_pr__cap_mim_m3_1 l=3 w=3
X727 B10 TOP sky130_fd_pr__cap_mim_m3_1 l=3 w=3
X728 B9 TOP sky130_fd_pr__cap_mim_m3_1 l=3 w=3
X729 B11 TOP sky130_fd_pr__cap_mim_m3_1 l=3 w=3
X730 B11 TOP sky130_fd_pr__cap_mim_m3_1 l=3 w=3
X731 B11 TOP sky130_fd_pr__cap_mim_m3_1 l=3 w=3
X732 B9 TOP sky130_fd_pr__cap_mim_m3_1 l=3 w=3
X733 B11 TOP sky130_fd_pr__cap_mim_m3_1 l=3 w=3
X734 B8 TOP sky130_fd_pr__cap_mim_m3_1 l=3 w=3
X735 B9 TOP sky130_fd_pr__cap_mim_m3_1 l=3 w=3
X736 EDGE_BIAS EDGE_BIAS sky130_fd_pr__cap_mim_m3_1 l=3 w=3
X737 B8 TOP sky130_fd_pr__cap_mim_m3_1 l=3 w=3
X738 B10 TOP sky130_fd_pr__cap_mim_m3_1 l=3 w=3
X739 B11 TOP sky130_fd_pr__cap_mim_m3_1 l=3 w=3
X740 B11 TOP sky130_fd_pr__cap_mim_m3_1 l=3 w=3
X741 B8 TOP sky130_fd_pr__cap_mim_m3_1 l=3 w=3
X742 B11 TOP sky130_fd_pr__cap_mim_m3_1 l=3 w=3
X743 B9 TOP sky130_fd_pr__cap_mim_m3_1 l=3 w=3
X744 B10 TOP sky130_fd_pr__cap_mim_m3_1 l=3 w=3
X745 B11 TOP sky130_fd_pr__cap_mim_m3_1 l=3 w=3
X746 B9 TOP sky130_fd_pr__cap_mim_m3_1 l=3 w=3
X747 B11 TOP sky130_fd_pr__cap_mim_m3_1 l=3 w=3
X748 B5 TOP sky130_fd_pr__cap_mim_m3_1 l=3 w=3
X749 B8 TOP sky130_fd_pr__cap_mim_m3_1 l=3 w=3
X750 EDGE_BIAS EDGE_BIAS sky130_fd_pr__cap_mim_m3_1 l=3 w=3
X751 B11 TOP sky130_fd_pr__cap_mim_m3_1 l=3 w=3
X752 B10 TOP sky130_fd_pr__cap_mim_m3_1 l=3 w=3
X753 B11 TOP sky130_fd_pr__cap_mim_m3_1 l=3 w=3
X754 B11 TOP sky130_fd_pr__cap_mim_m3_1 l=3 w=3
X755 B11 TOP sky130_fd_pr__cap_mim_m3_1 l=3 w=3
X756 B10 TOP sky130_fd_pr__cap_mim_m3_1 l=3 w=3
X757 B9 TOP sky130_fd_pr__cap_mim_m3_1 l=3 w=3
X758 B11 TOP sky130_fd_pr__cap_mim_m3_1 l=3 w=3
X759 B10 TOP sky130_fd_pr__cap_mim_m3_1 l=3 w=3
X760 B9 TOP sky130_fd_pr__cap_mim_m3_1 l=3 w=3
X761 B9 TOP sky130_fd_pr__cap_mim_m3_1 l=3 w=3
X762 B10 TOP sky130_fd_pr__cap_mim_m3_1 l=3 w=3
X763 B11 TOP sky130_fd_pr__cap_mim_m3_1 l=3 w=3
X764 B10 TOP sky130_fd_pr__cap_mim_m3_1 l=3 w=3
X765 EDGE_BIAS EDGE_BIAS sky130_fd_pr__cap_mim_m3_1 l=3 w=3
X766 B11 TOP sky130_fd_pr__cap_mim_m3_1 l=3 w=3
X767 B10 TOP sky130_fd_pr__cap_mim_m3_1 l=3 w=3
X768 B10 TOP sky130_fd_pr__cap_mim_m3_1 l=3 w=3
X769 B10 TOP sky130_fd_pr__cap_mim_m3_1 l=3 w=3
X770 B10 TOP sky130_fd_pr__cap_mim_m3_1 l=3 w=3
X771 B11 TOP sky130_fd_pr__cap_mim_m3_1 l=3 w=3
X772 B11 TOP sky130_fd_pr__cap_mim_m3_1 l=3 w=3
X773 B11 TOP sky130_fd_pr__cap_mim_m3_1 l=3 w=3
X774 B10 TOP sky130_fd_pr__cap_mim_m3_1 l=3 w=3
X775 B11 TOP sky130_fd_pr__cap_mim_m3_1 l=3 w=3
X776 B11 TOP sky130_fd_pr__cap_mim_m3_1 l=3 w=3
X777 EDGE_BIAS EDGE_BIAS sky130_fd_pr__cap_mim_m3_1 l=3 w=3
X778 B11 TOP sky130_fd_pr__cap_mim_m3_1 l=3 w=3
X779 EDGE_BIAS EDGE_BIAS sky130_fd_pr__cap_mim_m3_1 l=3 w=3
X780 B11 TOP sky130_fd_pr__cap_mim_m3_1 l=3 w=3
X781 B11 TOP sky130_fd_pr__cap_mim_m3_1 l=3 w=3
X782 B9 TOP sky130_fd_pr__cap_mim_m3_1 l=3 w=3
X783 B9 TOP sky130_fd_pr__cap_mim_m3_1 l=3 w=3
X784 B8 TOP sky130_fd_pr__cap_mim_m3_1 l=3 w=3
X785 B10 TOP sky130_fd_pr__cap_mim_m3_1 l=3 w=3
X786 B11 TOP sky130_fd_pr__cap_mim_m3_1 l=3 w=3
X787 B10 TOP sky130_fd_pr__cap_mim_m3_1 l=3 w=3
X788 B9 TOP sky130_fd_pr__cap_mim_m3_1 l=3 w=3
X789 B11 TOP sky130_fd_pr__cap_mim_m3_1 l=3 w=3
X790 B10 TOP sky130_fd_pr__cap_mim_m3_1 l=3 w=3
X791 B11 TOP sky130_fd_pr__cap_mim_m3_1 l=3 w=3
X792 B7 TOP sky130_fd_pr__cap_mim_m3_1 l=3 w=3
X793 B11 TOP sky130_fd_pr__cap_mim_m3_1 l=3 w=3
X794 B10 TOP sky130_fd_pr__cap_mim_m3_1 l=3 w=3
X795 B11 TOP sky130_fd_pr__cap_mim_m3_1 l=3 w=3
X796 B11 TOP sky130_fd_pr__cap_mim_m3_1 l=3 w=3
X797 B8 TOP sky130_fd_pr__cap_mim_m3_1 l=3 w=3
X798 B11 TOP sky130_fd_pr__cap_mim_m3_1 l=3 w=3
X799 B11 TOP sky130_fd_pr__cap_mim_m3_1 l=3 w=3
X800 B11 TOP sky130_fd_pr__cap_mim_m3_1 l=3 w=3
X801 B11 TOP sky130_fd_pr__cap_mim_m3_1 l=3 w=3
X802 B11 TOP sky130_fd_pr__cap_mim_m3_1 l=3 w=3
X803 B11 TOP sky130_fd_pr__cap_mim_m3_1 l=3 w=3
X804 B11 TOP sky130_fd_pr__cap_mim_m3_1 l=3 w=3
X805 B11 TOP sky130_fd_pr__cap_mim_m3_1 l=3 w=3
X806 B11 TOP sky130_fd_pr__cap_mim_m3_1 l=3 w=3
X807 B9 TOP sky130_fd_pr__cap_mim_m3_1 l=3 w=3
X808 B9 TOP sky130_fd_pr__cap_mim_m3_1 l=3 w=3
X809 B10 TOP sky130_fd_pr__cap_mim_m3_1 l=3 w=3
X810 B10 TOP sky130_fd_pr__cap_mim_m3_1 l=3 w=3
X811 B10 TOP sky130_fd_pr__cap_mim_m3_1 l=3 w=3
X812 B9 TOP sky130_fd_pr__cap_mim_m3_1 l=3 w=3
X813 B9 TOP sky130_fd_pr__cap_mim_m3_1 l=3 w=3
X814 B11 TOP sky130_fd_pr__cap_mim_m3_1 l=3 w=3
X815 B11 TOP sky130_fd_pr__cap_mim_m3_1 l=3 w=3
X816 B10 TOP sky130_fd_pr__cap_mim_m3_1 l=3 w=3
X817 B7 TOP sky130_fd_pr__cap_mim_m3_1 l=3 w=3
X818 B11 TOP sky130_fd_pr__cap_mim_m3_1 l=3 w=3
X819 EDGE_BIAS EDGE_BIAS sky130_fd_pr__cap_mim_m3_1 l=3 w=3
X820 B10 TOP sky130_fd_pr__cap_mim_m3_1 l=3 w=3
X821 B10 TOP sky130_fd_pr__cap_mim_m3_1 l=3 w=3
X822 B11 TOP sky130_fd_pr__cap_mim_m3_1 l=3 w=3
X823 B11 TOP sky130_fd_pr__cap_mim_m3_1 l=3 w=3
X824 B11 TOP sky130_fd_pr__cap_mim_m3_1 l=3 w=3
X825 B11 TOP sky130_fd_pr__cap_mim_m3_1 l=3 w=3
X826 B11 TOP sky130_fd_pr__cap_mim_m3_1 l=3 w=3
X827 B11 TOP sky130_fd_pr__cap_mim_m3_1 l=3 w=3
X828 B11 TOP sky130_fd_pr__cap_mim_m3_1 l=3 w=3
X829 B11 TOP sky130_fd_pr__cap_mim_m3_1 l=3 w=3
X830 B10 TOP sky130_fd_pr__cap_mim_m3_1 l=3 w=3
X831 B11 TOP sky130_fd_pr__cap_mim_m3_1 l=3 w=3
X832 B11 TOP sky130_fd_pr__cap_mim_m3_1 l=3 w=3
X833 B11 TOP sky130_fd_pr__cap_mim_m3_1 l=3 w=3
X834 B11 TOP sky130_fd_pr__cap_mim_m3_1 l=3 w=3
X835 B9 TOP sky130_fd_pr__cap_mim_m3_1 l=3 w=3
X836 B8 TOP sky130_fd_pr__cap_mim_m3_1 l=3 w=3
X837 B9 TOP sky130_fd_pr__cap_mim_m3_1 l=3 w=3
X838 B8 TOP sky130_fd_pr__cap_mim_m3_1 l=3 w=3
X839 B11 TOP sky130_fd_pr__cap_mim_m3_1 l=3 w=3
X840 B10 TOP sky130_fd_pr__cap_mim_m3_1 l=3 w=3
X841 B11 TOP sky130_fd_pr__cap_mim_m3_1 l=3 w=3
X842 B9 TOP sky130_fd_pr__cap_mim_m3_1 l=3 w=3
X843 B7 TOP sky130_fd_pr__cap_mim_m3_1 l=3 w=3
X844 B10 TOP sky130_fd_pr__cap_mim_m3_1 l=3 w=3
X845 B11 TOP sky130_fd_pr__cap_mim_m3_1 l=3 w=3
X846 B10 TOP sky130_fd_pr__cap_mim_m3_1 l=3 w=3
X847 B11 TOP sky130_fd_pr__cap_mim_m3_1 l=3 w=3
X848 B6 TOP sky130_fd_pr__cap_mim_m3_1 l=3 w=3
X849 B11 TOP sky130_fd_pr__cap_mim_m3_1 l=3 w=3
X850 B11 TOP sky130_fd_pr__cap_mim_m3_1 l=3 w=3
X851 B11 TOP sky130_fd_pr__cap_mim_m3_1 l=3 w=3
X852 B11 TOP sky130_fd_pr__cap_mim_m3_1 l=3 w=3
X853 EDGE_BIAS EDGE_BIAS sky130_fd_pr__cap_mim_m3_1 l=3 w=3
X854 EDGE_BIAS EDGE_BIAS sky130_fd_pr__cap_mim_m3_1 l=3 w=3
X855 B11 TOP sky130_fd_pr__cap_mim_m3_1 l=3 w=3
X856 B11 TOP sky130_fd_pr__cap_mim_m3_1 l=3 w=3
X857 B11 TOP sky130_fd_pr__cap_mim_m3_1 l=3 w=3
X858 B9 TOP sky130_fd_pr__cap_mim_m3_1 l=3 w=3
X859 B11 TOP sky130_fd_pr__cap_mim_m3_1 l=3 w=3
X860 B11 TOP sky130_fd_pr__cap_mim_m3_1 l=3 w=3
X861 B10 TOP sky130_fd_pr__cap_mim_m3_1 l=3 w=3
X862 EDGE_BIAS EDGE_BIAS sky130_fd_pr__cap_mim_m3_1 l=3 w=3
X863 B11 TOP sky130_fd_pr__cap_mim_m3_1 l=3 w=3
X864 B11 TOP sky130_fd_pr__cap_mim_m3_1 l=3 w=3
X865 B10 TOP sky130_fd_pr__cap_mim_m3_1 l=3 w=3
X866 B7 TOP sky130_fd_pr__cap_mim_m3_1 l=3 w=3
X867 B11 TOP sky130_fd_pr__cap_mim_m3_1 l=3 w=3
X868 EDGE_BIAS EDGE_BIAS sky130_fd_pr__cap_mim_m3_1 l=3 w=3
X869 B11 TOP sky130_fd_pr__cap_mim_m3_1 l=3 w=3
X870 B11 TOP sky130_fd_pr__cap_mim_m3_1 l=3 w=3
X871 B8 TOP sky130_fd_pr__cap_mim_m3_1 l=3 w=3
X872 B11 TOP sky130_fd_pr__cap_mim_m3_1 l=3 w=3
X873 B11 TOP sky130_fd_pr__cap_mim_m3_1 l=3 w=3
X874 B11 TOP sky130_fd_pr__cap_mim_m3_1 l=3 w=3
X875 B9 TOP sky130_fd_pr__cap_mim_m3_1 l=3 w=3
X876 B11 TOP sky130_fd_pr__cap_mim_m3_1 l=3 w=3
X877 B11 TOP sky130_fd_pr__cap_mim_m3_1 l=3 w=3
X878 EDGE_BIAS EDGE_BIAS sky130_fd_pr__cap_mim_m3_1 l=3 w=3
X879 B11 TOP sky130_fd_pr__cap_mim_m3_1 l=3 w=3
X880 B11 TOP sky130_fd_pr__cap_mim_m3_1 l=3 w=3
X881 B11 TOP sky130_fd_pr__cap_mim_m3_1 l=3 w=3
X882 B10 TOP sky130_fd_pr__cap_mim_m3_1 l=3 w=3
X883 B11 TOP sky130_fd_pr__cap_mim_m3_1 l=3 w=3
X884 B11 TOP sky130_fd_pr__cap_mim_m3_1 l=3 w=3
X885 B11 TOP sky130_fd_pr__cap_mim_m3_1 l=3 w=3
X886 B8 TOP sky130_fd_pr__cap_mim_m3_1 l=3 w=3
X887 B9 TOP sky130_fd_pr__cap_mim_m3_1 l=3 w=3
X888 B10 TOP sky130_fd_pr__cap_mim_m3_1 l=3 w=3
X889 B7 TOP sky130_fd_pr__cap_mim_m3_1 l=3 w=3
X890 B11 TOP sky130_fd_pr__cap_mim_m3_1 l=3 w=3
X891 B11 TOP sky130_fd_pr__cap_mim_m3_1 l=3 w=3
X892 B11 TOP sky130_fd_pr__cap_mim_m3_1 l=3 w=3
X893 B8 TOP sky130_fd_pr__cap_mim_m3_1 l=3 w=3
X894 B11 TOP sky130_fd_pr__cap_mim_m3_1 l=3 w=3
X895 B9 TOP sky130_fd_pr__cap_mim_m3_1 l=3 w=3
X896 B11 TOP sky130_fd_pr__cap_mim_m3_1 l=3 w=3
X897 B10 TOP sky130_fd_pr__cap_mim_m3_1 l=3 w=3
X898 B11 TOP sky130_fd_pr__cap_mim_m3_1 l=3 w=3
X899 B9 TOP sky130_fd_pr__cap_mim_m3_1 l=3 w=3
X900 B11 TOP sky130_fd_pr__cap_mim_m3_1 l=3 w=3
X901 B11 TOP sky130_fd_pr__cap_mim_m3_1 l=3 w=3
X902 B11 TOP sky130_fd_pr__cap_mim_m3_1 l=3 w=3
X903 B11 TOP sky130_fd_pr__cap_mim_m3_1 l=3 w=3
X904 B11 TOP sky130_fd_pr__cap_mim_m3_1 l=3 w=3
X905 B11 TOP sky130_fd_pr__cap_mim_m3_1 l=3 w=3
X906 B11 TOP sky130_fd_pr__cap_mim_m3_1 l=3 w=3
X907 B9 TOP sky130_fd_pr__cap_mim_m3_1 l=3 w=3
X908 B11 TOP sky130_fd_pr__cap_mim_m3_1 l=3 w=3
X909 B11 TOP sky130_fd_pr__cap_mim_m3_1 l=3 w=3
X910 B10 TOP sky130_fd_pr__cap_mim_m3_1 l=3 w=3
X911 B11 TOP sky130_fd_pr__cap_mim_m3_1 l=3 w=3
X912 B9 TOP sky130_fd_pr__cap_mim_m3_1 l=3 w=3
X913 B9 TOP sky130_fd_pr__cap_mim_m3_1 l=3 w=3
X914 B10 TOP sky130_fd_pr__cap_mim_m3_1 l=3 w=3
X915 B7 TOP sky130_fd_pr__cap_mim_m3_1 l=3 w=3
X916 B9 TOP sky130_fd_pr__cap_mim_m3_1 l=3 w=3
X917 B11 TOP sky130_fd_pr__cap_mim_m3_1 l=3 w=3
X918 B11 TOP sky130_fd_pr__cap_mim_m3_1 l=3 w=3
X919 B10 TOP sky130_fd_pr__cap_mim_m3_1 l=3 w=3
X920 B11 TOP sky130_fd_pr__cap_mim_m3_1 l=3 w=3
X921 B10 TOP sky130_fd_pr__cap_mim_m3_1 l=3 w=3
X922 B11 TOP sky130_fd_pr__cap_mim_m3_1 l=3 w=3
X923 B11 TOP sky130_fd_pr__cap_mim_m3_1 l=3 w=3
X924 B11 TOP sky130_fd_pr__cap_mim_m3_1 l=3 w=3
X925 B11 TOP sky130_fd_pr__cap_mim_m3_1 l=3 w=3
X926 B10 TOP sky130_fd_pr__cap_mim_m3_1 l=3 w=3
X927 B11 TOP sky130_fd_pr__cap_mim_m3_1 l=3 w=3
X928 B10 TOP sky130_fd_pr__cap_mim_m3_1 l=3 w=3
X929 B11 TOP sky130_fd_pr__cap_mim_m3_1 l=3 w=3
X930 B11 TOP sky130_fd_pr__cap_mim_m3_1 l=3 w=3
X931 B10 TOP sky130_fd_pr__cap_mim_m3_1 l=3 w=3
X932 B11 TOP sky130_fd_pr__cap_mim_m3_1 l=3 w=3
X933 B11 TOP sky130_fd_pr__cap_mim_m3_1 l=3 w=3
X934 B8 TOP sky130_fd_pr__cap_mim_m3_1 l=3 w=3
X935 EDGE_BIAS EDGE_BIAS sky130_fd_pr__cap_mim_m3_1 l=3 w=3
X936 B10 TOP sky130_fd_pr__cap_mim_m3_1 l=3 w=3
X937 B10 TOP sky130_fd_pr__cap_mim_m3_1 l=3 w=3
X938 B11 TOP sky130_fd_pr__cap_mim_m3_1 l=3 w=3
X939 B11 TOP sky130_fd_pr__cap_mim_m3_1 l=3 w=3
X940 B7 TOP sky130_fd_pr__cap_mim_m3_1 l=3 w=3
X941 B10 TOP sky130_fd_pr__cap_mim_m3_1 l=3 w=3
X942 B11 TOP sky130_fd_pr__cap_mim_m3_1 l=3 w=3
X943 B10 TOP sky130_fd_pr__cap_mim_m3_1 l=3 w=3
X944 B10 TOP sky130_fd_pr__cap_mim_m3_1 l=3 w=3
X945 B11 TOP sky130_fd_pr__cap_mim_m3_1 l=3 w=3
X946 B11 TOP sky130_fd_pr__cap_mim_m3_1 l=3 w=3
X947 B11 TOP sky130_fd_pr__cap_mim_m3_1 l=3 w=3
X948 B11 TOP sky130_fd_pr__cap_mim_m3_1 l=3 w=3
X949 EDGE_BIAS EDGE_BIAS sky130_fd_pr__cap_mim_m3_1 l=3 w=3
X950 EDGE_BIAS EDGE_BIAS sky130_fd_pr__cap_mim_m3_1 l=3 w=3
X951 B11 TOP sky130_fd_pr__cap_mim_m3_1 l=3 w=3
X952 B9 TOP sky130_fd_pr__cap_mim_m3_1 l=3 w=3
X953 B11 TOP sky130_fd_pr__cap_mim_m3_1 l=3 w=3
X954 B9 TOP sky130_fd_pr__cap_mim_m3_1 l=3 w=3
X955 B7 TOP sky130_fd_pr__cap_mim_m3_1 l=3 w=3
X956 B9 TOP sky130_fd_pr__cap_mim_m3_1 l=3 w=3
X957 B10 TOP sky130_fd_pr__cap_mim_m3_1 l=3 w=3
X958 B11 TOP sky130_fd_pr__cap_mim_m3_1 l=3 w=3
X959 B11 TOP sky130_fd_pr__cap_mim_m3_1 l=3 w=3
X960 B11 TOP sky130_fd_pr__cap_mim_m3_1 l=3 w=3
X961 B11 TOP sky130_fd_pr__cap_mim_m3_1 l=3 w=3
X962 B9 TOP sky130_fd_pr__cap_mim_m3_1 l=3 w=3
X963 B11 TOP sky130_fd_pr__cap_mim_m3_1 l=3 w=3
X964 B11 TOP sky130_fd_pr__cap_mim_m3_1 l=3 w=3
X965 B10 TOP sky130_fd_pr__cap_mim_m3_1 l=3 w=3
X966 B10 TOP sky130_fd_pr__cap_mim_m3_1 l=3 w=3
X967 B7 TOP sky130_fd_pr__cap_mim_m3_1 l=3 w=3
X968 B11 TOP sky130_fd_pr__cap_mim_m3_1 l=3 w=3
X969 EDGE_BIAS EDGE_BIAS sky130_fd_pr__cap_mim_m3_1 l=3 w=3
X970 B9 TOP sky130_fd_pr__cap_mim_m3_1 l=3 w=3
X971 B11 TOP sky130_fd_pr__cap_mim_m3_1 l=3 w=3
X972 B11 TOP sky130_fd_pr__cap_mim_m3_1 l=3 w=3
X973 B10 TOP sky130_fd_pr__cap_mim_m3_1 l=3 w=3
X974 B11 TOP sky130_fd_pr__cap_mim_m3_1 l=3 w=3
X975 EDGE_BIAS EDGE_BIAS sky130_fd_pr__cap_mim_m3_1 l=3 w=3
X976 B11 TOP sky130_fd_pr__cap_mim_m3_1 l=3 w=3
X977 B11 TOP sky130_fd_pr__cap_mim_m3_1 l=3 w=3
X978 B10 TOP sky130_fd_pr__cap_mim_m3_1 l=3 w=3
X979 B11 TOP sky130_fd_pr__cap_mim_m3_1 l=3 w=3
X980 B11 TOP sky130_fd_pr__cap_mim_m3_1 l=3 w=3
X981 B11 TOP sky130_fd_pr__cap_mim_m3_1 l=3 w=3
X982 B11 TOP sky130_fd_pr__cap_mim_m3_1 l=3 w=3
X983 B7 TOP sky130_fd_pr__cap_mim_m3_1 l=3 w=3
X984 B11 TOP sky130_fd_pr__cap_mim_m3_1 l=3 w=3
X985 B11 TOP sky130_fd_pr__cap_mim_m3_1 l=3 w=3
X986 B10 TOP sky130_fd_pr__cap_mim_m3_1 l=3 w=3
X987 B11 TOP sky130_fd_pr__cap_mim_m3_1 l=3 w=3
X988 B9 TOP sky130_fd_pr__cap_mim_m3_1 l=3 w=3
X989 B11 TOP sky130_fd_pr__cap_mim_m3_1 l=3 w=3
X990 B7 TOP sky130_fd_pr__cap_mim_m3_1 l=3 w=3
X991 B10 TOP sky130_fd_pr__cap_mim_m3_1 l=3 w=3
X992 B8 TOP sky130_fd_pr__cap_mim_m3_1 l=3 w=3
X993 B11 TOP sky130_fd_pr__cap_mim_m3_1 l=3 w=3
X994 B10 TOP sky130_fd_pr__cap_mim_m3_1 l=3 w=3
X995 B6 TOP sky130_fd_pr__cap_mim_m3_1 l=3 w=3
X996 B11 TOP sky130_fd_pr__cap_mim_m3_1 l=3 w=3
X997 B11 TOP sky130_fd_pr__cap_mim_m3_1 l=3 w=3
X998 B9 TOP sky130_fd_pr__cap_mim_m3_1 l=3 w=3
X999 EDGE_BIAS EDGE_BIAS sky130_fd_pr__cap_mim_m3_1 l=3 w=3
X1000 B11 TOP sky130_fd_pr__cap_mim_m3_1 l=3 w=3
X1001 B11 TOP sky130_fd_pr__cap_mim_m3_1 l=3 w=3
X1002 B11 TOP sky130_fd_pr__cap_mim_m3_1 l=3 w=3
X1003 B11 TOP sky130_fd_pr__cap_mim_m3_1 l=3 w=3
X1004 B9 TOP sky130_fd_pr__cap_mim_m3_1 l=3 w=3
X1005 B11 TOP sky130_fd_pr__cap_mim_m3_1 l=3 w=3
X1006 B10 TOP sky130_fd_pr__cap_mim_m3_1 l=3 w=3
X1007 B2 TOP sky130_fd_pr__cap_mim_m3_1 l=3 w=3
X1008 B11 TOP sky130_fd_pr__cap_mim_m3_1 l=3 w=3
X1009 B11 TOP sky130_fd_pr__cap_mim_m3_1 l=3 w=3
X1010 B9 TOP sky130_fd_pr__cap_mim_m3_1 l=3 w=3
X1011 B11 TOP sky130_fd_pr__cap_mim_m3_1 l=3 w=3
X1012 B10 TOP sky130_fd_pr__cap_mim_m3_1 l=3 w=3
X1013 B11 TOP sky130_fd_pr__cap_mim_m3_1 l=3 w=3
X1014 EDGE_BIAS EDGE_BIAS sky130_fd_pr__cap_mim_m3_1 l=3 w=3
X1015 B7 TOP sky130_fd_pr__cap_mim_m3_1 l=3 w=3
X1016 B9 TOP sky130_fd_pr__cap_mim_m3_1 l=3 w=3
X1017 B11 TOP sky130_fd_pr__cap_mim_m3_1 l=3 w=3
X1018 B11 TOP sky130_fd_pr__cap_mim_m3_1 l=3 w=3
X1019 B8 TOP sky130_fd_pr__cap_mim_m3_1 l=3 w=3
X1020 B11 TOP sky130_fd_pr__cap_mim_m3_1 l=3 w=3
X1021 B11 TOP sky130_fd_pr__cap_mim_m3_1 l=3 w=3
X1022 B11 TOP sky130_fd_pr__cap_mim_m3_1 l=3 w=3
X1023 B11 TOP sky130_fd_pr__cap_mim_m3_1 l=3 w=3
X1024 B11 TOP sky130_fd_pr__cap_mim_m3_1 l=3 w=3
X1025 B11 TOP sky130_fd_pr__cap_mim_m3_1 l=3 w=3
X1026 B11 TOP sky130_fd_pr__cap_mim_m3_1 l=3 w=3
X1027 B10 TOP sky130_fd_pr__cap_mim_m3_1 l=3 w=3
X1028 B11 TOP sky130_fd_pr__cap_mim_m3_1 l=3 w=3
X1029 B8 TOP sky130_fd_pr__cap_mim_m3_1 l=3 w=3
X1030 B11 TOP sky130_fd_pr__cap_mim_m3_1 l=3 w=3
X1031 B10 TOP sky130_fd_pr__cap_mim_m3_1 l=3 w=3
X1032 B10 TOP sky130_fd_pr__cap_mim_m3_1 l=3 w=3
X1033 B11 TOP sky130_fd_pr__cap_mim_m3_1 l=3 w=3
X1034 B11 TOP sky130_fd_pr__cap_mim_m3_1 l=3 w=3
X1035 B10 TOP sky130_fd_pr__cap_mim_m3_1 l=3 w=3
X1036 B7 TOP sky130_fd_pr__cap_mim_m3_1 l=3 w=3
X1037 B11 TOP sky130_fd_pr__cap_mim_m3_1 l=3 w=3
X1038 B11 TOP sky130_fd_pr__cap_mim_m3_1 l=3 w=3
X1039 B10 TOP sky130_fd_pr__cap_mim_m3_1 l=3 w=3
X1040 B6 TOP sky130_fd_pr__cap_mim_m3_1 l=3 w=3
X1041 B11 TOP sky130_fd_pr__cap_mim_m3_1 l=3 w=3
X1042 B10 TOP sky130_fd_pr__cap_mim_m3_1 l=3 w=3
X1043 B11 TOP sky130_fd_pr__cap_mim_m3_1 l=3 w=3
X1044 B11 TOP sky130_fd_pr__cap_mim_m3_1 l=3 w=3
X1045 B11 TOP sky130_fd_pr__cap_mim_m3_1 l=3 w=3
X1046 B10 TOP sky130_fd_pr__cap_mim_m3_1 l=3 w=3
X1047 B9 TOP sky130_fd_pr__cap_mim_m3_1 l=3 w=3
X1048 EDGE_BIAS EDGE_BIAS sky130_fd_pr__cap_mim_m3_1 l=3 w=3
X1049 B11 TOP sky130_fd_pr__cap_mim_m3_1 l=3 w=3
X1050 B11 TOP sky130_fd_pr__cap_mim_m3_1 l=3 w=3
X1051 B10 TOP sky130_fd_pr__cap_mim_m3_1 l=3 w=3
X1052 B11 TOP sky130_fd_pr__cap_mim_m3_1 l=3 w=3
X1053 B11 TOP sky130_fd_pr__cap_mim_m3_1 l=3 w=3
X1054 B9 TOP sky130_fd_pr__cap_mim_m3_1 l=3 w=3
X1055 B11 TOP sky130_fd_pr__cap_mim_m3_1 l=3 w=3
X1056 EDGE_BIAS EDGE_BIAS sky130_fd_pr__cap_mim_m3_1 l=3 w=3
X1057 B9 TOP sky130_fd_pr__cap_mim_m3_1 l=3 w=3
X1058 B11 TOP sky130_fd_pr__cap_mim_m3_1 l=3 w=3
X1059 B11 TOP sky130_fd_pr__cap_mim_m3_1 l=3 w=3
X1060 B9 TOP sky130_fd_pr__cap_mim_m3_1 l=3 w=3
X1061 B10 TOP sky130_fd_pr__cap_mim_m3_1 l=3 w=3
X1062 B7 TOP sky130_fd_pr__cap_mim_m3_1 l=3 w=3
X1063 B11 TOP sky130_fd_pr__cap_mim_m3_1 l=3 w=3
X1064 B8 TOP sky130_fd_pr__cap_mim_m3_1 l=3 w=3
X1065 B10 TOP sky130_fd_pr__cap_mim_m3_1 l=3 w=3
X1066 B11 TOP sky130_fd_pr__cap_mim_m3_1 l=3 w=3
X1067 B10 TOP sky130_fd_pr__cap_mim_m3_1 l=3 w=3
X1068 B11 TOP sky130_fd_pr__cap_mim_m3_1 l=3 w=3
X1069 B11 TOP sky130_fd_pr__cap_mim_m3_1 l=3 w=3
X1070 EDGE_BIAS EDGE_BIAS sky130_fd_pr__cap_mim_m3_1 l=3 w=3
X1071 B11 TOP sky130_fd_pr__cap_mim_m3_1 l=3 w=3
X1072 B11 TOP sky130_fd_pr__cap_mim_m3_1 l=3 w=3
X1073 B10 TOP sky130_fd_pr__cap_mim_m3_1 l=3 w=3
X1074 B11 TOP sky130_fd_pr__cap_mim_m3_1 l=3 w=3
X1075 B10 TOP sky130_fd_pr__cap_mim_m3_1 l=3 w=3
X1076 B11 TOP sky130_fd_pr__cap_mim_m3_1 l=3 w=3
X1077 B11 TOP sky130_fd_pr__cap_mim_m3_1 l=3 w=3
X1078 B10 TOP sky130_fd_pr__cap_mim_m3_1 l=3 w=3
X1079 B9 TOP sky130_fd_pr__cap_mim_m3_1 l=3 w=3
X1080 B11 TOP sky130_fd_pr__cap_mim_m3_1 l=3 w=3
X1081 B11 TOP sky130_fd_pr__cap_mim_m3_1 l=3 w=3
X1082 B11 TOP sky130_fd_pr__cap_mim_m3_1 l=3 w=3
X1083 B11 TOP sky130_fd_pr__cap_mim_m3_1 l=3 w=3
X1084 EDGE_BIAS EDGE_BIAS sky130_fd_pr__cap_mim_m3_1 l=3 w=3
X1085 B11 TOP sky130_fd_pr__cap_mim_m3_1 l=3 w=3
X1086 B10 TOP sky130_fd_pr__cap_mim_m3_1 l=3 w=3
X1087 B10 TOP sky130_fd_pr__cap_mim_m3_1 l=3 w=3
X1088 B11 TOP sky130_fd_pr__cap_mim_m3_1 l=3 w=3
X1089 B11 TOP sky130_fd_pr__cap_mim_m3_1 l=3 w=3
X1090 B7 TOP sky130_fd_pr__cap_mim_m3_1 l=3 w=3
X1091 B10 TOP sky130_fd_pr__cap_mim_m3_1 l=3 w=3
X1092 B10 TOP sky130_fd_pr__cap_mim_m3_1 l=3 w=3
X1093 B10 TOP sky130_fd_pr__cap_mim_m3_1 l=3 w=3
X1094 B6 TOP sky130_fd_pr__cap_mim_m3_1 l=3 w=3
X1095 B11 TOP sky130_fd_pr__cap_mim_m3_1 l=3 w=3
X1096 B11 TOP sky130_fd_pr__cap_mim_m3_1 l=3 w=3
X1097 B6 TOP sky130_fd_pr__cap_mim_m3_1 l=3 w=3
X1098 B11 TOP sky130_fd_pr__cap_mim_m3_1 l=3 w=3
X1099 EDGE_BIAS EDGE_BIAS sky130_fd_pr__cap_mim_m3_1 l=3 w=3
X1100 B11 TOP sky130_fd_pr__cap_mim_m3_1 l=3 w=3
X1101 EDGE_BIAS EDGE_BIAS sky130_fd_pr__cap_mim_m3_1 l=3 w=3
X1102 EDGE_BIAS EDGE_BIAS sky130_fd_pr__cap_mim_m3_1 l=3 w=3
X1103 B11 TOP sky130_fd_pr__cap_mim_m3_1 l=3 w=3
X1104 B11 TOP sky130_fd_pr__cap_mim_m3_1 l=3 w=3
X1105 B8 TOP sky130_fd_pr__cap_mim_m3_1 l=3 w=3
X1106 B11 TOP sky130_fd_pr__cap_mim_m3_1 l=3 w=3
X1107 B11 TOP sky130_fd_pr__cap_mim_m3_1 l=3 w=3
X1108 B11 TOP sky130_fd_pr__cap_mim_m3_1 l=3 w=3
X1109 EDGE_BIAS EDGE_BIAS sky130_fd_pr__cap_mim_m3_1 l=3 w=3
X1110 B11 TOP sky130_fd_pr__cap_mim_m3_1 l=3 w=3
X1111 B11 TOP sky130_fd_pr__cap_mim_m3_1 l=3 w=3
X1112 B11 TOP sky130_fd_pr__cap_mim_m3_1 l=3 w=3
X1113 B9 TOP sky130_fd_pr__cap_mim_m3_1 l=3 w=3
X1114 B10 TOP sky130_fd_pr__cap_mim_m3_1 l=3 w=3
X1115 B7 TOP sky130_fd_pr__cap_mim_m3_1 l=3 w=3
X1116 B9 TOP sky130_fd_pr__cap_mim_m3_1 l=3 w=3
X1117 B8 TOP sky130_fd_pr__cap_mim_m3_1 l=3 w=3
X1118 EDGE_BIAS EDGE_BIAS sky130_fd_pr__cap_mim_m3_1 l=3 w=3
X1119 B11 TOP sky130_fd_pr__cap_mim_m3_1 l=3 w=3
X1120 B10 TOP sky130_fd_pr__cap_mim_m3_1 l=3 w=3
X1121 B10 TOP sky130_fd_pr__cap_mim_m3_1 l=3 w=3
X1122 B8 TOP sky130_fd_pr__cap_mim_m3_1 l=3 w=3
X1123 B11 TOP sky130_fd_pr__cap_mim_m3_1 l=3 w=3
X1124 B10 TOP sky130_fd_pr__cap_mim_m3_1 l=3 w=3
X1125 B11 TOP sky130_fd_pr__cap_mim_m3_1 l=3 w=3
X1126 B11 TOP sky130_fd_pr__cap_mim_m3_1 l=3 w=3
X1127 B11 TOP sky130_fd_pr__cap_mim_m3_1 l=3 w=3
X1128 B10 TOP sky130_fd_pr__cap_mim_m3_1 l=3 w=3
X1129 B11 TOP sky130_fd_pr__cap_mim_m3_1 l=3 w=3
X1130 B11 TOP sky130_fd_pr__cap_mim_m3_1 l=3 w=3
X1131 B11 TOP sky130_fd_pr__cap_mim_m3_1 l=3 w=3
X1132 B11 TOP sky130_fd_pr__cap_mim_m3_1 l=3 w=3
X1133 B11 TOP sky130_fd_pr__cap_mim_m3_1 l=3 w=3
X1134 B10 TOP sky130_fd_pr__cap_mim_m3_1 l=3 w=3
X1135 B11 TOP sky130_fd_pr__cap_mim_m3_1 l=3 w=3
X1136 B7 TOP sky130_fd_pr__cap_mim_m3_1 l=3 w=3
X1137 B11 TOP sky130_fd_pr__cap_mim_m3_1 l=3 w=3
X1138 B10 TOP sky130_fd_pr__cap_mim_m3_1 l=3 w=3
X1139 B11 TOP sky130_fd_pr__cap_mim_m3_1 l=3 w=3
X1140 B10 TOP sky130_fd_pr__cap_mim_m3_1 l=3 w=3
X1141 B11 TOP sky130_fd_pr__cap_mim_m3_1 l=3 w=3
X1142 B11 TOP sky130_fd_pr__cap_mim_m3_1 l=3 w=3
X1143 B11 TOP sky130_fd_pr__cap_mim_m3_1 l=3 w=3
X1144 B11 TOP sky130_fd_pr__cap_mim_m3_1 l=3 w=3
X1145 EDGE_BIAS EDGE_BIAS sky130_fd_pr__cap_mim_m3_1 l=3 w=3
X1146 B11 TOP sky130_fd_pr__cap_mim_m3_1 l=3 w=3
X1147 EDGE_BIAS EDGE_BIAS sky130_fd_pr__cap_mim_m3_1 l=3 w=3
X1148 B11 TOP sky130_fd_pr__cap_mim_m3_1 l=3 w=3
X1149 B11 TOP sky130_fd_pr__cap_mim_m3_1 l=3 w=3
X1150 B11 TOP sky130_fd_pr__cap_mim_m3_1 l=3 w=3
X1151 B9 TOP sky130_fd_pr__cap_mim_m3_1 l=3 w=3
X1152 B9 TOP sky130_fd_pr__cap_mim_m3_1 l=3 w=3
X1153 EDGE_BIAS EDGE_BIAS sky130_fd_pr__cap_mim_m3_1 l=3 w=3
X1154 B11 TOP sky130_fd_pr__cap_mim_m3_1 l=3 w=3
X1155 B11 TOP sky130_fd_pr__cap_mim_m3_1 l=3 w=3
X1156 B11 TOP sky130_fd_pr__cap_mim_m3_1 l=3 w=3
X1157 B9 TOP sky130_fd_pr__cap_mim_m3_1 l=3 w=3
X1158 B11 TOP sky130_fd_pr__cap_mim_m3_1 l=3 w=3
X1159 B11 TOP sky130_fd_pr__cap_mim_m3_1 l=3 w=3
X1160 B7 TOP sky130_fd_pr__cap_mim_m3_1 l=3 w=3
X1161 B11 TOP sky130_fd_pr__cap_mim_m3_1 l=3 w=3
X1162 EDGE_BIAS EDGE_BIAS sky130_fd_pr__cap_mim_m3_1 l=3 w=3
X1163 B11 TOP sky130_fd_pr__cap_mim_m3_1 l=3 w=3
X1164 B9 TOP sky130_fd_pr__cap_mim_m3_1 l=3 w=3
X1165 B8 TOP sky130_fd_pr__cap_mim_m3_1 l=3 w=3
X1166 B11 TOP sky130_fd_pr__cap_mim_m3_1 l=3 w=3
X1167 B11 TOP sky130_fd_pr__cap_mim_m3_1 l=3 w=3
X1168 B11 TOP sky130_fd_pr__cap_mim_m3_1 l=3 w=3
X1169 B11 TOP sky130_fd_pr__cap_mim_m3_1 l=3 w=3
X1170 B11 TOP sky130_fd_pr__cap_mim_m3_1 l=3 w=3
X1171 B10 TOP sky130_fd_pr__cap_mim_m3_1 l=3 w=3
X1172 B10 TOP sky130_fd_pr__cap_mim_m3_1 l=3 w=3
X1173 EDGE_BIAS EDGE_BIAS sky130_fd_pr__cap_mim_m3_1 l=3 w=3
X1174 B11 TOP sky130_fd_pr__cap_mim_m3_1 l=3 w=3
X1175 B11 TOP sky130_fd_pr__cap_mim_m3_1 l=3 w=3
X1176 B11 TOP sky130_fd_pr__cap_mim_m3_1 l=3 w=3
X1177 B11 TOP sky130_fd_pr__cap_mim_m3_1 l=3 w=3
X1178 B10 TOP sky130_fd_pr__cap_mim_m3_1 l=3 w=3
X1179 B11 TOP sky130_fd_pr__cap_mim_m3_1 l=3 w=3
X1180 B11 TOP sky130_fd_pr__cap_mim_m3_1 l=3 w=3
X1181 B9 TOP sky130_fd_pr__cap_mim_m3_1 l=3 w=3
X1182 B11 TOP sky130_fd_pr__cap_mim_m3_1 l=3 w=3
X1183 B9 TOP sky130_fd_pr__cap_mim_m3_1 l=3 w=3
X1184 B10 TOP sky130_fd_pr__cap_mim_m3_1 l=3 w=3
X1185 B10 TOP sky130_fd_pr__cap_mim_m3_1 l=3 w=3
X1186 B6 TOP sky130_fd_pr__cap_mim_m3_1 l=3 w=3
X1187 B9 TOP sky130_fd_pr__cap_mim_m3_1 l=3 w=3
X1188 B10 TOP sky130_fd_pr__cap_mim_m3_1 l=3 w=3
X1189 B9 TOP sky130_fd_pr__cap_mim_m3_1 l=3 w=3
X1190 EDGE_BIAS EDGE_BIAS sky130_fd_pr__cap_mim_m3_1 l=3 w=3
X1191 B10 TOP sky130_fd_pr__cap_mim_m3_1 l=3 w=3
X1192 B11 TOP sky130_fd_pr__cap_mim_m3_1 l=3 w=3
X1193 B11 TOP sky130_fd_pr__cap_mim_m3_1 l=3 w=3
X1194 B11 TOP sky130_fd_pr__cap_mim_m3_1 l=3 w=3
X1195 B11 TOP sky130_fd_pr__cap_mim_m3_1 l=3 w=3
X1196 EDGE_BIAS EDGE_BIAS sky130_fd_pr__cap_mim_m3_1 l=3 w=3
X1197 B10 TOP sky130_fd_pr__cap_mim_m3_1 l=3 w=3
X1198 B11 TOP sky130_fd_pr__cap_mim_m3_1 l=3 w=3
X1199 B11 TOP sky130_fd_pr__cap_mim_m3_1 l=3 w=3
X1200 B9 TOP sky130_fd_pr__cap_mim_m3_1 l=3 w=3
X1201 B10 TOP sky130_fd_pr__cap_mim_m3_1 l=3 w=3
X1202 B11 TOP sky130_fd_pr__cap_mim_m3_1 l=3 w=3
X1203 B9 TOP sky130_fd_pr__cap_mim_m3_1 l=3 w=3
X1204 B11 TOP sky130_fd_pr__cap_mim_m3_1 l=3 w=3
X1205 B11 TOP sky130_fd_pr__cap_mim_m3_1 l=3 w=3
X1206 B8 TOP sky130_fd_pr__cap_mim_m3_1 l=3 w=3
X1207 B11 TOP sky130_fd_pr__cap_mim_m3_1 l=3 w=3
X1208 B10 TOP sky130_fd_pr__cap_mim_m3_1 l=3 w=3
X1209 B11 TOP sky130_fd_pr__cap_mim_m3_1 l=3 w=3
X1210 B10 TOP sky130_fd_pr__cap_mim_m3_1 l=3 w=3
X1211 B11 TOP sky130_fd_pr__cap_mim_m3_1 l=3 w=3
X1212 B10 TOP sky130_fd_pr__cap_mim_m3_1 l=3 w=3
X1213 B11 TOP sky130_fd_pr__cap_mim_m3_1 l=3 w=3
X1214 B11 TOP sky130_fd_pr__cap_mim_m3_1 l=3 w=3
X1215 B11 TOP sky130_fd_pr__cap_mim_m3_1 l=3 w=3
X1216 B11 TOP sky130_fd_pr__cap_mim_m3_1 l=3 w=3
X1217 B11 TOP sky130_fd_pr__cap_mim_m3_1 l=3 w=3
X1218 B11 TOP sky130_fd_pr__cap_mim_m3_1 l=3 w=3
X1219 B11 TOP sky130_fd_pr__cap_mim_m3_1 l=3 w=3
X1220 B11 TOP sky130_fd_pr__cap_mim_m3_1 l=3 w=3
X1221 B10 TOP sky130_fd_pr__cap_mim_m3_1 l=3 w=3
X1222 B9 TOP sky130_fd_pr__cap_mim_m3_1 l=3 w=3
X1223 B11 TOP sky130_fd_pr__cap_mim_m3_1 l=3 w=3
X1224 B10 TOP sky130_fd_pr__cap_mim_m3_1 l=3 w=3
X1225 B10 TOP sky130_fd_pr__cap_mim_m3_1 l=3 w=3
X1226 B9 TOP sky130_fd_pr__cap_mim_m3_1 l=3 w=3
X1227 EDGE_BIAS EDGE_BIAS sky130_fd_pr__cap_mim_m3_1 l=3 w=3
X1228 B11 TOP sky130_fd_pr__cap_mim_m3_1 l=3 w=3
X1229 B11 TOP sky130_fd_pr__cap_mim_m3_1 l=3 w=3
X1230 B10 TOP sky130_fd_pr__cap_mim_m3_1 l=3 w=3
X1231 B10 TOP sky130_fd_pr__cap_mim_m3_1 l=3 w=3
X1232 B11 TOP sky130_fd_pr__cap_mim_m3_1 l=3 w=3
X1233 B9 TOP sky130_fd_pr__cap_mim_m3_1 l=3 w=3
X1234 B11 TOP sky130_fd_pr__cap_mim_m3_1 l=3 w=3
X1235 B11 TOP sky130_fd_pr__cap_mim_m3_1 l=3 w=3
X1236 B11 TOP sky130_fd_pr__cap_mim_m3_1 l=3 w=3
X1237 B10 TOP sky130_fd_pr__cap_mim_m3_1 l=3 w=3
X1238 EDGE_BIAS EDGE_BIAS sky130_fd_pr__cap_mim_m3_1 l=3 w=3
X1239 EDGE_BIAS EDGE_BIAS sky130_fd_pr__cap_mim_m3_1 l=3 w=3
X1240 B11 TOP sky130_fd_pr__cap_mim_m3_1 l=3 w=3
X1241 B11 TOP sky130_fd_pr__cap_mim_m3_1 l=3 w=3
X1242 B8 TOP sky130_fd_pr__cap_mim_m3_1 l=3 w=3
X1243 B11 TOP sky130_fd_pr__cap_mim_m3_1 l=3 w=3
X1244 B11 TOP sky130_fd_pr__cap_mim_m3_1 l=3 w=3
X1245 B11 TOP sky130_fd_pr__cap_mim_m3_1 l=3 w=3
X1246 B11 TOP sky130_fd_pr__cap_mim_m3_1 l=3 w=3
X1247 B11 TOP sky130_fd_pr__cap_mim_m3_1 l=3 w=3
X1248 B9 TOP sky130_fd_pr__cap_mim_m3_1 l=3 w=3
X1249 B11 TOP sky130_fd_pr__cap_mim_m3_1 l=3 w=3
X1250 B11 TOP sky130_fd_pr__cap_mim_m3_1 l=3 w=3
X1251 B10 TOP sky130_fd_pr__cap_mim_m3_1 l=3 w=3
X1252 B9 TOP sky130_fd_pr__cap_mim_m3_1 l=3 w=3
X1253 B9 TOP sky130_fd_pr__cap_mim_m3_1 l=3 w=3
X1254 B8 TOP sky130_fd_pr__cap_mim_m3_1 l=3 w=3
X1255 B11 TOP sky130_fd_pr__cap_mim_m3_1 l=3 w=3
X1256 B11 TOP sky130_fd_pr__cap_mim_m3_1 l=3 w=3
X1257 B10 TOP sky130_fd_pr__cap_mim_m3_1 l=3 w=3
X1258 B10 TOP sky130_fd_pr__cap_mim_m3_1 l=3 w=3
X1259 B10 TOP sky130_fd_pr__cap_mim_m3_1 l=3 w=3
X1260 B10 TOP sky130_fd_pr__cap_mim_m3_1 l=3 w=3
X1261 B7 TOP sky130_fd_pr__cap_mim_m3_1 l=3 w=3
X1262 B11 TOP sky130_fd_pr__cap_mim_m3_1 l=3 w=3
X1263 B11 TOP sky130_fd_pr__cap_mim_m3_1 l=3 w=3
X1264 B10 TOP sky130_fd_pr__cap_mim_m3_1 l=3 w=3
X1265 B11 TOP sky130_fd_pr__cap_mim_m3_1 l=3 w=3
X1266 B10 TOP sky130_fd_pr__cap_mim_m3_1 l=3 w=3
X1267 EDGE_BIAS EDGE_BIAS sky130_fd_pr__cap_mim_m3_1 l=3 w=3
X1268 B11 TOP sky130_fd_pr__cap_mim_m3_1 l=3 w=3
X1269 B11 TOP sky130_fd_pr__cap_mim_m3_1 l=3 w=3
X1270 B11 TOP sky130_fd_pr__cap_mim_m3_1 l=3 w=3
X1271 B8 TOP sky130_fd_pr__cap_mim_m3_1 l=3 w=3
X1272 B11 TOP sky130_fd_pr__cap_mim_m3_1 l=3 w=3
X1273 B11 TOP sky130_fd_pr__cap_mim_m3_1 l=3 w=3
X1274 B11 TOP sky130_fd_pr__cap_mim_m3_1 l=3 w=3
X1275 B11 TOP sky130_fd_pr__cap_mim_m3_1 l=3 w=3
X1276 EDGE_BIAS EDGE_BIAS sky130_fd_pr__cap_mim_m3_1 l=3 w=3
X1277 B11 TOP sky130_fd_pr__cap_mim_m3_1 l=3 w=3
X1278 B10 TOP sky130_fd_pr__cap_mim_m3_1 l=3 w=3
X1279 B11 TOP sky130_fd_pr__cap_mim_m3_1 l=3 w=3
X1280 B10 TOP sky130_fd_pr__cap_mim_m3_1 l=3 w=3
X1281 B11 TOP sky130_fd_pr__cap_mim_m3_1 l=3 w=3
X1282 B5 TOP sky130_fd_pr__cap_mim_m3_1 l=3 w=3
X1283 B11 TOP sky130_fd_pr__cap_mim_m3_1 l=3 w=3
X1284 B11 TOP sky130_fd_pr__cap_mim_m3_1 l=3 w=3
X1285 EDGE_BIAS EDGE_BIAS sky130_fd_pr__cap_mim_m3_1 l=3 w=3
X1286 B7 TOP sky130_fd_pr__cap_mim_m3_1 l=3 w=3
X1287 EDGE_BIAS EDGE_BIAS sky130_fd_pr__cap_mim_m3_1 l=3 w=3
X1288 EDGE_BIAS EDGE_BIAS sky130_fd_pr__cap_mim_m3_1 l=3 w=3
X1289 B11 TOP sky130_fd_pr__cap_mim_m3_1 l=3 w=3
X1290 B11 TOP sky130_fd_pr__cap_mim_m3_1 l=3 w=3
X1291 B11 TOP sky130_fd_pr__cap_mim_m3_1 l=3 w=3
X1292 B11 TOP sky130_fd_pr__cap_mim_m3_1 l=3 w=3
X1293 B11 TOP sky130_fd_pr__cap_mim_m3_1 l=3 w=3
X1294 B10 TOP sky130_fd_pr__cap_mim_m3_1 l=3 w=3
X1295 B11 TOP sky130_fd_pr__cap_mim_m3_1 l=3 w=3
X1296 B11 TOP sky130_fd_pr__cap_mim_m3_1 l=3 w=3
X1297 B8 TOP sky130_fd_pr__cap_mim_m3_1 l=3 w=3
X1298 B9 TOP sky130_fd_pr__cap_mim_m3_1 l=3 w=3
X1299 B11 TOP sky130_fd_pr__cap_mim_m3_1 l=3 w=3
X1300 B11 TOP sky130_fd_pr__cap_mim_m3_1 l=3 w=3
X1301 B8 TOP sky130_fd_pr__cap_mim_m3_1 l=3 w=3
X1302 B10 TOP sky130_fd_pr__cap_mim_m3_1 l=3 w=3
X1303 B8 TOP sky130_fd_pr__cap_mim_m3_1 l=3 w=3
X1304 B11 TOP sky130_fd_pr__cap_mim_m3_1 l=3 w=3
X1305 B11 TOP sky130_fd_pr__cap_mim_m3_1 l=3 w=3
X1306 EDGE_BIAS EDGE_BIAS sky130_fd_pr__cap_mim_m3_1 l=3 w=3
X1307 B11 TOP sky130_fd_pr__cap_mim_m3_1 l=3 w=3
X1308 B11 TOP sky130_fd_pr__cap_mim_m3_1 l=3 w=3
X1309 B11 TOP sky130_fd_pr__cap_mim_m3_1 l=3 w=3
X1310 B11 TOP sky130_fd_pr__cap_mim_m3_1 l=3 w=3
X1311 B11 TOP sky130_fd_pr__cap_mim_m3_1 l=3 w=3
X1312 B11 TOP sky130_fd_pr__cap_mim_m3_1 l=3 w=3
X1313 B11 TOP sky130_fd_pr__cap_mim_m3_1 l=3 w=3
X1314 B8 TOP sky130_fd_pr__cap_mim_m3_1 l=3 w=3
X1315 B11 TOP sky130_fd_pr__cap_mim_m3_1 l=3 w=3
X1316 B9 TOP sky130_fd_pr__cap_mim_m3_1 l=3 w=3
X1317 B11 TOP sky130_fd_pr__cap_mim_m3_1 l=3 w=3
X1318 B9 TOP sky130_fd_pr__cap_mim_m3_1 l=3 w=3
X1319 B10 TOP sky130_fd_pr__cap_mim_m3_1 l=3 w=3
X1320 B6 TOP sky130_fd_pr__cap_mim_m3_1 l=3 w=3
X1321 B9 TOP sky130_fd_pr__cap_mim_m3_1 l=3 w=3
X1322 B10 TOP sky130_fd_pr__cap_mim_m3_1 l=3 w=3
X1323 B11 TOP sky130_fd_pr__cap_mim_m3_1 l=3 w=3
X1324 B11 TOP sky130_fd_pr__cap_mim_m3_1 l=3 w=3
X1325 B11 TOP sky130_fd_pr__cap_mim_m3_1 l=3 w=3
X1326 EDGE_BIAS EDGE_BIAS sky130_fd_pr__cap_mim_m3_1 l=3 w=3
X1327 B11 TOP sky130_fd_pr__cap_mim_m3_1 l=3 w=3
X1328 B11 TOP sky130_fd_pr__cap_mim_m3_1 l=3 w=3
X1329 B10 TOP sky130_fd_pr__cap_mim_m3_1 l=3 w=3
X1330 B11 TOP sky130_fd_pr__cap_mim_m3_1 l=3 w=3
X1331 B11 TOP sky130_fd_pr__cap_mim_m3_1 l=3 w=3
X1332 B11 TOP sky130_fd_pr__cap_mim_m3_1 l=3 w=3
X1333 B11 TOP sky130_fd_pr__cap_mim_m3_1 l=3 w=3
X1334 B11 TOP sky130_fd_pr__cap_mim_m3_1 l=3 w=3
X1335 B10 TOP sky130_fd_pr__cap_mim_m3_1 l=3 w=3
X1336 B11 TOP sky130_fd_pr__cap_mim_m3_1 l=3 w=3
X1337 B11 TOP sky130_fd_pr__cap_mim_m3_1 l=3 w=3
X1338 B10 TOP sky130_fd_pr__cap_mim_m3_1 l=3 w=3
X1339 B9 TOP sky130_fd_pr__cap_mim_m3_1 l=3 w=3
X1340 B11 TOP sky130_fd_pr__cap_mim_m3_1 l=3 w=3
X1341 B11 TOP sky130_fd_pr__cap_mim_m3_1 l=3 w=3
X1342 B10 TOP sky130_fd_pr__cap_mim_m3_1 l=3 w=3
X1343 B11 TOP sky130_fd_pr__cap_mim_m3_1 l=3 w=3
X1344 B11 TOP sky130_fd_pr__cap_mim_m3_1 l=3 w=3
X1345 B10 TOP sky130_fd_pr__cap_mim_m3_1 l=3 w=3
X1346 B8 TOP sky130_fd_pr__cap_mim_m3_1 l=3 w=3
X1347 B10 TOP sky130_fd_pr__cap_mim_m3_1 l=3 w=3
X1348 B10 TOP sky130_fd_pr__cap_mim_m3_1 l=3 w=3
X1349 B10 TOP sky130_fd_pr__cap_mim_m3_1 l=3 w=3
X1350 B11 TOP sky130_fd_pr__cap_mim_m3_1 l=3 w=3
X1351 B11 TOP sky130_fd_pr__cap_mim_m3_1 l=3 w=3
X1352 B11 TOP sky130_fd_pr__cap_mim_m3_1 l=3 w=3
X1353 EDGE_BIAS EDGE_BIAS sky130_fd_pr__cap_mim_m3_1 l=3 w=3
X1354 B11 TOP sky130_fd_pr__cap_mim_m3_1 l=3 w=3
X1355 B11 TOP sky130_fd_pr__cap_mim_m3_1 l=3 w=3
X1356 B8 TOP sky130_fd_pr__cap_mim_m3_1 l=3 w=3
X1357 B9 TOP sky130_fd_pr__cap_mim_m3_1 l=3 w=3
X1358 B11 TOP sky130_fd_pr__cap_mim_m3_1 l=3 w=3
X1359 B10 TOP sky130_fd_pr__cap_mim_m3_1 l=3 w=3
X1360 B11 TOP sky130_fd_pr__cap_mim_m3_1 l=3 w=3
X1361 B11 TOP sky130_fd_pr__cap_mim_m3_1 l=3 w=3
X1362 B10 TOP sky130_fd_pr__cap_mim_m3_1 l=3 w=3
X1363 B9 TOP sky130_fd_pr__cap_mim_m3_1 l=3 w=3
X1364 B11 TOP sky130_fd_pr__cap_mim_m3_1 l=3 w=3
X1365 B11 TOP sky130_fd_pr__cap_mim_m3_1 l=3 w=3
X1366 B10 TOP sky130_fd_pr__cap_mim_m3_1 l=3 w=3
X1367 B10 TOP sky130_fd_pr__cap_mim_m3_1 l=3 w=3
X1368 B9 TOP sky130_fd_pr__cap_mim_m3_1 l=3 w=3
X1369 B9 TOP sky130_fd_pr__cap_mim_m3_1 l=3 w=3
X1370 B11 TOP sky130_fd_pr__cap_mim_m3_1 l=3 w=3
X1371 B10 TOP sky130_fd_pr__cap_mim_m3_1 l=3 w=3
X1372 EDGE_BIAS EDGE_BIAS sky130_fd_pr__cap_mim_m3_1 l=3 w=3
X1373 EDGE_BIAS EDGE_BIAS sky130_fd_pr__cap_mim_m3_1 l=3 w=3
X1374 B11 TOP sky130_fd_pr__cap_mim_m3_1 l=3 w=3
X1375 EDGE_BIAS EDGE_BIAS sky130_fd_pr__cap_mim_m3_1 l=3 w=3
X1376 B11 TOP sky130_fd_pr__cap_mim_m3_1 l=3 w=3
X1377 B10 TOP sky130_fd_pr__cap_mim_m3_1 l=3 w=3
X1378 B11 TOP sky130_fd_pr__cap_mim_m3_1 l=3 w=3
X1379 B11 TOP sky130_fd_pr__cap_mim_m3_1 l=3 w=3
X1380 B11 TOP sky130_fd_pr__cap_mim_m3_1 l=3 w=3
X1381 B11 TOP sky130_fd_pr__cap_mim_m3_1 l=3 w=3
X1382 B11 TOP sky130_fd_pr__cap_mim_m3_1 l=3 w=3
X1383 B11 TOP sky130_fd_pr__cap_mim_m3_1 l=3 w=3
X1384 B11 TOP sky130_fd_pr__cap_mim_m3_1 l=3 w=3
X1385 B11 TOP sky130_fd_pr__cap_mim_m3_1 l=3 w=3
X1386 B11 TOP sky130_fd_pr__cap_mim_m3_1 l=3 w=3
X1387 B9 TOP sky130_fd_pr__cap_mim_m3_1 l=3 w=3
X1388 B8 TOP sky130_fd_pr__cap_mim_m3_1 l=3 w=3
X1389 B11 TOP sky130_fd_pr__cap_mim_m3_1 l=3 w=3
X1390 B11 TOP sky130_fd_pr__cap_mim_m3_1 l=3 w=3
X1391 B10 TOP sky130_fd_pr__cap_mim_m3_1 l=3 w=3
X1392 B9 TOP sky130_fd_pr__cap_mim_m3_1 l=3 w=3
X1393 B7 TOP sky130_fd_pr__cap_mim_m3_1 l=3 w=3
X1394 B11 TOP sky130_fd_pr__cap_mim_m3_1 l=3 w=3
X1395 B10 TOP sky130_fd_pr__cap_mim_m3_1 l=3 w=3
X1396 B11 TOP sky130_fd_pr__cap_mim_m3_1 l=3 w=3
X1397 B10 TOP sky130_fd_pr__cap_mim_m3_1 l=3 w=3
X1398 B11 TOP sky130_fd_pr__cap_mim_m3_1 l=3 w=3
X1399 B11 TOP sky130_fd_pr__cap_mim_m3_1 l=3 w=3
X1400 B11 TOP sky130_fd_pr__cap_mim_m3_1 l=3 w=3
X1401 B11 TOP sky130_fd_pr__cap_mim_m3_1 l=3 w=3
X1402 B11 TOP sky130_fd_pr__cap_mim_m3_1 l=3 w=3
X1403 B8 TOP sky130_fd_pr__cap_mim_m3_1 l=3 w=3
X1404 B11 TOP sky130_fd_pr__cap_mim_m3_1 l=3 w=3
X1405 B9 TOP sky130_fd_pr__cap_mim_m3_1 l=3 w=3
X1406 B11 TOP sky130_fd_pr__cap_mim_m3_1 l=3 w=3
X1407 B11 TOP sky130_fd_pr__cap_mim_m3_1 l=3 w=3
X1408 B10 TOP sky130_fd_pr__cap_mim_m3_1 l=3 w=3
X1409 B11 TOP sky130_fd_pr__cap_mim_m3_1 l=3 w=3
X1410 B11 TOP sky130_fd_pr__cap_mim_m3_1 l=3 w=3
X1411 B9 TOP sky130_fd_pr__cap_mim_m3_1 l=3 w=3
X1412 B11 TOP sky130_fd_pr__cap_mim_m3_1 l=3 w=3
X1413 B7 TOP sky130_fd_pr__cap_mim_m3_1 l=3 w=3
X1414 B11 TOP sky130_fd_pr__cap_mim_m3_1 l=3 w=3
X1415 EDGE_BIAS EDGE_BIAS sky130_fd_pr__cap_mim_m3_1 l=3 w=3
X1416 B11 TOP sky130_fd_pr__cap_mim_m3_1 l=3 w=3
X1417 B11 TOP sky130_fd_pr__cap_mim_m3_1 l=3 w=3
X1418 B11 TOP sky130_fd_pr__cap_mim_m3_1 l=3 w=3
X1419 B11 TOP sky130_fd_pr__cap_mim_m3_1 l=3 w=3
X1420 B11 TOP sky130_fd_pr__cap_mim_m3_1 l=3 w=3
X1421 B11 TOP sky130_fd_pr__cap_mim_m3_1 l=3 w=3
X1422 B11 TOP sky130_fd_pr__cap_mim_m3_1 l=3 w=3
X1423 B10 TOP sky130_fd_pr__cap_mim_m3_1 l=3 w=3
X1424 B10 TOP sky130_fd_pr__cap_mim_m3_1 l=3 w=3
X1425 B11 TOP sky130_fd_pr__cap_mim_m3_1 l=3 w=3
X1426 B11 TOP sky130_fd_pr__cap_mim_m3_1 l=3 w=3
X1427 B11 TOP sky130_fd_pr__cap_mim_m3_1 l=3 w=3
X1428 B8 TOP sky130_fd_pr__cap_mim_m3_1 l=3 w=3
X1429 B9 TOP sky130_fd_pr__cap_mim_m3_1 l=3 w=3
X1430 B11 TOP sky130_fd_pr__cap_mim_m3_1 l=3 w=3
X1431 B11 TOP sky130_fd_pr__cap_mim_m3_1 l=3 w=3
X1432 B10 TOP sky130_fd_pr__cap_mim_m3_1 l=3 w=3
X1433 B11 TOP sky130_fd_pr__cap_mim_m3_1 l=3 w=3
X1434 EDGE_BIAS EDGE_BIAS sky130_fd_pr__cap_mim_m3_1 l=3 w=3
X1435 B5 TOP sky130_fd_pr__cap_mim_m3_1 l=3 w=3
X1436 B10 TOP sky130_fd_pr__cap_mim_m3_1 l=3 w=3
X1437 B11 TOP sky130_fd_pr__cap_mim_m3_1 l=3 w=3
X1438 B11 TOP sky130_fd_pr__cap_mim_m3_1 l=3 w=3
X1439 B11 TOP sky130_fd_pr__cap_mim_m3_1 l=3 w=3
X1440 EDGE_BIAS EDGE_BIAS sky130_fd_pr__cap_mim_m3_1 l=3 w=3
X1441 B11 TOP sky130_fd_pr__cap_mim_m3_1 l=3 w=3
X1442 B11 TOP sky130_fd_pr__cap_mim_m3_1 l=3 w=3
X1443 B11 TOP sky130_fd_pr__cap_mim_m3_1 l=3 w=3
X1444 B11 TOP sky130_fd_pr__cap_mim_m3_1 l=3 w=3
X1445 B9 TOP sky130_fd_pr__cap_mim_m3_1 l=3 w=3
X1446 B9 TOP sky130_fd_pr__cap_mim_m3_1 l=3 w=3
X1447 B10 TOP sky130_fd_pr__cap_mim_m3_1 l=3 w=3
X1448 B11 TOP sky130_fd_pr__cap_mim_m3_1 l=3 w=3
X1449 B11 TOP sky130_fd_pr__cap_mim_m3_1 l=3 w=3
X1450 B10 TOP sky130_fd_pr__cap_mim_m3_1 l=3 w=3
X1451 B11 TOP sky130_fd_pr__cap_mim_m3_1 l=3 w=3
X1452 B9 TOP sky130_fd_pr__cap_mim_m3_1 l=3 w=3
X1453 B10 TOP sky130_fd_pr__cap_mim_m3_1 l=3 w=3
X1454 B11 TOP sky130_fd_pr__cap_mim_m3_1 l=3 w=3
X1455 B11 TOP sky130_fd_pr__cap_mim_m3_1 l=3 w=3
X1456 B10 TOP sky130_fd_pr__cap_mim_m3_1 l=3 w=3
X1457 B11 TOP sky130_fd_pr__cap_mim_m3_1 l=3 w=3
X1458 EDGE_BIAS EDGE_BIAS sky130_fd_pr__cap_mim_m3_1 l=3 w=3
X1459 B10 TOP sky130_fd_pr__cap_mim_m3_1 l=3 w=3
X1460 B11 TOP sky130_fd_pr__cap_mim_m3_1 l=3 w=3
X1461 B11 TOP sky130_fd_pr__cap_mim_m3_1 l=3 w=3
X1462 B11 TOP sky130_fd_pr__cap_mim_m3_1 l=3 w=3
X1463 B11 TOP sky130_fd_pr__cap_mim_m3_1 l=3 w=3
X1464 B9 TOP sky130_fd_pr__cap_mim_m3_1 l=3 w=3
X1465 EDGE_BIAS EDGE_BIAS sky130_fd_pr__cap_mim_m3_1 l=3 w=3
X1466 B11 TOP sky130_fd_pr__cap_mim_m3_1 l=3 w=3
X1467 B11 TOP sky130_fd_pr__cap_mim_m3_1 l=3 w=3
X1468 B11 TOP sky130_fd_pr__cap_mim_m3_1 l=3 w=3
X1469 B10 TOP sky130_fd_pr__cap_mim_m3_1 l=3 w=3
X1470 B11 TOP sky130_fd_pr__cap_mim_m3_1 l=3 w=3
X1471 B11 TOP sky130_fd_pr__cap_mim_m3_1 l=3 w=3
X1472 B11 TOP sky130_fd_pr__cap_mim_m3_1 l=3 w=3
X1473 B10 TOP sky130_fd_pr__cap_mim_m3_1 l=3 w=3
X1474 B8 TOP sky130_fd_pr__cap_mim_m3_1 l=3 w=3
X1475 B10 TOP sky130_fd_pr__cap_mim_m3_1 l=3 w=3
X1476 B11 TOP sky130_fd_pr__cap_mim_m3_1 l=3 w=3
X1477 B10 TOP sky130_fd_pr__cap_mim_m3_1 l=3 w=3
X1478 B7 TOP sky130_fd_pr__cap_mim_m3_1 l=3 w=3
X1479 B10 TOP sky130_fd_pr__cap_mim_m3_1 l=3 w=3
X1480 B11 TOP sky130_fd_pr__cap_mim_m3_1 l=3 w=3
X1481 EDGE_BIAS EDGE_BIAS sky130_fd_pr__cap_mim_m3_1 l=3 w=3
X1482 B10 TOP sky130_fd_pr__cap_mim_m3_1 l=3 w=3
X1483 B6 TOP sky130_fd_pr__cap_mim_m3_1 l=3 w=3
X1484 B11 TOP sky130_fd_pr__cap_mim_m3_1 l=3 w=3
X1485 B10 TOP sky130_fd_pr__cap_mim_m3_1 l=3 w=3
X1486 B11 TOP sky130_fd_pr__cap_mim_m3_1 l=3 w=3
X1487 B11 TOP sky130_fd_pr__cap_mim_m3_1 l=3 w=3
X1488 B11 TOP sky130_fd_pr__cap_mim_m3_1 l=3 w=3
X1489 B10 TOP sky130_fd_pr__cap_mim_m3_1 l=3 w=3
X1490 B8 TOP sky130_fd_pr__cap_mim_m3_1 l=3 w=3
X1491 EDGE_BIAS EDGE_BIAS sky130_fd_pr__cap_mim_m3_1 l=3 w=3
X1492 B11 TOP sky130_fd_pr__cap_mim_m3_1 l=3 w=3
X1493 B11 TOP sky130_fd_pr__cap_mim_m3_1 l=3 w=3
X1494 B11 TOP sky130_fd_pr__cap_mim_m3_1 l=3 w=3
X1495 B9 TOP sky130_fd_pr__cap_mim_m3_1 l=3 w=3
X1496 B11 TOP sky130_fd_pr__cap_mim_m3_1 l=3 w=3
X1497 B10 TOP sky130_fd_pr__cap_mim_m3_1 l=3 w=3
X1498 B11 TOP sky130_fd_pr__cap_mim_m3_1 l=3 w=3
X1499 B9 TOP sky130_fd_pr__cap_mim_m3_1 l=3 w=3
X1500 B9 TOP sky130_fd_pr__cap_mim_m3_1 l=3 w=3
X1501 B10 TOP sky130_fd_pr__cap_mim_m3_1 l=3 w=3
X1502 B10 TOP sky130_fd_pr__cap_mim_m3_1 l=3 w=3
X1503 B7 TOP sky130_fd_pr__cap_mim_m3_1 l=3 w=3
X1504 B11 TOP sky130_fd_pr__cap_mim_m3_1 l=3 w=3
X1505 B11 TOP sky130_fd_pr__cap_mim_m3_1 l=3 w=3
X1506 B10 TOP sky130_fd_pr__cap_mim_m3_1 l=3 w=3
X1507 EDGE_BIAS EDGE_BIAS sky130_fd_pr__cap_mim_m3_1 l=3 w=3
X1508 B11 TOP sky130_fd_pr__cap_mim_m3_1 l=3 w=3
X1509 B11 TOP sky130_fd_pr__cap_mim_m3_1 l=3 w=3
X1510 B11 TOP sky130_fd_pr__cap_mim_m3_1 l=3 w=3
X1511 B10 TOP sky130_fd_pr__cap_mim_m3_1 l=3 w=3
X1512 B11 TOP sky130_fd_pr__cap_mim_m3_1 l=3 w=3
X1513 B11 TOP sky130_fd_pr__cap_mim_m3_1 l=3 w=3
X1514 B10 TOP sky130_fd_pr__cap_mim_m3_1 l=3 w=3
X1515 B11 TOP sky130_fd_pr__cap_mim_m3_1 l=3 w=3
X1516 B11 TOP sky130_fd_pr__cap_mim_m3_1 l=3 w=3
X1517 B11 TOP sky130_fd_pr__cap_mim_m3_1 l=3 w=3
X1518 B10 TOP sky130_fd_pr__cap_mim_m3_1 l=3 w=3
X1519 B8 TOP sky130_fd_pr__cap_mim_m3_1 l=3 w=3
X1520 B11 TOP sky130_fd_pr__cap_mim_m3_1 l=3 w=3
X1521 EDGE_BIAS EDGE_BIAS sky130_fd_pr__cap_mim_m3_1 l=3 w=3
X1522 B10 TOP sky130_fd_pr__cap_mim_m3_1 l=3 w=3
X1523 B11 TOP sky130_fd_pr__cap_mim_m3_1 l=3 w=3
X1524 B11 TOP sky130_fd_pr__cap_mim_m3_1 l=3 w=3
X1525 B7 TOP sky130_fd_pr__cap_mim_m3_1 l=3 w=3
X1526 B10 TOP sky130_fd_pr__cap_mim_m3_1 l=3 w=3
X1527 B10 TOP sky130_fd_pr__cap_mim_m3_1 l=3 w=3
X1528 B11 TOP sky130_fd_pr__cap_mim_m3_1 l=3 w=3
X1529 B11 TOP sky130_fd_pr__cap_mim_m3_1 l=3 w=3
X1530 B11 TOP sky130_fd_pr__cap_mim_m3_1 l=3 w=3
X1531 B11 TOP sky130_fd_pr__cap_mim_m3_1 l=3 w=3
X1532 B8 TOP sky130_fd_pr__cap_mim_m3_1 l=3 w=3
X1533 EDGE_BIAS EDGE_BIAS sky130_fd_pr__cap_mim_m3_1 l=3 w=3
X1534 B11 TOP sky130_fd_pr__cap_mim_m3_1 l=3 w=3
X1535 B8 TOP sky130_fd_pr__cap_mim_m3_1 l=3 w=3
X1536 B9 TOP sky130_fd_pr__cap_mim_m3_1 l=3 w=3
X1537 B11 TOP sky130_fd_pr__cap_mim_m3_1 l=3 w=3
X1538 B10 TOP sky130_fd_pr__cap_mim_m3_1 l=3 w=3
X1539 B11 TOP sky130_fd_pr__cap_mim_m3_1 l=3 w=3
X1540 B11 TOP sky130_fd_pr__cap_mim_m3_1 l=3 w=3
X1541 B11 TOP sky130_fd_pr__cap_mim_m3_1 l=3 w=3
X1542 B11 TOP sky130_fd_pr__cap_mim_m3_1 l=3 w=3
X1543 B7 TOP sky130_fd_pr__cap_mim_m3_1 l=3 w=3
X1544 B11 TOP sky130_fd_pr__cap_mim_m3_1 l=3 w=3
X1545 B11 TOP sky130_fd_pr__cap_mim_m3_1 l=3 w=3
X1546 B11 TOP sky130_fd_pr__cap_mim_m3_1 l=3 w=3
X1547 B11 TOP sky130_fd_pr__cap_mim_m3_1 l=3 w=3
X1548 B11 TOP sky130_fd_pr__cap_mim_m3_1 l=3 w=3
X1549 B11 TOP sky130_fd_pr__cap_mim_m3_1 l=3 w=3
X1550 EDGE_BIAS EDGE_BIAS sky130_fd_pr__cap_mim_m3_1 l=3 w=3
X1551 B9 TOP sky130_fd_pr__cap_mim_m3_1 l=3 w=3
X1552 B11 TOP sky130_fd_pr__cap_mim_m3_1 l=3 w=3
X1553 B10 TOP sky130_fd_pr__cap_mim_m3_1 l=3 w=3
X1554 B11 TOP sky130_fd_pr__cap_mim_m3_1 l=3 w=3
X1555 B11 TOP sky130_fd_pr__cap_mim_m3_1 l=3 w=3
X1556 B10 TOP sky130_fd_pr__cap_mim_m3_1 l=3 w=3
X1557 B11 TOP sky130_fd_pr__cap_mim_m3_1 l=3 w=3
X1558 B11 TOP sky130_fd_pr__cap_mim_m3_1 l=3 w=3
X1559 B11 TOP sky130_fd_pr__cap_mim_m3_1 l=3 w=3
X1560 B11 TOP sky130_fd_pr__cap_mim_m3_1 l=3 w=3
X1561 B10 TOP sky130_fd_pr__cap_mim_m3_1 l=3 w=3
X1562 B8 TOP sky130_fd_pr__cap_mim_m3_1 l=3 w=3
X1563 B11 TOP sky130_fd_pr__cap_mim_m3_1 l=3 w=3
X1564 B10 TOP sky130_fd_pr__cap_mim_m3_1 l=3 w=3
X1565 B9 TOP sky130_fd_pr__cap_mim_m3_1 l=3 w=3
X1566 B5 TOP sky130_fd_pr__cap_mim_m3_1 l=3 w=3
X1567 B10 TOP sky130_fd_pr__cap_mim_m3_1 l=3 w=3
X1568 B10 TOP sky130_fd_pr__cap_mim_m3_1 l=3 w=3
X1569 B11 TOP sky130_fd_pr__cap_mim_m3_1 l=3 w=3
X1570 B9 TOP sky130_fd_pr__cap_mim_m3_1 l=3 w=3
X1571 EDGE_BIAS EDGE_BIAS sky130_fd_pr__cap_mim_m3_1 l=3 w=3
X1572 B11 TOP sky130_fd_pr__cap_mim_m3_1 l=3 w=3
X1573 B10 TOP sky130_fd_pr__cap_mim_m3_1 l=3 w=3
X1574 B11 TOP sky130_fd_pr__cap_mim_m3_1 l=3 w=3
X1575 B11 TOP sky130_fd_pr__cap_mim_m3_1 l=3 w=3
X1576 B9 TOP sky130_fd_pr__cap_mim_m3_1 l=3 w=3
X1577 B11 TOP sky130_fd_pr__cap_mim_m3_1 l=3 w=3
X1578 B11 TOP sky130_fd_pr__cap_mim_m3_1 l=3 w=3
X1579 B11 TOP sky130_fd_pr__cap_mim_m3_1 l=3 w=3
X1580 B2 TOP sky130_fd_pr__cap_mim_m3_1 l=3 w=3
X1581 B11 TOP sky130_fd_pr__cap_mim_m3_1 l=3 w=3
X1582 B10 TOP sky130_fd_pr__cap_mim_m3_1 l=3 w=3
X1583 B11 TOP sky130_fd_pr__cap_mim_m3_1 l=3 w=3
X1584 B9 TOP sky130_fd_pr__cap_mim_m3_1 l=3 w=3
X1585 B9 TOP sky130_fd_pr__cap_mim_m3_1 l=3 w=3
X1586 B10 TOP sky130_fd_pr__cap_mim_m3_1 l=3 w=3
X1587 EDGE_BIAS EDGE_BIAS sky130_fd_pr__cap_mim_m3_1 l=3 w=3
X1588 B11 TOP sky130_fd_pr__cap_mim_m3_1 l=3 w=3
X1589 B10 TOP sky130_fd_pr__cap_mim_m3_1 l=3 w=3
X1590 B10 TOP sky130_fd_pr__cap_mim_m3_1 l=3 w=3
X1591 B11 TOP sky130_fd_pr__cap_mim_m3_1 l=3 w=3
X1592 B11 TOP sky130_fd_pr__cap_mim_m3_1 l=3 w=3
X1593 B10 TOP sky130_fd_pr__cap_mim_m3_1 l=3 w=3
X1594 B11 TOP sky130_fd_pr__cap_mim_m3_1 l=3 w=3
X1595 B11 TOP sky130_fd_pr__cap_mim_m3_1 l=3 w=3
X1596 B11 TOP sky130_fd_pr__cap_mim_m3_1 l=3 w=3
X1597 B11 TOP sky130_fd_pr__cap_mim_m3_1 l=3 w=3
X1598 B10 TOP sky130_fd_pr__cap_mim_m3_1 l=3 w=3
X1599 B11 TOP sky130_fd_pr__cap_mim_m3_1 l=3 w=3
X1600 B8 TOP sky130_fd_pr__cap_mim_m3_1 l=3 w=3
X1601 B10 TOP sky130_fd_pr__cap_mim_m3_1 l=3 w=3
X1602 B11 TOP sky130_fd_pr__cap_mim_m3_1 l=3 w=3
X1603 B10 TOP sky130_fd_pr__cap_mim_m3_1 l=3 w=3
X1604 B10 TOP sky130_fd_pr__cap_mim_m3_1 l=3 w=3
X1605 EDGE_BIAS EDGE_BIAS sky130_fd_pr__cap_mim_m3_1 l=3 w=3
X1606 B11 TOP sky130_fd_pr__cap_mim_m3_1 l=3 w=3
X1607 B11 TOP sky130_fd_pr__cap_mim_m3_1 l=3 w=3
X1608 B11 TOP sky130_fd_pr__cap_mim_m3_1 l=3 w=3
X1609 B11 TOP sky130_fd_pr__cap_mim_m3_1 l=3 w=3
X1610 B10 TOP sky130_fd_pr__cap_mim_m3_1 l=3 w=3
X1611 B9 TOP sky130_fd_pr__cap_mim_m3_1 l=3 w=3
X1612 B10 TOP sky130_fd_pr__cap_mim_m3_1 l=3 w=3
X1613 B10 TOP sky130_fd_pr__cap_mim_m3_1 l=3 w=3
X1614 B6 TOP sky130_fd_pr__cap_mim_m3_1 l=3 w=3
X1615 EDGE_BIAS EDGE_BIAS sky130_fd_pr__cap_mim_m3_1 l=3 w=3
X1616 B11 TOP sky130_fd_pr__cap_mim_m3_1 l=3 w=3
X1617 B10 TOP sky130_fd_pr__cap_mim_m3_1 l=3 w=3
X1618 B11 TOP sky130_fd_pr__cap_mim_m3_1 l=3 w=3
X1619 B9 TOP sky130_fd_pr__cap_mim_m3_1 l=3 w=3
X1620 B11 TOP sky130_fd_pr__cap_mim_m3_1 l=3 w=3
X1621 B11 TOP sky130_fd_pr__cap_mim_m3_1 l=3 w=3
X1622 B9 TOP sky130_fd_pr__cap_mim_m3_1 l=3 w=3
X1623 EDGE_BIAS EDGE_BIAS sky130_fd_pr__cap_mim_m3_1 l=3 w=3
X1624 B11 TOP sky130_fd_pr__cap_mim_m3_1 l=3 w=3
X1625 EDGE_BIAS EDGE_BIAS sky130_fd_pr__cap_mim_m3_1 l=3 w=3
X1626 B11 TOP sky130_fd_pr__cap_mim_m3_1 l=3 w=3
X1627 B11 TOP sky130_fd_pr__cap_mim_m3_1 l=3 w=3
X1628 B10 TOP sky130_fd_pr__cap_mim_m3_1 l=3 w=3
X1629 B9 TOP sky130_fd_pr__cap_mim_m3_1 l=3 w=3
X1630 B9 TOP sky130_fd_pr__cap_mim_m3_1 l=3 w=3
X1631 B11 TOP sky130_fd_pr__cap_mim_m3_1 l=3 w=3
X1632 B11 TOP sky130_fd_pr__cap_mim_m3_1 l=3 w=3
X1633 B10 TOP sky130_fd_pr__cap_mim_m3_1 l=3 w=3
X1634 B9 TOP sky130_fd_pr__cap_mim_m3_1 l=3 w=3
X1635 B10 TOP sky130_fd_pr__cap_mim_m3_1 l=3 w=3
X1636 B11 TOP sky130_fd_pr__cap_mim_m3_1 l=3 w=3
X1637 B10 TOP sky130_fd_pr__cap_mim_m3_1 l=3 w=3
X1638 B8 TOP sky130_fd_pr__cap_mim_m3_1 l=3 w=3
X1639 B10 TOP sky130_fd_pr__cap_mim_m3_1 l=3 w=3
X1640 B11 TOP sky130_fd_pr__cap_mim_m3_1 l=3 w=3
X1641 B11 TOP sky130_fd_pr__cap_mim_m3_1 l=3 w=3
X1642 B10 TOP sky130_fd_pr__cap_mim_m3_1 l=3 w=3
X1643 B11 TOP sky130_fd_pr__cap_mim_m3_1 l=3 w=3
X1644 B11 TOP sky130_fd_pr__cap_mim_m3_1 l=3 w=3
X1645 B10 TOP sky130_fd_pr__cap_mim_m3_1 l=3 w=3
X1646 B11 TOP sky130_fd_pr__cap_mim_m3_1 l=3 w=3
X1647 EDGE_BIAS EDGE_BIAS sky130_fd_pr__cap_mim_m3_1 l=3 w=3
X1648 B10 TOP sky130_fd_pr__cap_mim_m3_1 l=3 w=3
X1649 B11 TOP sky130_fd_pr__cap_mim_m3_1 l=3 w=3
X1650 B11 TOP sky130_fd_pr__cap_mim_m3_1 l=3 w=3
X1651 B10 TOP sky130_fd_pr__cap_mim_m3_1 l=3 w=3
X1652 B11 TOP sky130_fd_pr__cap_mim_m3_1 l=3 w=3
X1653 B11 TOP sky130_fd_pr__cap_mim_m3_1 l=3 w=3
X1654 B11 TOP sky130_fd_pr__cap_mim_m3_1 l=3 w=3
X1655 B9 TOP sky130_fd_pr__cap_mim_m3_1 l=3 w=3
X1656 B11 TOP sky130_fd_pr__cap_mim_m3_1 l=3 w=3
X1657 B10 TOP sky130_fd_pr__cap_mim_m3_1 l=3 w=3
X1658 B11 TOP sky130_fd_pr__cap_mim_m3_1 l=3 w=3
X1659 B11 TOP sky130_fd_pr__cap_mim_m3_1 l=3 w=3
X1660 B10 TOP sky130_fd_pr__cap_mim_m3_1 l=3 w=3
X1661 B8 TOP sky130_fd_pr__cap_mim_m3_1 l=3 w=3
X1662 DUMMY TOP sky130_fd_pr__cap_mim_m3_1 l=3 w=3
X1663 B11 TOP sky130_fd_pr__cap_mim_m3_1 l=3 w=3
X1664 B11 TOP sky130_fd_pr__cap_mim_m3_1 l=3 w=3
X1665 B7 TOP sky130_fd_pr__cap_mim_m3_1 l=3 w=3
X1666 B11 TOP sky130_fd_pr__cap_mim_m3_1 l=3 w=3
X1667 B10 TOP sky130_fd_pr__cap_mim_m3_1 l=3 w=3
X1668 B6 TOP sky130_fd_pr__cap_mim_m3_1 l=3 w=3
X1669 B11 TOP sky130_fd_pr__cap_mim_m3_1 l=3 w=3
X1670 B6 TOP sky130_fd_pr__cap_mim_m3_1 l=3 w=3
X1671 B11 TOP sky130_fd_pr__cap_mim_m3_1 l=3 w=3
X1672 B11 TOP sky130_fd_pr__cap_mim_m3_1 l=3 w=3
X1673 EDGE_BIAS EDGE_BIAS sky130_fd_pr__cap_mim_m3_1 l=3 w=3
X1674 EDGE_BIAS EDGE_BIAS sky130_fd_pr__cap_mim_m3_1 l=3 w=3
X1675 EDGE_BIAS EDGE_BIAS sky130_fd_pr__cap_mim_m3_1 l=3 w=3
X1676 B11 TOP sky130_fd_pr__cap_mim_m3_1 l=3 w=3
X1677 B11 TOP sky130_fd_pr__cap_mim_m3_1 l=3 w=3
X1678 B10 TOP sky130_fd_pr__cap_mim_m3_1 l=3 w=3
X1679 B11 TOP sky130_fd_pr__cap_mim_m3_1 l=3 w=3
X1680 B11 TOP sky130_fd_pr__cap_mim_m3_1 l=3 w=3
X1681 B11 TOP sky130_fd_pr__cap_mim_m3_1 l=3 w=3
X1682 B11 TOP sky130_fd_pr__cap_mim_m3_1 l=3 w=3
X1683 B7 TOP sky130_fd_pr__cap_mim_m3_1 l=3 w=3
X1684 B11 TOP sky130_fd_pr__cap_mim_m3_1 l=3 w=3
X1685 B11 TOP sky130_fd_pr__cap_mim_m3_1 l=3 w=3
X1686 EDGE_BIAS EDGE_BIAS sky130_fd_pr__cap_mim_m3_1 l=3 w=3
X1687 B11 TOP sky130_fd_pr__cap_mim_m3_1 l=3 w=3
X1688 B10 TOP sky130_fd_pr__cap_mim_m3_1 l=3 w=3
X1689 B8 TOP sky130_fd_pr__cap_mim_m3_1 l=3 w=3
X1690 B10 TOP sky130_fd_pr__cap_mim_m3_1 l=3 w=3
X1691 B11 TOP sky130_fd_pr__cap_mim_m3_1 l=3 w=3
X1692 B11 TOP sky130_fd_pr__cap_mim_m3_1 l=3 w=3
X1693 B10 TOP sky130_fd_pr__cap_mim_m3_1 l=3 w=3
X1694 B11 TOP sky130_fd_pr__cap_mim_m3_1 l=3 w=3
X1695 B11 TOP sky130_fd_pr__cap_mim_m3_1 l=3 w=3
X1696 B9 TOP sky130_fd_pr__cap_mim_m3_1 l=3 w=3
X1697 B11 TOP sky130_fd_pr__cap_mim_m3_1 l=3 w=3
X1698 B11 TOP sky130_fd_pr__cap_mim_m3_1 l=3 w=3
X1699 B11 TOP sky130_fd_pr__cap_mim_m3_1 l=3 w=3
X1700 B8 TOP sky130_fd_pr__cap_mim_m3_1 l=3 w=3
X1701 B8 TOP sky130_fd_pr__cap_mim_m3_1 l=3 w=3
X1702 B11 TOP sky130_fd_pr__cap_mim_m3_1 l=3 w=3
X1703 B9 TOP sky130_fd_pr__cap_mim_m3_1 l=3 w=3
X1704 B6 TOP sky130_fd_pr__cap_mim_m3_1 l=3 w=3
X1705 B11 TOP sky130_fd_pr__cap_mim_m3_1 l=3 w=3
X1706 B11 TOP sky130_fd_pr__cap_mim_m3_1 l=3 w=3
X1707 B10 TOP sky130_fd_pr__cap_mim_m3_1 l=3 w=3
X1708 B11 TOP sky130_fd_pr__cap_mim_m3_1 l=3 w=3
X1709 B10 TOP sky130_fd_pr__cap_mim_m3_1 l=3 w=3
X1710 B11 TOP sky130_fd_pr__cap_mim_m3_1 l=3 w=3
X1711 B11 TOP sky130_fd_pr__cap_mim_m3_1 l=3 w=3
X1712 B11 TOP sky130_fd_pr__cap_mim_m3_1 l=3 w=3
X1713 EDGE_BIAS EDGE_BIAS sky130_fd_pr__cap_mim_m3_1 l=3 w=3
X1714 B11 TOP sky130_fd_pr__cap_mim_m3_1 l=3 w=3
X1715 EDGE_BIAS EDGE_BIAS sky130_fd_pr__cap_mim_m3_1 l=3 w=3
X1716 B11 TOP sky130_fd_pr__cap_mim_m3_1 l=3 w=3
X1717 B9 TOP sky130_fd_pr__cap_mim_m3_1 l=3 w=3
X1718 B11 TOP sky130_fd_pr__cap_mim_m3_1 l=3 w=3
X1719 B11 TOP sky130_fd_pr__cap_mim_m3_1 l=3 w=3
X1720 B9 TOP sky130_fd_pr__cap_mim_m3_1 l=3 w=3
X1721 B11 TOP sky130_fd_pr__cap_mim_m3_1 l=3 w=3
X1722 B10 TOP sky130_fd_pr__cap_mim_m3_1 l=3 w=3
X1723 B11 TOP sky130_fd_pr__cap_mim_m3_1 l=3 w=3
X1724 B10 TOP sky130_fd_pr__cap_mim_m3_1 l=3 w=3
X1725 B10 TOP sky130_fd_pr__cap_mim_m3_1 l=3 w=3
X1726 B11 TOP sky130_fd_pr__cap_mim_m3_1 l=3 w=3
X1727 EDGE_BIAS EDGE_BIAS sky130_fd_pr__cap_mim_m3_1 l=3 w=3
X1728 B11 TOP sky130_fd_pr__cap_mim_m3_1 l=3 w=3
X1729 B10 TOP sky130_fd_pr__cap_mim_m3_1 l=3 w=3
X1730 EDGE_BIAS EDGE_BIAS sky130_fd_pr__cap_mim_m3_1 l=3 w=3
X1731 B10 TOP sky130_fd_pr__cap_mim_m3_1 l=3 w=3
X1732 B10 TOP sky130_fd_pr__cap_mim_m3_1 l=3 w=3
X1733 B11 TOP sky130_fd_pr__cap_mim_m3_1 l=3 w=3
X1734 B11 TOP sky130_fd_pr__cap_mim_m3_1 l=3 w=3
X1735 B11 TOP sky130_fd_pr__cap_mim_m3_1 l=3 w=3
X1736 B10 TOP sky130_fd_pr__cap_mim_m3_1 l=3 w=3
X1737 B10 TOP sky130_fd_pr__cap_mim_m3_1 l=3 w=3
X1738 B11 TOP sky130_fd_pr__cap_mim_m3_1 l=3 w=3
X1739 B11 TOP sky130_fd_pr__cap_mim_m3_1 l=3 w=3
X1740 B11 TOP sky130_fd_pr__cap_mim_m3_1 l=3 w=3
X1741 B10 TOP sky130_fd_pr__cap_mim_m3_1 l=3 w=3
X1742 B10 TOP sky130_fd_pr__cap_mim_m3_1 l=3 w=3
X1743 B11 TOP sky130_fd_pr__cap_mim_m3_1 l=3 w=3
X1744 B11 TOP sky130_fd_pr__cap_mim_m3_1 l=3 w=3
X1745 B9 TOP sky130_fd_pr__cap_mim_m3_1 l=3 w=3
X1746 B11 TOP sky130_fd_pr__cap_mim_m3_1 l=3 w=3
X1747 B9 TOP sky130_fd_pr__cap_mim_m3_1 l=3 w=3
X1748 B10 TOP sky130_fd_pr__cap_mim_m3_1 l=3 w=3
X1749 B10 TOP sky130_fd_pr__cap_mim_m3_1 l=3 w=3
X1750 B10 TOP sky130_fd_pr__cap_mim_m3_1 l=3 w=3
X1751 B6 TOP sky130_fd_pr__cap_mim_m3_1 l=3 w=3
X1752 B11 TOP sky130_fd_pr__cap_mim_m3_1 l=3 w=3
X1753 B9 TOP sky130_fd_pr__cap_mim_m3_1 l=3 w=3
X1754 B11 TOP sky130_fd_pr__cap_mim_m3_1 l=3 w=3
X1755 B11 TOP sky130_fd_pr__cap_mim_m3_1 l=3 w=3
X1756 EDGE_BIAS EDGE_BIAS sky130_fd_pr__cap_mim_m3_1 l=3 w=3
X1757 B11 TOP sky130_fd_pr__cap_mim_m3_1 l=3 w=3
X1758 B11 TOP sky130_fd_pr__cap_mim_m3_1 l=3 w=3
X1759 B11 TOP sky130_fd_pr__cap_mim_m3_1 l=3 w=3
X1760 B10 TOP sky130_fd_pr__cap_mim_m3_1 l=3 w=3
X1761 B11 TOP sky130_fd_pr__cap_mim_m3_1 l=3 w=3
X1762 B11 TOP sky130_fd_pr__cap_mim_m3_1 l=3 w=3
X1763 EDGE_BIAS EDGE_BIAS sky130_fd_pr__cap_mim_m3_1 l=3 w=3
X1764 B11 TOP sky130_fd_pr__cap_mim_m3_1 l=3 w=3
X1765 B9 TOP sky130_fd_pr__cap_mim_m3_1 l=3 w=3
X1766 B10 TOP sky130_fd_pr__cap_mim_m3_1 l=3 w=3
X1767 B9 TOP sky130_fd_pr__cap_mim_m3_1 l=3 w=3
X1768 B11 TOP sky130_fd_pr__cap_mim_m3_1 l=3 w=3
X1769 B8 TOP sky130_fd_pr__cap_mim_m3_1 l=3 w=3
X1770 B10 TOP sky130_fd_pr__cap_mim_m3_1 l=3 w=3
X1771 B11 TOP sky130_fd_pr__cap_mim_m3_1 l=3 w=3
X1772 B10 TOP sky130_fd_pr__cap_mim_m3_1 l=3 w=3
X1773 B11 TOP sky130_fd_pr__cap_mim_m3_1 l=3 w=3
X1774 B10 TOP sky130_fd_pr__cap_mim_m3_1 l=3 w=3
X1775 B11 TOP sky130_fd_pr__cap_mim_m3_1 l=3 w=3
X1776 B11 TOP sky130_fd_pr__cap_mim_m3_1 l=3 w=3
X1777 B11 TOP sky130_fd_pr__cap_mim_m3_1 l=3 w=3
X1778 B9 TOP sky130_fd_pr__cap_mim_m3_1 l=3 w=3
X1779 B11 TOP sky130_fd_pr__cap_mim_m3_1 l=3 w=3
X1780 B10 TOP sky130_fd_pr__cap_mim_m3_1 l=3 w=3
X1781 B8 TOP sky130_fd_pr__cap_mim_m3_1 l=3 w=3
X1782 B11 TOP sky130_fd_pr__cap_mim_m3_1 l=3 w=3
X1783 B9 TOP sky130_fd_pr__cap_mim_m3_1 l=3 w=3
X1784 B11 TOP sky130_fd_pr__cap_mim_m3_1 l=3 w=3
X1785 B10 TOP sky130_fd_pr__cap_mim_m3_1 l=3 w=3
X1786 B11 TOP sky130_fd_pr__cap_mim_m3_1 l=3 w=3
X1787 B11 TOP sky130_fd_pr__cap_mim_m3_1 l=3 w=3
X1788 B10 TOP sky130_fd_pr__cap_mim_m3_1 l=3 w=3
X1789 B9 TOP sky130_fd_pr__cap_mim_m3_1 l=3 w=3
X1790 B11 TOP sky130_fd_pr__cap_mim_m3_1 l=3 w=3
X1791 B11 TOP sky130_fd_pr__cap_mim_m3_1 l=3 w=3
X1792 EDGE_BIAS EDGE_BIAS sky130_fd_pr__cap_mim_m3_1 l=3 w=3
X1793 EDGE_BIAS EDGE_BIAS sky130_fd_pr__cap_mim_m3_1 l=3 w=3
X1794 B11 TOP sky130_fd_pr__cap_mim_m3_1 l=3 w=3
X1795 B11 TOP sky130_fd_pr__cap_mim_m3_1 l=3 w=3
X1796 B11 TOP sky130_fd_pr__cap_mim_m3_1 l=3 w=3
X1797 B8 TOP sky130_fd_pr__cap_mim_m3_1 l=3 w=3
X1798 B11 TOP sky130_fd_pr__cap_mim_m3_1 l=3 w=3
X1799 B11 TOP sky130_fd_pr__cap_mim_m3_1 l=3 w=3
X1800 B9 TOP sky130_fd_pr__cap_mim_m3_1 l=3 w=3
X1801 B11 TOP sky130_fd_pr__cap_mim_m3_1 l=3 w=3
X1802 B3 TOP sky130_fd_pr__cap_mim_m3_1 l=3 w=3
X1803 B11 TOP sky130_fd_pr__cap_mim_m3_1 l=3 w=3
X1804 B11 TOP sky130_fd_pr__cap_mim_m3_1 l=3 w=3
X1805 B11 TOP sky130_fd_pr__cap_mim_m3_1 l=3 w=3
X1806 B11 TOP sky130_fd_pr__cap_mim_m3_1 l=3 w=3
X1807 B10 TOP sky130_fd_pr__cap_mim_m3_1 l=3 w=3
X1808 B9 TOP sky130_fd_pr__cap_mim_m3_1 l=3 w=3
X1809 B10 TOP sky130_fd_pr__cap_mim_m3_1 l=3 w=3
X1810 B10 TOP sky130_fd_pr__cap_mim_m3_1 l=3 w=3
X1811 B11 TOP sky130_fd_pr__cap_mim_m3_1 l=3 w=3
X1812 B11 TOP sky130_fd_pr__cap_mim_m3_1 l=3 w=3
X1813 B10 TOP sky130_fd_pr__cap_mim_m3_1 l=3 w=3
X1814 B11 TOP sky130_fd_pr__cap_mim_m3_1 l=3 w=3
X1815 B10 TOP sky130_fd_pr__cap_mim_m3_1 l=3 w=3
X1816 B11 TOP sky130_fd_pr__cap_mim_m3_1 l=3 w=3
X1817 B11 TOP sky130_fd_pr__cap_mim_m3_1 l=3 w=3
X1818 B11 TOP sky130_fd_pr__cap_mim_m3_1 l=3 w=3
X1819 B8 TOP sky130_fd_pr__cap_mim_m3_1 l=3 w=3
X1820 B8 TOP sky130_fd_pr__cap_mim_m3_1 l=3 w=3
X1821 B11 TOP sky130_fd_pr__cap_mim_m3_1 l=3 w=3
X1822 B11 TOP sky130_fd_pr__cap_mim_m3_1 l=3 w=3
X1823 B9 TOP sky130_fd_pr__cap_mim_m3_1 l=3 w=3
X1824 B11 TOP sky130_fd_pr__cap_mim_m3_1 l=3 w=3
X1825 B9 TOP sky130_fd_pr__cap_mim_m3_1 l=3 w=3
X1826 EDGE_BIAS EDGE_BIAS sky130_fd_pr__cap_mim_m3_1 l=3 w=3
X1827 B11 TOP sky130_fd_pr__cap_mim_m3_1 l=3 w=3
X1828 B10 TOP sky130_fd_pr__cap_mim_m3_1 l=3 w=3
X1829 B6 TOP sky130_fd_pr__cap_mim_m3_1 l=3 w=3
X1830 B11 TOP sky130_fd_pr__cap_mim_m3_1 l=3 w=3
X1831 B11 TOP sky130_fd_pr__cap_mim_m3_1 l=3 w=3
X1832 EDGE_BIAS EDGE_BIAS sky130_fd_pr__cap_mim_m3_1 l=3 w=3
X1833 B9 TOP sky130_fd_pr__cap_mim_m3_1 l=3 w=3
X1834 B9 TOP sky130_fd_pr__cap_mim_m3_1 l=3 w=3
X1835 B10 TOP sky130_fd_pr__cap_mim_m3_1 l=3 w=3
X1836 B11 TOP sky130_fd_pr__cap_mim_m3_1 l=3 w=3
X1837 B11 TOP sky130_fd_pr__cap_mim_m3_1 l=3 w=3
X1838 EDGE_BIAS EDGE_BIAS sky130_fd_pr__cap_mim_m3_1 l=3 w=3
X1839 EDGE_BIAS EDGE_BIAS sky130_fd_pr__cap_mim_m3_1 l=3 w=3
X1840 EDGE_BIAS EDGE_BIAS sky130_fd_pr__cap_mim_m3_1 l=3 w=3
X1841 B11 TOP sky130_fd_pr__cap_mim_m3_1 l=3 w=3
X1842 B11 TOP sky130_fd_pr__cap_mim_m3_1 l=3 w=3
X1843 B11 TOP sky130_fd_pr__cap_mim_m3_1 l=3 w=3
X1844 B11 TOP sky130_fd_pr__cap_mim_m3_1 l=3 w=3
X1845 B11 TOP sky130_fd_pr__cap_mim_m3_1 l=3 w=3
X1846 B11 TOP sky130_fd_pr__cap_mim_m3_1 l=3 w=3
X1847 B10 TOP sky130_fd_pr__cap_mim_m3_1 l=3 w=3
X1848 B11 TOP sky130_fd_pr__cap_mim_m3_1 l=3 w=3
X1849 B10 TOP sky130_fd_pr__cap_mim_m3_1 l=3 w=3
X1850 B10 TOP sky130_fd_pr__cap_mim_m3_1 l=3 w=3
X1851 B11 TOP sky130_fd_pr__cap_mim_m3_1 l=3 w=3
X1852 B11 TOP sky130_fd_pr__cap_mim_m3_1 l=3 w=3
X1853 B8 TOP sky130_fd_pr__cap_mim_m3_1 l=3 w=3
X1854 EDGE_BIAS EDGE_BIAS sky130_fd_pr__cap_mim_m3_1 l=3 w=3
X1855 B10 TOP sky130_fd_pr__cap_mim_m3_1 l=3 w=3
X1856 B10 TOP sky130_fd_pr__cap_mim_m3_1 l=3 w=3
X1857 B11 TOP sky130_fd_pr__cap_mim_m3_1 l=3 w=3
X1858 B10 TOP sky130_fd_pr__cap_mim_m3_1 l=3 w=3
X1859 B10 TOP sky130_fd_pr__cap_mim_m3_1 l=3 w=3
X1860 B10 TOP sky130_fd_pr__cap_mim_m3_1 l=3 w=3
X1861 B11 TOP sky130_fd_pr__cap_mim_m3_1 l=3 w=3
X1862 B10 TOP sky130_fd_pr__cap_mim_m3_1 l=3 w=3
X1863 B4 TOP sky130_fd_pr__cap_mim_m3_1 l=3 w=3
X1864 B9 TOP sky130_fd_pr__cap_mim_m3_1 l=3 w=3
X1865 B11 TOP sky130_fd_pr__cap_mim_m3_1 l=3 w=3
X1866 B10 TOP sky130_fd_pr__cap_mim_m3_1 l=3 w=3
X1867 B11 TOP sky130_fd_pr__cap_mim_m3_1 l=3 w=3
X1868 B11 TOP sky130_fd_pr__cap_mim_m3_1 l=3 w=3
X1869 EDGE_BIAS EDGE_BIAS sky130_fd_pr__cap_mim_m3_1 l=3 w=3
X1870 B11 TOP sky130_fd_pr__cap_mim_m3_1 l=3 w=3
X1871 B11 TOP sky130_fd_pr__cap_mim_m3_1 l=3 w=3
X1872 B11 TOP sky130_fd_pr__cap_mim_m3_1 l=3 w=3
X1873 B11 TOP sky130_fd_pr__cap_mim_m3_1 l=3 w=3
X1874 B8 TOP sky130_fd_pr__cap_mim_m3_1 l=3 w=3
X1875 B9 TOP sky130_fd_pr__cap_mim_m3_1 l=3 w=3
X1876 B11 TOP sky130_fd_pr__cap_mim_m3_1 l=3 w=3
X1877 B9 TOP sky130_fd_pr__cap_mim_m3_1 l=3 w=3
X1878 B9 TOP sky130_fd_pr__cap_mim_m3_1 l=3 w=3
X1879 B11 TOP sky130_fd_pr__cap_mim_m3_1 l=3 w=3
X1880 B10 TOP sky130_fd_pr__cap_mim_m3_1 l=3 w=3
X1881 B6 TOP sky130_fd_pr__cap_mim_m3_1 l=3 w=3
X1882 B10 TOP sky130_fd_pr__cap_mim_m3_1 l=3 w=3
X1883 B9 TOP sky130_fd_pr__cap_mim_m3_1 l=3 w=3
X1884 B11 TOP sky130_fd_pr__cap_mim_m3_1 l=3 w=3
X1885 B11 TOP sky130_fd_pr__cap_mim_m3_1 l=3 w=3
X1886 B11 TOP sky130_fd_pr__cap_mim_m3_1 l=3 w=3
X1887 B10 TOP sky130_fd_pr__cap_mim_m3_1 l=3 w=3
X1888 B11 TOP sky130_fd_pr__cap_mim_m3_1 l=3 w=3
X1889 B11 TOP sky130_fd_pr__cap_mim_m3_1 l=3 w=3
X1890 B11 TOP sky130_fd_pr__cap_mim_m3_1 l=3 w=3
X1891 EDGE_BIAS EDGE_BIAS sky130_fd_pr__cap_mim_m3_1 l=3 w=3
X1892 B10 TOP sky130_fd_pr__cap_mim_m3_1 l=3 w=3
X1893 B11 TOP sky130_fd_pr__cap_mim_m3_1 l=3 w=3
X1894 B11 TOP sky130_fd_pr__cap_mim_m3_1 l=3 w=3
X1895 B6 TOP sky130_fd_pr__cap_mim_m3_1 l=3 w=3
X1896 B11 TOP sky130_fd_pr__cap_mim_m3_1 l=3 w=3
X1897 B11 TOP sky130_fd_pr__cap_mim_m3_1 l=3 w=3
X1898 B10 TOP sky130_fd_pr__cap_mim_m3_1 l=3 w=3
X1899 B11 TOP sky130_fd_pr__cap_mim_m3_1 l=3 w=3
X1900 B11 TOP sky130_fd_pr__cap_mim_m3_1 l=3 w=3
X1901 B11 TOP sky130_fd_pr__cap_mim_m3_1 l=3 w=3
X1902 B11 TOP sky130_fd_pr__cap_mim_m3_1 l=3 w=3
X1903 B11 TOP sky130_fd_pr__cap_mim_m3_1 l=3 w=3
X1904 B10 TOP sky130_fd_pr__cap_mim_m3_1 l=3 w=3
X1905 B9 TOP sky130_fd_pr__cap_mim_m3_1 l=3 w=3
X1906 B11 TOP sky130_fd_pr__cap_mim_m3_1 l=3 w=3
X1907 B10 TOP sky130_fd_pr__cap_mim_m3_1 l=3 w=3
X1908 B11 TOP sky130_fd_pr__cap_mim_m3_1 l=3 w=3
X1909 B10 TOP sky130_fd_pr__cap_mim_m3_1 l=3 w=3
X1910 B10 TOP sky130_fd_pr__cap_mim_m3_1 l=3 w=3
X1911 B8 TOP sky130_fd_pr__cap_mim_m3_1 l=3 w=3
X1912 B11 TOP sky130_fd_pr__cap_mim_m3_1 l=3 w=3
X1913 B10 TOP sky130_fd_pr__cap_mim_m3_1 l=3 w=3
X1914 B10 TOP sky130_fd_pr__cap_mim_m3_1 l=3 w=3
X1915 B11 TOP sky130_fd_pr__cap_mim_m3_1 l=3 w=3
X1916 B11 TOP sky130_fd_pr__cap_mim_m3_1 l=3 w=3
X1917 EDGE_BIAS EDGE_BIAS sky130_fd_pr__cap_mim_m3_1 l=3 w=3
X1918 B9 TOP sky130_fd_pr__cap_mim_m3_1 l=3 w=3
X1919 B8 TOP sky130_fd_pr__cap_mim_m3_1 l=3 w=3
X1920 B11 TOP sky130_fd_pr__cap_mim_m3_1 l=3 w=3
X1921 B11 TOP sky130_fd_pr__cap_mim_m3_1 l=3 w=3
X1922 B8 TOP sky130_fd_pr__cap_mim_m3_1 l=3 w=3
X1923 B11 TOP sky130_fd_pr__cap_mim_m3_1 l=3 w=3
X1924 B5 TOP sky130_fd_pr__cap_mim_m3_1 l=3 w=3
X1925 B11 TOP sky130_fd_pr__cap_mim_m3_1 l=3 w=3
X1926 B10 TOP sky130_fd_pr__cap_mim_m3_1 l=3 w=3
X1927 B11 TOP sky130_fd_pr__cap_mim_m3_1 l=3 w=3
X1928 B11 TOP sky130_fd_pr__cap_mim_m3_1 l=3 w=3
X1929 B11 TOP sky130_fd_pr__cap_mim_m3_1 l=3 w=3
X1930 B11 TOP sky130_fd_pr__cap_mim_m3_1 l=3 w=3
X1931 B9 TOP sky130_fd_pr__cap_mim_m3_1 l=3 w=3
X1932 B11 TOP sky130_fd_pr__cap_mim_m3_1 l=3 w=3
X1933 B11 TOP sky130_fd_pr__cap_mim_m3_1 l=3 w=3
X1934 EDGE_BIAS EDGE_BIAS sky130_fd_pr__cap_mim_m3_1 l=3 w=3
X1935 B11 TOP sky130_fd_pr__cap_mim_m3_1 l=3 w=3
X1936 B11 TOP sky130_fd_pr__cap_mim_m3_1 l=3 w=3
X1937 B11 TOP sky130_fd_pr__cap_mim_m3_1 l=3 w=3
X1938 B11 TOP sky130_fd_pr__cap_mim_m3_1 l=3 w=3
X1939 B11 TOP sky130_fd_pr__cap_mim_m3_1 l=3 w=3
X1940 B11 TOP sky130_fd_pr__cap_mim_m3_1 l=3 w=3
X1941 B10 TOP sky130_fd_pr__cap_mim_m3_1 l=3 w=3
X1942 B9 TOP sky130_fd_pr__cap_mim_m3_1 l=3 w=3
X1943 B11 TOP sky130_fd_pr__cap_mim_m3_1 l=3 w=3
X1944 B11 TOP sky130_fd_pr__cap_mim_m3_1 l=3 w=3
X1945 B11 TOP sky130_fd_pr__cap_mim_m3_1 l=3 w=3
X1946 B11 TOP sky130_fd_pr__cap_mim_m3_1 l=3 w=3
X1947 B11 TOP sky130_fd_pr__cap_mim_m3_1 l=3 w=3
X1948 B11 TOP sky130_fd_pr__cap_mim_m3_1 l=3 w=3
X1949 B10 TOP sky130_fd_pr__cap_mim_m3_1 l=3 w=3
X1950 B8 TOP sky130_fd_pr__cap_mim_m3_1 l=3 w=3
X1951 B11 TOP sky130_fd_pr__cap_mim_m3_1 l=3 w=3
X1952 B8 TOP sky130_fd_pr__cap_mim_m3_1 l=3 w=3
X1953 B10 TOP sky130_fd_pr__cap_mim_m3_1 l=3 w=3
X1954 B10 TOP sky130_fd_pr__cap_mim_m3_1 l=3 w=3
X1955 B11 TOP sky130_fd_pr__cap_mim_m3_1 l=3 w=3
X1956 B10 TOP sky130_fd_pr__cap_mim_m3_1 l=3 w=3
X1957 B11 TOP sky130_fd_pr__cap_mim_m3_1 l=3 w=3
X1958 B10 TOP sky130_fd_pr__cap_mim_m3_1 l=3 w=3
X1959 B11 TOP sky130_fd_pr__cap_mim_m3_1 l=3 w=3
X1960 B11 TOP sky130_fd_pr__cap_mim_m3_1 l=3 w=3
X1961 B10 TOP sky130_fd_pr__cap_mim_m3_1 l=3 w=3
X1962 B11 TOP sky130_fd_pr__cap_mim_m3_1 l=3 w=3
X1963 B11 TOP sky130_fd_pr__cap_mim_m3_1 l=3 w=3
X1964 B11 TOP sky130_fd_pr__cap_mim_m3_1 l=3 w=3
X1965 B8 TOP sky130_fd_pr__cap_mim_m3_1 l=3 w=3
X1966 B10 TOP sky130_fd_pr__cap_mim_m3_1 l=3 w=3
X1967 B3 TOP sky130_fd_pr__cap_mim_m3_1 l=3 w=3
X1968 B9 TOP sky130_fd_pr__cap_mim_m3_1 l=3 w=3
X1969 B11 TOP sky130_fd_pr__cap_mim_m3_1 l=3 w=3
X1970 B11 TOP sky130_fd_pr__cap_mim_m3_1 l=3 w=3
X1971 B9 TOP sky130_fd_pr__cap_mim_m3_1 l=3 w=3
X1972 B6 TOP sky130_fd_pr__cap_mim_m3_1 l=3 w=3
X1973 B9 TOP sky130_fd_pr__cap_mim_m3_1 l=3 w=3
X1974 B11 TOP sky130_fd_pr__cap_mim_m3_1 l=3 w=3
X1975 B10 TOP sky130_fd_pr__cap_mim_m3_1 l=3 w=3
X1976 B9 TOP sky130_fd_pr__cap_mim_m3_1 l=3 w=3
X1977 B11 TOP sky130_fd_pr__cap_mim_m3_1 l=3 w=3
X1978 B9 TOP sky130_fd_pr__cap_mim_m3_1 l=3 w=3
X1979 B10 TOP sky130_fd_pr__cap_mim_m3_1 l=3 w=3
X1980 B11 TOP sky130_fd_pr__cap_mim_m3_1 l=3 w=3
X1981 EDGE_BIAS EDGE_BIAS sky130_fd_pr__cap_mim_m3_1 l=3 w=3
X1982 B10 TOP sky130_fd_pr__cap_mim_m3_1 l=3 w=3
X1983 B11 TOP sky130_fd_pr__cap_mim_m3_1 l=3 w=3
X1984 B11 TOP sky130_fd_pr__cap_mim_m3_1 l=3 w=3
X1985 B11 TOP sky130_fd_pr__cap_mim_m3_1 l=3 w=3
X1986 B11 TOP sky130_fd_pr__cap_mim_m3_1 l=3 w=3
X1987 B11 TOP sky130_fd_pr__cap_mim_m3_1 l=3 w=3
X1988 B11 TOP sky130_fd_pr__cap_mim_m3_1 l=3 w=3
X1989 B10 TOP sky130_fd_pr__cap_mim_m3_1 l=3 w=3
X1990 B8 TOP sky130_fd_pr__cap_mim_m3_1 l=3 w=3
X1991 B10 TOP sky130_fd_pr__cap_mim_m3_1 l=3 w=3
X1992 B10 TOP sky130_fd_pr__cap_mim_m3_1 l=3 w=3
X1993 B11 TOP sky130_fd_pr__cap_mim_m3_1 l=3 w=3
X1994 EDGE_BIAS EDGE_BIAS sky130_fd_pr__cap_mim_m3_1 l=3 w=3
X1995 B11 TOP sky130_fd_pr__cap_mim_m3_1 l=3 w=3
X1996 B10 TOP sky130_fd_pr__cap_mim_m3_1 l=3 w=3
X1997 B8 TOP sky130_fd_pr__cap_mim_m3_1 l=3 w=3
X1998 B11 TOP sky130_fd_pr__cap_mim_m3_1 l=3 w=3
X1999 B11 TOP sky130_fd_pr__cap_mim_m3_1 l=3 w=3
X2000 B11 TOP sky130_fd_pr__cap_mim_m3_1 l=3 w=3
X2001 B11 TOP sky130_fd_pr__cap_mim_m3_1 l=3 w=3
X2002 B10 TOP sky130_fd_pr__cap_mim_m3_1 l=3 w=3
X2003 B10 TOP sky130_fd_pr__cap_mim_m3_1 l=3 w=3
X2004 B10 TOP sky130_fd_pr__cap_mim_m3_1 l=3 w=3
X2005 B11 TOP sky130_fd_pr__cap_mim_m3_1 l=3 w=3
X2006 B9 TOP sky130_fd_pr__cap_mim_m3_1 l=3 w=3
X2007 EDGE_BIAS EDGE_BIAS sky130_fd_pr__cap_mim_m3_1 l=3 w=3
X2008 B9 TOP sky130_fd_pr__cap_mim_m3_1 l=3 w=3
X2009 B5 TOP sky130_fd_pr__cap_mim_m3_1 l=3 w=3
X2010 B10 TOP sky130_fd_pr__cap_mim_m3_1 l=3 w=3
X2011 B11 TOP sky130_fd_pr__cap_mim_m3_1 l=3 w=3
X2012 EDGE_BIAS EDGE_BIAS sky130_fd_pr__cap_mim_m3_1 l=3 w=3
X2013 B10 TOP sky130_fd_pr__cap_mim_m3_1 l=3 w=3
X2014 B11 TOP sky130_fd_pr__cap_mim_m3_1 l=3 w=3
X2015 B11 TOP sky130_fd_pr__cap_mim_m3_1 l=3 w=3
X2016 B10 TOP sky130_fd_pr__cap_mim_m3_1 l=3 w=3
X2017 B10 TOP sky130_fd_pr__cap_mim_m3_1 l=3 w=3
X2018 B9 TOP sky130_fd_pr__cap_mim_m3_1 l=3 w=3
X2019 B9 TOP sky130_fd_pr__cap_mim_m3_1 l=3 w=3
X2020 B11 TOP sky130_fd_pr__cap_mim_m3_1 l=3 w=3
X2021 B11 TOP sky130_fd_pr__cap_mim_m3_1 l=3 w=3
X2022 B10 TOP sky130_fd_pr__cap_mim_m3_1 l=3 w=3
X2023 B10 TOP sky130_fd_pr__cap_mim_m3_1 l=3 w=3
X2024 B9 TOP sky130_fd_pr__cap_mim_m3_1 l=3 w=3
X2025 B10 TOP sky130_fd_pr__cap_mim_m3_1 l=3 w=3
X2026 B11 TOP sky130_fd_pr__cap_mim_m3_1 l=3 w=3
X2027 B11 TOP sky130_fd_pr__cap_mim_m3_1 l=3 w=3
X2028 B11 TOP sky130_fd_pr__cap_mim_m3_1 l=3 w=3
X2029 B11 TOP sky130_fd_pr__cap_mim_m3_1 l=3 w=3
X2030 B11 TOP sky130_fd_pr__cap_mim_m3_1 l=3 w=3
X2031 B10 TOP sky130_fd_pr__cap_mim_m3_1 l=3 w=3
X2032 B10 TOP sky130_fd_pr__cap_mim_m3_1 l=3 w=3
X2033 B10 TOP sky130_fd_pr__cap_mim_m3_1 l=3 w=3
X2034 B11 TOP sky130_fd_pr__cap_mim_m3_1 l=3 w=3
X2035 EDGE_BIAS EDGE_BIAS sky130_fd_pr__cap_mim_m3_1 l=3 w=3
X2036 B8 TOP sky130_fd_pr__cap_mim_m3_1 l=3 w=3
X2037 B11 TOP sky130_fd_pr__cap_mim_m3_1 l=3 w=3
X2038 B11 TOP sky130_fd_pr__cap_mim_m3_1 l=3 w=3
X2039 B11 TOP sky130_fd_pr__cap_mim_m3_1 l=3 w=3
X2040 B9 TOP sky130_fd_pr__cap_mim_m3_1 l=3 w=3
X2041 B11 TOP sky130_fd_pr__cap_mim_m3_1 l=3 w=3
X2042 B11 TOP sky130_fd_pr__cap_mim_m3_1 l=3 w=3
X2043 B11 TOP sky130_fd_pr__cap_mim_m3_1 l=3 w=3
X2044 B10 TOP sky130_fd_pr__cap_mim_m3_1 l=3 w=3
X2045 B10 TOP sky130_fd_pr__cap_mim_m3_1 l=3 w=3
X2046 B9 TOP sky130_fd_pr__cap_mim_m3_1 l=3 w=3
X2047 B11 TOP sky130_fd_pr__cap_mim_m3_1 l=3 w=3
X2048 B10 TOP sky130_fd_pr__cap_mim_m3_1 l=3 w=3
X2049 B10 TOP sky130_fd_pr__cap_mim_m3_1 l=3 w=3
X2050 B8 TOP sky130_fd_pr__cap_mim_m3_1 l=3 w=3
X2051 B11 TOP sky130_fd_pr__cap_mim_m3_1 l=3 w=3
X2052 B11 TOP sky130_fd_pr__cap_mim_m3_1 l=3 w=3
X2053 B10 TOP sky130_fd_pr__cap_mim_m3_1 l=3 w=3
X2054 B7 TOP sky130_fd_pr__cap_mim_m3_1 l=3 w=3
X2055 B10 TOP sky130_fd_pr__cap_mim_m3_1 l=3 w=3
X2056 B11 TOP sky130_fd_pr__cap_mim_m3_1 l=3 w=3
X2057 B10 TOP sky130_fd_pr__cap_mim_m3_1 l=3 w=3
X2058 B6 TOP sky130_fd_pr__cap_mim_m3_1 l=3 w=3
X2059 B9 TOP sky130_fd_pr__cap_mim_m3_1 l=3 w=3
X2060 B11 TOP sky130_fd_pr__cap_mim_m3_1 l=3 w=3
X2061 B10 TOP sky130_fd_pr__cap_mim_m3_1 l=3 w=3
X2062 B11 TOP sky130_fd_pr__cap_mim_m3_1 l=3 w=3
X2063 B11 TOP sky130_fd_pr__cap_mim_m3_1 l=3 w=3
X2064 B11 TOP sky130_fd_pr__cap_mim_m3_1 l=3 w=3
X2065 B10 TOP sky130_fd_pr__cap_mim_m3_1 l=3 w=3
X2066 B10 TOP sky130_fd_pr__cap_mim_m3_1 l=3 w=3
X2067 EDGE_BIAS EDGE_BIAS sky130_fd_pr__cap_mim_m3_1 l=3 w=3
X2068 B11 TOP sky130_fd_pr__cap_mim_m3_1 l=3 w=3
X2069 B8 TOP sky130_fd_pr__cap_mim_m3_1 l=3 w=3
X2070 B4 TOP sky130_fd_pr__cap_mim_m3_1 l=3 w=3
X2071 B10 TOP sky130_fd_pr__cap_mim_m3_1 l=3 w=3
X2072 B11 TOP sky130_fd_pr__cap_mim_m3_1 l=3 w=3
X2073 B11 TOP sky130_fd_pr__cap_mim_m3_1 l=3 w=3
X2074 B11 TOP sky130_fd_pr__cap_mim_m3_1 l=3 w=3
X2075 B11 TOP sky130_fd_pr__cap_mim_m3_1 l=3 w=3
X2076 B9 TOP sky130_fd_pr__cap_mim_m3_1 l=3 w=3
X2077 B10 TOP sky130_fd_pr__cap_mim_m3_1 l=3 w=3
X2078 B11 TOP sky130_fd_pr__cap_mim_m3_1 l=3 w=3
X2079 B7 TOP sky130_fd_pr__cap_mim_m3_1 l=3 w=3
X2080 B11 TOP sky130_fd_pr__cap_mim_m3_1 l=3 w=3
X2081 B11 TOP sky130_fd_pr__cap_mim_m3_1 l=3 w=3
X2082 B10 TOP sky130_fd_pr__cap_mim_m3_1 l=3 w=3
X2083 B11 TOP sky130_fd_pr__cap_mim_m3_1 l=3 w=3
X2084 B11 TOP sky130_fd_pr__cap_mim_m3_1 l=3 w=3
X2085 B11 TOP sky130_fd_pr__cap_mim_m3_1 l=3 w=3
X2086 B10 TOP sky130_fd_pr__cap_mim_m3_1 l=3 w=3
X2087 B9 TOP sky130_fd_pr__cap_mim_m3_1 l=3 w=3
X2088 B9 TOP sky130_fd_pr__cap_mim_m3_1 l=3 w=3
X2089 B11 TOP sky130_fd_pr__cap_mim_m3_1 l=3 w=3
X2090 B10 TOP sky130_fd_pr__cap_mim_m3_1 l=3 w=3
X2091 B8 TOP sky130_fd_pr__cap_mim_m3_1 l=3 w=3
X2092 B11 TOP sky130_fd_pr__cap_mim_m3_1 l=3 w=3
X2093 B9 TOP sky130_fd_pr__cap_mim_m3_1 l=3 w=3
X2094 B10 TOP sky130_fd_pr__cap_mim_m3_1 l=3 w=3
X2095 B8 TOP sky130_fd_pr__cap_mim_m3_1 l=3 w=3
X2096 B11 TOP sky130_fd_pr__cap_mim_m3_1 l=3 w=3
X2097 B10 TOP sky130_fd_pr__cap_mim_m3_1 l=3 w=3
X2098 B8 TOP sky130_fd_pr__cap_mim_m3_1 l=3 w=3
X2099 B11 TOP sky130_fd_pr__cap_mim_m3_1 l=3 w=3
X2100 B11 TOP sky130_fd_pr__cap_mim_m3_1 l=3 w=3
X2101 B11 TOP sky130_fd_pr__cap_mim_m3_1 l=3 w=3
X2102 EDGE_BIAS EDGE_BIAS sky130_fd_pr__cap_mim_m3_1 l=3 w=3
X2103 B4 TOP sky130_fd_pr__cap_mim_m3_1 l=3 w=3
X2104 B10 TOP sky130_fd_pr__cap_mim_m3_1 l=3 w=3
X2105 B6 TOP sky130_fd_pr__cap_mim_m3_1 l=3 w=3
X2106 B11 TOP sky130_fd_pr__cap_mim_m3_1 l=3 w=3
X2107 EDGE_BIAS EDGE_BIAS sky130_fd_pr__cap_mim_m3_1 l=3 w=3
X2108 B11 TOP sky130_fd_pr__cap_mim_m3_1 l=3 w=3
X2109 B11 TOP sky130_fd_pr__cap_mim_m3_1 l=3 w=3
X2110 EDGE_BIAS EDGE_BIAS sky130_fd_pr__cap_mim_m3_1 l=3 w=3
X2111 B11 TOP sky130_fd_pr__cap_mim_m3_1 l=3 w=3
X2112 B8 TOP sky130_fd_pr__cap_mim_m3_1 l=3 w=3
X2113 B11 TOP sky130_fd_pr__cap_mim_m3_1 l=3 w=3
X2114 B11 TOP sky130_fd_pr__cap_mim_m3_1 l=3 w=3
X2115 B10 TOP sky130_fd_pr__cap_mim_m3_1 l=3 w=3
X2116 B9 TOP sky130_fd_pr__cap_mim_m3_1 l=3 w=3
X2117 B11 TOP sky130_fd_pr__cap_mim_m3_1 l=3 w=3
X2118 B9 TOP sky130_fd_pr__cap_mim_m3_1 l=3 w=3
X2119 B10 TOP sky130_fd_pr__cap_mim_m3_1 l=3 w=3
X2120 B10 TOP sky130_fd_pr__cap_mim_m3_1 l=3 w=3
X2121 B11 TOP sky130_fd_pr__cap_mim_m3_1 l=3 w=3
X2122 B11 TOP sky130_fd_pr__cap_mim_m3_1 l=3 w=3
X2123 B9 TOP sky130_fd_pr__cap_mim_m3_1 l=3 w=3
X2124 B10 TOP sky130_fd_pr__cap_mim_m3_1 l=3 w=3
X2125 B11 TOP sky130_fd_pr__cap_mim_m3_1 l=3 w=3
X2126 EDGE_BIAS EDGE_BIAS sky130_fd_pr__cap_mim_m3_1 l=3 w=3
X2127 B10 TOP sky130_fd_pr__cap_mim_m3_1 l=3 w=3
X2128 B11 TOP sky130_fd_pr__cap_mim_m3_1 l=3 w=3
X2129 B11 TOP sky130_fd_pr__cap_mim_m3_1 l=3 w=3
X2130 B10 TOP sky130_fd_pr__cap_mim_m3_1 l=3 w=3
X2131 B11 TOP sky130_fd_pr__cap_mim_m3_1 l=3 w=3
X2132 B11 TOP sky130_fd_pr__cap_mim_m3_1 l=3 w=3
X2133 B11 TOP sky130_fd_pr__cap_mim_m3_1 l=3 w=3
X2134 B11 TOP sky130_fd_pr__cap_mim_m3_1 l=3 w=3
X2135 B10 TOP sky130_fd_pr__cap_mim_m3_1 l=3 w=3
X2136 B9 TOP sky130_fd_pr__cap_mim_m3_1 l=3 w=3
X2137 B11 TOP sky130_fd_pr__cap_mim_m3_1 l=3 w=3
X2138 B10 TOP sky130_fd_pr__cap_mim_m3_1 l=3 w=3
X2139 B11 TOP sky130_fd_pr__cap_mim_m3_1 l=3 w=3
X2140 B10 TOP sky130_fd_pr__cap_mim_m3_1 l=3 w=3
X2141 B11 TOP sky130_fd_pr__cap_mim_m3_1 l=3 w=3
X2142 B11 TOP sky130_fd_pr__cap_mim_m3_1 l=3 w=3
X2143 B11 TOP sky130_fd_pr__cap_mim_m3_1 l=3 w=3
X2144 B10 TOP sky130_fd_pr__cap_mim_m3_1 l=3 w=3
X2145 B10 TOP sky130_fd_pr__cap_mim_m3_1 l=3 w=3
X2146 B8 TOP sky130_fd_pr__cap_mim_m3_1 l=3 w=3
X2147 B11 TOP sky130_fd_pr__cap_mim_m3_1 l=3 w=3
X2148 B10 TOP sky130_fd_pr__cap_mim_m3_1 l=3 w=3
X2149 B10 TOP sky130_fd_pr__cap_mim_m3_1 l=3 w=3
X2150 B11 TOP sky130_fd_pr__cap_mim_m3_1 l=3 w=3
X2151 B9 TOP sky130_fd_pr__cap_mim_m3_1 l=3 w=3
X2152 B10 TOP sky130_fd_pr__cap_mim_m3_1 l=3 w=3
X2153 B5 TOP sky130_fd_pr__cap_mim_m3_1 l=3 w=3
X2154 B11 TOP sky130_fd_pr__cap_mim_m3_1 l=3 w=3
X2155 B10 TOP sky130_fd_pr__cap_mim_m3_1 l=3 w=3
X2156 B11 TOP sky130_fd_pr__cap_mim_m3_1 l=3 w=3
X2157 B11 TOP sky130_fd_pr__cap_mim_m3_1 l=3 w=3
X2158 B11 TOP sky130_fd_pr__cap_mim_m3_1 l=3 w=3
X2159 B11 TOP sky130_fd_pr__cap_mim_m3_1 l=3 w=3
X2160 B10 TOP sky130_fd_pr__cap_mim_m3_1 l=3 w=3
X2161 EDGE_BIAS EDGE_BIAS sky130_fd_pr__cap_mim_m3_1 l=3 w=3
X2162 B11 TOP sky130_fd_pr__cap_mim_m3_1 l=3 w=3
X2163 B11 TOP sky130_fd_pr__cap_mim_m3_1 l=3 w=3
X2164 B11 TOP sky130_fd_pr__cap_mim_m3_1 l=3 w=3
X2165 B10 TOP sky130_fd_pr__cap_mim_m3_1 l=3 w=3
X2166 B9 TOP sky130_fd_pr__cap_mim_m3_1 l=3 w=3
X2167 B11 TOP sky130_fd_pr__cap_mim_m3_1 l=3 w=3
X2168 B11 TOP sky130_fd_pr__cap_mim_m3_1 l=3 w=3
X2169 B3 TOP sky130_fd_pr__cap_mim_m3_1 l=3 w=3
X2170 B9 TOP sky130_fd_pr__cap_mim_m3_1 l=3 w=3
X2171 B11 TOP sky130_fd_pr__cap_mim_m3_1 l=3 w=3
X2172 B11 TOP sky130_fd_pr__cap_mim_m3_1 l=3 w=3
X2173 B10 TOP sky130_fd_pr__cap_mim_m3_1 l=3 w=3
X2174 B9 TOP sky130_fd_pr__cap_mim_m3_1 l=3 w=3
X2175 B10 TOP sky130_fd_pr__cap_mim_m3_1 l=3 w=3
X2176 EDGE_BIAS EDGE_BIAS sky130_fd_pr__cap_mim_m3_1 l=3 w=3
X2177 B11 TOP sky130_fd_pr__cap_mim_m3_1 l=3 w=3
X2178 B11 TOP sky130_fd_pr__cap_mim_m3_1 l=3 w=3
X2179 B10 TOP sky130_fd_pr__cap_mim_m3_1 l=3 w=3
X2180 B10 TOP sky130_fd_pr__cap_mim_m3_1 l=3 w=3
X2181 B11 TOP sky130_fd_pr__cap_mim_m3_1 l=3 w=3
X2182 B11 TOP sky130_fd_pr__cap_mim_m3_1 l=3 w=3
X2183 EDGE_BIAS EDGE_BIAS sky130_fd_pr__cap_mim_m3_1 l=3 w=3
X2184 B10 TOP sky130_fd_pr__cap_mim_m3_1 l=3 w=3
X2185 B9 TOP sky130_fd_pr__cap_mim_m3_1 l=3 w=3
X2186 B10 TOP sky130_fd_pr__cap_mim_m3_1 l=3 w=3
X2187 B11 TOP sky130_fd_pr__cap_mim_m3_1 l=3 w=3
X2188 B9 TOP sky130_fd_pr__cap_mim_m3_1 l=3 w=3
X2189 B10 TOP sky130_fd_pr__cap_mim_m3_1 l=3 w=3
X2190 B8 TOP sky130_fd_pr__cap_mim_m3_1 l=3 w=3
X2191 B10 TOP sky130_fd_pr__cap_mim_m3_1 l=3 w=3
X2192 B11 TOP sky130_fd_pr__cap_mim_m3_1 l=3 w=3
X2193 B10 TOP sky130_fd_pr__cap_mim_m3_1 l=3 w=3
X2194 B11 TOP sky130_fd_pr__cap_mim_m3_1 l=3 w=3
X2195 B11 TOP sky130_fd_pr__cap_mim_m3_1 l=3 w=3
X2196 B9 TOP sky130_fd_pr__cap_mim_m3_1 l=3 w=3
X2197 B10 TOP sky130_fd_pr__cap_mim_m3_1 l=3 w=3
X2198 B6 TOP sky130_fd_pr__cap_mim_m3_1 l=3 w=3
X2199 B11 TOP sky130_fd_pr__cap_mim_m3_1 l=3 w=3
X2200 B10 TOP sky130_fd_pr__cap_mim_m3_1 l=3 w=3
X2201 B9 TOP sky130_fd_pr__cap_mim_m3_1 l=3 w=3
X2202 B11 TOP sky130_fd_pr__cap_mim_m3_1 l=3 w=3
X2203 B11 TOP sky130_fd_pr__cap_mim_m3_1 l=3 w=3
X2204 B9 TOP sky130_fd_pr__cap_mim_m3_1 l=3 w=3
X2205 B11 TOP sky130_fd_pr__cap_mim_m3_1 l=3 w=3
X2206 EDGE_BIAS EDGE_BIAS sky130_fd_pr__cap_mim_m3_1 l=3 w=3
X2207 B8 TOP sky130_fd_pr__cap_mim_m3_1 l=3 w=3
X2208 B1 TOP sky130_fd_pr__cap_mim_m3_1 l=3 w=3
X2209 B11 TOP sky130_fd_pr__cap_mim_m3_1 l=3 w=3
X2210 B11 TOP sky130_fd_pr__cap_mim_m3_1 l=3 w=3
X2211 B10 TOP sky130_fd_pr__cap_mim_m3_1 l=3 w=3
X2212 B11 TOP sky130_fd_pr__cap_mim_m3_1 l=3 w=3
X2213 EDGE_BIAS EDGE_BIAS sky130_fd_pr__cap_mim_m3_1 l=3 w=3
X2214 B11 TOP sky130_fd_pr__cap_mim_m3_1 l=3 w=3
X2215 B11 TOP sky130_fd_pr__cap_mim_m3_1 l=3 w=3
X2216 B10 TOP sky130_fd_pr__cap_mim_m3_1 l=3 w=3
X2217 B10 TOP sky130_fd_pr__cap_mim_m3_1 l=3 w=3
X2218 B10 TOP sky130_fd_pr__cap_mim_m3_1 l=3 w=3
X2219 B11 TOP sky130_fd_pr__cap_mim_m3_1 l=3 w=3
X2220 B10 TOP sky130_fd_pr__cap_mim_m3_1 l=3 w=3
X2221 B11 TOP sky130_fd_pr__cap_mim_m3_1 l=3 w=3
X2222 B10 TOP sky130_fd_pr__cap_mim_m3_1 l=3 w=3
X2223 B9 TOP sky130_fd_pr__cap_mim_m3_1 l=3 w=3
X2224 B11 TOP sky130_fd_pr__cap_mim_m3_1 l=3 w=3
X2225 B8 TOP sky130_fd_pr__cap_mim_m3_1 l=3 w=3
X2226 B10 TOP sky130_fd_pr__cap_mim_m3_1 l=3 w=3
X2227 B11 TOP sky130_fd_pr__cap_mim_m3_1 l=3 w=3
X2228 B11 TOP sky130_fd_pr__cap_mim_m3_1 l=3 w=3
X2229 B11 TOP sky130_fd_pr__cap_mim_m3_1 l=3 w=3
X2230 B9 TOP sky130_fd_pr__cap_mim_m3_1 l=3 w=3
X2231 B11 TOP sky130_fd_pr__cap_mim_m3_1 l=3 w=3
X2232 B10 TOP sky130_fd_pr__cap_mim_m3_1 l=3 w=3
X2233 B8 TOP sky130_fd_pr__cap_mim_m3_1 l=3 w=3
X2234 B11 TOP sky130_fd_pr__cap_mim_m3_1 l=3 w=3
X2235 B11 TOP sky130_fd_pr__cap_mim_m3_1 l=3 w=3
X2236 B11 TOP sky130_fd_pr__cap_mim_m3_1 l=3 w=3
X2237 EDGE_BIAS EDGE_BIAS sky130_fd_pr__cap_mim_m3_1 l=3 w=3
X2238 B8 TOP sky130_fd_pr__cap_mim_m3_1 l=3 w=3
X2239 B11 TOP sky130_fd_pr__cap_mim_m3_1 l=3 w=3
X2240 B9 TOP sky130_fd_pr__cap_mim_m3_1 l=3 w=3
X2241 B9 TOP sky130_fd_pr__cap_mim_m3_1 l=3 w=3
X2242 B9 TOP sky130_fd_pr__cap_mim_m3_1 l=3 w=3
X2243 B11 TOP sky130_fd_pr__cap_mim_m3_1 l=3 w=3
X2244 B5 TOP sky130_fd_pr__cap_mim_m3_1 l=3 w=3
X2245 B10 TOP sky130_fd_pr__cap_mim_m3_1 l=3 w=3
X2246 B6 TOP sky130_fd_pr__cap_mim_m3_1 l=3 w=3
X2247 B11 TOP sky130_fd_pr__cap_mim_m3_1 l=3 w=3
X2248 B9 TOP sky130_fd_pr__cap_mim_m3_1 l=3 w=3
X2249 EDGE_BIAS EDGE_BIAS sky130_fd_pr__cap_mim_m3_1 l=3 w=3
X2250 B11 TOP sky130_fd_pr__cap_mim_m3_1 l=3 w=3
X2251 B11 TOP sky130_fd_pr__cap_mim_m3_1 l=3 w=3
X2252 B11 TOP sky130_fd_pr__cap_mim_m3_1 l=3 w=3
X2253 B11 TOP sky130_fd_pr__cap_mim_m3_1 l=3 w=3
X2254 B11 TOP sky130_fd_pr__cap_mim_m3_1 l=3 w=3
X2255 EDGE_BIAS EDGE_BIAS sky130_fd_pr__cap_mim_m3_1 l=3 w=3
X2256 B11 TOP sky130_fd_pr__cap_mim_m3_1 l=3 w=3
X2257 B11 TOP sky130_fd_pr__cap_mim_m3_1 l=3 w=3
X2258 B10 TOP sky130_fd_pr__cap_mim_m3_1 l=3 w=3
X2259 B10 TOP sky130_fd_pr__cap_mim_m3_1 l=3 w=3
X2260 B11 TOP sky130_fd_pr__cap_mim_m3_1 l=3 w=3
X2261 B11 TOP sky130_fd_pr__cap_mim_m3_1 l=3 w=3
X2262 B10 TOP sky130_fd_pr__cap_mim_m3_1 l=3 w=3
X2263 B10 TOP sky130_fd_pr__cap_mim_m3_1 l=3 w=3
X2264 EDGE_BIAS EDGE_BIAS sky130_fd_pr__cap_mim_m3_1 l=3 w=3
X2265 B9 TOP sky130_fd_pr__cap_mim_m3_1 l=3 w=3
X2266 B11 TOP sky130_fd_pr__cap_mim_m3_1 l=3 w=3
X2267 B11 TOP sky130_fd_pr__cap_mim_m3_1 l=3 w=3
X2268 B10 TOP sky130_fd_pr__cap_mim_m3_1 l=3 w=3
X2269 B10 TOP sky130_fd_pr__cap_mim_m3_1 l=3 w=3
X2270 B10 TOP sky130_fd_pr__cap_mim_m3_1 l=3 w=3
X2271 B11 TOP sky130_fd_pr__cap_mim_m3_1 l=3 w=3
X2272 EDGE_BIAS EDGE_BIAS sky130_fd_pr__cap_mim_m3_1 l=3 w=3
X2273 B11 TOP sky130_fd_pr__cap_mim_m3_1 l=3 w=3
X2274 B10 TOP sky130_fd_pr__cap_mim_m3_1 l=3 w=3
X2275 B10 TOP sky130_fd_pr__cap_mim_m3_1 l=3 w=3
X2276 B10 TOP sky130_fd_pr__cap_mim_m3_1 l=3 w=3
X2277 B9 TOP sky130_fd_pr__cap_mim_m3_1 l=3 w=3
X2278 B10 TOP sky130_fd_pr__cap_mim_m3_1 l=3 w=3
X2279 B11 TOP sky130_fd_pr__cap_mim_m3_1 l=3 w=3
X2280 B11 TOP sky130_fd_pr__cap_mim_m3_1 l=3 w=3
X2281 B10 TOP sky130_fd_pr__cap_mim_m3_1 l=3 w=3
X2282 B11 TOP sky130_fd_pr__cap_mim_m3_1 l=3 w=3
X2283 B9 TOP sky130_fd_pr__cap_mim_m3_1 l=3 w=3
X2284 B8 TOP sky130_fd_pr__cap_mim_m3_1 l=3 w=3
X2285 B11 TOP sky130_fd_pr__cap_mim_m3_1 l=3 w=3
X2286 B11 TOP sky130_fd_pr__cap_mim_m3_1 l=3 w=3
X2287 B8 TOP sky130_fd_pr__cap_mim_m3_1 l=3 w=3
X2288 B11 TOP sky130_fd_pr__cap_mim_m3_1 l=3 w=3
X2289 B11 TOP sky130_fd_pr__cap_mim_m3_1 l=3 w=3
X2290 B10 TOP sky130_fd_pr__cap_mim_m3_1 l=3 w=3
X2291 B9 TOP sky130_fd_pr__cap_mim_m3_1 l=3 w=3
X2292 B9 TOP sky130_fd_pr__cap_mim_m3_1 l=3 w=3
X2293 B11 TOP sky130_fd_pr__cap_mim_m3_1 l=3 w=3
X2294 B6 TOP sky130_fd_pr__cap_mim_m3_1 l=3 w=3
X2295 B11 TOP sky130_fd_pr__cap_mim_m3_1 l=3 w=3
X2296 B11 TOP sky130_fd_pr__cap_mim_m3_1 l=3 w=3
X2297 B11 TOP sky130_fd_pr__cap_mim_m3_1 l=3 w=3
X2298 B10 TOP sky130_fd_pr__cap_mim_m3_1 l=3 w=3
X2299 B11 TOP sky130_fd_pr__cap_mim_m3_1 l=3 w=3
X2300 B10 TOP sky130_fd_pr__cap_mim_m3_1 l=3 w=3
X2301 B11 TOP sky130_fd_pr__cap_mim_m3_1 l=3 w=3
X2302 B11 TOP sky130_fd_pr__cap_mim_m3_1 l=3 w=3
X2303 B7 TOP sky130_fd_pr__cap_mim_m3_1 l=3 w=3
X2304 B11 TOP sky130_fd_pr__cap_mim_m3_1 l=3 w=3
X2305 B10 TOP sky130_fd_pr__cap_mim_m3_1 l=3 w=3
X2306 B10 TOP sky130_fd_pr__cap_mim_m3_1 l=3 w=3
X2307 EDGE_BIAS EDGE_BIAS sky130_fd_pr__cap_mim_m3_1 l=3 w=3
X2308 B11 TOP sky130_fd_pr__cap_mim_m3_1 l=3 w=3
X2309 B11 TOP sky130_fd_pr__cap_mim_m3_1 l=3 w=3
X2310 B11 TOP sky130_fd_pr__cap_mim_m3_1 l=3 w=3
X2311 B10 TOP sky130_fd_pr__cap_mim_m3_1 l=3 w=3
X2312 B9 TOP sky130_fd_pr__cap_mim_m3_1 l=3 w=3
X2313 B10 TOP sky130_fd_pr__cap_mim_m3_1 l=3 w=3
X2314 B11 TOP sky130_fd_pr__cap_mim_m3_1 l=3 w=3
X2315 B10 TOP sky130_fd_pr__cap_mim_m3_1 l=3 w=3
X2316 B10 TOP sky130_fd_pr__cap_mim_m3_1 l=3 w=3
X2317 B10 TOP sky130_fd_pr__cap_mim_m3_1 l=3 w=3
X2318 B11 TOP sky130_fd_pr__cap_mim_m3_1 l=3 w=3
X2319 B10 TOP sky130_fd_pr__cap_mim_m3_1 l=3 w=3
X2320 B11 TOP sky130_fd_pr__cap_mim_m3_1 l=3 w=3
X2321 EDGE_BIAS EDGE_BIAS sky130_fd_pr__cap_mim_m3_1 l=3 w=3
X2322 B10 TOP sky130_fd_pr__cap_mim_m3_1 l=3 w=3
X2323 EDGE_BIAS EDGE_BIAS sky130_fd_pr__cap_mim_m3_1 l=3 w=3
X2324 B11 TOP sky130_fd_pr__cap_mim_m3_1 l=3 w=3
X2325 B10 TOP sky130_fd_pr__cap_mim_m3_1 l=3 w=3
X2326 B7 TOP sky130_fd_pr__cap_mim_m3_1 l=3 w=3
X2327 B10 TOP sky130_fd_pr__cap_mim_m3_1 l=3 w=3
X2328 B9 TOP sky130_fd_pr__cap_mim_m3_1 l=3 w=3
X2329 B11 TOP sky130_fd_pr__cap_mim_m3_1 l=3 w=3
X2330 B11 TOP sky130_fd_pr__cap_mim_m3_1 l=3 w=3
X2331 B9 TOP sky130_fd_pr__cap_mim_m3_1 l=3 w=3
X2332 B7 TOP sky130_fd_pr__cap_mim_m3_1 l=3 w=3
X2333 B10 TOP sky130_fd_pr__cap_mim_m3_1 l=3 w=3
X2334 B11 TOP sky130_fd_pr__cap_mim_m3_1 l=3 w=3
X2335 B11 TOP sky130_fd_pr__cap_mim_m3_1 l=3 w=3
X2336 B10 TOP sky130_fd_pr__cap_mim_m3_1 l=3 w=3
X2337 B11 TOP sky130_fd_pr__cap_mim_m3_1 l=3 w=3
X2338 B11 TOP sky130_fd_pr__cap_mim_m3_1 l=3 w=3
X2339 B8 TOP sky130_fd_pr__cap_mim_m3_1 l=3 w=3
X2340 B11 TOP sky130_fd_pr__cap_mim_m3_1 l=3 w=3
X2341 B8 TOP sky130_fd_pr__cap_mim_m3_1 l=3 w=3
X2342 B6 TOP sky130_fd_pr__cap_mim_m3_1 l=3 w=3
X2343 B11 TOP sky130_fd_pr__cap_mim_m3_1 l=3 w=3
X2344 B9 TOP sky130_fd_pr__cap_mim_m3_1 l=3 w=3
X2345 B11 TOP sky130_fd_pr__cap_mim_m3_1 l=3 w=3
X2346 B11 TOP sky130_fd_pr__cap_mim_m3_1 l=3 w=3
X2347 B6 TOP sky130_fd_pr__cap_mim_m3_1 l=3 w=3
X2348 B11 TOP sky130_fd_pr__cap_mim_m3_1 l=3 w=3
X2349 B11 TOP sky130_fd_pr__cap_mim_m3_1 l=3 w=3
X2350 B9 TOP sky130_fd_pr__cap_mim_m3_1 l=3 w=3
X2351 EDGE_BIAS EDGE_BIAS sky130_fd_pr__cap_mim_m3_1 l=3 w=3
X2352 B11 TOP sky130_fd_pr__cap_mim_m3_1 l=3 w=3
X2353 B11 TOP sky130_fd_pr__cap_mim_m3_1 l=3 w=3
X2354 B11 TOP sky130_fd_pr__cap_mim_m3_1 l=3 w=3
X2355 EDGE_BIAS EDGE_BIAS sky130_fd_pr__cap_mim_m3_1 l=3 w=3
X2356 B8 TOP sky130_fd_pr__cap_mim_m3_1 l=3 w=3
X2357 B11 TOP sky130_fd_pr__cap_mim_m3_1 l=3 w=3
X2358 B11 TOP sky130_fd_pr__cap_mim_m3_1 l=3 w=3
X2359 B10 TOP sky130_fd_pr__cap_mim_m3_1 l=3 w=3
X2360 B10 TOP sky130_fd_pr__cap_mim_m3_1 l=3 w=3
X2361 B7 TOP sky130_fd_pr__cap_mim_m3_1 l=3 w=3
X2362 B11 TOP sky130_fd_pr__cap_mim_m3_1 l=3 w=3
X2363 B11 TOP sky130_fd_pr__cap_mim_m3_1 l=3 w=3
X2364 B10 TOP sky130_fd_pr__cap_mim_m3_1 l=3 w=3
X2365 B8 TOP sky130_fd_pr__cap_mim_m3_1 l=3 w=3
X2366 B10 TOP sky130_fd_pr__cap_mim_m3_1 l=3 w=3
X2367 B10 TOP sky130_fd_pr__cap_mim_m3_1 l=3 w=3
X2368 B11 TOP sky130_fd_pr__cap_mim_m3_1 l=3 w=3
X2369 B10 TOP sky130_fd_pr__cap_mim_m3_1 l=3 w=3
X2370 B11 TOP sky130_fd_pr__cap_mim_m3_1 l=3 w=3
X2371 B10 TOP sky130_fd_pr__cap_mim_m3_1 l=3 w=3
X2372 B11 TOP sky130_fd_pr__cap_mim_m3_1 l=3 w=3
X2373 B10 TOP sky130_fd_pr__cap_mim_m3_1 l=3 w=3
X2374 EDGE_BIAS EDGE_BIAS sky130_fd_pr__cap_mim_m3_1 l=3 w=3
X2375 B10 TOP sky130_fd_pr__cap_mim_m3_1 l=3 w=3
X2376 B9 TOP sky130_fd_pr__cap_mim_m3_1 l=3 w=3
X2377 B11 TOP sky130_fd_pr__cap_mim_m3_1 l=3 w=3
X2378 B11 TOP sky130_fd_pr__cap_mim_m3_1 l=3 w=3
X2379 B9 TOP sky130_fd_pr__cap_mim_m3_1 l=3 w=3
X2380 B7 TOP sky130_fd_pr__cap_mim_m3_1 l=3 w=3
X2381 B11 TOP sky130_fd_pr__cap_mim_m3_1 l=3 w=3
X2382 B11 TOP sky130_fd_pr__cap_mim_m3_1 l=3 w=3
X2383 B8 TOP sky130_fd_pr__cap_mim_m3_1 l=3 w=3
X2384 B8 TOP sky130_fd_pr__cap_mim_m3_1 l=3 w=3
X2385 B11 TOP sky130_fd_pr__cap_mim_m3_1 l=3 w=3
X2386 B5 TOP sky130_fd_pr__cap_mim_m3_1 l=3 w=3
X2387 B9 TOP sky130_fd_pr__cap_mim_m3_1 l=3 w=3
X2388 B10 TOP sky130_fd_pr__cap_mim_m3_1 l=3 w=3
X2389 B9 TOP sky130_fd_pr__cap_mim_m3_1 l=3 w=3
X2390 B9 TOP sky130_fd_pr__cap_mim_m3_1 l=3 w=3
X2391 B11 TOP sky130_fd_pr__cap_mim_m3_1 l=3 w=3
X2392 B10 TOP sky130_fd_pr__cap_mim_m3_1 l=3 w=3
X2393 B11 TOP sky130_fd_pr__cap_mim_m3_1 l=3 w=3
X2394 B10 TOP sky130_fd_pr__cap_mim_m3_1 l=3 w=3
X2395 B10 TOP sky130_fd_pr__cap_mim_m3_1 l=3 w=3
X2396 B9 TOP sky130_fd_pr__cap_mim_m3_1 l=3 w=3
X2397 B11 TOP sky130_fd_pr__cap_mim_m3_1 l=3 w=3
X2398 B11 TOP sky130_fd_pr__cap_mim_m3_1 l=3 w=3
X2399 B11 TOP sky130_fd_pr__cap_mim_m3_1 l=3 w=3
X2400 B11 TOP sky130_fd_pr__cap_mim_m3_1 l=3 w=3
X2401 EDGE_BIAS EDGE_BIAS sky130_fd_pr__cap_mim_m3_1 l=3 w=3
X2402 B11 TOP sky130_fd_pr__cap_mim_m3_1 l=3 w=3
X2403 B11 TOP sky130_fd_pr__cap_mim_m3_1 l=3 w=3
X2404 B11 TOP sky130_fd_pr__cap_mim_m3_1 l=3 w=3
X2405 B11 TOP sky130_fd_pr__cap_mim_m3_1 l=3 w=3
X2406 B8 TOP sky130_fd_pr__cap_mim_m3_1 l=3 w=3
X2407 B11 TOP sky130_fd_pr__cap_mim_m3_1 l=3 w=3
X2408 B7 TOP sky130_fd_pr__cap_mim_m3_1 l=3 w=3
X2409 B9 TOP sky130_fd_pr__cap_mim_m3_1 l=3 w=3
X2410 B11 TOP sky130_fd_pr__cap_mim_m3_1 l=3 w=3
X2411 B11 TOP sky130_fd_pr__cap_mim_m3_1 l=3 w=3
X2412 EDGE_BIAS EDGE_BIAS sky130_fd_pr__cap_mim_m3_1 l=3 w=3
X2413 B10 TOP sky130_fd_pr__cap_mim_m3_1 l=3 w=3
X2414 B10 TOP sky130_fd_pr__cap_mim_m3_1 l=3 w=3
X2415 B8 TOP sky130_fd_pr__cap_mim_m3_1 l=3 w=3
X2416 B10 TOP sky130_fd_pr__cap_mim_m3_1 l=3 w=3
X2417 B11 TOP sky130_fd_pr__cap_mim_m3_1 l=3 w=3
X2418 B11 TOP sky130_fd_pr__cap_mim_m3_1 l=3 w=3
X2419 B10 TOP sky130_fd_pr__cap_mim_m3_1 l=3 w=3
X2420 B10 TOP sky130_fd_pr__cap_mim_m3_1 l=3 w=3
X2421 B8 TOP sky130_fd_pr__cap_mim_m3_1 l=3 w=3
X2422 B9 TOP sky130_fd_pr__cap_mim_m3_1 l=3 w=3
X2423 B10 TOP sky130_fd_pr__cap_mim_m3_1 l=3 w=3
X2424 B10 TOP sky130_fd_pr__cap_mim_m3_1 l=3 w=3
X2425 B10 TOP sky130_fd_pr__cap_mim_m3_1 l=3 w=3
X2426 B10 TOP sky130_fd_pr__cap_mim_m3_1 l=3 w=3
X2427 B10 TOP sky130_fd_pr__cap_mim_m3_1 l=3 w=3
X2428 B11 TOP sky130_fd_pr__cap_mim_m3_1 l=3 w=3
X2429 B11 TOP sky130_fd_pr__cap_mim_m3_1 l=3 w=3
X2430 B11 TOP sky130_fd_pr__cap_mim_m3_1 l=3 w=3
X2431 B11 TOP sky130_fd_pr__cap_mim_m3_1 l=3 w=3
X2432 B10 TOP sky130_fd_pr__cap_mim_m3_1 l=3 w=3
X2433 B8 TOP sky130_fd_pr__cap_mim_m3_1 l=3 w=3
X2434 B11 TOP sky130_fd_pr__cap_mim_m3_1 l=3 w=3
X2435 B8 TOP sky130_fd_pr__cap_mim_m3_1 l=3 w=3
X2436 B11 TOP sky130_fd_pr__cap_mim_m3_1 l=3 w=3
X2437 B9 TOP sky130_fd_pr__cap_mim_m3_1 l=3 w=3
X2438 B11 TOP sky130_fd_pr__cap_mim_m3_1 l=3 w=3
X2439 B10 TOP sky130_fd_pr__cap_mim_m3_1 l=3 w=3
X2440 B9 TOP sky130_fd_pr__cap_mim_m3_1 l=3 w=3
X2441 B11 TOP sky130_fd_pr__cap_mim_m3_1 l=3 w=3
X2442 B11 TOP sky130_fd_pr__cap_mim_m3_1 l=3 w=3
X2443 B10 TOP sky130_fd_pr__cap_mim_m3_1 l=3 w=3
X2444 B6 TOP sky130_fd_pr__cap_mim_m3_1 l=3 w=3
X2445 B11 TOP sky130_fd_pr__cap_mim_m3_1 l=3 w=3
X2446 B11 TOP sky130_fd_pr__cap_mim_m3_1 l=3 w=3
X2447 EDGE_BIAS EDGE_BIAS sky130_fd_pr__cap_mim_m3_1 l=3 w=3
X2448 B10 TOP sky130_fd_pr__cap_mim_m3_1 l=3 w=3
X2449 B9 TOP sky130_fd_pr__cap_mim_m3_1 l=3 w=3
X2450 B9 TOP sky130_fd_pr__cap_mim_m3_1 l=3 w=3
X2451 B9 TOP sky130_fd_pr__cap_mim_m3_1 l=3 w=3
X2452 B10 TOP sky130_fd_pr__cap_mim_m3_1 l=3 w=3
X2453 B11 TOP sky130_fd_pr__cap_mim_m3_1 l=3 w=3
X2454 B11 TOP sky130_fd_pr__cap_mim_m3_1 l=3 w=3
X2455 B11 TOP sky130_fd_pr__cap_mim_m3_1 l=3 w=3
X2456 EDGE_BIAS EDGE_BIAS sky130_fd_pr__cap_mim_m3_1 l=3 w=3
X2457 EDGE_BIAS EDGE_BIAS sky130_fd_pr__cap_mim_m3_1 l=3 w=3
X2458 B11 TOP sky130_fd_pr__cap_mim_m3_1 l=3 w=3
X2459 B11 TOP sky130_fd_pr__cap_mim_m3_1 l=3 w=3
X2460 B11 TOP sky130_fd_pr__cap_mim_m3_1 l=3 w=3
X2461 B9 TOP sky130_fd_pr__cap_mim_m3_1 l=3 w=3
X2462 B11 TOP sky130_fd_pr__cap_mim_m3_1 l=3 w=3
X2463 B11 TOP sky130_fd_pr__cap_mim_m3_1 l=3 w=3
X2464 B10 TOP sky130_fd_pr__cap_mim_m3_1 l=3 w=3
X2465 B10 TOP sky130_fd_pr__cap_mim_m3_1 l=3 w=3
X2466 B10 TOP sky130_fd_pr__cap_mim_m3_1 l=3 w=3
X2467 B10 TOP sky130_fd_pr__cap_mim_m3_1 l=3 w=3
X2468 B11 TOP sky130_fd_pr__cap_mim_m3_1 l=3 w=3
X2469 B9 TOP sky130_fd_pr__cap_mim_m3_1 l=3 w=3
X2470 B10 TOP sky130_fd_pr__cap_mim_m3_1 l=3 w=3
X2471 B10 TOP sky130_fd_pr__cap_mim_m3_1 l=3 w=3
X2472 B11 TOP sky130_fd_pr__cap_mim_m3_1 l=3 w=3
X2473 B11 TOP sky130_fd_pr__cap_mim_m3_1 l=3 w=3
X2474 B10 TOP sky130_fd_pr__cap_mim_m3_1 l=3 w=3
X2475 B8 TOP sky130_fd_pr__cap_mim_m3_1 l=3 w=3
X2476 B11 TOP sky130_fd_pr__cap_mim_m3_1 l=3 w=3
X2477 B10 TOP sky130_fd_pr__cap_mim_m3_1 l=3 w=3
X2478 B11 TOP sky130_fd_pr__cap_mim_m3_1 l=3 w=3
X2479 B10 TOP sky130_fd_pr__cap_mim_m3_1 l=3 w=3
X2480 B10 TOP sky130_fd_pr__cap_mim_m3_1 l=3 w=3
X2481 B10 TOP sky130_fd_pr__cap_mim_m3_1 l=3 w=3
X2482 B11 TOP sky130_fd_pr__cap_mim_m3_1 l=3 w=3
X2483 B10 TOP sky130_fd_pr__cap_mim_m3_1 l=3 w=3
X2484 B4 TOP sky130_fd_pr__cap_mim_m3_1 l=3 w=3
X2485 B11 TOP sky130_fd_pr__cap_mim_m3_1 l=3 w=3
X2486 B11 TOP sky130_fd_pr__cap_mim_m3_1 l=3 w=3
X2487 B10 TOP sky130_fd_pr__cap_mim_m3_1 l=3 w=3
X2488 B10 TOP sky130_fd_pr__cap_mim_m3_1 l=3 w=3
X2489 B9 TOP sky130_fd_pr__cap_mim_m3_1 l=3 w=3
X2490 B11 TOP sky130_fd_pr__cap_mim_m3_1 l=3 w=3
X2491 B7 TOP sky130_fd_pr__cap_mim_m3_1 l=3 w=3
X2492 B10 TOP sky130_fd_pr__cap_mim_m3_1 l=3 w=3
X2493 B11 TOP sky130_fd_pr__cap_mim_m3_1 l=3 w=3
X2494 B10 TOP sky130_fd_pr__cap_mim_m3_1 l=3 w=3
X2495 B8 TOP sky130_fd_pr__cap_mim_m3_1 l=3 w=3
X2496 B11 TOP sky130_fd_pr__cap_mim_m3_1 l=3 w=3
X2497 B11 TOP sky130_fd_pr__cap_mim_m3_1 l=3 w=3
X2498 B8 TOP sky130_fd_pr__cap_mim_m3_1 l=3 w=3
X2499 B6 TOP sky130_fd_pr__cap_mim_m3_1 l=3 w=3
X2500 B10 TOP sky130_fd_pr__cap_mim_m3_1 l=3 w=3
X2501 B9 TOP sky130_fd_pr__cap_mim_m3_1 l=3 w=3
X2502 B11 TOP sky130_fd_pr__cap_mim_m3_1 l=3 w=3
X2503 EDGE_BIAS EDGE_BIAS sky130_fd_pr__cap_mim_m3_1 l=3 w=3
X2504 B9 TOP sky130_fd_pr__cap_mim_m3_1 l=3 w=3
X2505 B11 TOP sky130_fd_pr__cap_mim_m3_1 l=3 w=3
X2506 B11 TOP sky130_fd_pr__cap_mim_m3_1 l=3 w=3
X2507 B11 TOP sky130_fd_pr__cap_mim_m3_1 l=3 w=3
X2508 B11 TOP sky130_fd_pr__cap_mim_m3_1 l=3 w=3
X2509 B9 TOP sky130_fd_pr__cap_mim_m3_1 l=3 w=3
X2510 B11 TOP sky130_fd_pr__cap_mim_m3_1 l=3 w=3
X2511 B11 TOP sky130_fd_pr__cap_mim_m3_1 l=3 w=3
X2512 B10 TOP sky130_fd_pr__cap_mim_m3_1 l=3 w=3
X2513 B11 TOP sky130_fd_pr__cap_mim_m3_1 l=3 w=3
X2514 B11 TOP sky130_fd_pr__cap_mim_m3_1 l=3 w=3
X2515 EDGE_BIAS EDGE_BIAS sky130_fd_pr__cap_mim_m3_1 l=3 w=3
X2516 B10 TOP sky130_fd_pr__cap_mim_m3_1 l=3 w=3
X2517 B11 TOP sky130_fd_pr__cap_mim_m3_1 l=3 w=3
X2518 B11 TOP sky130_fd_pr__cap_mim_m3_1 l=3 w=3
X2519 B9 TOP sky130_fd_pr__cap_mim_m3_1 l=3 w=3
X2520 B6 TOP sky130_fd_pr__cap_mim_m3_1 l=3 w=3
X2521 B11 TOP sky130_fd_pr__cap_mim_m3_1 l=3 w=3
X2522 B11 TOP sky130_fd_pr__cap_mim_m3_1 l=3 w=3
X2523 B7 TOP sky130_fd_pr__cap_mim_m3_1 l=3 w=3
X2524 B9 TOP sky130_fd_pr__cap_mim_m3_1 l=3 w=3
X2525 B11 TOP sky130_fd_pr__cap_mim_m3_1 l=3 w=3
X2526 B9 TOP sky130_fd_pr__cap_mim_m3_1 l=3 w=3
X2527 B11 TOP sky130_fd_pr__cap_mim_m3_1 l=3 w=3
X2528 B11 TOP sky130_fd_pr__cap_mim_m3_1 l=3 w=3
X2529 B10 TOP sky130_fd_pr__cap_mim_m3_1 l=3 w=3
X2530 B8 TOP sky130_fd_pr__cap_mim_m3_1 l=3 w=3
X2531 B9 TOP sky130_fd_pr__cap_mim_m3_1 l=3 w=3
X2532 B9 TOP sky130_fd_pr__cap_mim_m3_1 l=3 w=3
X2533 B11 TOP sky130_fd_pr__cap_mim_m3_1 l=3 w=3
X2534 B10 TOP sky130_fd_pr__cap_mim_m3_1 l=3 w=3
X2535 B11 TOP sky130_fd_pr__cap_mim_m3_1 l=3 w=3
X2536 EDGE_BIAS EDGE_BIAS sky130_fd_pr__cap_mim_m3_1 l=3 w=3
X2537 B11 TOP sky130_fd_pr__cap_mim_m3_1 l=3 w=3
X2538 B10 TOP sky130_fd_pr__cap_mim_m3_1 l=3 w=3
X2539 B11 TOP sky130_fd_pr__cap_mim_m3_1 l=3 w=3
X2540 B11 TOP sky130_fd_pr__cap_mim_m3_1 l=3 w=3
X2541 B10 TOP sky130_fd_pr__cap_mim_m3_1 l=3 w=3
X2542 B10 TOP sky130_fd_pr__cap_mim_m3_1 l=3 w=3
X2543 B11 TOP sky130_fd_pr__cap_mim_m3_1 l=3 w=3
X2544 B5 TOP sky130_fd_pr__cap_mim_m3_1 l=3 w=3
X2545 B11 TOP sky130_fd_pr__cap_mim_m3_1 l=3 w=3
X2546 B8 TOP sky130_fd_pr__cap_mim_m3_1 l=3 w=3
X2547 B11 TOP sky130_fd_pr__cap_mim_m3_1 l=3 w=3
X2548 B11 TOP sky130_fd_pr__cap_mim_m3_1 l=3 w=3
X2549 B11 TOP sky130_fd_pr__cap_mim_m3_1 l=3 w=3
X2550 B8 TOP sky130_fd_pr__cap_mim_m3_1 l=3 w=3
X2551 B11 TOP sky130_fd_pr__cap_mim_m3_1 l=3 w=3
X2552 B11 TOP sky130_fd_pr__cap_mim_m3_1 l=3 w=3
X2553 B8 TOP sky130_fd_pr__cap_mim_m3_1 l=3 w=3
X2554 B10 TOP sky130_fd_pr__cap_mim_m3_1 l=3 w=3
X2555 B11 TOP sky130_fd_pr__cap_mim_m3_1 l=3 w=3
X2556 B5 TOP sky130_fd_pr__cap_mim_m3_1 l=3 w=3
X2557 B9 TOP sky130_fd_pr__cap_mim_m3_1 l=3 w=3
X2558 B10 TOP sky130_fd_pr__cap_mim_m3_1 l=3 w=3
X2559 B11 TOP sky130_fd_pr__cap_mim_m3_1 l=3 w=3
X2560 B9 TOP sky130_fd_pr__cap_mim_m3_1 l=3 w=3
X2561 B11 TOP sky130_fd_pr__cap_mim_m3_1 l=3 w=3
X2562 EDGE_BIAS EDGE_BIAS sky130_fd_pr__cap_mim_m3_1 l=3 w=3
X2563 B1 TOP sky130_fd_pr__cap_mim_m3_1 l=3 w=3
X2564 B9 TOP sky130_fd_pr__cap_mim_m3_1 l=3 w=3
X2565 B10 TOP sky130_fd_pr__cap_mim_m3_1 l=3 w=3
X2566 B10 TOP sky130_fd_pr__cap_mim_m3_1 l=3 w=3
X2567 EDGE_BIAS EDGE_BIAS sky130_fd_pr__cap_mim_m3_1 l=3 w=3
X2568 B11 TOP sky130_fd_pr__cap_mim_m3_1 l=3 w=3
X2569 B11 TOP sky130_fd_pr__cap_mim_m3_1 l=3 w=3
X2570 EDGE_BIAS EDGE_BIAS sky130_fd_pr__cap_mim_m3_1 l=3 w=3
X2571 B11 TOP sky130_fd_pr__cap_mim_m3_1 l=3 w=3
X2572 B11 TOP sky130_fd_pr__cap_mim_m3_1 l=3 w=3
X2573 B10 TOP sky130_fd_pr__cap_mim_m3_1 l=3 w=3
X2574 B11 TOP sky130_fd_pr__cap_mim_m3_1 l=3 w=3
X2575 B11 TOP sky130_fd_pr__cap_mim_m3_1 l=3 w=3
X2576 B11 TOP sky130_fd_pr__cap_mim_m3_1 l=3 w=3
X2577 B10 TOP sky130_fd_pr__cap_mim_m3_1 l=3 w=3
X2578 B11 TOP sky130_fd_pr__cap_mim_m3_1 l=3 w=3
X2579 B10 TOP sky130_fd_pr__cap_mim_m3_1 l=3 w=3
X2580 B11 TOP sky130_fd_pr__cap_mim_m3_1 l=3 w=3
X2581 B11 TOP sky130_fd_pr__cap_mim_m3_1 l=3 w=3
X2582 B9 TOP sky130_fd_pr__cap_mim_m3_1 l=3 w=3
X2583 B11 TOP sky130_fd_pr__cap_mim_m3_1 l=3 w=3
X2584 B11 TOP sky130_fd_pr__cap_mim_m3_1 l=3 w=3
X2585 B10 TOP sky130_fd_pr__cap_mim_m3_1 l=3 w=3
X2586 B8 TOP sky130_fd_pr__cap_mim_m3_1 l=3 w=3
X2587 B10 TOP sky130_fd_pr__cap_mim_m3_1 l=3 w=3
X2588 B11 TOP sky130_fd_pr__cap_mim_m3_1 l=3 w=3
X2589 B11 TOP sky130_fd_pr__cap_mim_m3_1 l=3 w=3
X2590 B10 TOP sky130_fd_pr__cap_mim_m3_1 l=3 w=3
X2591 B8 TOP sky130_fd_pr__cap_mim_m3_1 l=3 w=3
X2592 B10 TOP sky130_fd_pr__cap_mim_m3_1 l=3 w=3
X2593 B11 TOP sky130_fd_pr__cap_mim_m3_1 l=3 w=3
X2594 B11 TOP sky130_fd_pr__cap_mim_m3_1 l=3 w=3
X2595 B10 TOP sky130_fd_pr__cap_mim_m3_1 l=3 w=3
X2596 B11 TOP sky130_fd_pr__cap_mim_m3_1 l=3 w=3
X2597 B10 TOP sky130_fd_pr__cap_mim_m3_1 l=3 w=3
X2598 B10 TOP sky130_fd_pr__cap_mim_m3_1 l=3 w=3
X2599 B11 TOP sky130_fd_pr__cap_mim_m3_1 l=3 w=3
X2600 B11 TOP sky130_fd_pr__cap_mim_m3_1 l=3 w=3
X2601 B11 TOP sky130_fd_pr__cap_mim_m3_1 l=3 w=3
X2602 B10 TOP sky130_fd_pr__cap_mim_m3_1 l=3 w=3
X2603 B11 TOP sky130_fd_pr__cap_mim_m3_1 l=3 w=3
X2604 B11 TOP sky130_fd_pr__cap_mim_m3_1 l=3 w=3
X2605 B11 TOP sky130_fd_pr__cap_mim_m3_1 l=3 w=3
X2606 B11 TOP sky130_fd_pr__cap_mim_m3_1 l=3 w=3
X2607 B11 TOP sky130_fd_pr__cap_mim_m3_1 l=3 w=3
X2608 B10 TOP sky130_fd_pr__cap_mim_m3_1 l=3 w=3
X2609 B11 TOP sky130_fd_pr__cap_mim_m3_1 l=3 w=3
X2610 B8 TOP sky130_fd_pr__cap_mim_m3_1 l=3 w=3
X2611 B10 TOP sky130_fd_pr__cap_mim_m3_1 l=3 w=3
X2612 B3 TOP sky130_fd_pr__cap_mim_m3_1 l=3 w=3
X2613 B9 TOP sky130_fd_pr__cap_mim_m3_1 l=3 w=3
X2614 B11 TOP sky130_fd_pr__cap_mim_m3_1 l=3 w=3
X2615 B11 TOP sky130_fd_pr__cap_mim_m3_1 l=3 w=3
X2616 B9 TOP sky130_fd_pr__cap_mim_m3_1 l=3 w=3
X2617 B9 TOP sky130_fd_pr__cap_mim_m3_1 l=3 w=3
X2618 B11 TOP sky130_fd_pr__cap_mim_m3_1 l=3 w=3
X2619 B11 TOP sky130_fd_pr__cap_mim_m3_1 l=3 w=3
X2620 B10 TOP sky130_fd_pr__cap_mim_m3_1 l=3 w=3
X2621 B9 TOP sky130_fd_pr__cap_mim_m3_1 l=3 w=3
X2622 B11 TOP sky130_fd_pr__cap_mim_m3_1 l=3 w=3
X2623 B11 TOP sky130_fd_pr__cap_mim_m3_1 l=3 w=3
X2624 B11 TOP sky130_fd_pr__cap_mim_m3_1 l=3 w=3
X2625 B9 TOP sky130_fd_pr__cap_mim_m3_1 l=3 w=3
X2626 B10 TOP sky130_fd_pr__cap_mim_m3_1 l=3 w=3
X2627 B11 TOP sky130_fd_pr__cap_mim_m3_1 l=3 w=3
X2628 B10 TOP sky130_fd_pr__cap_mim_m3_1 l=3 w=3
X2629 B11 TOP sky130_fd_pr__cap_mim_m3_1 l=3 w=3
X2630 B11 TOP sky130_fd_pr__cap_mim_m3_1 l=3 w=3
X2631 B10 TOP sky130_fd_pr__cap_mim_m3_1 l=3 w=3
X2632 B9 TOP sky130_fd_pr__cap_mim_m3_1 l=3 w=3
X2633 B11 TOP sky130_fd_pr__cap_mim_m3_1 l=3 w=3
X2634 B10 TOP sky130_fd_pr__cap_mim_m3_1 l=3 w=3
X2635 B10 TOP sky130_fd_pr__cap_mim_m3_1 l=3 w=3
X2636 B9 TOP sky130_fd_pr__cap_mim_m3_1 l=3 w=3
X2637 B11 TOP sky130_fd_pr__cap_mim_m3_1 l=3 w=3
X2638 B10 TOP sky130_fd_pr__cap_mim_m3_1 l=3 w=3
X2639 B8 TOP sky130_fd_pr__cap_mim_m3_1 l=3 w=3
X2640 B10 TOP sky130_fd_pr__cap_mim_m3_1 l=3 w=3
X2641 B10 TOP sky130_fd_pr__cap_mim_m3_1 l=3 w=3
X2642 B11 TOP sky130_fd_pr__cap_mim_m3_1 l=3 w=3
X2643 B10 TOP sky130_fd_pr__cap_mim_m3_1 l=3 w=3
X2644 B10 TOP sky130_fd_pr__cap_mim_m3_1 l=3 w=3
X2645 B8 TOP sky130_fd_pr__cap_mim_m3_1 l=3 w=3
X2646 B11 TOP sky130_fd_pr__cap_mim_m3_1 l=3 w=3
X2647 B11 TOP sky130_fd_pr__cap_mim_m3_1 l=3 w=3
X2648 B11 TOP sky130_fd_pr__cap_mim_m3_1 l=3 w=3
X2649 B10 TOP sky130_fd_pr__cap_mim_m3_1 l=3 w=3
X2650 B10 TOP sky130_fd_pr__cap_mim_m3_1 l=3 w=3
X2651 B9 TOP sky130_fd_pr__cap_mim_m3_1 l=3 w=3
X2652 B11 TOP sky130_fd_pr__cap_mim_m3_1 l=3 w=3
X2653 EDGE_BIAS EDGE_BIAS sky130_fd_pr__cap_mim_m3_1 l=3 w=3
X2654 B9 TOP sky130_fd_pr__cap_mim_m3_1 l=3 w=3
X2655 B5 TOP sky130_fd_pr__cap_mim_m3_1 l=3 w=3
X2656 B10 TOP sky130_fd_pr__cap_mim_m3_1 l=3 w=3
X2657 B9 TOP sky130_fd_pr__cap_mim_m3_1 l=3 w=3
X2658 B7 TOP sky130_fd_pr__cap_mim_m3_1 l=3 w=3
X2659 B10 TOP sky130_fd_pr__cap_mim_m3_1 l=3 w=3
X2660 EDGE_BIAS EDGE_BIAS sky130_fd_pr__cap_mim_m3_1 l=3 w=3
X2661 B8 TOP sky130_fd_pr__cap_mim_m3_1 l=3 w=3
X2662 B11 TOP sky130_fd_pr__cap_mim_m3_1 l=3 w=3
X2663 B11 TOP sky130_fd_pr__cap_mim_m3_1 l=3 w=3
X2664 B5 TOP sky130_fd_pr__cap_mim_m3_1 l=3 w=3
X2665 B11 TOP sky130_fd_pr__cap_mim_m3_1 l=3 w=3
X2666 B10 TOP sky130_fd_pr__cap_mim_m3_1 l=3 w=3
X2667 B10 TOP sky130_fd_pr__cap_mim_m3_1 l=3 w=3
X2668 EDGE_BIAS EDGE_BIAS sky130_fd_pr__cap_mim_m3_1 l=3 w=3
X2669 B11 TOP sky130_fd_pr__cap_mim_m3_1 l=3 w=3
X2670 B11 TOP sky130_fd_pr__cap_mim_m3_1 l=3 w=3
X2671 B10 TOP sky130_fd_pr__cap_mim_m3_1 l=3 w=3
X2672 B9 TOP sky130_fd_pr__cap_mim_m3_1 l=3 w=3
X2673 B10 TOP sky130_fd_pr__cap_mim_m3_1 l=3 w=3
X2674 B11 TOP sky130_fd_pr__cap_mim_m3_1 l=3 w=3
X2675 B11 TOP sky130_fd_pr__cap_mim_m3_1 l=3 w=3
X2676 B10 TOP sky130_fd_pr__cap_mim_m3_1 l=3 w=3
X2677 B10 TOP sky130_fd_pr__cap_mim_m3_1 l=3 w=3
X2678 B11 TOP sky130_fd_pr__cap_mim_m3_1 l=3 w=3
X2679 B11 TOP sky130_fd_pr__cap_mim_m3_1 l=3 w=3
X2680 B11 TOP sky130_fd_pr__cap_mim_m3_1 l=3 w=3
X2681 B7 TOP sky130_fd_pr__cap_mim_m3_1 l=3 w=3
X2682 B9 TOP sky130_fd_pr__cap_mim_m3_1 l=3 w=3
X2683 B11 TOP sky130_fd_pr__cap_mim_m3_1 l=3 w=3
X2684 B11 TOP sky130_fd_pr__cap_mim_m3_1 l=3 w=3
X2685 B9 TOP sky130_fd_pr__cap_mim_m3_1 l=3 w=3
X2686 B9 TOP sky130_fd_pr__cap_mim_m3_1 l=3 w=3
X2687 B11 TOP sky130_fd_pr__cap_mim_m3_1 l=3 w=3
X2688 B8 TOP sky130_fd_pr__cap_mim_m3_1 l=3 w=3
X2689 B11 TOP sky130_fd_pr__cap_mim_m3_1 l=3 w=3
X2690 B10 TOP sky130_fd_pr__cap_mim_m3_1 l=3 w=3
X2691 B9 TOP sky130_fd_pr__cap_mim_m3_1 l=3 w=3
X2692 B11 TOP sky130_fd_pr__cap_mim_m3_1 l=3 w=3
X2693 B11 TOP sky130_fd_pr__cap_mim_m3_1 l=3 w=3
X2694 EDGE_BIAS EDGE_BIAS sky130_fd_pr__cap_mim_m3_1 l=3 w=3
X2695 B10 TOP sky130_fd_pr__cap_mim_m3_1 l=3 w=3
X2696 B8 TOP sky130_fd_pr__cap_mim_m3_1 l=3 w=3
X2697 EDGE_BIAS EDGE_BIAS sky130_fd_pr__cap_mim_m3_1 l=3 w=3
X2698 B11 TOP sky130_fd_pr__cap_mim_m3_1 l=3 w=3
X2699 B8 TOP sky130_fd_pr__cap_mim_m3_1 l=3 w=3
X2700 B11 TOP sky130_fd_pr__cap_mim_m3_1 l=3 w=3
X2701 B10 TOP sky130_fd_pr__cap_mim_m3_1 l=3 w=3
X2702 B11 TOP sky130_fd_pr__cap_mim_m3_1 l=3 w=3
X2703 B10 TOP sky130_fd_pr__cap_mim_m3_1 l=3 w=3
X2704 B9 TOP sky130_fd_pr__cap_mim_m3_1 l=3 w=3
X2705 EDGE_BIAS EDGE_BIAS sky130_fd_pr__cap_mim_m3_1 l=3 w=3
X2706 B11 TOP sky130_fd_pr__cap_mim_m3_1 l=3 w=3
X2707 B10 TOP sky130_fd_pr__cap_mim_m3_1 l=3 w=3
X2708 B11 TOP sky130_fd_pr__cap_mim_m3_1 l=3 w=3
X2709 B6 TOP sky130_fd_pr__cap_mim_m3_1 l=3 w=3
X2710 B9 TOP sky130_fd_pr__cap_mim_m3_1 l=3 w=3
X2711 B11 TOP sky130_fd_pr__cap_mim_m3_1 l=3 w=3
X2712 B11 TOP sky130_fd_pr__cap_mim_m3_1 l=3 w=3
X2713 B11 TOP sky130_fd_pr__cap_mim_m3_1 l=3 w=3
X2714 B11 TOP sky130_fd_pr__cap_mim_m3_1 l=3 w=3
X2715 B11 TOP sky130_fd_pr__cap_mim_m3_1 l=3 w=3
X2716 B11 TOP sky130_fd_pr__cap_mim_m3_1 l=3 w=3
X2717 B10 TOP sky130_fd_pr__cap_mim_m3_1 l=3 w=3
X2718 B10 TOP sky130_fd_pr__cap_mim_m3_1 l=3 w=3
X2719 B11 TOP sky130_fd_pr__cap_mim_m3_1 l=3 w=3
X2720 B8 TOP sky130_fd_pr__cap_mim_m3_1 l=3 w=3
X2721 B4 TOP sky130_fd_pr__cap_mim_m3_1 l=3 w=3
X2722 B10 TOP sky130_fd_pr__cap_mim_m3_1 l=3 w=3
X2723 B10 TOP sky130_fd_pr__cap_mim_m3_1 l=3 w=3
X2724 B9 TOP sky130_fd_pr__cap_mim_m3_1 l=3 w=3
X2725 EDGE_BIAS EDGE_BIAS sky130_fd_pr__cap_mim_m3_1 l=3 w=3
X2726 B9 TOP sky130_fd_pr__cap_mim_m3_1 l=3 w=3
X2727 EDGE_BIAS EDGE_BIAS sky130_fd_pr__cap_mim_m3_1 l=3 w=3
X2728 B10 TOP sky130_fd_pr__cap_mim_m3_1 l=3 w=3
X2729 B9 TOP sky130_fd_pr__cap_mim_m3_1 l=3 w=3
X2730 B10 TOP sky130_fd_pr__cap_mim_m3_1 l=3 w=3
X2731 B11 TOP sky130_fd_pr__cap_mim_m3_1 l=3 w=3
X2732 B10 TOP sky130_fd_pr__cap_mim_m3_1 l=3 w=3
X2733 B10 TOP sky130_fd_pr__cap_mim_m3_1 l=3 w=3
X2734 B11 TOP sky130_fd_pr__cap_mim_m3_1 l=3 w=3
X2735 B11 TOP sky130_fd_pr__cap_mim_m3_1 l=3 w=3
X2736 B11 TOP sky130_fd_pr__cap_mim_m3_1 l=3 w=3
X2737 B11 TOP sky130_fd_pr__cap_mim_m3_1 l=3 w=3
X2738 B10 TOP sky130_fd_pr__cap_mim_m3_1 l=3 w=3
X2739 B10 TOP sky130_fd_pr__cap_mim_m3_1 l=3 w=3
X2740 B10 TOP sky130_fd_pr__cap_mim_m3_1 l=3 w=3
X2741 B11 TOP sky130_fd_pr__cap_mim_m3_1 l=3 w=3
X2742 B11 TOP sky130_fd_pr__cap_mim_m3_1 l=3 w=3
X2743 B11 TOP sky130_fd_pr__cap_mim_m3_1 l=3 w=3
X2744 B10 TOP sky130_fd_pr__cap_mim_m3_1 l=3 w=3
X2745 B11 TOP sky130_fd_pr__cap_mim_m3_1 l=3 w=3
X2746 B9 TOP sky130_fd_pr__cap_mim_m3_1 l=3 w=3
X2747 B9 TOP sky130_fd_pr__cap_mim_m3_1 l=3 w=3
X2748 B10 TOP sky130_fd_pr__cap_mim_m3_1 l=3 w=3
X2749 B8 TOP sky130_fd_pr__cap_mim_m3_1 l=3 w=3
X2750 B11 TOP sky130_fd_pr__cap_mim_m3_1 l=3 w=3
X2751 B9 TOP sky130_fd_pr__cap_mim_m3_1 l=3 w=3
X2752 B11 TOP sky130_fd_pr__cap_mim_m3_1 l=3 w=3
X2753 B10 TOP sky130_fd_pr__cap_mim_m3_1 l=3 w=3
X2754 B10 TOP sky130_fd_pr__cap_mim_m3_1 l=3 w=3
X2755 B8 TOP sky130_fd_pr__cap_mim_m3_1 l=3 w=3
X2756 B11 TOP sky130_fd_pr__cap_mim_m3_1 l=3 w=3
X2757 B11 TOP sky130_fd_pr__cap_mim_m3_1 l=3 w=3
X2758 B11 TOP sky130_fd_pr__cap_mim_m3_1 l=3 w=3
X2759 B10 TOP sky130_fd_pr__cap_mim_m3_1 l=3 w=3
X2760 B8 TOP sky130_fd_pr__cap_mim_m3_1 l=3 w=3
X2761 B11 TOP sky130_fd_pr__cap_mim_m3_1 l=3 w=3
X2762 B11 TOP sky130_fd_pr__cap_mim_m3_1 l=3 w=3
X2763 B11 TOP sky130_fd_pr__cap_mim_m3_1 l=3 w=3
X2764 EDGE_BIAS EDGE_BIAS sky130_fd_pr__cap_mim_m3_1 l=3 w=3
X2765 B4 TOP sky130_fd_pr__cap_mim_m3_1 l=3 w=3
X2766 B9 TOP sky130_fd_pr__cap_mim_m3_1 l=3 w=3
X2767 B10 TOP sky130_fd_pr__cap_mim_m3_1 l=3 w=3
X2768 B8 TOP sky130_fd_pr__cap_mim_m3_1 l=3 w=3
X2769 B6 TOP sky130_fd_pr__cap_mim_m3_1 l=3 w=3
X2770 B11 TOP sky130_fd_pr__cap_mim_m3_1 l=3 w=3
X2771 B10 TOP sky130_fd_pr__cap_mim_m3_1 l=3 w=3
X2772 B10 TOP sky130_fd_pr__cap_mim_m3_1 l=3 w=3
X2773 EDGE_BIAS EDGE_BIAS sky130_fd_pr__cap_mim_m3_1 l=3 w=3
X2774 B11 TOP sky130_fd_pr__cap_mim_m3_1 l=3 w=3
X2775 B11 TOP sky130_fd_pr__cap_mim_m3_1 l=3 w=3
X2776 B10 TOP sky130_fd_pr__cap_mim_m3_1 l=3 w=3
X2777 B11 TOP sky130_fd_pr__cap_mim_m3_1 l=3 w=3
X2778 B11 TOP sky130_fd_pr__cap_mim_m3_1 l=3 w=3
X2779 B10 TOP sky130_fd_pr__cap_mim_m3_1 l=3 w=3
X2780 B8 TOP sky130_fd_pr__cap_mim_m3_1 l=3 w=3
X2781 B11 TOP sky130_fd_pr__cap_mim_m3_1 l=3 w=3
X2782 EDGE_BIAS EDGE_BIAS sky130_fd_pr__cap_mim_m3_1 l=3 w=3
X2783 B10 TOP sky130_fd_pr__cap_mim_m3_1 l=3 w=3
X2784 B10 TOP sky130_fd_pr__cap_mim_m3_1 l=3 w=3
X2785 B10 TOP sky130_fd_pr__cap_mim_m3_1 l=3 w=3
X2786 B10 TOP sky130_fd_pr__cap_mim_m3_1 l=3 w=3
X2787 B9 TOP sky130_fd_pr__cap_mim_m3_1 l=3 w=3
X2788 B11 TOP sky130_fd_pr__cap_mim_m3_1 l=3 w=3
X2789 B10 TOP sky130_fd_pr__cap_mim_m3_1 l=3 w=3
X2790 B10 TOP sky130_fd_pr__cap_mim_m3_1 l=3 w=3
X2791 B10 TOP sky130_fd_pr__cap_mim_m3_1 l=3 w=3
X2792 B11 TOP sky130_fd_pr__cap_mim_m3_1 l=3 w=3
X2793 EDGE_BIAS EDGE_BIAS sky130_fd_pr__cap_mim_m3_1 l=3 w=3
X2794 B11 TOP sky130_fd_pr__cap_mim_m3_1 l=3 w=3
X2795 B10 TOP sky130_fd_pr__cap_mim_m3_1 l=3 w=3
X2796 B9 TOP sky130_fd_pr__cap_mim_m3_1 l=3 w=3
X2797 B6 TOP sky130_fd_pr__cap_mim_m3_1 l=3 w=3
X2798 B11 TOP sky130_fd_pr__cap_mim_m3_1 l=3 w=3
X2799 B10 TOP sky130_fd_pr__cap_mim_m3_1 l=3 w=3
X2800 B11 TOP sky130_fd_pr__cap_mim_m3_1 l=3 w=3
X2801 B11 TOP sky130_fd_pr__cap_mim_m3_1 l=3 w=3
X2802 B11 TOP sky130_fd_pr__cap_mim_m3_1 l=3 w=3
X2803 B9 TOP sky130_fd_pr__cap_mim_m3_1 l=3 w=3
X2804 B10 TOP sky130_fd_pr__cap_mim_m3_1 l=3 w=3
X2805 B8 TOP sky130_fd_pr__cap_mim_m3_1 l=3 w=3
X2806 B9 TOP sky130_fd_pr__cap_mim_m3_1 l=3 w=3
X2807 B11 TOP sky130_fd_pr__cap_mim_m3_1 l=3 w=3
X2808 B11 TOP sky130_fd_pr__cap_mim_m3_1 l=3 w=3
X2809 B10 TOP sky130_fd_pr__cap_mim_m3_1 l=3 w=3
X2810 B11 TOP sky130_fd_pr__cap_mim_m3_1 l=3 w=3
X2811 B10 TOP sky130_fd_pr__cap_mim_m3_1 l=3 w=3
X2812 B9 TOP sky130_fd_pr__cap_mim_m3_1 l=3 w=3
X2813 B11 TOP sky130_fd_pr__cap_mim_m3_1 l=3 w=3
X2814 B11 TOP sky130_fd_pr__cap_mim_m3_1 l=3 w=3
X2815 B10 TOP sky130_fd_pr__cap_mim_m3_1 l=3 w=3
X2816 B9 TOP sky130_fd_pr__cap_mim_m3_1 l=3 w=3
X2817 B7 TOP sky130_fd_pr__cap_mim_m3_1 l=3 w=3
X2818 B10 TOP sky130_fd_pr__cap_mim_m3_1 l=3 w=3
X2819 B8 TOP sky130_fd_pr__cap_mim_m3_1 l=3 w=3
X2820 B11 TOP sky130_fd_pr__cap_mim_m3_1 l=3 w=3
X2821 B11 TOP sky130_fd_pr__cap_mim_m3_1 l=3 w=3
X2822 B11 TOP sky130_fd_pr__cap_mim_m3_1 l=3 w=3
X2823 B8 TOP sky130_fd_pr__cap_mim_m3_1 l=3 w=3
X2824 B11 TOP sky130_fd_pr__cap_mim_m3_1 l=3 w=3
X2825 B9 TOP sky130_fd_pr__cap_mim_m3_1 l=3 w=3
X2826 B11 TOP sky130_fd_pr__cap_mim_m3_1 l=3 w=3
X2827 B5 TOP sky130_fd_pr__cap_mim_m3_1 l=3 w=3
X2828 B11 TOP sky130_fd_pr__cap_mim_m3_1 l=3 w=3
X2829 B10 TOP sky130_fd_pr__cap_mim_m3_1 l=3 w=3
X2830 B8 TOP sky130_fd_pr__cap_mim_m3_1 l=3 w=3
X2831 B11 TOP sky130_fd_pr__cap_mim_m3_1 l=3 w=3
X2832 B11 TOP sky130_fd_pr__cap_mim_m3_1 l=3 w=3
X2833 B11 TOP sky130_fd_pr__cap_mim_m3_1 l=3 w=3
X2834 B10 TOP sky130_fd_pr__cap_mim_m3_1 l=3 w=3
X2835 EDGE_BIAS EDGE_BIAS sky130_fd_pr__cap_mim_m3_1 l=3 w=3
X2836 B10 TOP sky130_fd_pr__cap_mim_m3_1 l=3 w=3
X2837 B5 TOP sky130_fd_pr__cap_mim_m3_1 l=3 w=3
X2838 B11 TOP sky130_fd_pr__cap_mim_m3_1 l=3 w=3
X2839 B10 TOP sky130_fd_pr__cap_mim_m3_1 l=3 w=3
X2840 B8 TOP sky130_fd_pr__cap_mim_m3_1 l=3 w=3
X2841 B10 TOP sky130_fd_pr__cap_mim_m3_1 l=3 w=3
X2842 B11 TOP sky130_fd_pr__cap_mim_m3_1 l=3 w=3
X2843 B10 TOP sky130_fd_pr__cap_mim_m3_1 l=3 w=3
X2844 B7 TOP sky130_fd_pr__cap_mim_m3_1 l=3 w=3
X2845 B11 TOP sky130_fd_pr__cap_mim_m3_1 l=3 w=3
X2846 B3 TOP sky130_fd_pr__cap_mim_m3_1 l=3 w=3
X2847 B9 TOP sky130_fd_pr__cap_mim_m3_1 l=3 w=3
X2848 B10 TOP sky130_fd_pr__cap_mim_m3_1 l=3 w=3
X2849 B10 TOP sky130_fd_pr__cap_mim_m3_1 l=3 w=3
X2850 B10 TOP sky130_fd_pr__cap_mim_m3_1 l=3 w=3
X2851 B11 TOP sky130_fd_pr__cap_mim_m3_1 l=3 w=3
X2852 B11 TOP sky130_fd_pr__cap_mim_m3_1 l=3 w=3
X2853 B10 TOP sky130_fd_pr__cap_mim_m3_1 l=3 w=3
X2854 B10 TOP sky130_fd_pr__cap_mim_m3_1 l=3 w=3
X2855 B11 TOP sky130_fd_pr__cap_mim_m3_1 l=3 w=3
X2856 B10 TOP sky130_fd_pr__cap_mim_m3_1 l=3 w=3
X2857 EDGE_BIAS EDGE_BIAS sky130_fd_pr__cap_mim_m3_1 l=3 w=3
X2858 B10 TOP sky130_fd_pr__cap_mim_m3_1 l=3 w=3
X2859 B9 TOP sky130_fd_pr__cap_mim_m3_1 l=3 w=3
X2860 B9 TOP sky130_fd_pr__cap_mim_m3_1 l=3 w=3
X2861 B11 TOP sky130_fd_pr__cap_mim_m3_1 l=3 w=3
X2862 B8 TOP sky130_fd_pr__cap_mim_m3_1 l=3 w=3
X2863 B8 TOP sky130_fd_pr__cap_mim_m3_1 l=3 w=3
X2864 B11 TOP sky130_fd_pr__cap_mim_m3_1 l=3 w=3
X2865 B9 TOP sky130_fd_pr__cap_mim_m3_1 l=3 w=3
X2866 B10 TOP sky130_fd_pr__cap_mim_m3_1 l=3 w=3
X2867 B7 TOP sky130_fd_pr__cap_mim_m3_1 l=3 w=3
X2868 B8 TOP sky130_fd_pr__cap_mim_m3_1 l=3 w=3
X2869 B8 TOP sky130_fd_pr__cap_mim_m3_1 l=3 w=3
X2870 B10 TOP sky130_fd_pr__cap_mim_m3_1 l=3 w=3
X2871 B11 TOP sky130_fd_pr__cap_mim_m3_1 l=3 w=3
X2872 B10 TOP sky130_fd_pr__cap_mim_m3_1 l=3 w=3
X2873 B6 TOP sky130_fd_pr__cap_mim_m3_1 l=3 w=3
X2874 B11 TOP sky130_fd_pr__cap_mim_m3_1 l=3 w=3
X2875 B11 TOP sky130_fd_pr__cap_mim_m3_1 l=3 w=3
X2876 B11 TOP sky130_fd_pr__cap_mim_m3_1 l=3 w=3
X2877 B11 TOP sky130_fd_pr__cap_mim_m3_1 l=3 w=3
X2878 B11 TOP sky130_fd_pr__cap_mim_m3_1 l=3 w=3
X2879 B9 TOP sky130_fd_pr__cap_mim_m3_1 l=3 w=3
X2880 B10 TOP sky130_fd_pr__cap_mim_m3_1 l=3 w=3
X2881 B6 TOP sky130_fd_pr__cap_mim_m3_1 l=3 w=3
X2882 B11 TOP sky130_fd_pr__cap_mim_m3_1 l=3 w=3
X2883 B9 TOP sky130_fd_pr__cap_mim_m3_1 l=3 w=3
X2884 B11 TOP sky130_fd_pr__cap_mim_m3_1 l=3 w=3
X2885 B11 TOP sky130_fd_pr__cap_mim_m3_1 l=3 w=3
X2886 B11 TOP sky130_fd_pr__cap_mim_m3_1 l=3 w=3
X2887 B9 TOP sky130_fd_pr__cap_mim_m3_1 l=3 w=3
X2888 B11 TOP sky130_fd_pr__cap_mim_m3_1 l=3 w=3
X2889 B11 TOP sky130_fd_pr__cap_mim_m3_1 l=3 w=3
X2890 B11 TOP sky130_fd_pr__cap_mim_m3_1 l=3 w=3
X2891 B10 TOP sky130_fd_pr__cap_mim_m3_1 l=3 w=3
X2892 B11 TOP sky130_fd_pr__cap_mim_m3_1 l=3 w=3
X2893 B9 TOP sky130_fd_pr__cap_mim_m3_1 l=3 w=3
X2894 EDGE_BIAS EDGE_BIAS sky130_fd_pr__cap_mim_m3_1 l=3 w=3
X2895 B10 TOP sky130_fd_pr__cap_mim_m3_1 l=3 w=3
X2896 B7 TOP sky130_fd_pr__cap_mim_m3_1 l=3 w=3
X2897 B11 TOP sky130_fd_pr__cap_mim_m3_1 l=3 w=3
X2898 B10 TOP sky130_fd_pr__cap_mim_m3_1 l=3 w=3
X2899 B10 TOP sky130_fd_pr__cap_mim_m3_1 l=3 w=3
X2900 B11 TOP sky130_fd_pr__cap_mim_m3_1 l=3 w=3
X2901 B10 TOP sky130_fd_pr__cap_mim_m3_1 l=3 w=3
X2902 B8 TOP sky130_fd_pr__cap_mim_m3_1 l=3 w=3
X2903 EDGE_BIAS EDGE_BIAS sky130_fd_pr__cap_mim_m3_1 l=3 w=3
X2904 B9 TOP sky130_fd_pr__cap_mim_m3_1 l=3 w=3
X2905 B10 TOP sky130_fd_pr__cap_mim_m3_1 l=3 w=3
X2906 B11 TOP sky130_fd_pr__cap_mim_m3_1 l=3 w=3
X2907 B10 TOP sky130_fd_pr__cap_mim_m3_1 l=3 w=3
X2908 B10 TOP sky130_fd_pr__cap_mim_m3_1 l=3 w=3
X2909 B11 TOP sky130_fd_pr__cap_mim_m3_1 l=3 w=3
X2910 B10 TOP sky130_fd_pr__cap_mim_m3_1 l=3 w=3
X2911 B10 TOP sky130_fd_pr__cap_mim_m3_1 l=3 w=3
X2912 B11 TOP sky130_fd_pr__cap_mim_m3_1 l=3 w=3
X2913 B11 TOP sky130_fd_pr__cap_mim_m3_1 l=3 w=3
X2914 B11 TOP sky130_fd_pr__cap_mim_m3_1 l=3 w=3
X2915 B9 TOP sky130_fd_pr__cap_mim_m3_1 l=3 w=3
X2916 B10 TOP sky130_fd_pr__cap_mim_m3_1 l=3 w=3
X2917 B8 TOP sky130_fd_pr__cap_mim_m3_1 l=3 w=3
X2918 B11 TOP sky130_fd_pr__cap_mim_m3_1 l=3 w=3
X2919 B11 TOP sky130_fd_pr__cap_mim_m3_1 l=3 w=3
X2920 B11 TOP sky130_fd_pr__cap_mim_m3_1 l=3 w=3
X2921 B11 TOP sky130_fd_pr__cap_mim_m3_1 l=3 w=3
X2922 B9 TOP sky130_fd_pr__cap_mim_m3_1 l=3 w=3
X2923 B10 TOP sky130_fd_pr__cap_mim_m3_1 l=3 w=3
X2924 B8 TOP sky130_fd_pr__cap_mim_m3_1 l=3 w=3
X2925 B11 TOP sky130_fd_pr__cap_mim_m3_1 l=3 w=3
X2926 B11 TOP sky130_fd_pr__cap_mim_m3_1 l=3 w=3
X2927 B8 TOP sky130_fd_pr__cap_mim_m3_1 l=3 w=3
X2928 B11 TOP sky130_fd_pr__cap_mim_m3_1 l=3 w=3
X2929 B11 TOP sky130_fd_pr__cap_mim_m3_1 l=3 w=3
X2930 B11 TOP sky130_fd_pr__cap_mim_m3_1 l=3 w=3
X2931 EDGE_BIAS EDGE_BIAS sky130_fd_pr__cap_mim_m3_1 l=3 w=3
X2932 B10 TOP sky130_fd_pr__cap_mim_m3_1 l=3 w=3
X2933 B9 TOP sky130_fd_pr__cap_mim_m3_1 l=3 w=3
X2934 B9 TOP sky130_fd_pr__cap_mim_m3_1 l=3 w=3
X2935 B9 TOP sky130_fd_pr__cap_mim_m3_1 l=3 w=3
X2936 B11 TOP sky130_fd_pr__cap_mim_m3_1 l=3 w=3
X2937 B9 TOP sky130_fd_pr__cap_mim_m3_1 l=3 w=3
X2938 B5 TOP sky130_fd_pr__cap_mim_m3_1 l=3 w=3
X2939 B11 TOP sky130_fd_pr__cap_mim_m3_1 l=3 w=3
X2940 B10 TOP sky130_fd_pr__cap_mim_m3_1 l=3 w=3
X2941 B6 TOP sky130_fd_pr__cap_mim_m3_1 l=3 w=3
X2942 B11 TOP sky130_fd_pr__cap_mim_m3_1 l=3 w=3
X2943 B9 TOP sky130_fd_pr__cap_mim_m3_1 l=3 w=3
X2944 B11 TOP sky130_fd_pr__cap_mim_m3_1 l=3 w=3
X2945 B11 TOP sky130_fd_pr__cap_mim_m3_1 l=3 w=3
X2946 B11 TOP sky130_fd_pr__cap_mim_m3_1 l=3 w=3
X2947 B11 TOP sky130_fd_pr__cap_mim_m3_1 l=3 w=3
X2948 B11 TOP sky130_fd_pr__cap_mim_m3_1 l=3 w=3
X2949 B11 TOP sky130_fd_pr__cap_mim_m3_1 l=3 w=3
X2950 B10 TOP sky130_fd_pr__cap_mim_m3_1 l=3 w=3
X2951 B9 TOP sky130_fd_pr__cap_mim_m3_1 l=3 w=3
X2952 EDGE_BIAS EDGE_BIAS sky130_fd_pr__cap_mim_m3_1 l=3 w=3
X2953 B10 TOP sky130_fd_pr__cap_mim_m3_1 l=3 w=3
X2954 B11 TOP sky130_fd_pr__cap_mim_m3_1 l=3 w=3
X2955 B11 TOP sky130_fd_pr__cap_mim_m3_1 l=3 w=3
X2956 B11 TOP sky130_fd_pr__cap_mim_m3_1 l=3 w=3
X2957 B9 TOP sky130_fd_pr__cap_mim_m3_1 l=3 w=3
X2958 B10 TOP sky130_fd_pr__cap_mim_m3_1 l=3 w=3
X2959 B10 TOP sky130_fd_pr__cap_mim_m3_1 l=3 w=3
X2960 B10 TOP sky130_fd_pr__cap_mim_m3_1 l=3 w=3
X2961 B10 TOP sky130_fd_pr__cap_mim_m3_1 l=3 w=3
X2962 B10 TOP sky130_fd_pr__cap_mim_m3_1 l=3 w=3
X2963 B11 TOP sky130_fd_pr__cap_mim_m3_1 l=3 w=3
X2964 B10 TOP sky130_fd_pr__cap_mim_m3_1 l=3 w=3
X2965 B10 TOP sky130_fd_pr__cap_mim_m3_1 l=3 w=3
X2966 B11 TOP sky130_fd_pr__cap_mim_m3_1 l=3 w=3
X2967 EDGE_BIAS EDGE_BIAS sky130_fd_pr__cap_mim_m3_1 l=3 w=3
X2968 B10 TOP sky130_fd_pr__cap_mim_m3_1 l=3 w=3
X2969 B11 TOP sky130_fd_pr__cap_mim_m3_1 l=3 w=3
X2970 B10 TOP sky130_fd_pr__cap_mim_m3_1 l=3 w=3
X2971 B10 TOP sky130_fd_pr__cap_mim_m3_1 l=3 w=3
X2972 B11 TOP sky130_fd_pr__cap_mim_m3_1 l=3 w=3
X2973 B10 TOP sky130_fd_pr__cap_mim_m3_1 l=3 w=3
X2974 B10 TOP sky130_fd_pr__cap_mim_m3_1 l=3 w=3
X2975 B10 TOP sky130_fd_pr__cap_mim_m3_1 l=3 w=3
X2976 B11 TOP sky130_fd_pr__cap_mim_m3_1 l=3 w=3
X2977 B10 TOP sky130_fd_pr__cap_mim_m3_1 l=3 w=3
X2978 B10 TOP sky130_fd_pr__cap_mim_m3_1 l=3 w=3
X2979 B11 TOP sky130_fd_pr__cap_mim_m3_1 l=3 w=3
X2980 B9 TOP sky130_fd_pr__cap_mim_m3_1 l=3 w=3
X2981 B10 TOP sky130_fd_pr__cap_mim_m3_1 l=3 w=3
X2982 B8 TOP sky130_fd_pr__cap_mim_m3_1 l=3 w=3
X2983 B10 TOP sky130_fd_pr__cap_mim_m3_1 l=3 w=3
X2984 EDGE_BIAS EDGE_BIAS sky130_fd_pr__cap_mim_m3_1 l=3 w=3
X2985 B9 TOP sky130_fd_pr__cap_mim_m3_1 l=3 w=3
X2986 B7 TOP sky130_fd_pr__cap_mim_m3_1 l=3 w=3
X2987 B11 TOP sky130_fd_pr__cap_mim_m3_1 l=3 w=3
X2988 B11 TOP sky130_fd_pr__cap_mim_m3_1 l=3 w=3
X2989 B10 TOP sky130_fd_pr__cap_mim_m3_1 l=3 w=3
X2990 B9 TOP sky130_fd_pr__cap_mim_m3_1 l=3 w=3
X2991 B10 TOP sky130_fd_pr__cap_mim_m3_1 l=3 w=3
X2992 B8 TOP sky130_fd_pr__cap_mim_m3_1 l=3 w=3
X2993 B11 TOP sky130_fd_pr__cap_mim_m3_1 l=3 w=3
X2994 B11 TOP sky130_fd_pr__cap_mim_m3_1 l=3 w=3
X2995 B11 TOP sky130_fd_pr__cap_mim_m3_1 l=3 w=3
X2996 B8 TOP sky130_fd_pr__cap_mim_m3_1 l=3 w=3
X2997 B11 TOP sky130_fd_pr__cap_mim_m3_1 l=3 w=3
X2998 B9 TOP sky130_fd_pr__cap_mim_m3_1 l=3 w=3
X2999 B11 TOP sky130_fd_pr__cap_mim_m3_1 l=3 w=3
X3000 B9 TOP sky130_fd_pr__cap_mim_m3_1 l=3 w=3
X3001 B11 TOP sky130_fd_pr__cap_mim_m3_1 l=3 w=3
X3002 B6 TOP sky130_fd_pr__cap_mim_m3_1 l=3 w=3
X3003 B9 TOP sky130_fd_pr__cap_mim_m3_1 l=3 w=3
X3004 B11 TOP sky130_fd_pr__cap_mim_m3_1 l=3 w=3
X3005 B11 TOP sky130_fd_pr__cap_mim_m3_1 l=3 w=3
X3006 B10 TOP sky130_fd_pr__cap_mim_m3_1 l=3 w=3
X3007 B11 TOP sky130_fd_pr__cap_mim_m3_1 l=3 w=3
X3008 B10 TOP sky130_fd_pr__cap_mim_m3_1 l=3 w=3
X3009 B11 TOP sky130_fd_pr__cap_mim_m3_1 l=3 w=3
X3010 B9 TOP sky130_fd_pr__cap_mim_m3_1 l=3 w=3
X3011 B7 TOP sky130_fd_pr__cap_mim_m3_1 l=3 w=3
X3012 B11 TOP sky130_fd_pr__cap_mim_m3_1 l=3 w=3
X3013 EDGE_BIAS EDGE_BIAS sky130_fd_pr__cap_mim_m3_1 l=3 w=3
X3014 B11 TOP sky130_fd_pr__cap_mim_m3_1 l=3 w=3
X3015 B3 TOP sky130_fd_pr__cap_mim_m3_1 l=3 w=3
X3016 B11 TOP sky130_fd_pr__cap_mim_m3_1 l=3 w=3
X3017 B11 TOP sky130_fd_pr__cap_mim_m3_1 l=3 w=3
X3018 B9 TOP sky130_fd_pr__cap_mim_m3_1 l=3 w=3
X3019 B11 TOP sky130_fd_pr__cap_mim_m3_1 l=3 w=3
X3020 B11 TOP sky130_fd_pr__cap_mim_m3_1 l=3 w=3
X3021 B10 TOP sky130_fd_pr__cap_mim_m3_1 l=3 w=3
X3022 B10 TOP sky130_fd_pr__cap_mim_m3_1 l=3 w=3
X3023 B7 TOP sky130_fd_pr__cap_mim_m3_1 l=3 w=3
X3024 B9 TOP sky130_fd_pr__cap_mim_m3_1 l=3 w=3
X3025 B9 TOP sky130_fd_pr__cap_mim_m3_1 l=3 w=3
X3026 B11 TOP sky130_fd_pr__cap_mim_m3_1 l=3 w=3
X3027 B10 TOP sky130_fd_pr__cap_mim_m3_1 l=3 w=3
X3028 B11 TOP sky130_fd_pr__cap_mim_m3_1 l=3 w=3
X3029 B10 TOP sky130_fd_pr__cap_mim_m3_1 l=3 w=3
X3030 EDGE_BIAS EDGE_BIAS sky130_fd_pr__cap_mim_m3_1 l=3 w=3
X3031 B11 TOP sky130_fd_pr__cap_mim_m3_1 l=3 w=3
X3032 B11 TOP sky130_fd_pr__cap_mim_m3_1 l=3 w=3
X3033 B10 TOP sky130_fd_pr__cap_mim_m3_1 l=3 w=3
X3034 B11 TOP sky130_fd_pr__cap_mim_m3_1 l=3 w=3
X3035 B10 TOP sky130_fd_pr__cap_mim_m3_1 l=3 w=3
X3036 B11 TOP sky130_fd_pr__cap_mim_m3_1 l=3 w=3
X3037 B11 TOP sky130_fd_pr__cap_mim_m3_1 l=3 w=3
X3038 B10 TOP sky130_fd_pr__cap_mim_m3_1 l=3 w=3
X3039 B7 TOP sky130_fd_pr__cap_mim_m3_1 l=3 w=3
X3040 B11 TOP sky130_fd_pr__cap_mim_m3_1 l=3 w=3
X3041 B11 TOP sky130_fd_pr__cap_mim_m3_1 l=3 w=3
X3042 B9 TOP sky130_fd_pr__cap_mim_m3_1 l=3 w=3
X3043 B8 TOP sky130_fd_pr__cap_mim_m3_1 l=3 w=3
X3044 B11 TOP sky130_fd_pr__cap_mim_m3_1 l=3 w=3
X3045 B11 TOP sky130_fd_pr__cap_mim_m3_1 l=3 w=3
X3046 B11 TOP sky130_fd_pr__cap_mim_m3_1 l=3 w=3
X3047 B9 TOP sky130_fd_pr__cap_mim_m3_1 l=3 w=3
X3048 B7 TOP sky130_fd_pr__cap_mim_m3_1 l=3 w=3
X3049 B10 TOP sky130_fd_pr__cap_mim_m3_1 l=3 w=3
X3050 B11 TOP sky130_fd_pr__cap_mim_m3_1 l=3 w=3
X3051 B10 TOP sky130_fd_pr__cap_mim_m3_1 l=3 w=3
X3052 B8 TOP sky130_fd_pr__cap_mim_m3_1 l=3 w=3
X3053 B11 TOP sky130_fd_pr__cap_mim_m3_1 l=3 w=3
X3054 B8 TOP sky130_fd_pr__cap_mim_m3_1 l=3 w=3
X3055 B11 TOP sky130_fd_pr__cap_mim_m3_1 l=3 w=3
X3056 B10 TOP sky130_fd_pr__cap_mim_m3_1 l=3 w=3
X3057 B8 TOP sky130_fd_pr__cap_mim_m3_1 l=3 w=3
X3058 B6 TOP sky130_fd_pr__cap_mim_m3_1 l=3 w=3
X3059 EDGE_BIAS EDGE_BIAS sky130_fd_pr__cap_mim_m3_1 l=3 w=3
X3060 B9 TOP sky130_fd_pr__cap_mim_m3_1 l=3 w=3
X3061 B9 TOP sky130_fd_pr__cap_mim_m3_1 l=3 w=3
X3062 B11 TOP sky130_fd_pr__cap_mim_m3_1 l=3 w=3
X3063 B9 TOP sky130_fd_pr__cap_mim_m3_1 l=3 w=3
X3064 B11 TOP sky130_fd_pr__cap_mim_m3_1 l=3 w=3
X3065 B6 TOP sky130_fd_pr__cap_mim_m3_1 l=3 w=3
X3066 B11 TOP sky130_fd_pr__cap_mim_m3_1 l=3 w=3
X3067 B11 TOP sky130_fd_pr__cap_mim_m3_1 l=3 w=3
X3068 B9 TOP sky130_fd_pr__cap_mim_m3_1 l=3 w=3
X3069 EDGE_BIAS EDGE_BIAS sky130_fd_pr__cap_mim_m3_1 l=3 w=3
X3070 B11 TOP sky130_fd_pr__cap_mim_m3_1 l=3 w=3
X3071 B10 TOP sky130_fd_pr__cap_mim_m3_1 l=3 w=3
X3072 B11 TOP sky130_fd_pr__cap_mim_m3_1 l=3 w=3
X3073 B11 TOP sky130_fd_pr__cap_mim_m3_1 l=3 w=3
X3074 B11 TOP sky130_fd_pr__cap_mim_m3_1 l=3 w=3
X3075 B11 TOP sky130_fd_pr__cap_mim_m3_1 l=3 w=3
X3076 B11 TOP sky130_fd_pr__cap_mim_m3_1 l=3 w=3
X3077 B11 TOP sky130_fd_pr__cap_mim_m3_1 l=3 w=3
X3078 B10 TOP sky130_fd_pr__cap_mim_m3_1 l=3 w=3
X3079 B10 TOP sky130_fd_pr__cap_mim_m3_1 l=3 w=3
X3080 B10 TOP sky130_fd_pr__cap_mim_m3_1 l=3 w=3
X3081 B7 TOP sky130_fd_pr__cap_mim_m3_1 l=3 w=3
X3082 B11 TOP sky130_fd_pr__cap_mim_m3_1 l=3 w=3
X3083 B11 TOP sky130_fd_pr__cap_mim_m3_1 l=3 w=3
X3084 B10 TOP sky130_fd_pr__cap_mim_m3_1 l=3 w=3
X3085 B9 TOP sky130_fd_pr__cap_mim_m3_1 l=3 w=3
X3086 B10 TOP sky130_fd_pr__cap_mim_m3_1 l=3 w=3
X3087 B8 TOP sky130_fd_pr__cap_mim_m3_1 l=3 w=3
X3088 B10 TOP sky130_fd_pr__cap_mim_m3_1 l=3 w=3
X3089 B11 TOP sky130_fd_pr__cap_mim_m3_1 l=3 w=3
X3090 B10 TOP sky130_fd_pr__cap_mim_m3_1 l=3 w=3
X3091 B11 TOP sky130_fd_pr__cap_mim_m3_1 l=3 w=3
X3092 B10 TOP sky130_fd_pr__cap_mim_m3_1 l=3 w=3
X3093 B10 TOP sky130_fd_pr__cap_mim_m3_1 l=3 w=3
X3094 B11 TOP sky130_fd_pr__cap_mim_m3_1 l=3 w=3
X3095 B11 TOP sky130_fd_pr__cap_mim_m3_1 l=3 w=3
X3096 B10 TOP sky130_fd_pr__cap_mim_m3_1 l=3 w=3
X3097 B10 TOP sky130_fd_pr__cap_mim_m3_1 l=3 w=3
X3098 B11 TOP sky130_fd_pr__cap_mim_m3_1 l=3 w=3
X3099 B11 TOP sky130_fd_pr__cap_mim_m3_1 l=3 w=3
X3100 B10 TOP sky130_fd_pr__cap_mim_m3_1 l=3 w=3
X3101 B11 TOP sky130_fd_pr__cap_mim_m3_1 l=3 w=3
X3102 EDGE_BIAS EDGE_BIAS sky130_fd_pr__cap_mim_m3_1 l=3 w=3
X3103 B11 TOP sky130_fd_pr__cap_mim_m3_1 l=3 w=3
X3104 B11 TOP sky130_fd_pr__cap_mim_m3_1 l=3 w=3
X3105 B9 TOP sky130_fd_pr__cap_mim_m3_1 l=3 w=3
X3106 B10 TOP sky130_fd_pr__cap_mim_m3_1 l=3 w=3
X3107 B11 TOP sky130_fd_pr__cap_mim_m3_1 l=3 w=3
X3108 B9 TOP sky130_fd_pr__cap_mim_m3_1 l=3 w=3
X3109 B11 TOP sky130_fd_pr__cap_mim_m3_1 l=3 w=3
X3110 B11 TOP sky130_fd_pr__cap_mim_m3_1 l=3 w=3
X3111 B7 TOP sky130_fd_pr__cap_mim_m3_1 l=3 w=3
X3112 B11 TOP sky130_fd_pr__cap_mim_m3_1 l=3 w=3
X3113 EDGE_BIAS EDGE_BIAS sky130_fd_pr__cap_mim_m3_1 l=3 w=3
X3114 B8 TOP sky130_fd_pr__cap_mim_m3_1 l=3 w=3
X3115 B11 TOP sky130_fd_pr__cap_mim_m3_1 l=3 w=3
X3116 B8 TOP sky130_fd_pr__cap_mim_m3_1 l=3 w=3
X3117 B11 TOP sky130_fd_pr__cap_mim_m3_1 l=3 w=3
X3118 B11 TOP sky130_fd_pr__cap_mim_m3_1 l=3 w=3
X3119 B5 TOP sky130_fd_pr__cap_mim_m3_1 l=3 w=3
X3120 B9 TOP sky130_fd_pr__cap_mim_m3_1 l=3 w=3
X3121 B11 TOP sky130_fd_pr__cap_mim_m3_1 l=3 w=3
X3122 B10 TOP sky130_fd_pr__cap_mim_m3_1 l=3 w=3
X3123 B9 TOP sky130_fd_pr__cap_mim_m3_1 l=3 w=3
X3124 B9 TOP sky130_fd_pr__cap_mim_m3_1 l=3 w=3
X3125 B11 TOP sky130_fd_pr__cap_mim_m3_1 l=3 w=3
X3126 B11 TOP sky130_fd_pr__cap_mim_m3_1 l=3 w=3
X3127 B10 TOP sky130_fd_pr__cap_mim_m3_1 l=3 w=3
X3128 B11 TOP sky130_fd_pr__cap_mim_m3_1 l=3 w=3
X3129 B11 TOP sky130_fd_pr__cap_mim_m3_1 l=3 w=3
X3130 B10 TOP sky130_fd_pr__cap_mim_m3_1 l=3 w=3
X3131 B9 TOP sky130_fd_pr__cap_mim_m3_1 l=3 w=3
X3132 B11 TOP sky130_fd_pr__cap_mim_m3_1 l=3 w=3
X3133 B8 TOP sky130_fd_pr__cap_mim_m3_1 l=3 w=3
X3134 B9 TOP sky130_fd_pr__cap_mim_m3_1 l=3 w=3
X3135 B11 TOP sky130_fd_pr__cap_mim_m3_1 l=3 w=3
X3136 B11 TOP sky130_fd_pr__cap_mim_m3_1 l=3 w=3
X3137 B10 TOP sky130_fd_pr__cap_mim_m3_1 l=3 w=3
X3138 B10 TOP sky130_fd_pr__cap_mim_m3_1 l=3 w=3
X3139 B11 TOP sky130_fd_pr__cap_mim_m3_1 l=3 w=3
X3140 B10 TOP sky130_fd_pr__cap_mim_m3_1 l=3 w=3
X3141 B11 TOP sky130_fd_pr__cap_mim_m3_1 l=3 w=3
X3142 B11 TOP sky130_fd_pr__cap_mim_m3_1 l=3 w=3
X3143 B9 TOP sky130_fd_pr__cap_mim_m3_1 l=3 w=3
X3144 B8 TOP sky130_fd_pr__cap_mim_m3_1 l=3 w=3
X3145 B10 TOP sky130_fd_pr__cap_mim_m3_1 l=3 w=3
X3146 B10 TOP sky130_fd_pr__cap_mim_m3_1 l=3 w=3
X3147 B11 TOP sky130_fd_pr__cap_mim_m3_1 l=3 w=3
X3148 B7 TOP sky130_fd_pr__cap_mim_m3_1 l=3 w=3
X3149 B9 TOP sky130_fd_pr__cap_mim_m3_1 l=3 w=3
X3150 B10 TOP sky130_fd_pr__cap_mim_m3_1 l=3 w=3
X3151 B11 TOP sky130_fd_pr__cap_mim_m3_1 l=3 w=3
X3152 B10 TOP sky130_fd_pr__cap_mim_m3_1 l=3 w=3
X3153 B11 TOP sky130_fd_pr__cap_mim_m3_1 l=3 w=3
X3154 B10 TOP sky130_fd_pr__cap_mim_m3_1 l=3 w=3
X3155 B8 TOP sky130_fd_pr__cap_mim_m3_1 l=3 w=3
X3156 B10 TOP sky130_fd_pr__cap_mim_m3_1 l=3 w=3
X3157 B11 TOP sky130_fd_pr__cap_mim_m3_1 l=3 w=3
X3158 B11 TOP sky130_fd_pr__cap_mim_m3_1 l=3 w=3
X3159 B10 TOP sky130_fd_pr__cap_mim_m3_1 l=3 w=3
X3160 B8 TOP sky130_fd_pr__cap_mim_m3_1 l=3 w=3
X3161 B10 TOP sky130_fd_pr__cap_mim_m3_1 l=3 w=3
X3162 B11 TOP sky130_fd_pr__cap_mim_m3_1 l=3 w=3
X3163 B10 TOP sky130_fd_pr__cap_mim_m3_1 l=3 w=3
X3164 B9 TOP sky130_fd_pr__cap_mim_m3_1 l=3 w=3
X3165 B10 TOP sky130_fd_pr__cap_mim_m3_1 l=3 w=3
X3166 B10 TOP sky130_fd_pr__cap_mim_m3_1 l=3 w=3
X3167 B9 TOP sky130_fd_pr__cap_mim_m3_1 l=3 w=3
X3168 B8 TOP sky130_fd_pr__cap_mim_m3_1 l=3 w=3
X3169 B10 TOP sky130_fd_pr__cap_mim_m3_1 l=3 w=3
X3170 B11 TOP sky130_fd_pr__cap_mim_m3_1 l=3 w=3
X3171 B10 TOP sky130_fd_pr__cap_mim_m3_1 l=3 w=3
X3172 B11 TOP sky130_fd_pr__cap_mim_m3_1 l=3 w=3
X3173 B11 TOP sky130_fd_pr__cap_mim_m3_1 l=3 w=3
X3174 B9 TOP sky130_fd_pr__cap_mim_m3_1 l=3 w=3
X3175 B7 TOP sky130_fd_pr__cap_mim_m3_1 l=3 w=3
X3176 EDGE_BIAS EDGE_BIAS sky130_fd_pr__cap_mim_m3_1 l=3 w=3
X3177 B11 TOP sky130_fd_pr__cap_mim_m3_1 l=3 w=3
X3178 B11 TOP sky130_fd_pr__cap_mim_m3_1 l=3 w=3
X3179 B10 TOP sky130_fd_pr__cap_mim_m3_1 l=3 w=3
X3180 B10 TOP sky130_fd_pr__cap_mim_m3_1 l=3 w=3
X3181 B11 TOP sky130_fd_pr__cap_mim_m3_1 l=3 w=3
X3182 B8 TOP sky130_fd_pr__cap_mim_m3_1 l=3 w=3
X3183 B6 TOP sky130_fd_pr__cap_mim_m3_1 l=3 w=3
X3184 B4 TOP sky130_fd_pr__cap_mim_m3_1 l=3 w=3
X3185 B9 TOP sky130_fd_pr__cap_mim_m3_1 l=3 w=3
X3186 B11 TOP sky130_fd_pr__cap_mim_m3_1 l=3 w=3
X3187 B10 TOP sky130_fd_pr__cap_mim_m3_1 l=3 w=3
X3188 B9 TOP sky130_fd_pr__cap_mim_m3_1 l=3 w=3
X3189 B11 TOP sky130_fd_pr__cap_mim_m3_1 l=3 w=3
X3190 B6 TOP sky130_fd_pr__cap_mim_m3_1 l=3 w=3
X3191 B11 TOP sky130_fd_pr__cap_mim_m3_1 l=3 w=3
X3192 B10 TOP sky130_fd_pr__cap_mim_m3_1 l=3 w=3
X3193 B9 TOP sky130_fd_pr__cap_mim_m3_1 l=3 w=3
X3194 B8 TOP sky130_fd_pr__cap_mim_m3_1 l=3 w=3
X3195 B10 TOP sky130_fd_pr__cap_mim_m3_1 l=3 w=3
X3196 B11 TOP sky130_fd_pr__cap_mim_m3_1 l=3 w=3
X3197 B11 TOP sky130_fd_pr__cap_mim_m3_1 l=3 w=3
X3198 B11 TOP sky130_fd_pr__cap_mim_m3_1 l=3 w=3
X3199 EDGE_BIAS EDGE_BIAS sky130_fd_pr__cap_mim_m3_1 l=3 w=3
X3200 EDGE_BIAS EDGE_BIAS sky130_fd_pr__cap_mim_m3_1 l=3 w=3
X3201 EDGE_BIAS EDGE_BIAS sky130_fd_pr__cap_mim_m3_1 l=3 w=3
X3202 B11 TOP sky130_fd_pr__cap_mim_m3_1 l=3 w=3
X3203 B11 TOP sky130_fd_pr__cap_mim_m3_1 l=3 w=3
X3204 B11 TOP sky130_fd_pr__cap_mim_m3_1 l=3 w=3
X3205 B9 TOP sky130_fd_pr__cap_mim_m3_1 l=3 w=3
X3206 B11 TOP sky130_fd_pr__cap_mim_m3_1 l=3 w=3
X3207 B11 TOP sky130_fd_pr__cap_mim_m3_1 l=3 w=3
X3208 B10 TOP sky130_fd_pr__cap_mim_m3_1 l=3 w=3
X3209 B10 TOP sky130_fd_pr__cap_mim_m3_1 l=3 w=3
X3210 B7 TOP sky130_fd_pr__cap_mim_m3_1 l=3 w=3
X3211 EDGE_BIAS EDGE_BIAS sky130_fd_pr__cap_mim_m3_1 l=3 w=3
X3212 B11 TOP sky130_fd_pr__cap_mim_m3_1 l=3 w=3
X3213 B9 TOP sky130_fd_pr__cap_mim_m3_1 l=3 w=3
X3214 B10 TOP sky130_fd_pr__cap_mim_m3_1 l=3 w=3
X3215 B8 TOP sky130_fd_pr__cap_mim_m3_1 l=3 w=3
X3216 B8 TOP sky130_fd_pr__cap_mim_m3_1 l=3 w=3
X3217 B10 TOP sky130_fd_pr__cap_mim_m3_1 l=3 w=3
X3218 B11 TOP sky130_fd_pr__cap_mim_m3_1 l=3 w=3
X3219 B10 TOP sky130_fd_pr__cap_mim_m3_1 l=3 w=3
X3220 B8 TOP sky130_fd_pr__cap_mim_m3_1 l=3 w=3
X3221 EDGE_BIAS EDGE_BIAS sky130_fd_pr__cap_mim_m3_1 l=3 w=3
X3222 B11 TOP sky130_fd_pr__cap_mim_m3_1 l=3 w=3
X3223 B11 TOP sky130_fd_pr__cap_mim_m3_1 l=3 w=3
X3224 B10 TOP sky130_fd_pr__cap_mim_m3_1 l=3 w=3
X3225 B11 TOP sky130_fd_pr__cap_mim_m3_1 l=3 w=3
X3226 B11 TOP sky130_fd_pr__cap_mim_m3_1 l=3 w=3
X3227 B10 TOP sky130_fd_pr__cap_mim_m3_1 l=3 w=3
X3228 B9 TOP sky130_fd_pr__cap_mim_m3_1 l=3 w=3
X3229 B11 TOP sky130_fd_pr__cap_mim_m3_1 l=3 w=3
X3230 B4 TOP sky130_fd_pr__cap_mim_m3_1 l=3 w=3
X3231 B11 TOP sky130_fd_pr__cap_mim_m3_1 l=3 w=3
X3232 B11 TOP sky130_fd_pr__cap_mim_m3_1 l=3 w=3
X3233 B10 TOP sky130_fd_pr__cap_mim_m3_1 l=3 w=3
X3234 B10 TOP sky130_fd_pr__cap_mim_m3_1 l=3 w=3
X3235 B9 TOP sky130_fd_pr__cap_mim_m3_1 l=3 w=3
X3236 B11 TOP sky130_fd_pr__cap_mim_m3_1 l=3 w=3
X3237 B7 TOP sky130_fd_pr__cap_mim_m3_1 l=3 w=3
X3238 EDGE_BIAS EDGE_BIAS sky130_fd_pr__cap_mim_m3_1 l=3 w=3
X3239 B10 TOP sky130_fd_pr__cap_mim_m3_1 l=3 w=3
X3240 B8 TOP sky130_fd_pr__cap_mim_m3_1 l=3 w=3
X3241 B8 TOP sky130_fd_pr__cap_mim_m3_1 l=3 w=3
X3242 B11 TOP sky130_fd_pr__cap_mim_m3_1 l=3 w=3
X3243 B8 TOP sky130_fd_pr__cap_mim_m3_1 l=3 w=3
X3244 B6 TOP sky130_fd_pr__cap_mim_m3_1 l=3 w=3
X3245 B10 TOP sky130_fd_pr__cap_mim_m3_1 l=3 w=3
X3246 B10 TOP sky130_fd_pr__cap_mim_m3_1 l=3 w=3
X3247 B10 TOP sky130_fd_pr__cap_mim_m3_1 l=3 w=3
X3248 B9 TOP sky130_fd_pr__cap_mim_m3_1 l=3 w=3
X3249 B9 TOP sky130_fd_pr__cap_mim_m3_1 l=3 w=3
X3250 B11 TOP sky130_fd_pr__cap_mim_m3_1 l=3 w=3
X3251 B9 TOP sky130_fd_pr__cap_mim_m3_1 l=3 w=3
X3252 B11 TOP sky130_fd_pr__cap_mim_m3_1 l=3 w=3
X3253 B11 TOP sky130_fd_pr__cap_mim_m3_1 l=3 w=3
X3254 B11 TOP sky130_fd_pr__cap_mim_m3_1 l=3 w=3
X3255 EDGE_BIAS EDGE_BIAS sky130_fd_pr__cap_mim_m3_1 l=3 w=3
X3256 B10 TOP sky130_fd_pr__cap_mim_m3_1 l=3 w=3
X3257 B11 TOP sky130_fd_pr__cap_mim_m3_1 l=3 w=3
X3258 B9 TOP sky130_fd_pr__cap_mim_m3_1 l=3 w=3
X3259 B11 TOP sky130_fd_pr__cap_mim_m3_1 l=3 w=3
X3260 B11 TOP sky130_fd_pr__cap_mim_m3_1 l=3 w=3
X3261 B11 TOP sky130_fd_pr__cap_mim_m3_1 l=3 w=3
X3262 B11 TOP sky130_fd_pr__cap_mim_m3_1 l=3 w=3
X3263 B10 TOP sky130_fd_pr__cap_mim_m3_1 l=3 w=3
X3264 B11 TOP sky130_fd_pr__cap_mim_m3_1 l=3 w=3
X3265 B11 TOP sky130_fd_pr__cap_mim_m3_1 l=3 w=3
X3266 B10 TOP sky130_fd_pr__cap_mim_m3_1 l=3 w=3
X3267 B11 TOP sky130_fd_pr__cap_mim_m3_1 l=3 w=3
X3268 B11 TOP sky130_fd_pr__cap_mim_m3_1 l=3 w=3
X3269 B11 TOP sky130_fd_pr__cap_mim_m3_1 l=3 w=3
X3270 EDGE_BIAS EDGE_BIAS sky130_fd_pr__cap_mim_m3_1 l=3 w=3
X3271 B9 TOP sky130_fd_pr__cap_mim_m3_1 l=3 w=3
X3272 B6 TOP sky130_fd_pr__cap_mim_m3_1 l=3 w=3
X3273 B7 TOP sky130_fd_pr__cap_mim_m3_1 l=3 w=3
X3274 B11 TOP sky130_fd_pr__cap_mim_m3_1 l=3 w=3
X3275 B11 TOP sky130_fd_pr__cap_mim_m3_1 l=3 w=3
X3276 B9 TOP sky130_fd_pr__cap_mim_m3_1 l=3 w=3
X3277 B9 TOP sky130_fd_pr__cap_mim_m3_1 l=3 w=3
X3278 B11 TOP sky130_fd_pr__cap_mim_m3_1 l=3 w=3
X3279 B11 TOP sky130_fd_pr__cap_mim_m3_1 l=3 w=3
X3280 B11 TOP sky130_fd_pr__cap_mim_m3_1 l=3 w=3
X3281 B10 TOP sky130_fd_pr__cap_mim_m3_1 l=3 w=3
X3282 B10 TOP sky130_fd_pr__cap_mim_m3_1 l=3 w=3
X3283 B8 TOP sky130_fd_pr__cap_mim_m3_1 l=3 w=3
X3284 B9 TOP sky130_fd_pr__cap_mim_m3_1 l=3 w=3
X3285 B9 TOP sky130_fd_pr__cap_mim_m3_1 l=3 w=3
X3286 B11 TOP sky130_fd_pr__cap_mim_m3_1 l=3 w=3
X3287 B11 TOP sky130_fd_pr__cap_mim_m3_1 l=3 w=3
X3288 B10 TOP sky130_fd_pr__cap_mim_m3_1 l=3 w=3
X3289 B11 TOP sky130_fd_pr__cap_mim_m3_1 l=3 w=3
X3290 B11 TOP sky130_fd_pr__cap_mim_m3_1 l=3 w=3
X3291 B10 TOP sky130_fd_pr__cap_mim_m3_1 l=3 w=3
X3292 EDGE_BIAS EDGE_BIAS sky130_fd_pr__cap_mim_m3_1 l=3 w=3
X3293 B11 TOP sky130_fd_pr__cap_mim_m3_1 l=3 w=3
X3294 B10 TOP sky130_fd_pr__cap_mim_m3_1 l=3 w=3
X3295 B11 TOP sky130_fd_pr__cap_mim_m3_1 l=3 w=3
X3296 B10 TOP sky130_fd_pr__cap_mim_m3_1 l=3 w=3
X3297 B11 TOP sky130_fd_pr__cap_mim_m3_1 l=3 w=3
X3298 B10 TOP sky130_fd_pr__cap_mim_m3_1 l=3 w=3
X3299 B10 TOP sky130_fd_pr__cap_mim_m3_1 l=3 w=3
X3300 B11 TOP sky130_fd_pr__cap_mim_m3_1 l=3 w=3
X3301 B11 TOP sky130_fd_pr__cap_mim_m3_1 l=3 w=3
X3302 B5 TOP sky130_fd_pr__cap_mim_m3_1 l=3 w=3
X3303 B11 TOP sky130_fd_pr__cap_mim_m3_1 l=3 w=3
X3304 B10 TOP sky130_fd_pr__cap_mim_m3_1 l=3 w=3
X3305 B8 TOP sky130_fd_pr__cap_mim_m3_1 l=3 w=3
X3306 B11 TOP sky130_fd_pr__cap_mim_m3_1 l=3 w=3
X3307 EDGE_BIAS EDGE_BIAS sky130_fd_pr__cap_mim_m3_1 l=3 w=3
X3308 B11 TOP sky130_fd_pr__cap_mim_m3_1 l=3 w=3
X3309 B10 TOP sky130_fd_pr__cap_mim_m3_1 l=3 w=3
X3310 B10 TOP sky130_fd_pr__cap_mim_m3_1 l=3 w=3
X3311 B10 TOP sky130_fd_pr__cap_mim_m3_1 l=3 w=3
X3312 B11 TOP sky130_fd_pr__cap_mim_m3_1 l=3 w=3
X3313 B8 TOP sky130_fd_pr__cap_mim_m3_1 l=3 w=3
X3314 B11 TOP sky130_fd_pr__cap_mim_m3_1 l=3 w=3
X3315 B10 TOP sky130_fd_pr__cap_mim_m3_1 l=3 w=3
X3316 B10 TOP sky130_fd_pr__cap_mim_m3_1 l=3 w=3
X3317 B11 TOP sky130_fd_pr__cap_mim_m3_1 l=3 w=3
X3318 B5 TOP sky130_fd_pr__cap_mim_m3_1 l=3 w=3
X3319 B10 TOP sky130_fd_pr__cap_mim_m3_1 l=3 w=3
X3320 B9 TOP sky130_fd_pr__cap_mim_m3_1 l=3 w=3
X3321 B11 TOP sky130_fd_pr__cap_mim_m3_1 l=3 w=3
X3322 B11 TOP sky130_fd_pr__cap_mim_m3_1 l=3 w=3
X3323 B11 TOP sky130_fd_pr__cap_mim_m3_1 l=3 w=3
X3324 EDGE_BIAS EDGE_BIAS sky130_fd_pr__cap_mim_m3_1 l=3 w=3
X3325 B9 TOP sky130_fd_pr__cap_mim_m3_1 l=3 w=3
X3326 B10 TOP sky130_fd_pr__cap_mim_m3_1 l=3 w=3
X3327 B10 TOP sky130_fd_pr__cap_mim_m3_1 l=3 w=3
X3328 EDGE_BIAS EDGE_BIAS sky130_fd_pr__cap_mim_m3_1 l=3 w=3
X3329 B9 TOP sky130_fd_pr__cap_mim_m3_1 l=3 w=3
X3330 B7 TOP sky130_fd_pr__cap_mim_m3_1 l=3 w=3
X3331 B11 TOP sky130_fd_pr__cap_mim_m3_1 l=3 w=3
X3332 B11 TOP sky130_fd_pr__cap_mim_m3_1 l=3 w=3
X3333 B10 TOP sky130_fd_pr__cap_mim_m3_1 l=3 w=3
X3334 B11 TOP sky130_fd_pr__cap_mim_m3_1 l=3 w=3
X3335 B11 TOP sky130_fd_pr__cap_mim_m3_1 l=3 w=3
X3336 B9 TOP sky130_fd_pr__cap_mim_m3_1 l=3 w=3
X3337 B11 TOP sky130_fd_pr__cap_mim_m3_1 l=3 w=3
X3338 B11 TOP sky130_fd_pr__cap_mim_m3_1 l=3 w=3
X3339 B10 TOP sky130_fd_pr__cap_mim_m3_1 l=3 w=3
X3340 B10 TOP sky130_fd_pr__cap_mim_m3_1 l=3 w=3
X3341 B10 TOP sky130_fd_pr__cap_mim_m3_1 l=3 w=3
X3342 EDGE_BIAS EDGE_BIAS sky130_fd_pr__cap_mim_m3_1 l=3 w=3
X3343 B11 TOP sky130_fd_pr__cap_mim_m3_1 l=3 w=3
X3344 B9 TOP sky130_fd_pr__cap_mim_m3_1 l=3 w=3
X3345 B9 TOP sky130_fd_pr__cap_mim_m3_1 l=3 w=3
X3346 B8 TOP sky130_fd_pr__cap_mim_m3_1 l=3 w=3
X3347 B9 TOP sky130_fd_pr__cap_mim_m3_1 l=3 w=3
X3348 B10 TOP sky130_fd_pr__cap_mim_m3_1 l=3 w=3
X3349 B8 TOP sky130_fd_pr__cap_mim_m3_1 l=3 w=3
X3350 B11 TOP sky130_fd_pr__cap_mim_m3_1 l=3 w=3
X3351 B10 TOP sky130_fd_pr__cap_mim_m3_1 l=3 w=3
X3352 B11 TOP sky130_fd_pr__cap_mim_m3_1 l=3 w=3
X3353 B9 TOP sky130_fd_pr__cap_mim_m3_1 l=3 w=3
X3354 B11 TOP sky130_fd_pr__cap_mim_m3_1 l=3 w=3
X3355 B10 TOP sky130_fd_pr__cap_mim_m3_1 l=3 w=3
X3356 B8 TOP sky130_fd_pr__cap_mim_m3_1 l=3 w=3
X3357 B11 TOP sky130_fd_pr__cap_mim_m3_1 l=3 w=3
X3358 B11 TOP sky130_fd_pr__cap_mim_m3_1 l=3 w=3
X3359 B10 TOP sky130_fd_pr__cap_mim_m3_1 l=3 w=3
X3360 B11 TOP sky130_fd_pr__cap_mim_m3_1 l=3 w=3
X3361 B7 TOP sky130_fd_pr__cap_mim_m3_1 l=3 w=3
X3362 B10 TOP sky130_fd_pr__cap_mim_m3_1 l=3 w=3
X3363 B10 TOP sky130_fd_pr__cap_mim_m3_1 l=3 w=3
X3364 B11 TOP sky130_fd_pr__cap_mim_m3_1 l=3 w=3
X3365 B11 TOP sky130_fd_pr__cap_mim_m3_1 l=3 w=3
X3366 B11 TOP sky130_fd_pr__cap_mim_m3_1 l=3 w=3
X3367 B10 TOP sky130_fd_pr__cap_mim_m3_1 l=3 w=3
X3368 B11 TOP sky130_fd_pr__cap_mim_m3_1 l=3 w=3
X3369 B10 TOP sky130_fd_pr__cap_mim_m3_1 l=3 w=3
X3370 B7 TOP sky130_fd_pr__cap_mim_m3_1 l=3 w=3
X3371 B11 TOP sky130_fd_pr__cap_mim_m3_1 l=3 w=3
X3372 B9 TOP sky130_fd_pr__cap_mim_m3_1 l=3 w=3
X3373 B11 TOP sky130_fd_pr__cap_mim_m3_1 l=3 w=3
X3374 B10 TOP sky130_fd_pr__cap_mim_m3_1 l=3 w=3
X3375 B10 TOP sky130_fd_pr__cap_mim_m3_1 l=3 w=3
X3376 B11 TOP sky130_fd_pr__cap_mim_m3_1 l=3 w=3
X3377 B11 TOP sky130_fd_pr__cap_mim_m3_1 l=3 w=3
X3378 B8 TOP sky130_fd_pr__cap_mim_m3_1 l=3 w=3
X3379 B6 TOP sky130_fd_pr__cap_mim_m3_1 l=3 w=3
X3380 B2 TOP sky130_fd_pr__cap_mim_m3_1 l=3 w=3
X3381 B10 TOP sky130_fd_pr__cap_mim_m3_1 l=3 w=3
X3382 B9 TOP sky130_fd_pr__cap_mim_m3_1 l=3 w=3
X3383 B10 TOP sky130_fd_pr__cap_mim_m3_1 l=3 w=3
X3384 B9 TOP sky130_fd_pr__cap_mim_m3_1 l=3 w=3
X3385 B11 TOP sky130_fd_pr__cap_mim_m3_1 l=3 w=3
X3386 B11 TOP sky130_fd_pr__cap_mim_m3_1 l=3 w=3
X3387 B10 TOP sky130_fd_pr__cap_mim_m3_1 l=3 w=3
X3388 B9 TOP sky130_fd_pr__cap_mim_m3_1 l=3 w=3
X3389 B10 TOP sky130_fd_pr__cap_mim_m3_1 l=3 w=3
X3390 B11 TOP sky130_fd_pr__cap_mim_m3_1 l=3 w=3
X3391 B11 TOP sky130_fd_pr__cap_mim_m3_1 l=3 w=3
X3392 B11 TOP sky130_fd_pr__cap_mim_m3_1 l=3 w=3
X3393 B10 TOP sky130_fd_pr__cap_mim_m3_1 l=3 w=3
X3394 B11 TOP sky130_fd_pr__cap_mim_m3_1 l=3 w=3
X3395 B9 TOP sky130_fd_pr__cap_mim_m3_1 l=3 w=3
X3396 B11 TOP sky130_fd_pr__cap_mim_m3_1 l=3 w=3
X3397 B7 TOP sky130_fd_pr__cap_mim_m3_1 l=3 w=3
X3398 B9 TOP sky130_fd_pr__cap_mim_m3_1 l=3 w=3
X3399 B9 TOP sky130_fd_pr__cap_mim_m3_1 l=3 w=3
X3400 B11 TOP sky130_fd_pr__cap_mim_m3_1 l=3 w=3
X3401 B8 TOP sky130_fd_pr__cap_mim_m3_1 l=3 w=3
X3402 B9 TOP sky130_fd_pr__cap_mim_m3_1 l=3 w=3
X3403 B10 TOP sky130_fd_pr__cap_mim_m3_1 l=3 w=3
X3404 B8 TOP sky130_fd_pr__cap_mim_m3_1 l=3 w=3
X3405 B8 TOP sky130_fd_pr__cap_mim_m3_1 l=3 w=3
X3406 B10 TOP sky130_fd_pr__cap_mim_m3_1 l=3 w=3
X3407 B10 TOP sky130_fd_pr__cap_mim_m3_1 l=3 w=3
X3408 B7 TOP sky130_fd_pr__cap_mim_m3_1 l=3 w=3
X3409 B11 TOP sky130_fd_pr__cap_mim_m3_1 l=3 w=3
X3410 B11 TOP sky130_fd_pr__cap_mim_m3_1 l=3 w=3
X3411 B10 TOP sky130_fd_pr__cap_mim_m3_1 l=3 w=3
X3412 B10 TOP sky130_fd_pr__cap_mim_m3_1 l=3 w=3
X3413 B8 TOP sky130_fd_pr__cap_mim_m3_1 l=3 w=3
X3414 B11 TOP sky130_fd_pr__cap_mim_m3_1 l=3 w=3
X3415 B11 TOP sky130_fd_pr__cap_mim_m3_1 l=3 w=3
X3416 B11 TOP sky130_fd_pr__cap_mim_m3_1 l=3 w=3
X3417 B11 TOP sky130_fd_pr__cap_mim_m3_1 l=3 w=3
X3418 B10 TOP sky130_fd_pr__cap_mim_m3_1 l=3 w=3
X3419 B9 TOP sky130_fd_pr__cap_mim_m3_1 l=3 w=3
X3420 B11 TOP sky130_fd_pr__cap_mim_m3_1 l=3 w=3
X3421 EDGE_BIAS EDGE_BIAS sky130_fd_pr__cap_mim_m3_1 l=3 w=3
X3422 B11 TOP sky130_fd_pr__cap_mim_m3_1 l=3 w=3
X3423 B11 TOP sky130_fd_pr__cap_mim_m3_1 l=3 w=3
X3424 B9 TOP sky130_fd_pr__cap_mim_m3_1 l=3 w=3
X3425 B5 TOP sky130_fd_pr__cap_mim_m3_1 l=3 w=3
X3426 B11 TOP sky130_fd_pr__cap_mim_m3_1 l=3 w=3
X3427 B11 TOP sky130_fd_pr__cap_mim_m3_1 l=3 w=3
X3428 B11 TOP sky130_fd_pr__cap_mim_m3_1 l=3 w=3
X3429 B11 TOP sky130_fd_pr__cap_mim_m3_1 l=3 w=3
X3430 B10 TOP sky130_fd_pr__cap_mim_m3_1 l=3 w=3
X3431 B10 TOP sky130_fd_pr__cap_mim_m3_1 l=3 w=3
X3432 B11 TOP sky130_fd_pr__cap_mim_m3_1 l=3 w=3
X3433 B5 TOP sky130_fd_pr__cap_mim_m3_1 l=3 w=3
X3434 B11 TOP sky130_fd_pr__cap_mim_m3_1 l=3 w=3
X3435 B10 TOP sky130_fd_pr__cap_mim_m3_1 l=3 w=3
X3436 B10 TOP sky130_fd_pr__cap_mim_m3_1 l=3 w=3
X3437 B9 TOP sky130_fd_pr__cap_mim_m3_1 l=3 w=3
X3438 B11 TOP sky130_fd_pr__cap_mim_m3_1 l=3 w=3
X3439 B7 TOP sky130_fd_pr__cap_mim_m3_1 l=3 w=3
X3440 EDGE_BIAS EDGE_BIAS sky130_fd_pr__cap_mim_m3_1 l=3 w=3
X3441 B11 TOP sky130_fd_pr__cap_mim_m3_1 l=3 w=3
X3442 B10 TOP sky130_fd_pr__cap_mim_m3_1 l=3 w=3
X3443 B11 TOP sky130_fd_pr__cap_mim_m3_1 l=3 w=3
X3444 B10 TOP sky130_fd_pr__cap_mim_m3_1 l=3 w=3
X3445 B9 TOP sky130_fd_pr__cap_mim_m3_1 l=3 w=3
X3446 B10 TOP sky130_fd_pr__cap_mim_m3_1 l=3 w=3
X3447 B11 TOP sky130_fd_pr__cap_mim_m3_1 l=3 w=3
X3448 B11 TOP sky130_fd_pr__cap_mim_m3_1 l=3 w=3
X3449 B10 TOP sky130_fd_pr__cap_mim_m3_1 l=3 w=3
X3450 B11 TOP sky130_fd_pr__cap_mim_m3_1 l=3 w=3
X3451 B11 TOP sky130_fd_pr__cap_mim_m3_1 l=3 w=3
X3452 B10 TOP sky130_fd_pr__cap_mim_m3_1 l=3 w=3
X3453 B11 TOP sky130_fd_pr__cap_mim_m3_1 l=3 w=3
X3454 B11 TOP sky130_fd_pr__cap_mim_m3_1 l=3 w=3
X3455 B11 TOP sky130_fd_pr__cap_mim_m3_1 l=3 w=3
X3456 B7 TOP sky130_fd_pr__cap_mim_m3_1 l=3 w=3
X3457 B11 TOP sky130_fd_pr__cap_mim_m3_1 l=3 w=3
X3458 B11 TOP sky130_fd_pr__cap_mim_m3_1 l=3 w=3
X3459 B11 TOP sky130_fd_pr__cap_mim_m3_1 l=3 w=3
X3460 B9 TOP sky130_fd_pr__cap_mim_m3_1 l=3 w=3
X3461 B9 TOP sky130_fd_pr__cap_mim_m3_1 l=3 w=3
X3462 B8 TOP sky130_fd_pr__cap_mim_m3_1 l=3 w=3
X3463 B10 TOP sky130_fd_pr__cap_mim_m3_1 l=3 w=3
X3464 B9 TOP sky130_fd_pr__cap_mim_m3_1 l=3 w=3
X3465 B11 TOP sky130_fd_pr__cap_mim_m3_1 l=3 w=3
X3466 B11 TOP sky130_fd_pr__cap_mim_m3_1 l=3 w=3
X3467 B11 TOP sky130_fd_pr__cap_mim_m3_1 l=3 w=3
X3468 EDGE_BIAS EDGE_BIAS sky130_fd_pr__cap_mim_m3_1 l=3 w=3
X3469 B10 TOP sky130_fd_pr__cap_mim_m3_1 l=3 w=3
X3470 B8 TOP sky130_fd_pr__cap_mim_m3_1 l=3 w=3
X3471 B8 TOP sky130_fd_pr__cap_mim_m3_1 l=3 w=3
X3472 B11 TOP sky130_fd_pr__cap_mim_m3_1 l=3 w=3
X3473 B10 TOP sky130_fd_pr__cap_mim_m3_1 l=3 w=3
X3474 B10 TOP sky130_fd_pr__cap_mim_m3_1 l=3 w=3
X3475 B9 TOP sky130_fd_pr__cap_mim_m3_1 l=3 w=3
X3476 B11 TOP sky130_fd_pr__cap_mim_m3_1 l=3 w=3
X3477 B9 TOP sky130_fd_pr__cap_mim_m3_1 l=3 w=3
X3478 B11 TOP sky130_fd_pr__cap_mim_m3_1 l=3 w=3
X3479 B11 TOP sky130_fd_pr__cap_mim_m3_1 l=3 w=3
X3480 B10 TOP sky130_fd_pr__cap_mim_m3_1 l=3 w=3
X3481 B11 TOP sky130_fd_pr__cap_mim_m3_1 l=3 w=3
X3482 B11 TOP sky130_fd_pr__cap_mim_m3_1 l=3 w=3
X3483 B6 TOP sky130_fd_pr__cap_mim_m3_1 l=3 w=3
X3484 B9 TOP sky130_fd_pr__cap_mim_m3_1 l=3 w=3
X3485 B11 TOP sky130_fd_pr__cap_mim_m3_1 l=3 w=3
X3486 B10 TOP sky130_fd_pr__cap_mim_m3_1 l=3 w=3
X3487 B11 TOP sky130_fd_pr__cap_mim_m3_1 l=3 w=3
X3488 B11 TOP sky130_fd_pr__cap_mim_m3_1 l=3 w=3
X3489 B11 TOP sky130_fd_pr__cap_mim_m3_1 l=3 w=3
X3490 B11 TOP sky130_fd_pr__cap_mim_m3_1 l=3 w=3
X3491 B10 TOP sky130_fd_pr__cap_mim_m3_1 l=3 w=3
X3492 B11 TOP sky130_fd_pr__cap_mim_m3_1 l=3 w=3
X3493 B9 TOP sky130_fd_pr__cap_mim_m3_1 l=3 w=3
X3494 B11 TOP sky130_fd_pr__cap_mim_m3_1 l=3 w=3
X3495 B10 TOP sky130_fd_pr__cap_mim_m3_1 l=3 w=3
X3496 B10 TOP sky130_fd_pr__cap_mim_m3_1 l=3 w=3
X3497 B10 TOP sky130_fd_pr__cap_mim_m3_1 l=3 w=3
X3498 B10 TOP sky130_fd_pr__cap_mim_m3_1 l=3 w=3
X3499 B11 TOP sky130_fd_pr__cap_mim_m3_1 l=3 w=3
X3500 B8 TOP sky130_fd_pr__cap_mim_m3_1 l=3 w=3
X3501 B4 TOP sky130_fd_pr__cap_mim_m3_1 l=3 w=3
X3502 B10 TOP sky130_fd_pr__cap_mim_m3_1 l=3 w=3
X3503 B11 TOP sky130_fd_pr__cap_mim_m3_1 l=3 w=3
X3504 B10 TOP sky130_fd_pr__cap_mim_m3_1 l=3 w=3
X3505 B9 TOP sky130_fd_pr__cap_mim_m3_1 l=3 w=3
X3506 B11 TOP sky130_fd_pr__cap_mim_m3_1 l=3 w=3
X3507 EDGE_BIAS EDGE_BIAS sky130_fd_pr__cap_mim_m3_1 l=3 w=3
X3508 B11 TOP sky130_fd_pr__cap_mim_m3_1 l=3 w=3
X3509 B10 TOP sky130_fd_pr__cap_mim_m3_1 l=3 w=3
X3510 B9 TOP sky130_fd_pr__cap_mim_m3_1 l=3 w=3
X3511 B10 TOP sky130_fd_pr__cap_mim_m3_1 l=3 w=3
X3512 B11 TOP sky130_fd_pr__cap_mim_m3_1 l=3 w=3
X3513 B10 TOP sky130_fd_pr__cap_mim_m3_1 l=3 w=3
X3514 B10 TOP sky130_fd_pr__cap_mim_m3_1 l=3 w=3
X3515 B11 TOP sky130_fd_pr__cap_mim_m3_1 l=3 w=3
X3516 B11 TOP sky130_fd_pr__cap_mim_m3_1 l=3 w=3
X3517 B11 TOP sky130_fd_pr__cap_mim_m3_1 l=3 w=3
X3518 B10 TOP sky130_fd_pr__cap_mim_m3_1 l=3 w=3
X3519 B11 TOP sky130_fd_pr__cap_mim_m3_1 l=3 w=3
X3520 B10 TOP sky130_fd_pr__cap_mim_m3_1 l=3 w=3
X3521 B10 TOP sky130_fd_pr__cap_mim_m3_1 l=3 w=3
X3522 B11 TOP sky130_fd_pr__cap_mim_m3_1 l=3 w=3
X3523 B9 TOP sky130_fd_pr__cap_mim_m3_1 l=3 w=3
X3524 B9 TOP sky130_fd_pr__cap_mim_m3_1 l=3 w=3
X3525 B10 TOP sky130_fd_pr__cap_mim_m3_1 l=3 w=3
X3526 B11 TOP sky130_fd_pr__cap_mim_m3_1 l=3 w=3
X3527 B11 TOP sky130_fd_pr__cap_mim_m3_1 l=3 w=3
X3528 B9 TOP sky130_fd_pr__cap_mim_m3_1 l=3 w=3
X3529 B11 TOP sky130_fd_pr__cap_mim_m3_1 l=3 w=3
X3530 B10 TOP sky130_fd_pr__cap_mim_m3_1 l=3 w=3
X3531 B11 TOP sky130_fd_pr__cap_mim_m3_1 l=3 w=3
X3532 B9 TOP sky130_fd_pr__cap_mim_m3_1 l=3 w=3
X3533 B8 TOP sky130_fd_pr__cap_mim_m3_1 l=3 w=3
X3534 B9 TOP sky130_fd_pr__cap_mim_m3_1 l=3 w=3
X3535 B10 TOP sky130_fd_pr__cap_mim_m3_1 l=3 w=3
X3536 B8 TOP sky130_fd_pr__cap_mim_m3_1 l=3 w=3
X3537 B10 TOP sky130_fd_pr__cap_mim_m3_1 l=3 w=3
X3538 B11 TOP sky130_fd_pr__cap_mim_m3_1 l=3 w=3
X3539 B11 TOP sky130_fd_pr__cap_mim_m3_1 l=3 w=3
X3540 B11 TOP sky130_fd_pr__cap_mim_m3_1 l=3 w=3
X3541 B9 TOP sky130_fd_pr__cap_mim_m3_1 l=3 w=3
X3542 B11 TOP sky130_fd_pr__cap_mim_m3_1 l=3 w=3
X3543 B10 TOP sky130_fd_pr__cap_mim_m3_1 l=3 w=3
X3544 B8 TOP sky130_fd_pr__cap_mim_m3_1 l=3 w=3
X3545 B11 TOP sky130_fd_pr__cap_mim_m3_1 l=3 w=3
X3546 B11 TOP sky130_fd_pr__cap_mim_m3_1 l=3 w=3
X3547 B11 TOP sky130_fd_pr__cap_mim_m3_1 l=3 w=3
X3548 B10 TOP sky130_fd_pr__cap_mim_m3_1 l=3 w=3
X3549 B8 TOP sky130_fd_pr__cap_mim_m3_1 l=3 w=3
X3550 B11 TOP sky130_fd_pr__cap_mim_m3_1 l=3 w=3
X3551 B9 TOP sky130_fd_pr__cap_mim_m3_1 l=3 w=3
X3552 B11 TOP sky130_fd_pr__cap_mim_m3_1 l=3 w=3
X3553 B4 TOP sky130_fd_pr__cap_mim_m3_1 l=3 w=3
X3554 B10 TOP sky130_fd_pr__cap_mim_m3_1 l=3 w=3
X3555 B10 TOP sky130_fd_pr__cap_mim_m3_1 l=3 w=3
X3556 B8 TOP sky130_fd_pr__cap_mim_m3_1 l=3 w=3
X3557 B11 TOP sky130_fd_pr__cap_mim_m3_1 l=3 w=3
X3558 B11 TOP sky130_fd_pr__cap_mim_m3_1 l=3 w=3
X3559 EDGE_BIAS EDGE_BIAS sky130_fd_pr__cap_mim_m3_1 l=3 w=3
X3560 B11 TOP sky130_fd_pr__cap_mim_m3_1 l=3 w=3
X3561 B7 TOP sky130_fd_pr__cap_mim_m3_1 l=3 w=3
X3562 B11 TOP sky130_fd_pr__cap_mim_m3_1 l=3 w=3
X3563 B11 TOP sky130_fd_pr__cap_mim_m3_1 l=3 w=3
X3564 B10 TOP sky130_fd_pr__cap_mim_m3_1 l=3 w=3
X3565 B9 TOP sky130_fd_pr__cap_mim_m3_1 l=3 w=3
X3566 B10 TOP sky130_fd_pr__cap_mim_m3_1 l=3 w=3
X3567 B8 TOP sky130_fd_pr__cap_mim_m3_1 l=3 w=3
X3568 B11 TOP sky130_fd_pr__cap_mim_m3_1 l=3 w=3
X3569 B9 TOP sky130_fd_pr__cap_mim_m3_1 l=3 w=3
X3570 EDGE_BIAS EDGE_BIAS sky130_fd_pr__cap_mim_m3_1 l=3 w=3
X3571 B5 TOP sky130_fd_pr__cap_mim_m3_1 l=3 w=3
X3572 B10 TOP sky130_fd_pr__cap_mim_m3_1 l=3 w=3
X3573 B10 TOP sky130_fd_pr__cap_mim_m3_1 l=3 w=3
X3574 EDGE_BIAS EDGE_BIAS sky130_fd_pr__cap_mim_m3_1 l=3 w=3
X3575 B11 TOP sky130_fd_pr__cap_mim_m3_1 l=3 w=3
X3576 B11 TOP sky130_fd_pr__cap_mim_m3_1 l=3 w=3
X3577 B10 TOP sky130_fd_pr__cap_mim_m3_1 l=3 w=3
X3578 B10 TOP sky130_fd_pr__cap_mim_m3_1 l=3 w=3
X3579 B11 TOP sky130_fd_pr__cap_mim_m3_1 l=3 w=3
X3580 B10 TOP sky130_fd_pr__cap_mim_m3_1 l=3 w=3
X3581 B10 TOP sky130_fd_pr__cap_mim_m3_1 l=3 w=3
X3582 B11 TOP sky130_fd_pr__cap_mim_m3_1 l=3 w=3
X3583 B11 TOP sky130_fd_pr__cap_mim_m3_1 l=3 w=3
X3584 B11 TOP sky130_fd_pr__cap_mim_m3_1 l=3 w=3
X3585 B10 TOP sky130_fd_pr__cap_mim_m3_1 l=3 w=3
X3586 B11 TOP sky130_fd_pr__cap_mim_m3_1 l=3 w=3
X3587 B11 TOP sky130_fd_pr__cap_mim_m3_1 l=3 w=3
X3588 B11 TOP sky130_fd_pr__cap_mim_m3_1 l=3 w=3
X3589 B7 TOP sky130_fd_pr__cap_mim_m3_1 l=3 w=3
X3590 B11 TOP sky130_fd_pr__cap_mim_m3_1 l=3 w=3
X3591 B11 TOP sky130_fd_pr__cap_mim_m3_1 l=3 w=3
X3592 B11 TOP sky130_fd_pr__cap_mim_m3_1 l=3 w=3
X3593 B9 TOP sky130_fd_pr__cap_mim_m3_1 l=3 w=3
X3594 B9 TOP sky130_fd_pr__cap_mim_m3_1 l=3 w=3
X3595 B8 TOP sky130_fd_pr__cap_mim_m3_1 l=3 w=3
X3596 B8 TOP sky130_fd_pr__cap_mim_m3_1 l=3 w=3
X3597 B9 TOP sky130_fd_pr__cap_mim_m3_1 l=3 w=3
X3598 B10 TOP sky130_fd_pr__cap_mim_m3_1 l=3 w=3
X3599 B11 TOP sky130_fd_pr__cap_mim_m3_1 l=3 w=3
X3600 B10 TOP sky130_fd_pr__cap_mim_m3_1 l=3 w=3
X3601 B9 TOP sky130_fd_pr__cap_mim_m3_1 l=3 w=3
X3602 EDGE_BIAS EDGE_BIAS sky130_fd_pr__cap_mim_m3_1 l=3 w=3
X3603 B11 TOP sky130_fd_pr__cap_mim_m3_1 l=3 w=3
X3604 B11 TOP sky130_fd_pr__cap_mim_m3_1 l=3 w=3
X3605 B10 TOP sky130_fd_pr__cap_mim_m3_1 l=3 w=3
X3606 B9 TOP sky130_fd_pr__cap_mim_m3_1 l=3 w=3
X3607 B7 TOP sky130_fd_pr__cap_mim_m3_1 l=3 w=3
X3608 B10 TOP sky130_fd_pr__cap_mim_m3_1 l=3 w=3
X3609 B8 TOP sky130_fd_pr__cap_mim_m3_1 l=3 w=3
X3610 B11 TOP sky130_fd_pr__cap_mim_m3_1 l=3 w=3
X3611 B8 TOP sky130_fd_pr__cap_mim_m3_1 l=3 w=3
X3612 B11 TOP sky130_fd_pr__cap_mim_m3_1 l=3 w=3
X3613 B11 TOP sky130_fd_pr__cap_mim_m3_1 l=3 w=3
X3614 B11 TOP sky130_fd_pr__cap_mim_m3_1 l=3 w=3
X3615 B11 TOP sky130_fd_pr__cap_mim_m3_1 l=3 w=3
X3616 B11 TOP sky130_fd_pr__cap_mim_m3_1 l=3 w=3
X3617 B9 TOP sky130_fd_pr__cap_mim_m3_1 l=3 w=3
X3618 B9 TOP sky130_fd_pr__cap_mim_m3_1 l=3 w=3
X3619 B11 TOP sky130_fd_pr__cap_mim_m3_1 l=3 w=3
X3620 B11 TOP sky130_fd_pr__cap_mim_m3_1 l=3 w=3
X3621 B11 TOP sky130_fd_pr__cap_mim_m3_1 l=3 w=3
X3622 B5 TOP sky130_fd_pr__cap_mim_m3_1 l=3 w=3
X3623 B11 TOP sky130_fd_pr__cap_mim_m3_1 l=3 w=3
X3624 B11 TOP sky130_fd_pr__cap_mim_m3_1 l=3 w=3
X3625 B11 TOP sky130_fd_pr__cap_mim_m3_1 l=3 w=3
X3626 B11 TOP sky130_fd_pr__cap_mim_m3_1 l=3 w=3
X3627 B11 TOP sky130_fd_pr__cap_mim_m3_1 l=3 w=3
X3628 B11 TOP sky130_fd_pr__cap_mim_m3_1 l=3 w=3
X3629 B10 TOP sky130_fd_pr__cap_mim_m3_1 l=3 w=3
X3630 B11 TOP sky130_fd_pr__cap_mim_m3_1 l=3 w=3
X3631 B10 TOP sky130_fd_pr__cap_mim_m3_1 l=3 w=3
X3632 B4 TOP sky130_fd_pr__cap_mim_m3_1 l=3 w=3
X3633 B11 TOP sky130_fd_pr__cap_mim_m3_1 l=3 w=3
X3634 B10 TOP sky130_fd_pr__cap_mim_m3_1 l=3 w=3
X3635 EDGE_BIAS EDGE_BIAS sky130_fd_pr__cap_mim_m3_1 l=3 w=3
X3636 B11 TOP sky130_fd_pr__cap_mim_m3_1 l=3 w=3
X3637 B10 TOP sky130_fd_pr__cap_mim_m3_1 l=3 w=3
X3638 B7 TOP sky130_fd_pr__cap_mim_m3_1 l=3 w=3
X3639 B11 TOP sky130_fd_pr__cap_mim_m3_1 l=3 w=3
X3640 B10 TOP sky130_fd_pr__cap_mim_m3_1 l=3 w=3
X3641 B9 TOP sky130_fd_pr__cap_mim_m3_1 l=3 w=3
X3642 B3 TOP sky130_fd_pr__cap_mim_m3_1 l=3 w=3
X3643 B10 TOP sky130_fd_pr__cap_mim_m3_1 l=3 w=3
X3644 B10 TOP sky130_fd_pr__cap_mim_m3_1 l=3 w=3
X3645 B10 TOP sky130_fd_pr__cap_mim_m3_1 l=3 w=3
X3646 B10 TOP sky130_fd_pr__cap_mim_m3_1 l=3 w=3
X3647 B11 TOP sky130_fd_pr__cap_mim_m3_1 l=3 w=3
X3648 B11 TOP sky130_fd_pr__cap_mim_m3_1 l=3 w=3
X3649 B11 TOP sky130_fd_pr__cap_mim_m3_1 l=3 w=3
X3650 B11 TOP sky130_fd_pr__cap_mim_m3_1 l=3 w=3
X3651 B11 TOP sky130_fd_pr__cap_mim_m3_1 l=3 w=3
X3652 B11 TOP sky130_fd_pr__cap_mim_m3_1 l=3 w=3
X3653 B10 TOP sky130_fd_pr__cap_mim_m3_1 l=3 w=3
X3654 B11 TOP sky130_fd_pr__cap_mim_m3_1 l=3 w=3
X3655 B10 TOP sky130_fd_pr__cap_mim_m3_1 l=3 w=3
X3656 B11 TOP sky130_fd_pr__cap_mim_m3_1 l=3 w=3
X3657 B11 TOP sky130_fd_pr__cap_mim_m3_1 l=3 w=3
X3658 EDGE_BIAS EDGE_BIAS sky130_fd_pr__cap_mim_m3_1 l=3 w=3
X3659 B11 TOP sky130_fd_pr__cap_mim_m3_1 l=3 w=3
X3660 B11 TOP sky130_fd_pr__cap_mim_m3_1 l=3 w=3
X3661 B10 TOP sky130_fd_pr__cap_mim_m3_1 l=3 w=3
X3662 B11 TOP sky130_fd_pr__cap_mim_m3_1 l=3 w=3
X3663 B9 TOP sky130_fd_pr__cap_mim_m3_1 l=3 w=3
X3664 B9 TOP sky130_fd_pr__cap_mim_m3_1 l=3 w=3
X3665 EDGE_BIAS EDGE_BIAS sky130_fd_pr__cap_mim_m3_1 l=3 w=3
X3666 B8 TOP sky130_fd_pr__cap_mim_m3_1 l=3 w=3
X3667 B8 TOP sky130_fd_pr__cap_mim_m3_1 l=3 w=3
X3668 B11 TOP sky130_fd_pr__cap_mim_m3_1 l=3 w=3
X3669 B9 TOP sky130_fd_pr__cap_mim_m3_1 l=3 w=3
X3670 B7 TOP sky130_fd_pr__cap_mim_m3_1 l=3 w=3
X3671 B11 TOP sky130_fd_pr__cap_mim_m3_1 l=3 w=3
X3672 B10 TOP sky130_fd_pr__cap_mim_m3_1 l=3 w=3
X3673 B8 TOP sky130_fd_pr__cap_mim_m3_1 l=3 w=3
X3674 B11 TOP sky130_fd_pr__cap_mim_m3_1 l=3 w=3
X3675 B11 TOP sky130_fd_pr__cap_mim_m3_1 l=3 w=3
X3676 B8 TOP sky130_fd_pr__cap_mim_m3_1 l=3 w=3
X3677 B10 TOP sky130_fd_pr__cap_mim_m3_1 l=3 w=3
X3678 B11 TOP sky130_fd_pr__cap_mim_m3_1 l=3 w=3
X3679 B11 TOP sky130_fd_pr__cap_mim_m3_1 l=3 w=3
X3680 B6 TOP sky130_fd_pr__cap_mim_m3_1 l=3 w=3
X3681 B11 TOP sky130_fd_pr__cap_mim_m3_1 l=3 w=3
X3682 B9 TOP sky130_fd_pr__cap_mim_m3_1 l=3 w=3
X3683 B11 TOP sky130_fd_pr__cap_mim_m3_1 l=3 w=3
X3684 B8 TOP sky130_fd_pr__cap_mim_m3_1 l=3 w=3
X3685 B11 TOP sky130_fd_pr__cap_mim_m3_1 l=3 w=3
X3686 B11 TOP sky130_fd_pr__cap_mim_m3_1 l=3 w=3
X3687 B6 TOP sky130_fd_pr__cap_mim_m3_1 l=3 w=3
X3688 B11 TOP sky130_fd_pr__cap_mim_m3_1 l=3 w=3
X3689 B11 TOP sky130_fd_pr__cap_mim_m3_1 l=3 w=3
X3690 B11 TOP sky130_fd_pr__cap_mim_m3_1 l=3 w=3
X3691 B10 TOP sky130_fd_pr__cap_mim_m3_1 l=3 w=3
X3692 B9 TOP sky130_fd_pr__cap_mim_m3_1 l=3 w=3
X3693 B10 TOP sky130_fd_pr__cap_mim_m3_1 l=3 w=3
X3694 B11 TOP sky130_fd_pr__cap_mim_m3_1 l=3 w=3
X3695 B11 TOP sky130_fd_pr__cap_mim_m3_1 l=3 w=3
X3696 B11 TOP sky130_fd_pr__cap_mim_m3_1 l=3 w=3
X3697 B10 TOP sky130_fd_pr__cap_mim_m3_1 l=3 w=3
X3698 B9 TOP sky130_fd_pr__cap_mim_m3_1 l=3 w=3
X3699 B9 TOP sky130_fd_pr__cap_mim_m3_1 l=3 w=3
X3700 B11 TOP sky130_fd_pr__cap_mim_m3_1 l=3 w=3
X3701 B11 TOP sky130_fd_pr__cap_mim_m3_1 l=3 w=3
X3702 B10 TOP sky130_fd_pr__cap_mim_m3_1 l=3 w=3
X3703 EDGE_BIAS EDGE_BIAS sky130_fd_pr__cap_mim_m3_1 l=3 w=3
X3704 B10 TOP sky130_fd_pr__cap_mim_m3_1 l=3 w=3
X3705 B11 TOP sky130_fd_pr__cap_mim_m3_1 l=3 w=3
X3706 B11 TOP sky130_fd_pr__cap_mim_m3_1 l=3 w=3
X3707 B10 TOP sky130_fd_pr__cap_mim_m3_1 l=3 w=3
X3708 B10 TOP sky130_fd_pr__cap_mim_m3_1 l=3 w=3
X3709 B10 TOP sky130_fd_pr__cap_mim_m3_1 l=3 w=3
X3710 B7 TOP sky130_fd_pr__cap_mim_m3_1 l=3 w=3
X3711 B11 TOP sky130_fd_pr__cap_mim_m3_1 l=3 w=3
X3712 B11 TOP sky130_fd_pr__cap_mim_m3_1 l=3 w=3
X3713 B10 TOP sky130_fd_pr__cap_mim_m3_1 l=3 w=3
X3714 B10 TOP sky130_fd_pr__cap_mim_m3_1 l=3 w=3
X3715 B10 TOP sky130_fd_pr__cap_mim_m3_1 l=3 w=3
X3716 B8 TOP sky130_fd_pr__cap_mim_m3_1 l=3 w=3
X3717 B11 TOP sky130_fd_pr__cap_mim_m3_1 l=3 w=3
X3718 B9 TOP sky130_fd_pr__cap_mim_m3_1 l=3 w=3
X3719 B11 TOP sky130_fd_pr__cap_mim_m3_1 l=3 w=3
X3720 EDGE_BIAS EDGE_BIAS sky130_fd_pr__cap_mim_m3_1 l=3 w=3
X3721 B10 TOP sky130_fd_pr__cap_mim_m3_1 l=3 w=3
X3722 B10 TOP sky130_fd_pr__cap_mim_m3_1 l=3 w=3
X3723 B10 TOP sky130_fd_pr__cap_mim_m3_1 l=3 w=3
X3724 B9 TOP sky130_fd_pr__cap_mim_m3_1 l=3 w=3
X3725 B10 TOP sky130_fd_pr__cap_mim_m3_1 l=3 w=3
X3726 B10 TOP sky130_fd_pr__cap_mim_m3_1 l=3 w=3
X3727 B10 TOP sky130_fd_pr__cap_mim_m3_1 l=3 w=3
X3728 B10 TOP sky130_fd_pr__cap_mim_m3_1 l=3 w=3
X3729 B11 TOP sky130_fd_pr__cap_mim_m3_1 l=3 w=3
X3730 B11 TOP sky130_fd_pr__cap_mim_m3_1 l=3 w=3
X3731 B9 TOP sky130_fd_pr__cap_mim_m3_1 l=3 w=3
X3732 B8 TOP sky130_fd_pr__cap_mim_m3_1 l=3 w=3
X3733 B9 TOP sky130_fd_pr__cap_mim_m3_1 l=3 w=3
X3734 B10 TOP sky130_fd_pr__cap_mim_m3_1 l=3 w=3
X3735 EDGE_BIAS EDGE_BIAS sky130_fd_pr__cap_mim_m3_1 l=3 w=3
X3736 B10 TOP sky130_fd_pr__cap_mim_m3_1 l=3 w=3
X3737 B11 TOP sky130_fd_pr__cap_mim_m3_1 l=3 w=3
X3738 B11 TOP sky130_fd_pr__cap_mim_m3_1 l=3 w=3
X3739 B9 TOP sky130_fd_pr__cap_mim_m3_1 l=3 w=3
X3740 B7 TOP sky130_fd_pr__cap_mim_m3_1 l=3 w=3
X3741 B7 TOP sky130_fd_pr__cap_mim_m3_1 l=3 w=3
X3742 B11 TOP sky130_fd_pr__cap_mim_m3_1 l=3 w=3
X3743 B10 TOP sky130_fd_pr__cap_mim_m3_1 l=3 w=3
X3744 B8 TOP sky130_fd_pr__cap_mim_m3_1 l=3 w=3
X3745 B11 TOP sky130_fd_pr__cap_mim_m3_1 l=3 w=3
X3746 B11 TOP sky130_fd_pr__cap_mim_m3_1 l=3 w=3
X3747 B8 TOP sky130_fd_pr__cap_mim_m3_1 l=3 w=3
X3748 B11 TOP sky130_fd_pr__cap_mim_m3_1 l=3 w=3
X3749 B6 TOP sky130_fd_pr__cap_mim_m3_1 l=3 w=3
X3750 B10 TOP sky130_fd_pr__cap_mim_m3_1 l=3 w=3
X3751 B9 TOP sky130_fd_pr__cap_mim_m3_1 l=3 w=3
X3752 B9 TOP sky130_fd_pr__cap_mim_m3_1 l=3 w=3
X3753 B11 TOP sky130_fd_pr__cap_mim_m3_1 l=3 w=3
X3754 B9 TOP sky130_fd_pr__cap_mim_m3_1 l=3 w=3
X3755 B5 TOP sky130_fd_pr__cap_mim_m3_1 l=3 w=3
X3756 B11 TOP sky130_fd_pr__cap_mim_m3_1 l=3 w=3
X3757 B10 TOP sky130_fd_pr__cap_mim_m3_1 l=3 w=3
X3758 B11 TOP sky130_fd_pr__cap_mim_m3_1 l=3 w=3
X3759 B11 TOP sky130_fd_pr__cap_mim_m3_1 l=3 w=3
X3760 B11 TOP sky130_fd_pr__cap_mim_m3_1 l=3 w=3
X3761 B9 TOP sky130_fd_pr__cap_mim_m3_1 l=3 w=3
X3762 B11 TOP sky130_fd_pr__cap_mim_m3_1 l=3 w=3
X3763 B11 TOP sky130_fd_pr__cap_mim_m3_1 l=3 w=3
X3764 B11 TOP sky130_fd_pr__cap_mim_m3_1 l=3 w=3
X3765 B10 TOP sky130_fd_pr__cap_mim_m3_1 l=3 w=3
X3766 B0 TOP sky130_fd_pr__cap_mim_m3_1 l=3 w=3
X3767 EDGE_BIAS EDGE_BIAS sky130_fd_pr__cap_mim_m3_1 l=3 w=3
X3768 B10 TOP sky130_fd_pr__cap_mim_m3_1 l=3 w=3
X3769 B11 TOP sky130_fd_pr__cap_mim_m3_1 l=3 w=3
X3770 B9 TOP sky130_fd_pr__cap_mim_m3_1 l=3 w=3
X3771 EDGE_BIAS EDGE_BIAS sky130_fd_pr__cap_mim_m3_1 l=3 w=3
X3772 EDGE_BIAS EDGE_BIAS sky130_fd_pr__cap_mim_m3_1 l=3 w=3
X3773 B10 TOP sky130_fd_pr__cap_mim_m3_1 l=3 w=3
X3774 B6 TOP sky130_fd_pr__cap_mim_m3_1 l=3 w=3
X3775 B7 TOP sky130_fd_pr__cap_mim_m3_1 l=3 w=3
X3776 B10 TOP sky130_fd_pr__cap_mim_m3_1 l=3 w=3
X3777 B10 TOP sky130_fd_pr__cap_mim_m3_1 l=3 w=3
X3778 B7 TOP sky130_fd_pr__cap_mim_m3_1 l=3 w=3
X3779 B11 TOP sky130_fd_pr__cap_mim_m3_1 l=3 w=3
X3780 B10 TOP sky130_fd_pr__cap_mim_m3_1 l=3 w=3
X3781 B10 TOP sky130_fd_pr__cap_mim_m3_1 l=3 w=3
X3782 B8 TOP sky130_fd_pr__cap_mim_m3_1 l=3 w=3
X3783 B10 TOP sky130_fd_pr__cap_mim_m3_1 l=3 w=3
X3784 B11 TOP sky130_fd_pr__cap_mim_m3_1 l=3 w=3
X3785 B11 TOP sky130_fd_pr__cap_mim_m3_1 l=3 w=3
X3786 B10 TOP sky130_fd_pr__cap_mim_m3_1 l=3 w=3
X3787 B11 TOP sky130_fd_pr__cap_mim_m3_1 l=3 w=3
X3788 B11 TOP sky130_fd_pr__cap_mim_m3_1 l=3 w=3
X3789 B11 TOP sky130_fd_pr__cap_mim_m3_1 l=3 w=3
X3790 B10 TOP sky130_fd_pr__cap_mim_m3_1 l=3 w=3
X3791 EDGE_BIAS EDGE_BIAS sky130_fd_pr__cap_mim_m3_1 l=3 w=3
X3792 B9 TOP sky130_fd_pr__cap_mim_m3_1 l=3 w=3
X3793 B9 TOP sky130_fd_pr__cap_mim_m3_1 l=3 w=3
X3794 B8 TOP sky130_fd_pr__cap_mim_m3_1 l=3 w=3
X3795 B10 TOP sky130_fd_pr__cap_mim_m3_1 l=3 w=3
X3796 EDGE_BIAS EDGE_BIAS sky130_fd_pr__cap_mim_m3_1 l=3 w=3
X3797 B9 TOP sky130_fd_pr__cap_mim_m3_1 l=3 w=3
X3798 B9 TOP sky130_fd_pr__cap_mim_m3_1 l=3 w=3
X3799 B7 TOP sky130_fd_pr__cap_mim_m3_1 l=3 w=3
X3800 B8 TOP sky130_fd_pr__cap_mim_m3_1 l=3 w=3
X3801 B11 TOP sky130_fd_pr__cap_mim_m3_1 l=3 w=3
X3802 B11 TOP sky130_fd_pr__cap_mim_m3_1 l=3 w=3
X3803 B11 TOP sky130_fd_pr__cap_mim_m3_1 l=3 w=3
X3804 B10 TOP sky130_fd_pr__cap_mim_m3_1 l=3 w=3
X3805 B8 TOP sky130_fd_pr__cap_mim_m3_1 l=3 w=3
X3806 B11 TOP sky130_fd_pr__cap_mim_m3_1 l=3 w=3
X3807 B11 TOP sky130_fd_pr__cap_mim_m3_1 l=3 w=3
X3808 B8 TOP sky130_fd_pr__cap_mim_m3_1 l=3 w=3
X3809 B11 TOP sky130_fd_pr__cap_mim_m3_1 l=3 w=3
X3810 B9 TOP sky130_fd_pr__cap_mim_m3_1 l=3 w=3
X3811 B11 TOP sky130_fd_pr__cap_mim_m3_1 l=3 w=3
X3812 B10 TOP sky130_fd_pr__cap_mim_m3_1 l=3 w=3
X3813 B11 TOP sky130_fd_pr__cap_mim_m3_1 l=3 w=3
X3814 B11 TOP sky130_fd_pr__cap_mim_m3_1 l=3 w=3
X3815 B9 TOP sky130_fd_pr__cap_mim_m3_1 l=3 w=3
X3816 B11 TOP sky130_fd_pr__cap_mim_m3_1 l=3 w=3
X3817 B6 TOP sky130_fd_pr__cap_mim_m3_1 l=3 w=3
X3818 B11 TOP sky130_fd_pr__cap_mim_m3_1 l=3 w=3
X3819 B11 TOP sky130_fd_pr__cap_mim_m3_1 l=3 w=3
X3820 B11 TOP sky130_fd_pr__cap_mim_m3_1 l=3 w=3
X3821 B11 TOP sky130_fd_pr__cap_mim_m3_1 l=3 w=3
X3822 B10 TOP sky130_fd_pr__cap_mim_m3_1 l=3 w=3
X3823 B11 TOP sky130_fd_pr__cap_mim_m3_1 l=3 w=3
X3824 B9 TOP sky130_fd_pr__cap_mim_m3_1 l=3 w=3
X3825 B7 TOP sky130_fd_pr__cap_mim_m3_1 l=3 w=3
X3826 EDGE_BIAS EDGE_BIAS sky130_fd_pr__cap_mim_m3_1 l=3 w=3
X3827 B11 TOP sky130_fd_pr__cap_mim_m3_1 l=3 w=3
X3828 B11 TOP sky130_fd_pr__cap_mim_m3_1 l=3 w=3
X3829 B11 TOP sky130_fd_pr__cap_mim_m3_1 l=3 w=3
X3830 B11 TOP sky130_fd_pr__cap_mim_m3_1 l=3 w=3
X3831 B9 TOP sky130_fd_pr__cap_mim_m3_1 l=3 w=3
X3832 B11 TOP sky130_fd_pr__cap_mim_m3_1 l=3 w=3
X3833 B10 TOP sky130_fd_pr__cap_mim_m3_1 l=3 w=3
X3834 B10 TOP sky130_fd_pr__cap_mim_m3_1 l=3 w=3
X3835 B10 TOP sky130_fd_pr__cap_mim_m3_1 l=3 w=3
X3836 B7 TOP sky130_fd_pr__cap_mim_m3_1 l=3 w=3
X3837 B9 TOP sky130_fd_pr__cap_mim_m3_1 l=3 w=3
X3838 B10 TOP sky130_fd_pr__cap_mim_m3_1 l=3 w=3
X3839 B11 TOP sky130_fd_pr__cap_mim_m3_1 l=3 w=3
X3840 B9 TOP sky130_fd_pr__cap_mim_m3_1 l=3 w=3
X3841 B11 TOP sky130_fd_pr__cap_mim_m3_1 l=3 w=3
X3842 B11 TOP sky130_fd_pr__cap_mim_m3_1 l=3 w=3
X3843 B10 TOP sky130_fd_pr__cap_mim_m3_1 l=3 w=3
X3844 EDGE_BIAS EDGE_BIAS sky130_fd_pr__cap_mim_m3_1 l=3 w=3
X3845 B10 TOP sky130_fd_pr__cap_mim_m3_1 l=3 w=3
X3846 B11 TOP sky130_fd_pr__cap_mim_m3_1 l=3 w=3
X3847 B11 TOP sky130_fd_pr__cap_mim_m3_1 l=3 w=3
X3848 B11 TOP sky130_fd_pr__cap_mim_m3_1 l=3 w=3
X3849 B10 TOP sky130_fd_pr__cap_mim_m3_1 l=3 w=3
X3850 B10 TOP sky130_fd_pr__cap_mim_m3_1 l=3 w=3
X3851 B11 TOP sky130_fd_pr__cap_mim_m3_1 l=3 w=3
X3852 B10 TOP sky130_fd_pr__cap_mim_m3_1 l=3 w=3
X3853 B11 TOP sky130_fd_pr__cap_mim_m3_1 l=3 w=3
X3854 B11 TOP sky130_fd_pr__cap_mim_m3_1 l=3 w=3
X3855 B10 TOP sky130_fd_pr__cap_mim_m3_1 l=3 w=3
X3856 B11 TOP sky130_fd_pr__cap_mim_m3_1 l=3 w=3
X3857 B7 TOP sky130_fd_pr__cap_mim_m3_1 l=3 w=3
X3858 B11 TOP sky130_fd_pr__cap_mim_m3_1 l=3 w=3
X3859 EDGE_BIAS EDGE_BIAS sky130_fd_pr__cap_mim_m3_1 l=3 w=3
X3860 B9 TOP sky130_fd_pr__cap_mim_m3_1 l=3 w=3
X3861 B11 TOP sky130_fd_pr__cap_mim_m3_1 l=3 w=3
X3862 B10 TOP sky130_fd_pr__cap_mim_m3_1 l=3 w=3
X3863 B11 TOP sky130_fd_pr__cap_mim_m3_1 l=3 w=3
X3864 B10 TOP sky130_fd_pr__cap_mim_m3_1 l=3 w=3
X3865 B11 TOP sky130_fd_pr__cap_mim_m3_1 l=3 w=3
X3866 B11 TOP sky130_fd_pr__cap_mim_m3_1 l=3 w=3
X3867 B9 TOP sky130_fd_pr__cap_mim_m3_1 l=3 w=3
X3868 B7 TOP sky130_fd_pr__cap_mim_m3_1 l=3 w=3
X3869 B10 TOP sky130_fd_pr__cap_mim_m3_1 l=3 w=3
X3870 B10 TOP sky130_fd_pr__cap_mim_m3_1 l=3 w=3
X3871 B11 TOP sky130_fd_pr__cap_mim_m3_1 l=3 w=3
X3872 B10 TOP sky130_fd_pr__cap_mim_m3_1 l=3 w=3
X3873 B8 TOP sky130_fd_pr__cap_mim_m3_1 l=3 w=3
X3874 B11 TOP sky130_fd_pr__cap_mim_m3_1 l=3 w=3
X3875 B10 TOP sky130_fd_pr__cap_mim_m3_1 l=3 w=3
X3876 B6 TOP sky130_fd_pr__cap_mim_m3_1 l=3 w=3
X3877 B11 TOP sky130_fd_pr__cap_mim_m3_1 l=3 w=3
X3878 EDGE_BIAS EDGE_BIAS sky130_fd_pr__cap_mim_m3_1 l=3 w=3
X3879 B9 TOP sky130_fd_pr__cap_mim_m3_1 l=3 w=3
X3880 B9 TOP sky130_fd_pr__cap_mim_m3_1 l=3 w=3
X3881 B11 TOP sky130_fd_pr__cap_mim_m3_1 l=3 w=3
X3882 B11 TOP sky130_fd_pr__cap_mim_m3_1 l=3 w=3
X3883 B9 TOP sky130_fd_pr__cap_mim_m3_1 l=3 w=3
X3884 B11 TOP sky130_fd_pr__cap_mim_m3_1 l=3 w=3
X3885 B8 TOP sky130_fd_pr__cap_mim_m3_1 l=3 w=3
X3886 B6 TOP sky130_fd_pr__cap_mim_m3_1 l=3 w=3
X3887 B11 TOP sky130_fd_pr__cap_mim_m3_1 l=3 w=3
X3888 B9 TOP sky130_fd_pr__cap_mim_m3_1 l=3 w=3
X3889 B11 TOP sky130_fd_pr__cap_mim_m3_1 l=3 w=3
X3890 B9 TOP sky130_fd_pr__cap_mim_m3_1 l=3 w=3
X3891 B10 TOP sky130_fd_pr__cap_mim_m3_1 l=3 w=3
X3892 B11 TOP sky130_fd_pr__cap_mim_m3_1 l=3 w=3
X3893 B11 TOP sky130_fd_pr__cap_mim_m3_1 l=3 w=3
X3894 B11 TOP sky130_fd_pr__cap_mim_m3_1 l=3 w=3
X3895 B11 TOP sky130_fd_pr__cap_mim_m3_1 l=3 w=3
X3896 B10 TOP sky130_fd_pr__cap_mim_m3_1 l=3 w=3
X3897 B11 TOP sky130_fd_pr__cap_mim_m3_1 l=3 w=3
X3898 B10 TOP sky130_fd_pr__cap_mim_m3_1 l=3 w=3
X3899 B9 TOP sky130_fd_pr__cap_mim_m3_1 l=3 w=3
X3900 B9 TOP sky130_fd_pr__cap_mim_m3_1 l=3 w=3
X3901 EDGE_BIAS EDGE_BIAS sky130_fd_pr__cap_mim_m3_1 l=3 w=3
X3902 B10 TOP sky130_fd_pr__cap_mim_m3_1 l=3 w=3
X3903 B10 TOP sky130_fd_pr__cap_mim_m3_1 l=3 w=3
X3904 B10 TOP sky130_fd_pr__cap_mim_m3_1 l=3 w=3
X3905 B7 TOP sky130_fd_pr__cap_mim_m3_1 l=3 w=3
X3906 B11 TOP sky130_fd_pr__cap_mim_m3_1 l=3 w=3
X3907 B9 TOP sky130_fd_pr__cap_mim_m3_1 l=3 w=3
X3908 B9 TOP sky130_fd_pr__cap_mim_m3_1 l=3 w=3
X3909 B10 TOP sky130_fd_pr__cap_mim_m3_1 l=3 w=3
X3910 B8 TOP sky130_fd_pr__cap_mim_m3_1 l=3 w=3
X3911 B11 TOP sky130_fd_pr__cap_mim_m3_1 l=3 w=3
X3912 B10 TOP sky130_fd_pr__cap_mim_m3_1 l=3 w=3
X3913 B11 TOP sky130_fd_pr__cap_mim_m3_1 l=3 w=3
X3914 B10 TOP sky130_fd_pr__cap_mim_m3_1 l=3 w=3
X3915 B10 TOP sky130_fd_pr__cap_mim_m3_1 l=3 w=3
X3916 B11 TOP sky130_fd_pr__cap_mim_m3_1 l=3 w=3
X3917 B11 TOP sky130_fd_pr__cap_mim_m3_1 l=3 w=3
X3918 B10 TOP sky130_fd_pr__cap_mim_m3_1 l=3 w=3
X3919 B11 TOP sky130_fd_pr__cap_mim_m3_1 l=3 w=3
X3920 B10 TOP sky130_fd_pr__cap_mim_m3_1 l=3 w=3
X3921 B11 TOP sky130_fd_pr__cap_mim_m3_1 l=3 w=3
X3922 B10 TOP sky130_fd_pr__cap_mim_m3_1 l=3 w=3
X3923 EDGE_BIAS EDGE_BIAS sky130_fd_pr__cap_mim_m3_1 l=3 w=3
X3924 B11 TOP sky130_fd_pr__cap_mim_m3_1 l=3 w=3
X3925 B9 TOP sky130_fd_pr__cap_mim_m3_1 l=3 w=3
X3926 B8 TOP sky130_fd_pr__cap_mim_m3_1 l=3 w=3
X3927 B10 TOP sky130_fd_pr__cap_mim_m3_1 l=3 w=3
X3928 B11 TOP sky130_fd_pr__cap_mim_m3_1 l=3 w=3
X3929 B9 TOP sky130_fd_pr__cap_mim_m3_1 l=3 w=3
X3930 B7 TOP sky130_fd_pr__cap_mim_m3_1 l=3 w=3
X3931 B11 TOP sky130_fd_pr__cap_mim_m3_1 l=3 w=3
X3932 B11 TOP sky130_fd_pr__cap_mim_m3_1 l=3 w=3
X3933 B7 TOP sky130_fd_pr__cap_mim_m3_1 l=3 w=3
X3934 B8 TOP sky130_fd_pr__cap_mim_m3_1 l=3 w=3
X3935 B11 TOP sky130_fd_pr__cap_mim_m3_1 l=3 w=3
X3936 B10 TOP sky130_fd_pr__cap_mim_m3_1 l=3 w=3
X3937 EDGE_BIAS EDGE_BIAS sky130_fd_pr__cap_mim_m3_1 l=3 w=3
X3938 B8 TOP sky130_fd_pr__cap_mim_m3_1 l=3 w=3
X3939 B11 TOP sky130_fd_pr__cap_mim_m3_1 l=3 w=3
X3940 B11 TOP sky130_fd_pr__cap_mim_m3_1 l=3 w=3
X3941 B11 TOP sky130_fd_pr__cap_mim_m3_1 l=3 w=3
X3942 B5 TOP sky130_fd_pr__cap_mim_m3_1 l=3 w=3
X3943 B9 TOP sky130_fd_pr__cap_mim_m3_1 l=3 w=3
X3944 B10 TOP sky130_fd_pr__cap_mim_m3_1 l=3 w=3
X3945 B9 TOP sky130_fd_pr__cap_mim_m3_1 l=3 w=3
X3946 B11 TOP sky130_fd_pr__cap_mim_m3_1 l=3 w=3
X3947 B11 TOP sky130_fd_pr__cap_mim_m3_1 l=3 w=3
X3948 B11 TOP sky130_fd_pr__cap_mim_m3_1 l=3 w=3
X3949 B10 TOP sky130_fd_pr__cap_mim_m3_1 l=3 w=3
X3950 B11 TOP sky130_fd_pr__cap_mim_m3_1 l=3 w=3
X3951 EDGE_BIAS EDGE_BIAS sky130_fd_pr__cap_mim_m3_1 l=3 w=3
X3952 B9 TOP sky130_fd_pr__cap_mim_m3_1 l=3 w=3
X3953 B11 TOP sky130_fd_pr__cap_mim_m3_1 l=3 w=3
X3954 B11 TOP sky130_fd_pr__cap_mim_m3_1 l=3 w=3
X3955 B11 TOP sky130_fd_pr__cap_mim_m3_1 l=3 w=3
X3956 B11 TOP sky130_fd_pr__cap_mim_m3_1 l=3 w=3
X3957 B11 TOP sky130_fd_pr__cap_mim_m3_1 l=3 w=3
X3958 B9 TOP sky130_fd_pr__cap_mim_m3_1 l=3 w=3
X3959 B8 TOP sky130_fd_pr__cap_mim_m3_1 l=3 w=3
X3960 B11 TOP sky130_fd_pr__cap_mim_m3_1 l=3 w=3
X3961 B10 TOP sky130_fd_pr__cap_mim_m3_1 l=3 w=3
X3962 B7 TOP sky130_fd_pr__cap_mim_m3_1 l=3 w=3
X3963 B7 TOP sky130_fd_pr__cap_mim_m3_1 l=3 w=3
X3964 B9 TOP sky130_fd_pr__cap_mim_m3_1 l=3 w=3
X3965 B11 TOP sky130_fd_pr__cap_mim_m3_1 l=3 w=3
X3966 B10 TOP sky130_fd_pr__cap_mim_m3_1 l=3 w=3
X3967 B11 TOP sky130_fd_pr__cap_mim_m3_1 l=3 w=3
X3968 B8 TOP sky130_fd_pr__cap_mim_m3_1 l=3 w=3
X3969 B9 TOP sky130_fd_pr__cap_mim_m3_1 l=3 w=3
X3970 B10 TOP sky130_fd_pr__cap_mim_m3_1 l=3 w=3
X3971 B11 TOP sky130_fd_pr__cap_mim_m3_1 l=3 w=3
X3972 B11 TOP sky130_fd_pr__cap_mim_m3_1 l=3 w=3
X3973 B10 TOP sky130_fd_pr__cap_mim_m3_1 l=3 w=3
X3974 B8 TOP sky130_fd_pr__cap_mim_m3_1 l=3 w=3
X3975 B10 TOP sky130_fd_pr__cap_mim_m3_1 l=3 w=3
X3976 B11 TOP sky130_fd_pr__cap_mim_m3_1 l=3 w=3
X3977 B11 TOP sky130_fd_pr__cap_mim_m3_1 l=3 w=3
X3978 B8 TOP sky130_fd_pr__cap_mim_m3_1 l=3 w=3
X3979 B11 TOP sky130_fd_pr__cap_mim_m3_1 l=3 w=3
X3980 B10 TOP sky130_fd_pr__cap_mim_m3_1 l=3 w=3
X3981 B11 TOP sky130_fd_pr__cap_mim_m3_1 l=3 w=3
X3982 B11 TOP sky130_fd_pr__cap_mim_m3_1 l=3 w=3
X3983 B10 TOP sky130_fd_pr__cap_mim_m3_1 l=3 w=3
X3984 B9 TOP sky130_fd_pr__cap_mim_m3_1 l=3 w=3
X3985 B11 TOP sky130_fd_pr__cap_mim_m3_1 l=3 w=3
X3986 B11 TOP sky130_fd_pr__cap_mim_m3_1 l=3 w=3
X3987 B11 TOP sky130_fd_pr__cap_mim_m3_1 l=3 w=3
X3988 B11 TOP sky130_fd_pr__cap_mim_m3_1 l=3 w=3
X3989 B9 TOP sky130_fd_pr__cap_mim_m3_1 l=3 w=3
X3990 B10 TOP sky130_fd_pr__cap_mim_m3_1 l=3 w=3
X3991 B11 TOP sky130_fd_pr__cap_mim_m3_1 l=3 w=3
X3992 B7 TOP sky130_fd_pr__cap_mim_m3_1 l=3 w=3
X3993 B11 TOP sky130_fd_pr__cap_mim_m3_1 l=3 w=3
X3994 B11 TOP sky130_fd_pr__cap_mim_m3_1 l=3 w=3
X3995 B11 TOP sky130_fd_pr__cap_mim_m3_1 l=3 w=3
X3996 B11 TOP sky130_fd_pr__cap_mim_m3_1 l=3 w=3
X3997 B10 TOP sky130_fd_pr__cap_mim_m3_1 l=3 w=3
X3998 EDGE_BIAS EDGE_BIAS sky130_fd_pr__cap_mim_m3_1 l=3 w=3
X3999 B11 TOP sky130_fd_pr__cap_mim_m3_1 l=3 w=3
X4000 B8 TOP sky130_fd_pr__cap_mim_m3_1 l=3 w=3
X4001 B6 TOP sky130_fd_pr__cap_mim_m3_1 l=3 w=3
X4002 B10 TOP sky130_fd_pr__cap_mim_m3_1 l=3 w=3
X4003 B11 TOP sky130_fd_pr__cap_mim_m3_1 l=3 w=3
X4004 B11 TOP sky130_fd_pr__cap_mim_m3_1 l=3 w=3
X4005 B4 TOP sky130_fd_pr__cap_mim_m3_1 l=3 w=3
X4006 B9 TOP sky130_fd_pr__cap_mim_m3_1 l=3 w=3
X4007 B11 TOP sky130_fd_pr__cap_mim_m3_1 l=3 w=3
X4008 B9 TOP sky130_fd_pr__cap_mim_m3_1 l=3 w=3
X4009 B11 TOP sky130_fd_pr__cap_mim_m3_1 l=3 w=3
X4010 B10 TOP sky130_fd_pr__cap_mim_m3_1 l=3 w=3
X4011 B11 TOP sky130_fd_pr__cap_mim_m3_1 l=3 w=3
X4012 B9 TOP sky130_fd_pr__cap_mim_m3_1 l=3 w=3
X4013 B11 TOP sky130_fd_pr__cap_mim_m3_1 l=3 w=3
X4014 B10 TOP sky130_fd_pr__cap_mim_m3_1 l=3 w=3
X4015 B11 TOP sky130_fd_pr__cap_mim_m3_1 l=3 w=3
X4016 B11 TOP sky130_fd_pr__cap_mim_m3_1 l=3 w=3
X4017 B11 TOP sky130_fd_pr__cap_mim_m3_1 l=3 w=3
X4018 B11 TOP sky130_fd_pr__cap_mim_m3_1 l=3 w=3
X4019 B11 TOP sky130_fd_pr__cap_mim_m3_1 l=3 w=3
X4020 EDGE_BIAS EDGE_BIAS sky130_fd_pr__cap_mim_m3_1 l=3 w=3
X4021 EDGE_BIAS EDGE_BIAS sky130_fd_pr__cap_mim_m3_1 l=3 w=3
X4022 B11 TOP sky130_fd_pr__cap_mim_m3_1 l=3 w=3
X4023 B11 TOP sky130_fd_pr__cap_mim_m3_1 l=3 w=3
X4024 B11 TOP sky130_fd_pr__cap_mim_m3_1 l=3 w=3
X4025 B11 TOP sky130_fd_pr__cap_mim_m3_1 l=3 w=3
X4026 B11 TOP sky130_fd_pr__cap_mim_m3_1 l=3 w=3
X4027 B11 TOP sky130_fd_pr__cap_mim_m3_1 l=3 w=3
X4028 B9 TOP sky130_fd_pr__cap_mim_m3_1 l=3 w=3
X4029 B10 TOP sky130_fd_pr__cap_mim_m3_1 l=3 w=3
X4030 B10 TOP sky130_fd_pr__cap_mim_m3_1 l=3 w=3
X4031 B7 TOP sky130_fd_pr__cap_mim_m3_1 l=3 w=3
X4032 B11 TOP sky130_fd_pr__cap_mim_m3_1 l=3 w=3
X4033 B9 TOP sky130_fd_pr__cap_mim_m3_1 l=3 w=3
X4034 EDGE_BIAS EDGE_BIAS sky130_fd_pr__cap_mim_m3_1 l=3 w=3
X4035 EDGE_BIAS EDGE_BIAS sky130_fd_pr__cap_mim_m3_1 l=3 w=3
X4036 B10 TOP sky130_fd_pr__cap_mim_m3_1 l=3 w=3
X4037 B8 TOP sky130_fd_pr__cap_mim_m3_1 l=3 w=3
X4038 B8 TOP sky130_fd_pr__cap_mim_m3_1 l=3 w=3
X4039 B9 TOP sky130_fd_pr__cap_mim_m3_1 l=3 w=3
X4040 B10 TOP sky130_fd_pr__cap_mim_m3_1 l=3 w=3
X4041 B11 TOP sky130_fd_pr__cap_mim_m3_1 l=3 w=3
X4042 B8 TOP sky130_fd_pr__cap_mim_m3_1 l=3 w=3
X4043 B11 TOP sky130_fd_pr__cap_mim_m3_1 l=3 w=3
X4044 B11 TOP sky130_fd_pr__cap_mim_m3_1 l=3 w=3
X4045 B10 TOP sky130_fd_pr__cap_mim_m3_1 l=3 w=3
X4046 B11 TOP sky130_fd_pr__cap_mim_m3_1 l=3 w=3
X4047 B10 TOP sky130_fd_pr__cap_mim_m3_1 l=3 w=3
X4048 B11 TOP sky130_fd_pr__cap_mim_m3_1 l=3 w=3
X4049 B11 TOP sky130_fd_pr__cap_mim_m3_1 l=3 w=3
X4050 B11 TOP sky130_fd_pr__cap_mim_m3_1 l=3 w=3
X4051 B4 TOP sky130_fd_pr__cap_mim_m3_1 l=3 w=3
X4052 B11 TOP sky130_fd_pr__cap_mim_m3_1 l=3 w=3
X4053 B10 TOP sky130_fd_pr__cap_mim_m3_1 l=3 w=3
X4054 B11 TOP sky130_fd_pr__cap_mim_m3_1 l=3 w=3
X4055 B10 TOP sky130_fd_pr__cap_mim_m3_1 l=3 w=3
X4056 B11 TOP sky130_fd_pr__cap_mim_m3_1 l=3 w=3
X4057 B11 TOP sky130_fd_pr__cap_mim_m3_1 l=3 w=3
X4058 B10 TOP sky130_fd_pr__cap_mim_m3_1 l=3 w=3
X4059 B10 TOP sky130_fd_pr__cap_mim_m3_1 l=3 w=3
X4060 B9 TOP sky130_fd_pr__cap_mim_m3_1 l=3 w=3
X4061 B11 TOP sky130_fd_pr__cap_mim_m3_1 l=3 w=3
X4062 B7 TOP sky130_fd_pr__cap_mim_m3_1 l=3 w=3
X4063 B10 TOP sky130_fd_pr__cap_mim_m3_1 l=3 w=3
X4064 B8 TOP sky130_fd_pr__cap_mim_m3_1 l=3 w=3
X4065 B11 TOP sky130_fd_pr__cap_mim_m3_1 l=3 w=3
X4066 EDGE_BIAS EDGE_BIAS sky130_fd_pr__cap_mim_m3_1 l=3 w=3
X4067 B11 TOP sky130_fd_pr__cap_mim_m3_1 l=3 w=3
X4068 B6 TOP sky130_fd_pr__cap_mim_m3_1 l=3 w=3
X4069 B11 TOP sky130_fd_pr__cap_mim_m3_1 l=3 w=3
X4070 B10 TOP sky130_fd_pr__cap_mim_m3_1 l=3 w=3
X4071 B10 TOP sky130_fd_pr__cap_mim_m3_1 l=3 w=3
X4072 B10 TOP sky130_fd_pr__cap_mim_m3_1 l=3 w=3
X4073 B9 TOP sky130_fd_pr__cap_mim_m3_1 l=3 w=3
X4074 B9 TOP sky130_fd_pr__cap_mim_m3_1 l=3 w=3
X4075 B11 TOP sky130_fd_pr__cap_mim_m3_1 l=3 w=3
X4076 B9 TOP sky130_fd_pr__cap_mim_m3_1 l=3 w=3
X4077 B11 TOP sky130_fd_pr__cap_mim_m3_1 l=3 w=3
X4078 B11 TOP sky130_fd_pr__cap_mim_m3_1 l=3 w=3
X4079 EDGE_BIAS EDGE_BIAS sky130_fd_pr__cap_mim_m3_1 l=3 w=3
X4080 B10 TOP sky130_fd_pr__cap_mim_m3_1 l=3 w=3
X4081 B11 TOP sky130_fd_pr__cap_mim_m3_1 l=3 w=3
X4082 B9 TOP sky130_fd_pr__cap_mim_m3_1 l=3 w=3
X4083 B10 TOP sky130_fd_pr__cap_mim_m3_1 l=3 w=3
X4084 B11 TOP sky130_fd_pr__cap_mim_m3_1 l=3 w=3
X4085 B11 TOP sky130_fd_pr__cap_mim_m3_1 l=3 w=3
X4086 B9 TOP sky130_fd_pr__cap_mim_m3_1 l=3 w=3
X4087 B11 TOP sky130_fd_pr__cap_mim_m3_1 l=3 w=3
X4088 B9 TOP sky130_fd_pr__cap_mim_m3_1 l=3 w=3
X4089 B11 TOP sky130_fd_pr__cap_mim_m3_1 l=3 w=3
X4090 B11 TOP sky130_fd_pr__cap_mim_m3_1 l=3 w=3
X4091 B10 TOP sky130_fd_pr__cap_mim_m3_1 l=3 w=3
X4092 B10 TOP sky130_fd_pr__cap_mim_m3_1 l=3 w=3
X4093 B11 TOP sky130_fd_pr__cap_mim_m3_1 l=3 w=3
X4094 B9 TOP sky130_fd_pr__cap_mim_m3_1 l=3 w=3
X4095 B10 TOP sky130_fd_pr__cap_mim_m3_1 l=3 w=3
X4096 B9 TOP sky130_fd_pr__cap_mim_m3_1 l=3 w=3
X4097 B6 TOP sky130_fd_pr__cap_mim_m3_1 l=3 w=3
X4098 B11 TOP sky130_fd_pr__cap_mim_m3_1 l=3 w=3
X4099 EDGE_BIAS EDGE_BIAS sky130_fd_pr__cap_mim_m3_1 l=3 w=3
X4100 B7 TOP sky130_fd_pr__cap_mim_m3_1 l=3 w=3
X4101 B11 TOP sky130_fd_pr__cap_mim_m3_1 l=3 w=3
X4102 B11 TOP sky130_fd_pr__cap_mim_m3_1 l=3 w=3
X4103 B9 TOP sky130_fd_pr__cap_mim_m3_1 l=3 w=3
X4104 B9 TOP sky130_fd_pr__cap_mim_m3_1 l=3 w=3
X4105 EDGE_BIAS EDGE_BIAS sky130_fd_pr__cap_mim_m3_1 l=3 w=3
X4106 B11 TOP sky130_fd_pr__cap_mim_m3_1 l=3 w=3
X4107 B11 TOP sky130_fd_pr__cap_mim_m3_1 l=3 w=3
X4108 B10 TOP sky130_fd_pr__cap_mim_m3_1 l=3 w=3
X4109 B8 TOP sky130_fd_pr__cap_mim_m3_1 l=3 w=3
X4110 B9 TOP sky130_fd_pr__cap_mim_m3_1 l=3 w=3
X4111 B11 TOP sky130_fd_pr__cap_mim_m3_1 l=3 w=3
X4112 B10 TOP sky130_fd_pr__cap_mim_m3_1 l=3 w=3
X4113 B11 TOP sky130_fd_pr__cap_mim_m3_1 l=3 w=3
X4114 B11 TOP sky130_fd_pr__cap_mim_m3_1 l=3 w=3
X4115 B10 TOP sky130_fd_pr__cap_mim_m3_1 l=3 w=3
X4116 B11 TOP sky130_fd_pr__cap_mim_m3_1 l=3 w=3
X4117 B10 TOP sky130_fd_pr__cap_mim_m3_1 l=3 w=3
X4118 B11 TOP sky130_fd_pr__cap_mim_m3_1 l=3 w=3
X4119 B10 TOP sky130_fd_pr__cap_mim_m3_1 l=3 w=3
X4120 B10 TOP sky130_fd_pr__cap_mim_m3_1 l=3 w=3
X4121 B10 TOP sky130_fd_pr__cap_mim_m3_1 l=3 w=3
X4122 B10 TOP sky130_fd_pr__cap_mim_m3_1 l=3 w=3
X4123 B8 TOP sky130_fd_pr__cap_mim_m3_1 l=3 w=3
X4124 B11 TOP sky130_fd_pr__cap_mim_m3_1 l=3 w=3
X4125 B11 TOP sky130_fd_pr__cap_mim_m3_1 l=3 w=3
X4126 EDGE_BIAS EDGE_BIAS sky130_fd_pr__cap_mim_m3_1 l=3 w=3
X4127 B11 TOP sky130_fd_pr__cap_mim_m3_1 l=3 w=3
X4128 B10 TOP sky130_fd_pr__cap_mim_m3_1 l=3 w=3
X4129 B8 TOP sky130_fd_pr__cap_mim_m3_1 l=3 w=3
X4130 B11 TOP sky130_fd_pr__cap_mim_m3_1 l=3 w=3
X4131 B7 TOP sky130_fd_pr__cap_mim_m3_1 l=3 w=3
X4132 B11 TOP sky130_fd_pr__cap_mim_m3_1 l=3 w=3
X4133 B9 TOP sky130_fd_pr__cap_mim_m3_1 l=3 w=3
X4134 EDGE_BIAS EDGE_BIAS sky130_fd_pr__cap_mim_m3_1 l=3 w=3
X4135 B10 TOP sky130_fd_pr__cap_mim_m3_1 l=3 w=3
X4136 B10 TOP sky130_fd_pr__cap_mim_m3_1 l=3 w=3
X4137 B10 TOP sky130_fd_pr__cap_mim_m3_1 l=3 w=3
X4138 B11 TOP sky130_fd_pr__cap_mim_m3_1 l=3 w=3
X4139 B11 TOP sky130_fd_pr__cap_mim_m3_1 l=3 w=3
X4140 B8 TOP sky130_fd_pr__cap_mim_m3_1 l=3 w=3
X4141 B10 TOP sky130_fd_pr__cap_mim_m3_1 l=3 w=3
X4142 B11 TOP sky130_fd_pr__cap_mim_m3_1 l=3 w=3
X4143 B5 TOP sky130_fd_pr__cap_mim_m3_1 l=3 w=3
X4144 B10 TOP sky130_fd_pr__cap_mim_m3_1 l=3 w=3
X4145 B9 TOP sky130_fd_pr__cap_mim_m3_1 l=3 w=3
X4146 B11 TOP sky130_fd_pr__cap_mim_m3_1 l=3 w=3
X4147 EDGE_BIAS EDGE_BIAS sky130_fd_pr__cap_mim_m3_1 l=3 w=3
X4148 B11 TOP sky130_fd_pr__cap_mim_m3_1 l=3 w=3
X4149 B10 TOP sky130_fd_pr__cap_mim_m3_1 l=3 w=3
X4150 B11 TOP sky130_fd_pr__cap_mim_m3_1 l=3 w=3
X4151 B11 TOP sky130_fd_pr__cap_mim_m3_1 l=3 w=3
X4152 B6 TOP sky130_fd_pr__cap_mim_m3_1 l=3 w=3
X4153 B11 TOP sky130_fd_pr__cap_mim_m3_1 l=3 w=3
X4154 B11 TOP sky130_fd_pr__cap_mim_m3_1 l=3 w=3
X4155 B11 TOP sky130_fd_pr__cap_mim_m3_1 l=3 w=3
X4156 B11 TOP sky130_fd_pr__cap_mim_m3_1 l=3 w=3
X4157 B9 TOP sky130_fd_pr__cap_mim_m3_1 l=3 w=3
X4158 B11 TOP sky130_fd_pr__cap_mim_m3_1 l=3 w=3
X4159 B10 TOP sky130_fd_pr__cap_mim_m3_1 l=3 w=3
X4160 B10 TOP sky130_fd_pr__cap_mim_m3_1 l=3 w=3
X4161 B7 TOP sky130_fd_pr__cap_mim_m3_1 l=3 w=3
X4162 EDGE_BIAS EDGE_BIAS sky130_fd_pr__cap_mim_m3_1 l=3 w=3
X4163 B11 TOP sky130_fd_pr__cap_mim_m3_1 l=3 w=3
X4164 B9 TOP sky130_fd_pr__cap_mim_m3_1 l=3 w=3
X4165 B9 TOP sky130_fd_pr__cap_mim_m3_1 l=3 w=3
X4166 B8 TOP sky130_fd_pr__cap_mim_m3_1 l=3 w=3
X4167 B9 TOP sky130_fd_pr__cap_mim_m3_1 l=3 w=3
X4168 B11 TOP sky130_fd_pr__cap_mim_m3_1 l=3 w=3
X4169 B10 TOP sky130_fd_pr__cap_mim_m3_1 l=3 w=3
X4170 B8 TOP sky130_fd_pr__cap_mim_m3_1 l=3 w=3
X4171 B6 TOP sky130_fd_pr__cap_mim_m3_1 l=3 w=3
X4172 B10 TOP sky130_fd_pr__cap_mim_m3_1 l=3 w=3
X4173 B11 TOP sky130_fd_pr__cap_mim_m3_1 l=3 w=3
X4174 B9 TOP sky130_fd_pr__cap_mim_m3_1 l=3 w=3
X4175 B11 TOP sky130_fd_pr__cap_mim_m3_1 l=3 w=3
X4176 B10 TOP sky130_fd_pr__cap_mim_m3_1 l=3 w=3
X4177 B8 TOP sky130_fd_pr__cap_mim_m3_1 l=3 w=3
X4178 B11 TOP sky130_fd_pr__cap_mim_m3_1 l=3 w=3
X4179 B11 TOP sky130_fd_pr__cap_mim_m3_1 l=3 w=3
X4180 B11 TOP sky130_fd_pr__cap_mim_m3_1 l=3 w=3
X4181 B11 TOP sky130_fd_pr__cap_mim_m3_1 l=3 w=3
X4182 B11 TOP sky130_fd_pr__cap_mim_m3_1 l=3 w=3
X4183 B11 TOP sky130_fd_pr__cap_mim_m3_1 l=3 w=3
X4184 B11 TOP sky130_fd_pr__cap_mim_m3_1 l=3 w=3
X4185 B11 TOP sky130_fd_pr__cap_mim_m3_1 l=3 w=3
X4186 B11 TOP sky130_fd_pr__cap_mim_m3_1 l=3 w=3
X4187 B11 TOP sky130_fd_pr__cap_mim_m3_1 l=3 w=3
X4188 B10 TOP sky130_fd_pr__cap_mim_m3_1 l=3 w=3
X4189 B11 TOP sky130_fd_pr__cap_mim_m3_1 l=3 w=3
X4190 EDGE_BIAS EDGE_BIAS sky130_fd_pr__cap_mim_m3_1 l=3 w=3
X4191 B7 TOP sky130_fd_pr__cap_mim_m3_1 l=3 w=3
X4192 B11 TOP sky130_fd_pr__cap_mim_m3_1 l=3 w=3
X4193 B11 TOP sky130_fd_pr__cap_mim_m3_1 l=3 w=3
X4194 B11 TOP sky130_fd_pr__cap_mim_m3_1 l=3 w=3
X4195 B11 TOP sky130_fd_pr__cap_mim_m3_1 l=3 w=3
X4196 B10 TOP sky130_fd_pr__cap_mim_m3_1 l=3 w=3
X4197 B10 TOP sky130_fd_pr__cap_mim_m3_1 l=3 w=3
X4198 B11 TOP sky130_fd_pr__cap_mim_m3_1 l=3 w=3
X4199 B10 TOP sky130_fd_pr__cap_mim_m3_1 l=3 w=3
X4200 B8 TOP sky130_fd_pr__cap_mim_m3_1 l=3 w=3
X4201 B6 TOP sky130_fd_pr__cap_mim_m3_1 l=3 w=3
X4202 B2 TOP sky130_fd_pr__cap_mim_m3_1 l=3 w=3
X4203 B10 TOP sky130_fd_pr__cap_mim_m3_1 l=3 w=3
X4204 B10 TOP sky130_fd_pr__cap_mim_m3_1 l=3 w=3
X4205 B9 TOP sky130_fd_pr__cap_mim_m3_1 l=3 w=3
X4206 EDGE_BIAS EDGE_BIAS sky130_fd_pr__cap_mim_m3_1 l=3 w=3
X4207 B11 TOP sky130_fd_pr__cap_mim_m3_1 l=3 w=3
X4208 B10 TOP sky130_fd_pr__cap_mim_m3_1 l=3 w=3
X4209 B11 TOP sky130_fd_pr__cap_mim_m3_1 l=3 w=3
X4210 B10 TOP sky130_fd_pr__cap_mim_m3_1 l=3 w=3
X4211 B11 TOP sky130_fd_pr__cap_mim_m3_1 l=3 w=3
X4212 B11 TOP sky130_fd_pr__cap_mim_m3_1 l=3 w=3
X4213 B11 TOP sky130_fd_pr__cap_mim_m3_1 l=3 w=3
X4214 B11 TOP sky130_fd_pr__cap_mim_m3_1 l=3 w=3
X4215 B11 TOP sky130_fd_pr__cap_mim_m3_1 l=3 w=3
X4216 B11 TOP sky130_fd_pr__cap_mim_m3_1 l=3 w=3
X4217 B11 TOP sky130_fd_pr__cap_mim_m3_1 l=3 w=3
X4218 B10 TOP sky130_fd_pr__cap_mim_m3_1 l=3 w=3
X4219 B11 TOP sky130_fd_pr__cap_mim_m3_1 l=3 w=3
X4220 B11 TOP sky130_fd_pr__cap_mim_m3_1 l=3 w=3
X4221 B9 TOP sky130_fd_pr__cap_mim_m3_1 l=3 w=3
X4222 EDGE_BIAS EDGE_BIAS sky130_fd_pr__cap_mim_m3_1 l=3 w=3
X4223 B7 TOP sky130_fd_pr__cap_mim_m3_1 l=3 w=3
X4224 B9 TOP sky130_fd_pr__cap_mim_m3_1 l=3 w=3
X4225 B9 TOP sky130_fd_pr__cap_mim_m3_1 l=3 w=3
X4226 B11 TOP sky130_fd_pr__cap_mim_m3_1 l=3 w=3
X4227 B8 TOP sky130_fd_pr__cap_mim_m3_1 l=3 w=3
X4228 B9 TOP sky130_fd_pr__cap_mim_m3_1 l=3 w=3
X4229 B10 TOP sky130_fd_pr__cap_mim_m3_1 l=3 w=3
X4230 B8 TOP sky130_fd_pr__cap_mim_m3_1 l=3 w=3
X4231 B8 TOP sky130_fd_pr__cap_mim_m3_1 l=3 w=3
X4232 B10 TOP sky130_fd_pr__cap_mim_m3_1 l=3 w=3
X4233 B11 TOP sky130_fd_pr__cap_mim_m3_1 l=3 w=3
X4234 B11 TOP sky130_fd_pr__cap_mim_m3_1 l=3 w=3
X4235 B11 TOP sky130_fd_pr__cap_mim_m3_1 l=3 w=3
X4236 B10 TOP sky130_fd_pr__cap_mim_m3_1 l=3 w=3
X4237 B7 TOP sky130_fd_pr__cap_mim_m3_1 l=3 w=3
X4238 B11 TOP sky130_fd_pr__cap_mim_m3_1 l=3 w=3
X4239 B8 TOP sky130_fd_pr__cap_mim_m3_1 l=3 w=3
X4240 B11 TOP sky130_fd_pr__cap_mim_m3_1 l=3 w=3
X4241 B7 TOP sky130_fd_pr__cap_mim_m3_1 l=3 w=3
X4242 B11 TOP sky130_fd_pr__cap_mim_m3_1 l=3 w=3
X4243 B10 TOP sky130_fd_pr__cap_mim_m3_1 l=3 w=3
X4244 B11 TOP sky130_fd_pr__cap_mim_m3_1 l=3 w=3
X4245 B11 TOP sky130_fd_pr__cap_mim_m3_1 l=3 w=3
X4246 B11 TOP sky130_fd_pr__cap_mim_m3_1 l=3 w=3
X4247 B11 TOP sky130_fd_pr__cap_mim_m3_1 l=3 w=3
X4248 B9 TOP sky130_fd_pr__cap_mim_m3_1 l=3 w=3
X4249 B11 TOP sky130_fd_pr__cap_mim_m3_1 l=3 w=3
X4250 B11 TOP sky130_fd_pr__cap_mim_m3_1 l=3 w=3
X4251 B11 TOP sky130_fd_pr__cap_mim_m3_1 l=3 w=3
X4252 B9 TOP sky130_fd_pr__cap_mim_m3_1 l=3 w=3
X4253 B5 TOP sky130_fd_pr__cap_mim_m3_1 l=3 w=3
X4254 B10 TOP sky130_fd_pr__cap_mim_m3_1 l=3 w=3
X4255 B11 TOP sky130_fd_pr__cap_mim_m3_1 l=3 w=3
X4256 B11 TOP sky130_fd_pr__cap_mim_m3_1 l=3 w=3
X4257 B11 TOP sky130_fd_pr__cap_mim_m3_1 l=3 w=3
X4258 B11 TOP sky130_fd_pr__cap_mim_m3_1 l=3 w=3
X4259 EDGE_BIAS EDGE_BIAS sky130_fd_pr__cap_mim_m3_1 l=3 w=3
X4260 EDGE_BIAS EDGE_BIAS sky130_fd_pr__cap_mim_m3_1 l=3 w=3
X4261 B11 TOP sky130_fd_pr__cap_mim_m3_1 l=3 w=3
X4262 B10 TOP sky130_fd_pr__cap_mim_m3_1 l=3 w=3
X4263 B10 TOP sky130_fd_pr__cap_mim_m3_1 l=3 w=3
X4264 B11 TOP sky130_fd_pr__cap_mim_m3_1 l=3 w=3
X4265 B10 TOP sky130_fd_pr__cap_mim_m3_1 l=3 w=3
X4266 B10 TOP sky130_fd_pr__cap_mim_m3_1 l=3 w=3
X4267 B11 TOP sky130_fd_pr__cap_mim_m3_1 l=3 w=3
X4268 B5 TOP sky130_fd_pr__cap_mim_m3_1 l=3 w=3
X4269 B11 TOP sky130_fd_pr__cap_mim_m3_1 l=3 w=3
X4270 B10 TOP sky130_fd_pr__cap_mim_m3_1 l=3 w=3
X4271 B10 TOP sky130_fd_pr__cap_mim_m3_1 l=3 w=3
X4272 B10 TOP sky130_fd_pr__cap_mim_m3_1 l=3 w=3
X4273 B7 TOP sky130_fd_pr__cap_mim_m3_1 l=3 w=3
X4274 B10 TOP sky130_fd_pr__cap_mim_m3_1 l=3 w=3
X4275 B10 TOP sky130_fd_pr__cap_mim_m3_1 l=3 w=3
X4276 B10 TOP sky130_fd_pr__cap_mim_m3_1 l=3 w=3
X4277 B9 TOP sky130_fd_pr__cap_mim_m3_1 l=3 w=3
X4278 B10 TOP sky130_fd_pr__cap_mim_m3_1 l=3 w=3
X4279 B9 TOP sky130_fd_pr__cap_mim_m3_1 l=3 w=3
X4280 B10 TOP sky130_fd_pr__cap_mim_m3_1 l=3 w=3
X4281 B11 TOP sky130_fd_pr__cap_mim_m3_1 l=3 w=3
X4282 B11 TOP sky130_fd_pr__cap_mim_m3_1 l=3 w=3
X4283 B10 TOP sky130_fd_pr__cap_mim_m3_1 l=3 w=3
X4284 B11 TOP sky130_fd_pr__cap_mim_m3_1 l=3 w=3
X4285 B9 TOP sky130_fd_pr__cap_mim_m3_1 l=3 w=3
X4286 B10 TOP sky130_fd_pr__cap_mim_m3_1 l=3 w=3
X4287 B11 TOP sky130_fd_pr__cap_mim_m3_1 l=3 w=3
X4288 EDGE_BIAS EDGE_BIAS sky130_fd_pr__cap_mim_m3_1 l=3 w=3
X4289 B11 TOP sky130_fd_pr__cap_mim_m3_1 l=3 w=3
X4290 B11 TOP sky130_fd_pr__cap_mim_m3_1 l=3 w=3
X4291 B11 TOP sky130_fd_pr__cap_mim_m3_1 l=3 w=3
X4292 B10 TOP sky130_fd_pr__cap_mim_m3_1 l=3 w=3
X4293 B9 TOP sky130_fd_pr__cap_mim_m3_1 l=3 w=3
X4294 B8 TOP sky130_fd_pr__cap_mim_m3_1 l=3 w=3
X4295 B9 TOP sky130_fd_pr__cap_mim_m3_1 l=3 w=3
X4296 B11 TOP sky130_fd_pr__cap_mim_m3_1 l=3 w=3
X4297 B8 TOP sky130_fd_pr__cap_mim_m3_1 l=3 w=3
X4298 B8 TOP sky130_fd_pr__cap_mim_m3_1 l=3 w=3
X4299 B10 TOP sky130_fd_pr__cap_mim_m3_1 l=3 w=3
X4300 B9 TOP sky130_fd_pr__cap_mim_m3_1 l=3 w=3
X4301 B11 TOP sky130_fd_pr__cap_mim_m3_1 l=3 w=3
X4302 B10 TOP sky130_fd_pr__cap_mim_m3_1 l=3 w=3
X4303 B7 TOP sky130_fd_pr__cap_mim_m3_1 l=3 w=3
X4304 B8 TOP sky130_fd_pr__cap_mim_m3_1 l=3 w=3
X4305 B9 TOP sky130_fd_pr__cap_mim_m3_1 l=3 w=3
X4306 B11 TOP sky130_fd_pr__cap_mim_m3_1 l=3 w=3
X4307 B10 TOP sky130_fd_pr__cap_mim_m3_1 l=3 w=3
X4308 B11 TOP sky130_fd_pr__cap_mim_m3_1 l=3 w=3
X4309 B11 TOP sky130_fd_pr__cap_mim_m3_1 l=3 w=3
X4310 B11 TOP sky130_fd_pr__cap_mim_m3_1 l=3 w=3
X4311 B11 TOP sky130_fd_pr__cap_mim_m3_1 l=3 w=3
X4312 B10 TOP sky130_fd_pr__cap_mim_m3_1 l=3 w=3
X4313 B11 TOP sky130_fd_pr__cap_mim_m3_1 l=3 w=3
X4314 B11 TOP sky130_fd_pr__cap_mim_m3_1 l=3 w=3
X4315 B9 TOP sky130_fd_pr__cap_mim_m3_1 l=3 w=3
X4316 B11 TOP sky130_fd_pr__cap_mim_m3_1 l=3 w=3
X4317 B10 TOP sky130_fd_pr__cap_mim_m3_1 l=3 w=3
X4318 B11 TOP sky130_fd_pr__cap_mim_m3_1 l=3 w=3
X4319 B11 TOP sky130_fd_pr__cap_mim_m3_1 l=3 w=3
X4320 B10 TOP sky130_fd_pr__cap_mim_m3_1 l=3 w=3
X4321 B9 TOP sky130_fd_pr__cap_mim_m3_1 l=3 w=3
X4322 B7 TOP sky130_fd_pr__cap_mim_m3_1 l=3 w=3
X4323 B11 TOP sky130_fd_pr__cap_mim_m3_1 l=3 w=3
X4324 B10 TOP sky130_fd_pr__cap_mim_m3_1 l=3 w=3
X4325 B10 TOP sky130_fd_pr__cap_mim_m3_1 l=3 w=3
X4326 B10 TOP sky130_fd_pr__cap_mim_m3_1 l=3 w=3
X4327 B4 TOP sky130_fd_pr__cap_mim_m3_1 l=3 w=3
X4328 B11 TOP sky130_fd_pr__cap_mim_m3_1 l=3 w=3
X4329 B10 TOP sky130_fd_pr__cap_mim_m3_1 l=3 w=3
X4330 B11 TOP sky130_fd_pr__cap_mim_m3_1 l=3 w=3
X4331 B10 TOP sky130_fd_pr__cap_mim_m3_1 l=3 w=3
X4332 B7 TOP sky130_fd_pr__cap_mim_m3_1 l=3 w=3
X4333 B9 TOP sky130_fd_pr__cap_mim_m3_1 l=3 w=3
X4334 B11 TOP sky130_fd_pr__cap_mim_m3_1 l=3 w=3
X4335 EDGE_BIAS EDGE_BIAS sky130_fd_pr__cap_mim_m3_1 l=3 w=3
X4336 B11 TOP sky130_fd_pr__cap_mim_m3_1 l=3 w=3
X4337 B10 TOP sky130_fd_pr__cap_mim_m3_1 l=3 w=3
X4338 B10 TOP sky130_fd_pr__cap_mim_m3_1 l=3 w=3
X4339 B11 TOP sky130_fd_pr__cap_mim_m3_1 l=3 w=3
X4340 B11 TOP sky130_fd_pr__cap_mim_m3_1 l=3 w=3
X4341 B11 TOP sky130_fd_pr__cap_mim_m3_1 l=3 w=3
X4342 B11 TOP sky130_fd_pr__cap_mim_m3_1 l=3 w=3
X4343 B11 TOP sky130_fd_pr__cap_mim_m3_1 l=3 w=3
X4344 B11 TOP sky130_fd_pr__cap_mim_m3_1 l=3 w=3
X4345 B10 TOP sky130_fd_pr__cap_mim_m3_1 l=3 w=3
X4346 EDGE_BIAS EDGE_BIAS sky130_fd_pr__cap_mim_m3_1 l=3 w=3
X4347 B9 TOP sky130_fd_pr__cap_mim_m3_1 l=3 w=3
X4348 B11 TOP sky130_fd_pr__cap_mim_m3_1 l=3 w=3
X4349 B11 TOP sky130_fd_pr__cap_mim_m3_1 l=3 w=3
X4350 B9 TOP sky130_fd_pr__cap_mim_m3_1 l=3 w=3
X4351 B7 TOP sky130_fd_pr__cap_mim_m3_1 l=3 w=3
X4352 B9 TOP sky130_fd_pr__cap_mim_m3_1 l=3 w=3
X4353 B8 TOP sky130_fd_pr__cap_mim_m3_1 l=3 w=3
X4354 B9 TOP sky130_fd_pr__cap_mim_m3_1 l=3 w=3
X4355 B8 TOP sky130_fd_pr__cap_mim_m3_1 l=3 w=3
.ends
