simulator lang=spectre

subckt sensor_adc_candidate (INP INN Q QB SAMPLE SAMPLEB ACQ CONV EVAL B11 B10 B9 B8 B7 B6 B5 B4 B3 B2 B1 B0 RP RN VCM VDD VSS)

// project1/p2adc_core_fix1_school_r1/schematic
XADC_XDN_XRN_XN (RN XADC_XDN_NL XADC_DN VSS) nfet_01v8_lvt w=(840n) l=150n m=(1)*(1)
XADC_XDN_XRP_XN (RP XADC_XDN_PH XADC_DN VSS) nfet_01v8_lvt w=(840n) l=150n m=(1)*(1)
XADC_XDN_XCM_XN (INN ACQ XADC_DN VSS) nfet_01v8_lvt w=(840n) l=150n m=(1)*(1)
XADC_XDP_XRN_XN (RN XADC_XDP_NL XADC_DP VSS) nfet_01v8_lvt w=(840n) l=150n m=(1)*(1)
XADC_XDP_XRP_XN (RP XADC_XDP_PH XADC_DP VSS) nfet_01v8_lvt w=(840n) l=150n m=(1)*(1)
XADC_XDP_XCM_XN (INP ACQ XADC_DP VSS) nfet_01v8_lvt w=(840n) l=150n m=(1)*(1)
XADC_XN11_XRN_XN (RP XADC_XN11_NL XADC_BN11 VSS) nfet_01v8_lvt w=(13.44u) l=150n m=(1)*(1)
XADC_XN11_XRP_XN (RN XADC_XN11_PH XADC_BN11 VSS) nfet_01v8_lvt w=(13.44u) l=150n m=(1)*(1)
XADC_XN11_XCM_XN (INN ACQ XADC_BN11 VSS) nfet_01v8_lvt w=(13.44u) l=150n m=(1)*(1)
XADC_XP11_XRN_XN (RN XADC_XP11_NL XADC_BP11 VSS) nfet_01v8_lvt w=(13.44u) l=150n m=(1)*(1)
XADC_XP11_XRP_XN (RP XADC_XP11_PH XADC_BP11 VSS) nfet_01v8_lvt w=(13.44u) l=150n m=(1)*(1)
XADC_XP11_XCM_XN (INP ACQ XADC_BP11 VSS) nfet_01v8_lvt w=(13.44u) l=150n m=(1)*(1)
XADC_XN10_XRN_XN (RP XADC_XN10_NL XADC_BN10 VSS) nfet_01v8_lvt w=(13.44u) l=150n m=(1)*(1)
XADC_XN10_XRP_XN (RN XADC_XN10_PH XADC_BN10 VSS) nfet_01v8_lvt w=(13.44u) l=150n m=(1)*(1)
XADC_XN10_XCM_XN (INN ACQ XADC_BN10 VSS) nfet_01v8_lvt w=(13.44u) l=150n m=(1)*(1)
XADC_XP10_XRN_XN (RN XADC_XP10_NL XADC_BP10 VSS) nfet_01v8_lvt w=(13.44u) l=150n m=(1)*(1)
XADC_XP10_XRP_XN (RP XADC_XP10_PH XADC_BP10 VSS) nfet_01v8_lvt w=(13.44u) l=150n m=(1)*(1)
XADC_XP10_XCM_XN (INP ACQ XADC_BP10 VSS) nfet_01v8_lvt w=(13.44u) l=150n m=(1)*(1)
XADC_XN9_XRN_XN (RP XADC_XN9_NL XADC_BN9 VSS) nfet_01v8_lvt w=(13.44u) l=150n m=(1)*(1)
XADC_XN9_XRP_XN (RN XADC_XN9_PH XADC_BN9 VSS) nfet_01v8_lvt w=(13.44u) l=150n m=(1)*(1)
XADC_XN9_XCM_XN (INN ACQ XADC_BN9 VSS) nfet_01v8_lvt w=(13.44u) l=150n m=(1)*(1)
XADC_XP9_XRN_XN (RN XADC_XP9_NL XADC_BP9 VSS) nfet_01v8_lvt w=(13.44u) l=150n m=(1)*(1)
XADC_XP9_XRP_XN (RP XADC_XP9_PH XADC_BP9 VSS) nfet_01v8_lvt w=(13.44u) l=150n m=(1)*(1)
XADC_XP9_XCM_XN (INP ACQ XADC_BP9 VSS) nfet_01v8_lvt w=(13.44u) l=150n m=(1)*(1)
XADC_XN8_XRN_XN (RP XADC_XN8_NL XADC_BN8 VSS) nfet_01v8_lvt w=(13.44u) l=150n m=(1)*(1)
XADC_XN8_XRP_XN (RN XADC_XN8_PH XADC_BN8 VSS) nfet_01v8_lvt w=(13.44u) l=150n m=(1)*(1)
XADC_XN8_XCM_XN (INN ACQ XADC_BN8 VSS) nfet_01v8_lvt w=(13.44u) l=150n m=(1)*(1)
XADC_XP8_XRN_XN (RN XADC_XP8_NL XADC_BP8 VSS) nfet_01v8_lvt w=(13.44u) l=150n m=(1)*(1)
XADC_XP8_XRP_XN (RP XADC_XP8_PH XADC_BP8 VSS) nfet_01v8_lvt w=(13.44u) l=150n m=(1)*(1)
XADC_XP8_XCM_XN (INP ACQ XADC_BP8 VSS) nfet_01v8_lvt w=(13.44u) l=150n m=(1)*(1)
XADC_XN7_XRN_XN (RP XADC_XN7_NL XADC_BN7 VSS) nfet_01v8_lvt w=(9.505u) l=150n m=(1)*(1)
XADC_XN7_XRP_XN (RN XADC_XN7_PH XADC_BN7 VSS) nfet_01v8_lvt w=(9.505u) l=150n m=(1)*(1)
XADC_XN7_XCM_XN (INN ACQ XADC_BN7 VSS) nfet_01v8_lvt w=(9.505u) l=150n m=(1)*(1)
XADC_XP7_XRN_XN (RN XADC_XP7_NL XADC_BP7 VSS) nfet_01v8_lvt w=(9.505u) l=150n m=(1)*(1)
XADC_XP7_XRP_XN (RP XADC_XP7_PH XADC_BP7 VSS) nfet_01v8_lvt w=(9.505u) l=150n m=(1)*(1)
XADC_XP7_XCM_XN (INP ACQ XADC_BP7 VSS) nfet_01v8_lvt w=(9.505u) l=150n m=(1)*(1)
XADC_XN6_XRN_XN (RP XADC_XN6_NL XADC_BN6 VSS) nfet_01v8_lvt w=(6.72u) l=150n m=(1)*(1)
XADC_XN6_XRP_XN (RN XADC_XN6_PH XADC_BN6 VSS) nfet_01v8_lvt w=(6.72u) l=150n m=(1)*(1)
XADC_XN6_XCM_XN (INN ACQ XADC_BN6 VSS) nfet_01v8_lvt w=(6.72u) l=150n m=(1)*(1)
XADC_XP6_XRN_XN (RN XADC_XP6_NL XADC_BP6 VSS) nfet_01v8_lvt w=(6.72u) l=150n m=(1)*(1)
XADC_XP6_XRP_XN (RP XADC_XP6_PH XADC_BP6 VSS) nfet_01v8_lvt w=(6.72u) l=150n m=(1)*(1)
XADC_XP6_XCM_XN (INP ACQ XADC_BP6 VSS) nfet_01v8_lvt w=(6.72u) l=150n m=(1)*(1)
XADC_XN5_XRN_XN (RP XADC_XN5_NL XADC_BN5 VSS) nfet_01v8_lvt w=(4.75u) l=150n m=(1)*(1)
XADC_XN5_XRP_XN (RN XADC_XN5_PH XADC_BN5 VSS) nfet_01v8_lvt w=(4.75u) l=150n m=(1)*(1)
XADC_XN5_XCM_XN (INN ACQ XADC_BN5 VSS) nfet_01v8_lvt w=(4.75u) l=150n m=(1)*(1)
XADC_XP5_XRN_XN (RN XADC_XP5_NL XADC_BP5 VSS) nfet_01v8_lvt w=(4.75u) l=150n m=(1)*(1)
XADC_XP5_XRP_XN (RP XADC_XP5_PH XADC_BP5 VSS) nfet_01v8_lvt w=(4.75u) l=150n m=(1)*(1)
XADC_XP5_XCM_XN (INP ACQ XADC_BP5 VSS) nfet_01v8_lvt w=(4.75u) l=150n m=(1)*(1)
XADC_XN4_XRN_XN (RP XADC_XN4_NL XADC_BN4 VSS) nfet_01v8_lvt w=(3.36u) l=150n m=(1)*(1)
XADC_XN4_XRP_XN (RN XADC_XN4_PH XADC_BN4 VSS) nfet_01v8_lvt w=(3.36u) l=150n m=(1)*(1)
XADC_XN4_XCM_XN (INN ACQ XADC_BN4 VSS) nfet_01v8_lvt w=(3.36u) l=150n m=(1)*(1)
XADC_XP4_XRN_XN (RN XADC_XP4_NL XADC_BP4 VSS) nfet_01v8_lvt w=(3.36u) l=150n m=(1)*(1)
XADC_XP4_XRP_XN (RP XADC_XP4_PH XADC_BP4 VSS) nfet_01v8_lvt w=(3.36u) l=150n m=(1)*(1)
XADC_XP4_XCM_XN (INP ACQ XADC_BP4 VSS) nfet_01v8_lvt w=(3.36u) l=150n m=(1)*(1)
XADC_XN3_XRN_XN (RP XADC_XN3_NL XADC_BN3 VSS) nfet_01v8_lvt w=(2.375u) l=150n m=(1)*(1)
XADC_XN3_XRP_XN (RN XADC_XN3_PH XADC_BN3 VSS) nfet_01v8_lvt w=(2.375u) l=150n m=(1)*(1)
XADC_XN3_XCM_XN (INN ACQ XADC_BN3 VSS) nfet_01v8_lvt w=(2.375u) l=150n m=(1)*(1)
XADC_XP3_XRN_XN (RN XADC_XP3_NL XADC_BP3 VSS) nfet_01v8_lvt w=(2.375u) l=150n m=(1)*(1)
XADC_XP3_XRP_XN (RP XADC_XP3_PH XADC_BP3 VSS) nfet_01v8_lvt w=(2.375u) l=150n m=(1)*(1)
XADC_XP3_XCM_XN (INP ACQ XADC_BP3 VSS) nfet_01v8_lvt w=(2.375u) l=150n m=(1)*(1)
XADC_XN2_XRN_XN (RP XADC_XN2_NL XADC_BN2 VSS) nfet_01v8_lvt w=(1.68u) l=150n m=(1)*(1)
XADC_XN2_XRP_XN (RN XADC_XN2_PH XADC_BN2 VSS) nfet_01v8_lvt w=(1.68u) l=150n m=(1)*(1)
XADC_XN2_XCM_XN (INN ACQ XADC_BN2 VSS) nfet_01v8_lvt w=(1.68u) l=150n m=(1)*(1)
XADC_XP2_XRN_XN (RN XADC_XP2_NL XADC_BP2 VSS) nfet_01v8_lvt w=(1.68u) l=150n m=(1)*(1)
XADC_XP2_XRP_XN (RP XADC_XP2_PH XADC_BP2 VSS) nfet_01v8_lvt w=(1.68u) l=150n m=(1)*(1)
XADC_XP2_XCM_XN (INP ACQ XADC_BP2 VSS) nfet_01v8_lvt w=(1.68u) l=150n m=(1)*(1)
XADC_XN1_XRN_XN (RP XADC_XN1_NL XADC_BN1 VSS) nfet_01v8_lvt w=(1.19u) l=150n m=(1)*(1)
XADC_XN1_XRP_XN (RN XADC_XN1_PH XADC_BN1 VSS) nfet_01v8_lvt w=(1.19u) l=150n m=(1)*(1)
XADC_XN1_XCM_XN (INN ACQ XADC_BN1 VSS) nfet_01v8_lvt w=(1.19u) l=150n m=(1)*(1)
XADC_XP1_XRN_XN (RN XADC_XP1_NL XADC_BP1 VSS) nfet_01v8_lvt w=(1.19u) l=150n m=(1)*(1)
XADC_XP1_XRP_XN (RP XADC_XP1_PH XADC_BP1 VSS) nfet_01v8_lvt w=(1.19u) l=150n m=(1)*(1)
XADC_XP1_XCM_XN (INP ACQ XADC_BP1 VSS) nfet_01v8_lvt w=(1.19u) l=150n m=(1)*(1)
XADC_XN0_XRN_XN (RP XADC_XN0_NL XADC_BN0 VSS) nfet_01v8_lvt w=(840n) l=150n m=(1)*(1)
XADC_XN0_XRP_XN (RN XADC_XN0_PH XADC_BN0 VSS) nfet_01v8_lvt w=(840n) l=150n m=(1)*(1)
XADC_XN0_XCM_XN (INN ACQ XADC_BN0 VSS) nfet_01v8_lvt w=(840n) l=150n m=(1)*(1)
XADC_XP0_XRN_XN (RN XADC_XP0_NL XADC_BP0 VSS) nfet_01v8_lvt w=(840n) l=150n m=(1)*(1)
XADC_XP0_XRP_XN (RP XADC_XP0_PH XADC_BP0 VSS) nfet_01v8_lvt w=(840n) l=150n m=(1)*(1)
XADC_XP0_XCM_XN (INP ACQ XADC_BP0 VSS) nfet_01v8_lvt w=(840n) l=150n m=(1)*(1)
XADC_XSN_XND (XADC_TN SAMPLEB XADC_TN VSS) nfet_01v8_lvt w=(2u) l=150n m=(1)*(1)
XADC_XSN_XN (XADC_TN SAMPLE VCM VSS) nfet_01v8_lvt w=(4u) l=150n m=(1)*(1)
XADC_XSP_XND (XADC_TP SAMPLEB XADC_TP VSS) nfet_01v8_lvt w=(2u) l=150n m=(1)*(1)
XADC_XSP_XN (XADC_TP SAMPLE VCM VSS) nfet_01v8_lvt w=(4u) l=150n m=(1)*(1)
XADC_XDN_XRN_XP (RN XADC_XDN_NLB XADC_DN VDD) pfet_01v8_lvt w=(1.68u) l=350n m=(1)*(1)
XADC_XDN_XRP_XP (RP XADC_XDN_PHB XADC_DN VDD) pfet_01v8_lvt w=(1.68u) l=350n m=(1)*(1)
XADC_XDN_XCM_XP (INN XADC_XDN_ACQB XADC_DN VDD) pfet_01v8_lvt w=(1.68u) l=350n m=(1)*(1)
XADC_XDP_XRN_XP (RN XADC_XDP_NLB XADC_DP VDD) pfet_01v8_lvt w=(1.68u) l=350n m=(1)*(1)
XADC_XDP_XRP_XP (RP XADC_XDP_PHB XADC_DP VDD) pfet_01v8_lvt w=(1.68u) l=350n m=(1)*(1)
XADC_XDP_XCM_XP (INP XADC_XDP_ACQB XADC_DP VDD) pfet_01v8_lvt w=(1.68u) l=350n m=(1)*(1)
XADC_XN11_XRN_XP (RP XADC_XN11_NLB XADC_BN11 VDD) pfet_01v8_lvt w=(26.88u) l=350n m=(1)*(1)
XADC_XN11_XRP_XP (RN XADC_XN11_PHB XADC_BN11 VDD) pfet_01v8_lvt w=(26.88u) l=350n m=(1)*(1)
XADC_XN11_XCM_XP (INN XADC_XN11_ACQB XADC_BN11 VDD) pfet_01v8_lvt w=(26.88u) l=350n m=(1)*(1)
XADC_XP11_XRN_XP (RN XADC_XP11_NLB XADC_BP11 VDD) pfet_01v8_lvt w=(26.88u) l=350n m=(1)*(1)
XADC_XP11_XRP_XP (RP XADC_XP11_PHB XADC_BP11 VDD) pfet_01v8_lvt w=(26.88u) l=350n m=(1)*(1)
XADC_XP11_XCM_XP (INP XADC_XP11_ACQB XADC_BP11 VDD) pfet_01v8_lvt w=(26.88u) l=350n m=(1)*(1)
XADC_XN10_XRN_XP (RP XADC_XN10_NLB XADC_BN10 VDD) pfet_01v8_lvt w=(26.88u) l=350n m=(1)*(1)
XADC_XN10_XRP_XP (RN XADC_XN10_PHB XADC_BN10 VDD) pfet_01v8_lvt w=(26.88u) l=350n m=(1)*(1)
XADC_XN10_XCM_XP (INN XADC_XN10_ACQB XADC_BN10 VDD) pfet_01v8_lvt w=(26.88u) l=350n m=(1)*(1)
XADC_XP10_XRN_XP (RN XADC_XP10_NLB XADC_BP10 VDD) pfet_01v8_lvt w=(26.88u) l=350n m=(1)*(1)
XADC_XP10_XRP_XP (RP XADC_XP10_PHB XADC_BP10 VDD) pfet_01v8_lvt w=(26.88u) l=350n m=(1)*(1)
XADC_XP10_XCM_XP (INP XADC_XP10_ACQB XADC_BP10 VDD) pfet_01v8_lvt w=(26.88u) l=350n m=(1)*(1)
XADC_XN9_XRN_XP (RP XADC_XN9_NLB XADC_BN9 VDD) pfet_01v8_lvt w=(26.88u) l=350n m=(1)*(1)
XADC_XN9_XRP_XP (RN XADC_XN9_PHB XADC_BN9 VDD) pfet_01v8_lvt w=(26.88u) l=350n m=(1)*(1)
XADC_XN9_XCM_XP (INN XADC_XN9_ACQB XADC_BN9 VDD) pfet_01v8_lvt w=(26.88u) l=350n m=(1)*(1)
XADC_XP9_XRN_XP (RN XADC_XP9_NLB XADC_BP9 VDD) pfet_01v8_lvt w=(26.88u) l=350n m=(1)*(1)
XADC_XP9_XRP_XP (RP XADC_XP9_PHB XADC_BP9 VDD) pfet_01v8_lvt w=(26.88u) l=350n m=(1)*(1)
XADC_XP9_XCM_XP (INP XADC_XP9_ACQB XADC_BP9 VDD) pfet_01v8_lvt w=(26.88u) l=350n m=(1)*(1)
XADC_XN8_XRN_XP (RP XADC_XN8_NLB XADC_BN8 VDD) pfet_01v8_lvt w=(26.88u) l=350n m=(1)*(1)
XADC_XN8_XRP_XP (RN XADC_XN8_PHB XADC_BN8 VDD) pfet_01v8_lvt w=(26.88u) l=350n m=(1)*(1)
XADC_XN8_XCM_XP (INN XADC_XN8_ACQB XADC_BN8 VDD) pfet_01v8_lvt w=(26.88u) l=350n m=(1)*(1)
XADC_XP8_XRN_XP (RN XADC_XP8_NLB XADC_BP8 VDD) pfet_01v8_lvt w=(26.88u) l=350n m=(1)*(1)
XADC_XP8_XRP_XP (RP XADC_XP8_PHB XADC_BP8 VDD) pfet_01v8_lvt w=(26.88u) l=350n m=(1)*(1)
XADC_XP8_XCM_XP (INP XADC_XP8_ACQB XADC_BP8 VDD) pfet_01v8_lvt w=(26.88u) l=350n m=(1)*(1)
XADC_XN7_XRN_XP (RP XADC_XN7_NLB XADC_BN7 VDD) pfet_01v8_lvt w=(19.005u) l=350n m=(1)*(1)
XADC_XN7_XRP_XP (RN XADC_XN7_PHB XADC_BN7 VDD) pfet_01v8_lvt w=(19.005u) l=350n m=(1)*(1)
XADC_XN7_XCM_XP (INN XADC_XN7_ACQB XADC_BN7 VDD) pfet_01v8_lvt w=(19.005u) l=350n m=(1)*(1)
XADC_XP7_XRN_XP (RN XADC_XP7_NLB XADC_BP7 VDD) pfet_01v8_lvt w=(19.005u) l=350n m=(1)*(1)
XADC_XP7_XRP_XP (RP XADC_XP7_PHB XADC_BP7 VDD) pfet_01v8_lvt w=(19.005u) l=350n m=(1)*(1)
XADC_XP7_XCM_XP (INP XADC_XP7_ACQB XADC_BP7 VDD) pfet_01v8_lvt w=(19.005u) l=350n m=(1)*(1)
XADC_XN6_XRN_XP (RP XADC_XN6_NLB XADC_BN6 VDD) pfet_01v8_lvt w=(13.44u) l=350n m=(1)*(1)
XADC_XN6_XRP_XP (RN XADC_XN6_PHB XADC_BN6 VDD) pfet_01v8_lvt w=(13.44u) l=350n m=(1)*(1)
XADC_XN6_XCM_XP (INN XADC_XN6_ACQB XADC_BN6 VDD) pfet_01v8_lvt w=(13.44u) l=350n m=(1)*(1)
XADC_XP6_XRN_XP (RN XADC_XP6_NLB XADC_BP6 VDD) pfet_01v8_lvt w=(13.44u) l=350n m=(1)*(1)
XADC_XP6_XRP_XP (RP XADC_XP6_PHB XADC_BP6 VDD) pfet_01v8_lvt w=(13.44u) l=350n m=(1)*(1)
XADC_XP6_XCM_XP (INP XADC_XP6_ACQB XADC_BP6 VDD) pfet_01v8_lvt w=(13.44u) l=350n m=(1)*(1)
XADC_XN5_XRN_XP (RP XADC_XN5_NLB XADC_BN5 VDD) pfet_01v8_lvt w=(9.505u) l=350n m=(1)*(1)
XADC_XN5_XRP_XP (RN XADC_XN5_PHB XADC_BN5 VDD) pfet_01v8_lvt w=(9.505u) l=350n m=(1)*(1)
XADC_XN5_XCM_XP (INN XADC_XN5_ACQB XADC_BN5 VDD) pfet_01v8_lvt w=(9.505u) l=350n m=(1)*(1)
XADC_XP5_XRN_XP (RN XADC_XP5_NLB XADC_BP5 VDD) pfet_01v8_lvt w=(9.505u) l=350n m=(1)*(1)
XADC_XP5_XRP_XP (RP XADC_XP5_PHB XADC_BP5 VDD) pfet_01v8_lvt w=(9.505u) l=350n m=(1)*(1)
XADC_XP5_XCM_XP (INP XADC_XP5_ACQB XADC_BP5 VDD) pfet_01v8_lvt w=(9.505u) l=350n m=(1)*(1)
XADC_XN4_XRN_XP (RP XADC_XN4_NLB XADC_BN4 VDD) pfet_01v8_lvt w=(6.72u) l=350n m=(1)*(1)
XADC_XN4_XRP_XP (RN XADC_XN4_PHB XADC_BN4 VDD) pfet_01v8_lvt w=(6.72u) l=350n m=(1)*(1)
XADC_XN4_XCM_XP (INN XADC_XN4_ACQB XADC_BN4 VDD) pfet_01v8_lvt w=(6.72u) l=350n m=(1)*(1)
XADC_XP4_XRN_XP (RN XADC_XP4_NLB XADC_BP4 VDD) pfet_01v8_lvt w=(6.72u) l=350n m=(1)*(1)
XADC_XP4_XRP_XP (RP XADC_XP4_PHB XADC_BP4 VDD) pfet_01v8_lvt w=(6.72u) l=350n m=(1)*(1)
XADC_XP4_XCM_XP (INP XADC_XP4_ACQB XADC_BP4 VDD) pfet_01v8_lvt w=(6.72u) l=350n m=(1)*(1)
XADC_XN3_XRN_XP (RP XADC_XN3_NLB XADC_BN3 VDD) pfet_01v8_lvt w=(4.75u) l=350n m=(1)*(1)
XADC_XN3_XRP_XP (RN XADC_XN3_PHB XADC_BN3 VDD) pfet_01v8_lvt w=(4.75u) l=350n m=(1)*(1)
XADC_XN3_XCM_XP (INN XADC_XN3_ACQB XADC_BN3 VDD) pfet_01v8_lvt w=(4.75u) l=350n m=(1)*(1)
XADC_XP3_XRN_XP (RN XADC_XP3_NLB XADC_BP3 VDD) pfet_01v8_lvt w=(4.75u) l=350n m=(1)*(1)
XADC_XP3_XRP_XP (RP XADC_XP3_PHB XADC_BP3 VDD) pfet_01v8_lvt w=(4.75u) l=350n m=(1)*(1)
XADC_XP3_XCM_XP (INP XADC_XP3_ACQB XADC_BP3 VDD) pfet_01v8_lvt w=(4.75u) l=350n m=(1)*(1)
XADC_XN2_XRN_XP (RP XADC_XN2_NLB XADC_BN2 VDD) pfet_01v8_lvt w=(3.36u) l=350n m=(1)*(1)
XADC_XN2_XRP_XP (RN XADC_XN2_PHB XADC_BN2 VDD) pfet_01v8_lvt w=(3.36u) l=350n m=(1)*(1)
XADC_XN2_XCM_XP (INN XADC_XN2_ACQB XADC_BN2 VDD) pfet_01v8_lvt w=(3.36u) l=350n m=(1)*(1)
XADC_XP2_XRN_XP (RN XADC_XP2_NLB XADC_BP2 VDD) pfet_01v8_lvt w=(3.36u) l=350n m=(1)*(1)
XADC_XP2_XRP_XP (RP XADC_XP2_PHB XADC_BP2 VDD) pfet_01v8_lvt w=(3.36u) l=350n m=(1)*(1)
XADC_XP2_XCM_XP (INP XADC_XP2_ACQB XADC_BP2 VDD) pfet_01v8_lvt w=(3.36u) l=350n m=(1)*(1)
XADC_XN1_XRN_XP (RP XADC_XN1_NLB XADC_BN1 VDD) pfet_01v8_lvt w=(2.375u) l=350n m=(1)*(1)
XADC_XN1_XRP_XP (RN XADC_XN1_PHB XADC_BN1 VDD) pfet_01v8_lvt w=(2.375u) l=350n m=(1)*(1)
XADC_XN1_XCM_XP (INN XADC_XN1_ACQB XADC_BN1 VDD) pfet_01v8_lvt w=(2.375u) l=350n m=(1)*(1)
XADC_XP1_XRN_XP (RN XADC_XP1_NLB XADC_BP1 VDD) pfet_01v8_lvt w=(2.375u) l=350n m=(1)*(1)
XADC_XP1_XRP_XP (RP XADC_XP1_PHB XADC_BP1 VDD) pfet_01v8_lvt w=(2.375u) l=350n m=(1)*(1)
XADC_XP1_XCM_XP (INP XADC_XP1_ACQB XADC_BP1 VDD) pfet_01v8_lvt w=(2.375u) l=350n m=(1)*(1)
XADC_XN0_XRN_XP (RP XADC_XN0_NLB XADC_BN0 VDD) pfet_01v8_lvt w=(1.68u) l=350n m=(1)*(1)
XADC_XN0_XRP_XP (RN XADC_XN0_PHB XADC_BN0 VDD) pfet_01v8_lvt w=(1.68u) l=350n m=(1)*(1)
XADC_XN0_XCM_XP (INN XADC_XN0_ACQB XADC_BN0 VDD) pfet_01v8_lvt w=(1.68u) l=350n m=(1)*(1)
XADC_XP0_XRN_XP (RN XADC_XP0_NLB XADC_BP0 VDD) pfet_01v8_lvt w=(1.68u) l=350n m=(1)*(1)
XADC_XP0_XRP_XP (RP XADC_XP0_PHB XADC_BP0 VDD) pfet_01v8_lvt w=(1.68u) l=350n m=(1)*(1)
XADC_XP0_XCM_XP (INP XADC_XP0_ACQB XADC_BP0 VDD) pfet_01v8_lvt w=(1.68u) l=350n m=(1)*(1)
XADC_XSN_XPD (XADC_TN SAMPLE XADC_TN VDD) pfet_01v8_lvt w=(4u) l=350n m=(1)*(1)
XADC_XSN_XP (XADC_TN SAMPLEB VCM VDD) pfet_01v8_lvt w=(8u) l=350n m=(1)*(1)
XADC_XSP_XPD (XADC_TP SAMPLE XADC_TP VDD) pfet_01v8_lvt w=(4u) l=350n m=(1)*(1)
XADC_XSP_XP (XADC_TP SAMPLEB VCM VDD) pfet_01v8_lvt w=(8u) l=350n m=(1)*(1)
XADC_XDN_XNI_XP (XADC_XDN_NL XADC_XDN_NLB VDD VDD) pfet_01v8 w=(2u) l=150n m=(1)*(1)
XADC_XDN_XNL_XP2 (XADC_XDN_NLB XADC_XDN_BITB VDD VDD) pfet_01v8 w=(2u) l=150n m=(1)*(1)
XADC_XDN_XNL_XP1 (XADC_XDN_NLB CONV VDD VDD) pfet_01v8 w=(2u) l=150n m=(1)*(1)
XADC_XDN_XPI_XP (XADC_XDN_PH XADC_XDN_PHB VDD VDD) pfet_01v8 w=(2u) l=150n m=(1)*(1)
XADC_XDN_XPH_XP2 (XADC_XDN_PHB VDD VDD VDD) pfet_01v8 w=(2u) l=150n m=(1)*(1)
XADC_XDN_XPH_XP1 (XADC_XDN_PHB CONV VDD VDD) pfet_01v8 w=(2u) l=150n m=(1)*(1)
XADC_XDN_XAI_XP (XADC_XDN_ACQB ACQ VDD VDD) pfet_01v8 w=(2u) l=150n m=(1)*(1)
XADC_XDN_XBI_XP (XADC_XDN_BITB VDD VDD VDD) pfet_01v8 w=(2u) l=150n m=(1)*(1)
XADC_XDP_XNI_XP (XADC_XDP_NL XADC_XDP_NLB VDD VDD) pfet_01v8 w=(2u) l=150n m=(1)*(1)
XADC_XDP_XNL_XP2 (XADC_XDP_NLB XADC_XDP_BITB VDD VDD) pfet_01v8 w=(2u) l=150n m=(1)*(1)
XADC_XDP_XNL_XP1 (XADC_XDP_NLB CONV VDD VDD) pfet_01v8 w=(2u) l=150n m=(1)*(1)
XADC_XDP_XPI_XP (XADC_XDP_PH XADC_XDP_PHB VDD VDD) pfet_01v8 w=(2u) l=150n m=(1)*(1)
XADC_XDP_XPH_XP2 (XADC_XDP_PHB VSS VDD VDD) pfet_01v8 w=(2u) l=150n m=(1)*(1)
XADC_XDP_XPH_XP1 (XADC_XDP_PHB CONV VDD VDD) pfet_01v8 w=(2u) l=150n m=(1)*(1)
XADC_XDP_XAI_XP (XADC_XDP_ACQB ACQ VDD VDD) pfet_01v8 w=(2u) l=150n m=(1)*(1)
XADC_XDP_XBI_XP (XADC_XDP_BITB VSS VDD VDD) pfet_01v8 w=(2u) l=150n m=(1)*(1)
XADC_XN11_XNI_XP (XADC_XN11_NL XADC_XN11_NLB VDD VDD) pfet_01v8 w=(2u) l=150n m=(1)*(1)
XADC_XN11_XNL_XP2 (XADC_XN11_NLB XADC_XN11_BITB VDD VDD) pfet_01v8 w=(2u) l=150n m=(1)*(1)
XADC_XN11_XNL_XP1 (XADC_XN11_NLB CONV VDD VDD) pfet_01v8 w=(2u) l=150n m=(1)*(1)
XADC_XN11_XPI_XP (XADC_XN11_PH XADC_XN11_PHB VDD VDD) pfet_01v8 w=(2u) l=150n m=(1)*(1)
XADC_XN11_XPH_XP2 (XADC_XN11_PHB B11 VDD VDD) pfet_01v8 w=(2u) l=150n m=(1)*(1)
XADC_XN11_XPH_XP1 (XADC_XN11_PHB CONV VDD VDD) pfet_01v8 w=(2u) l=150n m=(1)*(1)
XADC_XN11_XAI_XP (XADC_XN11_ACQB ACQ VDD VDD) pfet_01v8 w=(2u) l=150n m=(1)*(1)
XADC_XN11_XBI_XP (XADC_XN11_BITB B11 VDD VDD) pfet_01v8 w=(2u) l=150n m=(1)*(1)
XADC_XP11_XNI_XP (XADC_XP11_NL XADC_XP11_NLB VDD VDD) pfet_01v8 w=(2u) l=150n m=(1)*(1)
XADC_XP11_XNL_XP2 (XADC_XP11_NLB XADC_XP11_BITB VDD VDD) pfet_01v8 w=(2u) l=150n m=(1)*(1)
XADC_XP11_XNL_XP1 (XADC_XP11_NLB CONV VDD VDD) pfet_01v8 w=(2u) l=150n m=(1)*(1)
XADC_XP11_XPI_XP (XADC_XP11_PH XADC_XP11_PHB VDD VDD) pfet_01v8 w=(2u) l=150n m=(1)*(1)
XADC_XP11_XPH_XP2 (XADC_XP11_PHB B11 VDD VDD) pfet_01v8 w=(2u) l=150n m=(1)*(1)
XADC_XP11_XPH_XP1 (XADC_XP11_PHB CONV VDD VDD) pfet_01v8 w=(2u) l=150n m=(1)*(1)
XADC_XP11_XAI_XP (XADC_XP11_ACQB ACQ VDD VDD) pfet_01v8 w=(2u) l=150n m=(1)*(1)
XADC_XP11_XBI_XP (XADC_XP11_BITB B11 VDD VDD) pfet_01v8 w=(2u) l=150n m=(1)*(1)
XADC_XN10_XNI_XP (XADC_XN10_NL XADC_XN10_NLB VDD VDD) pfet_01v8 w=(2u) l=150n m=(1)*(1)
XADC_XN10_XNL_XP2 (XADC_XN10_NLB XADC_XN10_BITB VDD VDD) pfet_01v8 w=(2u) l=150n m=(1)*(1)
XADC_XN10_XNL_XP1 (XADC_XN10_NLB CONV VDD VDD) pfet_01v8 w=(2u) l=150n m=(1)*(1)
XADC_XN10_XPI_XP (XADC_XN10_PH XADC_XN10_PHB VDD VDD) pfet_01v8 w=(2u) l=150n m=(1)*(1)
XADC_XN10_XPH_XP2 (XADC_XN10_PHB B10 VDD VDD) pfet_01v8 w=(2u) l=150n m=(1)*(1)
XADC_XN10_XPH_XP1 (XADC_XN10_PHB CONV VDD VDD) pfet_01v8 w=(2u) l=150n m=(1)*(1)
XADC_XN10_XAI_XP (XADC_XN10_ACQB ACQ VDD VDD) pfet_01v8 w=(2u) l=150n m=(1)*(1)
XADC_XN10_XBI_XP (XADC_XN10_BITB B10 VDD VDD) pfet_01v8 w=(2u) l=150n m=(1)*(1)
XADC_XP10_XNI_XP (XADC_XP10_NL XADC_XP10_NLB VDD VDD) pfet_01v8 w=(2u) l=150n m=(1)*(1)
XADC_XP10_XNL_XP2 (XADC_XP10_NLB XADC_XP10_BITB VDD VDD) pfet_01v8 w=(2u) l=150n m=(1)*(1)
XADC_XP10_XNL_XP1 (XADC_XP10_NLB CONV VDD VDD) pfet_01v8 w=(2u) l=150n m=(1)*(1)
XADC_XP10_XPI_XP (XADC_XP10_PH XADC_XP10_PHB VDD VDD) pfet_01v8 w=(2u) l=150n m=(1)*(1)
XADC_XP10_XPH_XP2 (XADC_XP10_PHB B10 VDD VDD) pfet_01v8 w=(2u) l=150n m=(1)*(1)
XADC_XP10_XPH_XP1 (XADC_XP10_PHB CONV VDD VDD) pfet_01v8 w=(2u) l=150n m=(1)*(1)
XADC_XP10_XAI_XP (XADC_XP10_ACQB ACQ VDD VDD) pfet_01v8 w=(2u) l=150n m=(1)*(1)
XADC_XP10_XBI_XP (XADC_XP10_BITB B10 VDD VDD) pfet_01v8 w=(2u) l=150n m=(1)*(1)
XADC_XN9_XNI_XP (XADC_XN9_NL XADC_XN9_NLB VDD VDD) pfet_01v8 w=(2u) l=150n m=(1)*(1)
XADC_XN9_XNL_XP2 (XADC_XN9_NLB XADC_XN9_BITB VDD VDD) pfet_01v8 w=(2u) l=150n m=(1)*(1)
XADC_XN9_XNL_XP1 (XADC_XN9_NLB CONV VDD VDD) pfet_01v8 w=(2u) l=150n m=(1)*(1)
XADC_XN9_XPI_XP (XADC_XN9_PH XADC_XN9_PHB VDD VDD) pfet_01v8 w=(2u) l=150n m=(1)*(1)
XADC_XN9_XPH_XP2 (XADC_XN9_PHB B9 VDD VDD) pfet_01v8 w=(2u) l=150n m=(1)*(1)
XADC_XN9_XPH_XP1 (XADC_XN9_PHB CONV VDD VDD) pfet_01v8 w=(2u) l=150n m=(1)*(1)
XADC_XN9_XAI_XP (XADC_XN9_ACQB ACQ VDD VDD) pfet_01v8 w=(2u) l=150n m=(1)*(1)
XADC_XN9_XBI_XP (XADC_XN9_BITB B9 VDD VDD) pfet_01v8 w=(2u) l=150n m=(1)*(1)
XADC_XP9_XNI_XP (XADC_XP9_NL XADC_XP9_NLB VDD VDD) pfet_01v8 w=(2u) l=150n m=(1)*(1)
XADC_XP9_XNL_XP2 (XADC_XP9_NLB XADC_XP9_BITB VDD VDD) pfet_01v8 w=(2u) l=150n m=(1)*(1)
XADC_XP9_XNL_XP1 (XADC_XP9_NLB CONV VDD VDD) pfet_01v8 w=(2u) l=150n m=(1)*(1)
XADC_XP9_XPI_XP (XADC_XP9_PH XADC_XP9_PHB VDD VDD) pfet_01v8 w=(2u) l=150n m=(1)*(1)
XADC_XP9_XPH_XP2 (XADC_XP9_PHB B9 VDD VDD) pfet_01v8 w=(2u) l=150n m=(1)*(1)
XADC_XP9_XPH_XP1 (XADC_XP9_PHB CONV VDD VDD) pfet_01v8 w=(2u) l=150n m=(1)*(1)
XADC_XP9_XAI_XP (XADC_XP9_ACQB ACQ VDD VDD) pfet_01v8 w=(2u) l=150n m=(1)*(1)
XADC_XP9_XBI_XP (XADC_XP9_BITB B9 VDD VDD) pfet_01v8 w=(2u) l=150n m=(1)*(1)
XADC_XN8_XNI_XP (XADC_XN8_NL XADC_XN8_NLB VDD VDD) pfet_01v8 w=(2u) l=150n m=(1)*(1)
XADC_XN8_XNL_XP2 (XADC_XN8_NLB XADC_XN8_BITB VDD VDD) pfet_01v8 w=(2u) l=150n m=(1)*(1)
XADC_XN8_XNL_XP1 (XADC_XN8_NLB CONV VDD VDD) pfet_01v8 w=(2u) l=150n m=(1)*(1)
XADC_XN8_XPI_XP (XADC_XN8_PH XADC_XN8_PHB VDD VDD) pfet_01v8 w=(2u) l=150n m=(1)*(1)
XADC_XN8_XPH_XP2 (XADC_XN8_PHB B8 VDD VDD) pfet_01v8 w=(2u) l=150n m=(1)*(1)
XADC_XN8_XPH_XP1 (XADC_XN8_PHB CONV VDD VDD) pfet_01v8 w=(2u) l=150n m=(1)*(1)
XADC_XN8_XAI_XP (XADC_XN8_ACQB ACQ VDD VDD) pfet_01v8 w=(2u) l=150n m=(1)*(1)
XADC_XN8_XBI_XP (XADC_XN8_BITB B8 VDD VDD) pfet_01v8 w=(2u) l=150n m=(1)*(1)
XADC_XP8_XNI_XP (XADC_XP8_NL XADC_XP8_NLB VDD VDD) pfet_01v8 w=(2u) l=150n m=(1)*(1)
XADC_XP8_XNL_XP2 (XADC_XP8_NLB XADC_XP8_BITB VDD VDD) pfet_01v8 w=(2u) l=150n m=(1)*(1)
XADC_XP8_XNL_XP1 (XADC_XP8_NLB CONV VDD VDD) pfet_01v8 w=(2u) l=150n m=(1)*(1)
XADC_XP8_XPI_XP (XADC_XP8_PH XADC_XP8_PHB VDD VDD) pfet_01v8 w=(2u) l=150n m=(1)*(1)
XADC_XP8_XPH_XP2 (XADC_XP8_PHB B8 VDD VDD) pfet_01v8 w=(2u) l=150n m=(1)*(1)
XADC_XP8_XPH_XP1 (XADC_XP8_PHB CONV VDD VDD) pfet_01v8 w=(2u) l=150n m=(1)*(1)
XADC_XP8_XAI_XP (XADC_XP8_ACQB ACQ VDD VDD) pfet_01v8 w=(2u) l=150n m=(1)*(1)
XADC_XP8_XBI_XP (XADC_XP8_BITB B8 VDD VDD) pfet_01v8 w=(2u) l=150n m=(1)*(1)
XADC_XN7_XNI_XP (XADC_XN7_NL XADC_XN7_NLB VDD VDD) pfet_01v8 w=(2u) l=150n m=(1)*(1)
XADC_XN7_XNL_XP2 (XADC_XN7_NLB XADC_XN7_BITB VDD VDD) pfet_01v8 w=(2u) l=150n m=(1)*(1)
XADC_XN7_XNL_XP1 (XADC_XN7_NLB CONV VDD VDD) pfet_01v8 w=(2u) l=150n m=(1)*(1)
XADC_XN7_XPI_XP (XADC_XN7_PH XADC_XN7_PHB VDD VDD) pfet_01v8 w=(2u) l=150n m=(1)*(1)
XADC_XN7_XPH_XP2 (XADC_XN7_PHB B7 VDD VDD) pfet_01v8 w=(2u) l=150n m=(1)*(1)
XADC_XN7_XPH_XP1 (XADC_XN7_PHB CONV VDD VDD) pfet_01v8 w=(2u) l=150n m=(1)*(1)
XADC_XN7_XAI_XP (XADC_XN7_ACQB ACQ VDD VDD) pfet_01v8 w=(2u) l=150n m=(1)*(1)
XADC_XN7_XBI_XP (XADC_XN7_BITB B7 VDD VDD) pfet_01v8 w=(2u) l=150n m=(1)*(1)
XADC_XP7_XNI_XP (XADC_XP7_NL XADC_XP7_NLB VDD VDD) pfet_01v8 w=(2u) l=150n m=(1)*(1)
XADC_XP7_XNL_XP2 (XADC_XP7_NLB XADC_XP7_BITB VDD VDD) pfet_01v8 w=(2u) l=150n m=(1)*(1)
XADC_XP7_XNL_XP1 (XADC_XP7_NLB CONV VDD VDD) pfet_01v8 w=(2u) l=150n m=(1)*(1)
XADC_XP7_XPI_XP (XADC_XP7_PH XADC_XP7_PHB VDD VDD) pfet_01v8 w=(2u) l=150n m=(1)*(1)
XADC_XP7_XPH_XP2 (XADC_XP7_PHB B7 VDD VDD) pfet_01v8 w=(2u) l=150n m=(1)*(1)
XADC_XP7_XPH_XP1 (XADC_XP7_PHB CONV VDD VDD) pfet_01v8 w=(2u) l=150n m=(1)*(1)
XADC_XP7_XAI_XP (XADC_XP7_ACQB ACQ VDD VDD) pfet_01v8 w=(2u) l=150n m=(1)*(1)
XADC_XP7_XBI_XP (XADC_XP7_BITB B7 VDD VDD) pfet_01v8 w=(2u) l=150n m=(1)*(1)
XADC_XN6_XNI_XP (XADC_XN6_NL XADC_XN6_NLB VDD VDD) pfet_01v8 w=(2u) l=150n m=(1)*(1)
XADC_XN6_XNL_XP2 (XADC_XN6_NLB XADC_XN6_BITB VDD VDD) pfet_01v8 w=(2u) l=150n m=(1)*(1)
XADC_XN6_XNL_XP1 (XADC_XN6_NLB CONV VDD VDD) pfet_01v8 w=(2u) l=150n m=(1)*(1)
XADC_XN6_XPI_XP (XADC_XN6_PH XADC_XN6_PHB VDD VDD) pfet_01v8 w=(2u) l=150n m=(1)*(1)
XADC_XN6_XPH_XP2 (XADC_XN6_PHB B6 VDD VDD) pfet_01v8 w=(2u) l=150n m=(1)*(1)
XADC_XN6_XPH_XP1 (XADC_XN6_PHB CONV VDD VDD) pfet_01v8 w=(2u) l=150n m=(1)*(1)
XADC_XN6_XAI_XP (XADC_XN6_ACQB ACQ VDD VDD) pfet_01v8 w=(2u) l=150n m=(1)*(1)
XADC_XN6_XBI_XP (XADC_XN6_BITB B6 VDD VDD) pfet_01v8 w=(2u) l=150n m=(1)*(1)
XADC_XP6_XNI_XP (XADC_XP6_NL XADC_XP6_NLB VDD VDD) pfet_01v8 w=(2u) l=150n m=(1)*(1)
XADC_XP6_XNL_XP2 (XADC_XP6_NLB XADC_XP6_BITB VDD VDD) pfet_01v8 w=(2u) l=150n m=(1)*(1)
XADC_XP6_XNL_XP1 (XADC_XP6_NLB CONV VDD VDD) pfet_01v8 w=(2u) l=150n m=(1)*(1)
XADC_XP6_XPI_XP (XADC_XP6_PH XADC_XP6_PHB VDD VDD) pfet_01v8 w=(2u) l=150n m=(1)*(1)
XADC_XP6_XPH_XP2 (XADC_XP6_PHB B6 VDD VDD) pfet_01v8 w=(2u) l=150n m=(1)*(1)
XADC_XP6_XPH_XP1 (XADC_XP6_PHB CONV VDD VDD) pfet_01v8 w=(2u) l=150n m=(1)*(1)
XADC_XP6_XAI_XP (XADC_XP6_ACQB ACQ VDD VDD) pfet_01v8 w=(2u) l=150n m=(1)*(1)
XADC_XP6_XBI_XP (XADC_XP6_BITB B6 VDD VDD) pfet_01v8 w=(2u) l=150n m=(1)*(1)
XADC_XN5_XNI_XP (XADC_XN5_NL XADC_XN5_NLB VDD VDD) pfet_01v8 w=(2u) l=150n m=(1)*(1)
XADC_XN5_XNL_XP2 (XADC_XN5_NLB XADC_XN5_BITB VDD VDD) pfet_01v8 w=(2u) l=150n m=(1)*(1)
XADC_XN5_XNL_XP1 (XADC_XN5_NLB CONV VDD VDD) pfet_01v8 w=(2u) l=150n m=(1)*(1)
XADC_XN5_XPI_XP (XADC_XN5_PH XADC_XN5_PHB VDD VDD) pfet_01v8 w=(2u) l=150n m=(1)*(1)
XADC_XN5_XPH_XP2 (XADC_XN5_PHB B5 VDD VDD) pfet_01v8 w=(2u) l=150n m=(1)*(1)
XADC_XN5_XPH_XP1 (XADC_XN5_PHB CONV VDD VDD) pfet_01v8 w=(2u) l=150n m=(1)*(1)
XADC_XN5_XAI_XP (XADC_XN5_ACQB ACQ VDD VDD) pfet_01v8 w=(2u) l=150n m=(1)*(1)
XADC_XN5_XBI_XP (XADC_XN5_BITB B5 VDD VDD) pfet_01v8 w=(2u) l=150n m=(1)*(1)
XADC_XP5_XNI_XP (XADC_XP5_NL XADC_XP5_NLB VDD VDD) pfet_01v8 w=(2u) l=150n m=(1)*(1)
XADC_XP5_XNL_XP2 (XADC_XP5_NLB XADC_XP5_BITB VDD VDD) pfet_01v8 w=(2u) l=150n m=(1)*(1)
XADC_XP5_XNL_XP1 (XADC_XP5_NLB CONV VDD VDD) pfet_01v8 w=(2u) l=150n m=(1)*(1)
XADC_XP5_XPI_XP (XADC_XP5_PH XADC_XP5_PHB VDD VDD) pfet_01v8 w=(2u) l=150n m=(1)*(1)
XADC_XP5_XPH_XP2 (XADC_XP5_PHB B5 VDD VDD) pfet_01v8 w=(2u) l=150n m=(1)*(1)
XADC_XP5_XPH_XP1 (XADC_XP5_PHB CONV VDD VDD) pfet_01v8 w=(2u) l=150n m=(1)*(1)
XADC_XP5_XAI_XP (XADC_XP5_ACQB ACQ VDD VDD) pfet_01v8 w=(2u) l=150n m=(1)*(1)
XADC_XP5_XBI_XP (XADC_XP5_BITB B5 VDD VDD) pfet_01v8 w=(2u) l=150n m=(1)*(1)
XADC_XN4_XNI_XP (XADC_XN4_NL XADC_XN4_NLB VDD VDD) pfet_01v8 w=(2u) l=150n m=(1)*(1)
XADC_XN4_XNL_XP2 (XADC_XN4_NLB XADC_XN4_BITB VDD VDD) pfet_01v8 w=(2u) l=150n m=(1)*(1)
XADC_XN4_XNL_XP1 (XADC_XN4_NLB CONV VDD VDD) pfet_01v8 w=(2u) l=150n m=(1)*(1)
XADC_XN4_XPI_XP (XADC_XN4_PH XADC_XN4_PHB VDD VDD) pfet_01v8 w=(2u) l=150n m=(1)*(1)
XADC_XN4_XPH_XP2 (XADC_XN4_PHB B4 VDD VDD) pfet_01v8 w=(2u) l=150n m=(1)*(1)
XADC_XN4_XPH_XP1 (XADC_XN4_PHB CONV VDD VDD) pfet_01v8 w=(2u) l=150n m=(1)*(1)
XADC_XN4_XAI_XP (XADC_XN4_ACQB ACQ VDD VDD) pfet_01v8 w=(2u) l=150n m=(1)*(1)
XADC_XN4_XBI_XP (XADC_XN4_BITB B4 VDD VDD) pfet_01v8 w=(2u) l=150n m=(1)*(1)
XADC_XP4_XNI_XP (XADC_XP4_NL XADC_XP4_NLB VDD VDD) pfet_01v8 w=(2u) l=150n m=(1)*(1)
XADC_XP4_XNL_XP2 (XADC_XP4_NLB XADC_XP4_BITB VDD VDD) pfet_01v8 w=(2u) l=150n m=(1)*(1)
XADC_XP4_XNL_XP1 (XADC_XP4_NLB CONV VDD VDD) pfet_01v8 w=(2u) l=150n m=(1)*(1)
XADC_XP4_XPI_XP (XADC_XP4_PH XADC_XP4_PHB VDD VDD) pfet_01v8 w=(2u) l=150n m=(1)*(1)
XADC_XP4_XPH_XP2 (XADC_XP4_PHB B4 VDD VDD) pfet_01v8 w=(2u) l=150n m=(1)*(1)
XADC_XP4_XPH_XP1 (XADC_XP4_PHB CONV VDD VDD) pfet_01v8 w=(2u) l=150n m=(1)*(1)
XADC_XP4_XAI_XP (XADC_XP4_ACQB ACQ VDD VDD) pfet_01v8 w=(2u) l=150n m=(1)*(1)
XADC_XP4_XBI_XP (XADC_XP4_BITB B4 VDD VDD) pfet_01v8 w=(2u) l=150n m=(1)*(1)
XADC_XN3_XNI_XP (XADC_XN3_NL XADC_XN3_NLB VDD VDD) pfet_01v8 w=(2u) l=150n m=(1)*(1)
XADC_XN3_XNL_XP2 (XADC_XN3_NLB XADC_XN3_BITB VDD VDD) pfet_01v8 w=(2u) l=150n m=(1)*(1)
XADC_XN3_XNL_XP1 (XADC_XN3_NLB CONV VDD VDD) pfet_01v8 w=(2u) l=150n m=(1)*(1)
XADC_XN3_XPI_XP (XADC_XN3_PH XADC_XN3_PHB VDD VDD) pfet_01v8 w=(2u) l=150n m=(1)*(1)
XADC_XN3_XPH_XP2 (XADC_XN3_PHB B3 VDD VDD) pfet_01v8 w=(2u) l=150n m=(1)*(1)
XADC_XN3_XPH_XP1 (XADC_XN3_PHB CONV VDD VDD) pfet_01v8 w=(2u) l=150n m=(1)*(1)
XADC_XN3_XAI_XP (XADC_XN3_ACQB ACQ VDD VDD) pfet_01v8 w=(2u) l=150n m=(1)*(1)
XADC_XN3_XBI_XP (XADC_XN3_BITB B3 VDD VDD) pfet_01v8 w=(2u) l=150n m=(1)*(1)
XADC_XP3_XNI_XP (XADC_XP3_NL XADC_XP3_NLB VDD VDD) pfet_01v8 w=(2u) l=150n m=(1)*(1)
XADC_XP3_XNL_XP2 (XADC_XP3_NLB XADC_XP3_BITB VDD VDD) pfet_01v8 w=(2u) l=150n m=(1)*(1)
XADC_XP3_XNL_XP1 (XADC_XP3_NLB CONV VDD VDD) pfet_01v8 w=(2u) l=150n m=(1)*(1)
XADC_XP3_XPI_XP (XADC_XP3_PH XADC_XP3_PHB VDD VDD) pfet_01v8 w=(2u) l=150n m=(1)*(1)
XADC_XP3_XPH_XP2 (XADC_XP3_PHB B3 VDD VDD) pfet_01v8 w=(2u) l=150n m=(1)*(1)
XADC_XP3_XPH_XP1 (XADC_XP3_PHB CONV VDD VDD) pfet_01v8 w=(2u) l=150n m=(1)*(1)
XADC_XP3_XAI_XP (XADC_XP3_ACQB ACQ VDD VDD) pfet_01v8 w=(2u) l=150n m=(1)*(1)
XADC_XP3_XBI_XP (XADC_XP3_BITB B3 VDD VDD) pfet_01v8 w=(2u) l=150n m=(1)*(1)
XADC_XN2_XNI_XP (XADC_XN2_NL XADC_XN2_NLB VDD VDD) pfet_01v8 w=(2u) l=150n m=(1)*(1)
XADC_XN2_XNL_XP2 (XADC_XN2_NLB XADC_XN2_BITB VDD VDD) pfet_01v8 w=(2u) l=150n m=(1)*(1)
XADC_XN2_XNL_XP1 (XADC_XN2_NLB CONV VDD VDD) pfet_01v8 w=(2u) l=150n m=(1)*(1)
XADC_XN2_XPI_XP (XADC_XN2_PH XADC_XN2_PHB VDD VDD) pfet_01v8 w=(2u) l=150n m=(1)*(1)
XADC_XN2_XPH_XP2 (XADC_XN2_PHB B2 VDD VDD) pfet_01v8 w=(2u) l=150n m=(1)*(1)
XADC_XN2_XPH_XP1 (XADC_XN2_PHB CONV VDD VDD) pfet_01v8 w=(2u) l=150n m=(1)*(1)
XADC_XN2_XAI_XP (XADC_XN2_ACQB ACQ VDD VDD) pfet_01v8 w=(2u) l=150n m=(1)*(1)
XADC_XN2_XBI_XP (XADC_XN2_BITB B2 VDD VDD) pfet_01v8 w=(2u) l=150n m=(1)*(1)
XADC_XP2_XNI_XP (XADC_XP2_NL XADC_XP2_NLB VDD VDD) pfet_01v8 w=(2u) l=150n m=(1)*(1)
XADC_XP2_XNL_XP2 (XADC_XP2_NLB XADC_XP2_BITB VDD VDD) pfet_01v8 w=(2u) l=150n m=(1)*(1)
XADC_XP2_XNL_XP1 (XADC_XP2_NLB CONV VDD VDD) pfet_01v8 w=(2u) l=150n m=(1)*(1)
XADC_XP2_XPI_XP (XADC_XP2_PH XADC_XP2_PHB VDD VDD) pfet_01v8 w=(2u) l=150n m=(1)*(1)
XADC_XP2_XPH_XP2 (XADC_XP2_PHB B2 VDD VDD) pfet_01v8 w=(2u) l=150n m=(1)*(1)
XADC_XP2_XPH_XP1 (XADC_XP2_PHB CONV VDD VDD) pfet_01v8 w=(2u) l=150n m=(1)*(1)
XADC_XP2_XAI_XP (XADC_XP2_ACQB ACQ VDD VDD) pfet_01v8 w=(2u) l=150n m=(1)*(1)
XADC_XP2_XBI_XP (XADC_XP2_BITB B2 VDD VDD) pfet_01v8 w=(2u) l=150n m=(1)*(1)
XADC_XN1_XNI_XP (XADC_XN1_NL XADC_XN1_NLB VDD VDD) pfet_01v8 w=(2u) l=150n m=(1)*(1)
XADC_XN1_XNL_XP2 (XADC_XN1_NLB XADC_XN1_BITB VDD VDD) pfet_01v8 w=(2u) l=150n m=(1)*(1)
XADC_XN1_XNL_XP1 (XADC_XN1_NLB CONV VDD VDD) pfet_01v8 w=(2u) l=150n m=(1)*(1)
XADC_XN1_XPI_XP (XADC_XN1_PH XADC_XN1_PHB VDD VDD) pfet_01v8 w=(2u) l=150n m=(1)*(1)
XADC_XN1_XPH_XP2 (XADC_XN1_PHB B1 VDD VDD) pfet_01v8 w=(2u) l=150n m=(1)*(1)
XADC_XN1_XPH_XP1 (XADC_XN1_PHB CONV VDD VDD) pfet_01v8 w=(2u) l=150n m=(1)*(1)
XADC_XN1_XAI_XP (XADC_XN1_ACQB ACQ VDD VDD) pfet_01v8 w=(2u) l=150n m=(1)*(1)
XADC_XN1_XBI_XP (XADC_XN1_BITB B1 VDD VDD) pfet_01v8 w=(2u) l=150n m=(1)*(1)
XADC_XP1_XNI_XP (XADC_XP1_NL XADC_XP1_NLB VDD VDD) pfet_01v8 w=(2u) l=150n m=(1)*(1)
XADC_XP1_XNL_XP2 (XADC_XP1_NLB XADC_XP1_BITB VDD VDD) pfet_01v8 w=(2u) l=150n m=(1)*(1)
XADC_XP1_XNL_XP1 (XADC_XP1_NLB CONV VDD VDD) pfet_01v8 w=(2u) l=150n m=(1)*(1)
XADC_XP1_XPI_XP (XADC_XP1_PH XADC_XP1_PHB VDD VDD) pfet_01v8 w=(2u) l=150n m=(1)*(1)
XADC_XP1_XPH_XP2 (XADC_XP1_PHB B1 VDD VDD) pfet_01v8 w=(2u) l=150n m=(1)*(1)
XADC_XP1_XPH_XP1 (XADC_XP1_PHB CONV VDD VDD) pfet_01v8 w=(2u) l=150n m=(1)*(1)
XADC_XP1_XAI_XP (XADC_XP1_ACQB ACQ VDD VDD) pfet_01v8 w=(2u) l=150n m=(1)*(1)
XADC_XP1_XBI_XP (XADC_XP1_BITB B1 VDD VDD) pfet_01v8 w=(2u) l=150n m=(1)*(1)
XADC_XN0_XNI_XP (XADC_XN0_NL XADC_XN0_NLB VDD VDD) pfet_01v8 w=(2u) l=150n m=(1)*(1)
XADC_XN0_XNL_XP2 (XADC_XN0_NLB XADC_XN0_BITB VDD VDD) pfet_01v8 w=(2u) l=150n m=(1)*(1)
XADC_XN0_XNL_XP1 (XADC_XN0_NLB CONV VDD VDD) pfet_01v8 w=(2u) l=150n m=(1)*(1)
XADC_XN0_XPI_XP (XADC_XN0_PH XADC_XN0_PHB VDD VDD) pfet_01v8 w=(2u) l=150n m=(1)*(1)
XADC_XN0_XPH_XP2 (XADC_XN0_PHB B0 VDD VDD) pfet_01v8 w=(2u) l=150n m=(1)*(1)
XADC_XN0_XPH_XP1 (XADC_XN0_PHB CONV VDD VDD) pfet_01v8 w=(2u) l=150n m=(1)*(1)
XADC_XN0_XAI_XP (XADC_XN0_ACQB ACQ VDD VDD) pfet_01v8 w=(2u) l=150n m=(1)*(1)
XADC_XN0_XBI_XP (XADC_XN0_BITB B0 VDD VDD) pfet_01v8 w=(2u) l=150n m=(1)*(1)
XADC_XP0_XNI_XP (XADC_XP0_NL XADC_XP0_NLB VDD VDD) pfet_01v8 w=(2u) l=150n m=(1)*(1)
XADC_XP0_XNL_XP2 (XADC_XP0_NLB XADC_XP0_BITB VDD VDD) pfet_01v8 w=(2u) l=150n m=(1)*(1)
XADC_XP0_XNL_XP1 (XADC_XP0_NLB CONV VDD VDD) pfet_01v8 w=(2u) l=150n m=(1)*(1)
XADC_XP0_XPI_XP (XADC_XP0_PH XADC_XP0_PHB VDD VDD) pfet_01v8 w=(2u) l=150n m=(1)*(1)
XADC_XP0_XPH_XP2 (XADC_XP0_PHB B0 VDD VDD) pfet_01v8 w=(2u) l=150n m=(1)*(1)
XADC_XP0_XPH_XP1 (XADC_XP0_PHB CONV VDD VDD) pfet_01v8 w=(2u) l=150n m=(1)*(1)
XADC_XP0_XAI_XP (XADC_XP0_ACQB ACQ VDD VDD) pfet_01v8 w=(2u) l=150n m=(1)*(1)
XADC_XP0_XBI_XP (XADC_XP0_BITB B0 VDD VDD) pfet_01v8 w=(2u) l=150n m=(1)*(1)
XADC_XCMP_XRESET_XP2 (QB Q VDD VDD) pfet_01v8 w=(2u) l=150n m=(1)*(1)
XADC_XCMP_XRESET_XP1 (QB XADC_XCMP_BP VDD VDD) pfet_01v8 w=(2u) l=150n m=(1)*(1)
XADC_XCMP_XSET_XP2 (Q QB VDD VDD) pfet_01v8 w=(2u) l=150n m=(1)*(1)
XADC_XCMP_XSET_XP1 (Q XADC_XCMP_BN VDD VDD) pfet_01v8 w=(2u) l=150n m=(1)*(1)
XADC_XCMP_XBN2_XP (XADC_XCMP_BN XADC_XCMP_BNB VDD VDD) pfet_01v8 w=(2u) l=150n m=(1)*(1)
XADC_XCMP_XBN1_XP (XADC_XCMP_BNB XADC_XCMP_DNEG VDD VDD) pfet_01v8 w=(2u) l=150n m=(1)*(1)
XADC_XCMP_XBP2_XP (XADC_XCMP_BP XADC_XCMP_BPB VDD VDD) pfet_01v8 w=(2u) l=150n m=(1)*(1)
XADC_XCMP_XBP1_XP (XADC_XCMP_BPB XADC_XCMP_DPOS VDD VDD) pfet_01v8 w=(2u) l=150n m=(1)*(1)
XADC_XCMP_XCORE_XRDP (XADC_XCMP_XCORE_DN EVAL VDD VDD) pfet_01v8 w=(2u) l=150n m=(1)*(1)
XADC_XCMP_XCORE_XRDN (XADC_XCMP_XCORE_DP EVAL VDD VDD) pfet_01v8 w=(2u) l=150n m=(1)*(1)
XADC_XCMP_XCORE_XRP (XADC_XCMP_DPOS EVAL VDD VDD) pfet_01v8 w=(2u) l=150n m=(1)*(1)
XADC_XCMP_XCORE_XRN (XADC_XCMP_DNEG EVAL VDD VDD) pfet_01v8 w=(2u) l=150n m=(1)*(1)
XADC_XCMP_XCORE_XPP (XADC_XCMP_DPOS XADC_XCMP_DNEG VDD VDD) pfet_01v8 w=(8u) l=150n m=(1)*(1)
XADC_XCMP_XCORE_XPN (XADC_XCMP_DNEG XADC_XCMP_DPOS VDD VDD) pfet_01v8 w=(8u) l=150n m=(1)*(1)
XADC_XPRE_XSTPU (XADC_XPRE_START VSS VDD VDD) pfet_01v8 w=(550n) l=10u m=(1)*(1)
XADC_XPRE_XBP2 (XADC_XPRE_BN XADC_XPRE_BP VDD VDD) pfet_01v8 w=(10u) l=1u m=(1)*(1)
XADC_XPRE_XBP1 (XADC_XPRE_BP XADC_XPRE_BP VDD VDD) pfet_01v8 w=(10u) l=1u m=(1)*(1)
XADC_XDN_XNI_XN (XADC_XDN_NL XADC_XDN_NLB VSS VSS) nfet_01v8 w=(1u) l=150n m=(1)*(1)
XADC_XDN_XNL_XN2 (XADC_XDN_XNL_MID XADC_XDN_BITB VSS VSS) nfet_01v8 w=(2u) l=150n m=(1)*(1)
XADC_XDN_XNL_XN1 (XADC_XDN_NLB CONV XADC_XDN_XNL_MID VSS) nfet_01v8 w=(2u) l=150n m=(1)*(1)
XADC_XDN_XPI_XN (XADC_XDN_PH XADC_XDN_PHB VSS VSS) nfet_01v8 w=(1u) l=150n m=(1)*(1)
XADC_XDN_XPH_XN2 (XADC_XDN_XPH_MID VDD VSS VSS) nfet_01v8 w=(2u) l=150n m=(1)*(1)
XADC_XDN_XPH_XN1 (XADC_XDN_PHB CONV XADC_XDN_XPH_MID VSS) nfet_01v8 w=(2u) l=150n m=(1)*(1)
XADC_XDN_XAI_XN (XADC_XDN_ACQB ACQ VSS VSS) nfet_01v8 w=(1u) l=150n m=(1)*(1)
XADC_XDN_XBI_XN (XADC_XDN_BITB VDD VSS VSS) nfet_01v8 w=(1u) l=150n m=(1)*(1)
XADC_XDP_XNI_XN (XADC_XDP_NL XADC_XDP_NLB VSS VSS) nfet_01v8 w=(1u) l=150n m=(1)*(1)
XADC_XDP_XNL_XN2 (XADC_XDP_XNL_MID XADC_XDP_BITB VSS VSS) nfet_01v8 w=(2u) l=150n m=(1)*(1)
XADC_XDP_XNL_XN1 (XADC_XDP_NLB CONV XADC_XDP_XNL_MID VSS) nfet_01v8 w=(2u) l=150n m=(1)*(1)
XADC_XDP_XPI_XN (XADC_XDP_PH XADC_XDP_PHB VSS VSS) nfet_01v8 w=(1u) l=150n m=(1)*(1)
XADC_XDP_XPH_XN2 (XADC_XDP_XPH_MID VSS VSS VSS) nfet_01v8 w=(2u) l=150n m=(1)*(1)
XADC_XDP_XPH_XN1 (XADC_XDP_PHB CONV XADC_XDP_XPH_MID VSS) nfet_01v8 w=(2u) l=150n m=(1)*(1)
XADC_XDP_XAI_XN (XADC_XDP_ACQB ACQ VSS VSS) nfet_01v8 w=(1u) l=150n m=(1)*(1)
XADC_XDP_XBI_XN (XADC_XDP_BITB VSS VSS VSS) nfet_01v8 w=(1u) l=150n m=(1)*(1)
XADC_XN11_XNI_XN (XADC_XN11_NL XADC_XN11_NLB VSS VSS) nfet_01v8 w=(1u) l=150n m=(1)*(1)
XADC_XN11_XNL_XN2 (XADC_XN11_XNL_MID XADC_XN11_BITB VSS VSS) nfet_01v8 w=(2u) l=150n m=(1)*(1)
XADC_XN11_XNL_XN1 (XADC_XN11_NLB CONV XADC_XN11_XNL_MID VSS) nfet_01v8 w=(2u) l=150n m=(1)*(1)
XADC_XN11_XPI_XN (XADC_XN11_PH XADC_XN11_PHB VSS VSS) nfet_01v8 w=(1u) l=150n m=(1)*(1)
XADC_XN11_XPH_XN2 (XADC_XN11_XPH_MID B11 VSS VSS) nfet_01v8 w=(2u) l=150n m=(1)*(1)
XADC_XN11_XPH_XN1 (XADC_XN11_PHB CONV XADC_XN11_XPH_MID VSS) nfet_01v8 w=(2u) l=150n m=(1)*(1)
XADC_XN11_XAI_XN (XADC_XN11_ACQB ACQ VSS VSS) nfet_01v8 w=(1u) l=150n m=(1)*(1)
XADC_XN11_XBI_XN (XADC_XN11_BITB B11 VSS VSS) nfet_01v8 w=(1u) l=150n m=(1)*(1)
XADC_XP11_XNI_XN (XADC_XP11_NL XADC_XP11_NLB VSS VSS) nfet_01v8 w=(1u) l=150n m=(1)*(1)
XADC_XP11_XNL_XN2 (XADC_XP11_XNL_MID XADC_XP11_BITB VSS VSS) nfet_01v8 w=(2u) l=150n m=(1)*(1)
XADC_XP11_XNL_XN1 (XADC_XP11_NLB CONV XADC_XP11_XNL_MID VSS) nfet_01v8 w=(2u) l=150n m=(1)*(1)
XADC_XP11_XPI_XN (XADC_XP11_PH XADC_XP11_PHB VSS VSS) nfet_01v8 w=(1u) l=150n m=(1)*(1)
XADC_XP11_XPH_XN2 (XADC_XP11_XPH_MID B11 VSS VSS) nfet_01v8 w=(2u) l=150n m=(1)*(1)
XADC_XP11_XPH_XN1 (XADC_XP11_PHB CONV XADC_XP11_XPH_MID VSS) nfet_01v8 w=(2u) l=150n m=(1)*(1)
XADC_XP11_XAI_XN (XADC_XP11_ACQB ACQ VSS VSS) nfet_01v8 w=(1u) l=150n m=(1)*(1)
XADC_XP11_XBI_XN (XADC_XP11_BITB B11 VSS VSS) nfet_01v8 w=(1u) l=150n m=(1)*(1)
XADC_XN10_XNI_XN (XADC_XN10_NL XADC_XN10_NLB VSS VSS) nfet_01v8 w=(1u) l=150n m=(1)*(1)
XADC_XN10_XNL_XN2 (XADC_XN10_XNL_MID XADC_XN10_BITB VSS VSS) nfet_01v8 w=(2u) l=150n m=(1)*(1)
XADC_XN10_XNL_XN1 (XADC_XN10_NLB CONV XADC_XN10_XNL_MID VSS) nfet_01v8 w=(2u) l=150n m=(1)*(1)
XADC_XN10_XPI_XN (XADC_XN10_PH XADC_XN10_PHB VSS VSS) nfet_01v8 w=(1u) l=150n m=(1)*(1)
XADC_XN10_XPH_XN2 (XADC_XN10_XPH_MID B10 VSS VSS) nfet_01v8 w=(2u) l=150n m=(1)*(1)
XADC_XN10_XPH_XN1 (XADC_XN10_PHB CONV XADC_XN10_XPH_MID VSS) nfet_01v8 w=(2u) l=150n m=(1)*(1)
XADC_XN10_XAI_XN (XADC_XN10_ACQB ACQ VSS VSS) nfet_01v8 w=(1u) l=150n m=(1)*(1)
XADC_XN10_XBI_XN (XADC_XN10_BITB B10 VSS VSS) nfet_01v8 w=(1u) l=150n m=(1)*(1)
XADC_XP10_XNI_XN (XADC_XP10_NL XADC_XP10_NLB VSS VSS) nfet_01v8 w=(1u) l=150n m=(1)*(1)
XADC_XP10_XNL_XN2 (XADC_XP10_XNL_MID XADC_XP10_BITB VSS VSS) nfet_01v8 w=(2u) l=150n m=(1)*(1)
XADC_XP10_XNL_XN1 (XADC_XP10_NLB CONV XADC_XP10_XNL_MID VSS) nfet_01v8 w=(2u) l=150n m=(1)*(1)
XADC_XP10_XPI_XN (XADC_XP10_PH XADC_XP10_PHB VSS VSS) nfet_01v8 w=(1u) l=150n m=(1)*(1)
XADC_XP10_XPH_XN2 (XADC_XP10_XPH_MID B10 VSS VSS) nfet_01v8 w=(2u) l=150n m=(1)*(1)
XADC_XP10_XPH_XN1 (XADC_XP10_PHB CONV XADC_XP10_XPH_MID VSS) nfet_01v8 w=(2u) l=150n m=(1)*(1)
XADC_XP10_XAI_XN (XADC_XP10_ACQB ACQ VSS VSS) nfet_01v8 w=(1u) l=150n m=(1)*(1)
XADC_XP10_XBI_XN (XADC_XP10_BITB B10 VSS VSS) nfet_01v8 w=(1u) l=150n m=(1)*(1)
XADC_XN9_XNI_XN (XADC_XN9_NL XADC_XN9_NLB VSS VSS) nfet_01v8 w=(1u) l=150n m=(1)*(1)
XADC_XN9_XNL_XN2 (XADC_XN9_XNL_MID XADC_XN9_BITB VSS VSS) nfet_01v8 w=(2u) l=150n m=(1)*(1)
XADC_XN9_XNL_XN1 (XADC_XN9_NLB CONV XADC_XN9_XNL_MID VSS) nfet_01v8 w=(2u) l=150n m=(1)*(1)
XADC_XN9_XPI_XN (XADC_XN9_PH XADC_XN9_PHB VSS VSS) nfet_01v8 w=(1u) l=150n m=(1)*(1)
XADC_XN9_XPH_XN2 (XADC_XN9_XPH_MID B9 VSS VSS) nfet_01v8 w=(2u) l=150n m=(1)*(1)
XADC_XN9_XPH_XN1 (XADC_XN9_PHB CONV XADC_XN9_XPH_MID VSS) nfet_01v8 w=(2u) l=150n m=(1)*(1)
XADC_XN9_XAI_XN (XADC_XN9_ACQB ACQ VSS VSS) nfet_01v8 w=(1u) l=150n m=(1)*(1)
XADC_XN9_XBI_XN (XADC_XN9_BITB B9 VSS VSS) nfet_01v8 w=(1u) l=150n m=(1)*(1)
XADC_XP9_XNI_XN (XADC_XP9_NL XADC_XP9_NLB VSS VSS) nfet_01v8 w=(1u) l=150n m=(1)*(1)
XADC_XP9_XNL_XN2 (XADC_XP9_XNL_MID XADC_XP9_BITB VSS VSS) nfet_01v8 w=(2u) l=150n m=(1)*(1)
XADC_XP9_XNL_XN1 (XADC_XP9_NLB CONV XADC_XP9_XNL_MID VSS) nfet_01v8 w=(2u) l=150n m=(1)*(1)
XADC_XP9_XPI_XN (XADC_XP9_PH XADC_XP9_PHB VSS VSS) nfet_01v8 w=(1u) l=150n m=(1)*(1)
XADC_XP9_XPH_XN2 (XADC_XP9_XPH_MID B9 VSS VSS) nfet_01v8 w=(2u) l=150n m=(1)*(1)
XADC_XP9_XPH_XN1 (XADC_XP9_PHB CONV XADC_XP9_XPH_MID VSS) nfet_01v8 w=(2u) l=150n m=(1)*(1)
XADC_XP9_XAI_XN (XADC_XP9_ACQB ACQ VSS VSS) nfet_01v8 w=(1u) l=150n m=(1)*(1)
XADC_XP9_XBI_XN (XADC_XP9_BITB B9 VSS VSS) nfet_01v8 w=(1u) l=150n m=(1)*(1)
XADC_XN8_XNI_XN (XADC_XN8_NL XADC_XN8_NLB VSS VSS) nfet_01v8 w=(1u) l=150n m=(1)*(1)
XADC_XN8_XNL_XN2 (XADC_XN8_XNL_MID XADC_XN8_BITB VSS VSS) nfet_01v8 w=(2u) l=150n m=(1)*(1)
XADC_XN8_XNL_XN1 (XADC_XN8_NLB CONV XADC_XN8_XNL_MID VSS) nfet_01v8 w=(2u) l=150n m=(1)*(1)
XADC_XN8_XPI_XN (XADC_XN8_PH XADC_XN8_PHB VSS VSS) nfet_01v8 w=(1u) l=150n m=(1)*(1)
XADC_XN8_XPH_XN2 (XADC_XN8_XPH_MID B8 VSS VSS) nfet_01v8 w=(2u) l=150n m=(1)*(1)
XADC_XN8_XPH_XN1 (XADC_XN8_PHB CONV XADC_XN8_XPH_MID VSS) nfet_01v8 w=(2u) l=150n m=(1)*(1)
XADC_XN8_XAI_XN (XADC_XN8_ACQB ACQ VSS VSS) nfet_01v8 w=(1u) l=150n m=(1)*(1)
XADC_XN8_XBI_XN (XADC_XN8_BITB B8 VSS VSS) nfet_01v8 w=(1u) l=150n m=(1)*(1)
XADC_XP8_XNI_XN (XADC_XP8_NL XADC_XP8_NLB VSS VSS) nfet_01v8 w=(1u) l=150n m=(1)*(1)
XADC_XP8_XNL_XN2 (XADC_XP8_XNL_MID XADC_XP8_BITB VSS VSS) nfet_01v8 w=(2u) l=150n m=(1)*(1)
XADC_XP8_XNL_XN1 (XADC_XP8_NLB CONV XADC_XP8_XNL_MID VSS) nfet_01v8 w=(2u) l=150n m=(1)*(1)
XADC_XP8_XPI_XN (XADC_XP8_PH XADC_XP8_PHB VSS VSS) nfet_01v8 w=(1u) l=150n m=(1)*(1)
XADC_XP8_XPH_XN2 (XADC_XP8_XPH_MID B8 VSS VSS) nfet_01v8 w=(2u) l=150n m=(1)*(1)
XADC_XP8_XPH_XN1 (XADC_XP8_PHB CONV XADC_XP8_XPH_MID VSS) nfet_01v8 w=(2u) l=150n m=(1)*(1)
XADC_XP8_XAI_XN (XADC_XP8_ACQB ACQ VSS VSS) nfet_01v8 w=(1u) l=150n m=(1)*(1)
XADC_XP8_XBI_XN (XADC_XP8_BITB B8 VSS VSS) nfet_01v8 w=(1u) l=150n m=(1)*(1)
XADC_XN7_XNI_XN (XADC_XN7_NL XADC_XN7_NLB VSS VSS) nfet_01v8 w=(1u) l=150n m=(1)*(1)
XADC_XN7_XNL_XN2 (XADC_XN7_XNL_MID XADC_XN7_BITB VSS VSS) nfet_01v8 w=(2u) l=150n m=(1)*(1)
XADC_XN7_XNL_XN1 (XADC_XN7_NLB CONV XADC_XN7_XNL_MID VSS) nfet_01v8 w=(2u) l=150n m=(1)*(1)
XADC_XN7_XPI_XN (XADC_XN7_PH XADC_XN7_PHB VSS VSS) nfet_01v8 w=(1u) l=150n m=(1)*(1)
XADC_XN7_XPH_XN2 (XADC_XN7_XPH_MID B7 VSS VSS) nfet_01v8 w=(2u) l=150n m=(1)*(1)
XADC_XN7_XPH_XN1 (XADC_XN7_PHB CONV XADC_XN7_XPH_MID VSS) nfet_01v8 w=(2u) l=150n m=(1)*(1)
XADC_XN7_XAI_XN (XADC_XN7_ACQB ACQ VSS VSS) nfet_01v8 w=(1u) l=150n m=(1)*(1)
XADC_XN7_XBI_XN (XADC_XN7_BITB B7 VSS VSS) nfet_01v8 w=(1u) l=150n m=(1)*(1)
XADC_XP7_XNI_XN (XADC_XP7_NL XADC_XP7_NLB VSS VSS) nfet_01v8 w=(1u) l=150n m=(1)*(1)
XADC_XP7_XNL_XN2 (XADC_XP7_XNL_MID XADC_XP7_BITB VSS VSS) nfet_01v8 w=(2u) l=150n m=(1)*(1)
XADC_XP7_XNL_XN1 (XADC_XP7_NLB CONV XADC_XP7_XNL_MID VSS) nfet_01v8 w=(2u) l=150n m=(1)*(1)
XADC_XP7_XPI_XN (XADC_XP7_PH XADC_XP7_PHB VSS VSS) nfet_01v8 w=(1u) l=150n m=(1)*(1)
XADC_XP7_XPH_XN2 (XADC_XP7_XPH_MID B7 VSS VSS) nfet_01v8 w=(2u) l=150n m=(1)*(1)
XADC_XP7_XPH_XN1 (XADC_XP7_PHB CONV XADC_XP7_XPH_MID VSS) nfet_01v8 w=(2u) l=150n m=(1)*(1)
XADC_XP7_XAI_XN (XADC_XP7_ACQB ACQ VSS VSS) nfet_01v8 w=(1u) l=150n m=(1)*(1)
XADC_XP7_XBI_XN (XADC_XP7_BITB B7 VSS VSS) nfet_01v8 w=(1u) l=150n m=(1)*(1)
XADC_XN6_XNI_XN (XADC_XN6_NL XADC_XN6_NLB VSS VSS) nfet_01v8 w=(1u) l=150n m=(1)*(1)
XADC_XN6_XNL_XN2 (XADC_XN6_XNL_MID XADC_XN6_BITB VSS VSS) nfet_01v8 w=(2u) l=150n m=(1)*(1)
XADC_XN6_XNL_XN1 (XADC_XN6_NLB CONV XADC_XN6_XNL_MID VSS) nfet_01v8 w=(2u) l=150n m=(1)*(1)
XADC_XN6_XPI_XN (XADC_XN6_PH XADC_XN6_PHB VSS VSS) nfet_01v8 w=(1u) l=150n m=(1)*(1)
XADC_XN6_XPH_XN2 (XADC_XN6_XPH_MID B6 VSS VSS) nfet_01v8 w=(2u) l=150n m=(1)*(1)
XADC_XN6_XPH_XN1 (XADC_XN6_PHB CONV XADC_XN6_XPH_MID VSS) nfet_01v8 w=(2u) l=150n m=(1)*(1)
XADC_XN6_XAI_XN (XADC_XN6_ACQB ACQ VSS VSS) nfet_01v8 w=(1u) l=150n m=(1)*(1)
XADC_XN6_XBI_XN (XADC_XN6_BITB B6 VSS VSS) nfet_01v8 w=(1u) l=150n m=(1)*(1)
XADC_XP6_XNI_XN (XADC_XP6_NL XADC_XP6_NLB VSS VSS) nfet_01v8 w=(1u) l=150n m=(1)*(1)
XADC_XP6_XNL_XN2 (XADC_XP6_XNL_MID XADC_XP6_BITB VSS VSS) nfet_01v8 w=(2u) l=150n m=(1)*(1)
XADC_XP6_XNL_XN1 (XADC_XP6_NLB CONV XADC_XP6_XNL_MID VSS) nfet_01v8 w=(2u) l=150n m=(1)*(1)
XADC_XP6_XPI_XN (XADC_XP6_PH XADC_XP6_PHB VSS VSS) nfet_01v8 w=(1u) l=150n m=(1)*(1)
XADC_XP6_XPH_XN2 (XADC_XP6_XPH_MID B6 VSS VSS) nfet_01v8 w=(2u) l=150n m=(1)*(1)
XADC_XP6_XPH_XN1 (XADC_XP6_PHB CONV XADC_XP6_XPH_MID VSS) nfet_01v8 w=(2u) l=150n m=(1)*(1)
XADC_XP6_XAI_XN (XADC_XP6_ACQB ACQ VSS VSS) nfet_01v8 w=(1u) l=150n m=(1)*(1)
XADC_XP6_XBI_XN (XADC_XP6_BITB B6 VSS VSS) nfet_01v8 w=(1u) l=150n m=(1)*(1)
XADC_XN5_XNI_XN (XADC_XN5_NL XADC_XN5_NLB VSS VSS) nfet_01v8 w=(1u) l=150n m=(1)*(1)
XADC_XN5_XNL_XN2 (XADC_XN5_XNL_MID XADC_XN5_BITB VSS VSS) nfet_01v8 w=(2u) l=150n m=(1)*(1)
XADC_XN5_XNL_XN1 (XADC_XN5_NLB CONV XADC_XN5_XNL_MID VSS) nfet_01v8 w=(2u) l=150n m=(1)*(1)
XADC_XN5_XPI_XN (XADC_XN5_PH XADC_XN5_PHB VSS VSS) nfet_01v8 w=(1u) l=150n m=(1)*(1)
XADC_XN5_XPH_XN2 (XADC_XN5_XPH_MID B5 VSS VSS) nfet_01v8 w=(2u) l=150n m=(1)*(1)
XADC_XN5_XPH_XN1 (XADC_XN5_PHB CONV XADC_XN5_XPH_MID VSS) nfet_01v8 w=(2u) l=150n m=(1)*(1)
XADC_XN5_XAI_XN (XADC_XN5_ACQB ACQ VSS VSS) nfet_01v8 w=(1u) l=150n m=(1)*(1)
XADC_XN5_XBI_XN (XADC_XN5_BITB B5 VSS VSS) nfet_01v8 w=(1u) l=150n m=(1)*(1)
XADC_XP5_XNI_XN (XADC_XP5_NL XADC_XP5_NLB VSS VSS) nfet_01v8 w=(1u) l=150n m=(1)*(1)
XADC_XP5_XNL_XN2 (XADC_XP5_XNL_MID XADC_XP5_BITB VSS VSS) nfet_01v8 w=(2u) l=150n m=(1)*(1)
XADC_XP5_XNL_XN1 (XADC_XP5_NLB CONV XADC_XP5_XNL_MID VSS) nfet_01v8 w=(2u) l=150n m=(1)*(1)
XADC_XP5_XPI_XN (XADC_XP5_PH XADC_XP5_PHB VSS VSS) nfet_01v8 w=(1u) l=150n m=(1)*(1)
XADC_XP5_XPH_XN2 (XADC_XP5_XPH_MID B5 VSS VSS) nfet_01v8 w=(2u) l=150n m=(1)*(1)
XADC_XP5_XPH_XN1 (XADC_XP5_PHB CONV XADC_XP5_XPH_MID VSS) nfet_01v8 w=(2u) l=150n m=(1)*(1)
XADC_XP5_XAI_XN (XADC_XP5_ACQB ACQ VSS VSS) nfet_01v8 w=(1u) l=150n m=(1)*(1)
XADC_XP5_XBI_XN (XADC_XP5_BITB B5 VSS VSS) nfet_01v8 w=(1u) l=150n m=(1)*(1)
XADC_XN4_XNI_XN (XADC_XN4_NL XADC_XN4_NLB VSS VSS) nfet_01v8 w=(1u) l=150n m=(1)*(1)
XADC_XN4_XNL_XN2 (XADC_XN4_XNL_MID XADC_XN4_BITB VSS VSS) nfet_01v8 w=(2u) l=150n m=(1)*(1)
XADC_XN4_XNL_XN1 (XADC_XN4_NLB CONV XADC_XN4_XNL_MID VSS) nfet_01v8 w=(2u) l=150n m=(1)*(1)
XADC_XN4_XPI_XN (XADC_XN4_PH XADC_XN4_PHB VSS VSS) nfet_01v8 w=(1u) l=150n m=(1)*(1)
XADC_XN4_XPH_XN2 (XADC_XN4_XPH_MID B4 VSS VSS) nfet_01v8 w=(2u) l=150n m=(1)*(1)
XADC_XN4_XPH_XN1 (XADC_XN4_PHB CONV XADC_XN4_XPH_MID VSS) nfet_01v8 w=(2u) l=150n m=(1)*(1)
XADC_XN4_XAI_XN (XADC_XN4_ACQB ACQ VSS VSS) nfet_01v8 w=(1u) l=150n m=(1)*(1)
XADC_XN4_XBI_XN (XADC_XN4_BITB B4 VSS VSS) nfet_01v8 w=(1u) l=150n m=(1)*(1)
XADC_XP4_XNI_XN (XADC_XP4_NL XADC_XP4_NLB VSS VSS) nfet_01v8 w=(1u) l=150n m=(1)*(1)
XADC_XP4_XNL_XN2 (XADC_XP4_XNL_MID XADC_XP4_BITB VSS VSS) nfet_01v8 w=(2u) l=150n m=(1)*(1)
XADC_XP4_XNL_XN1 (XADC_XP4_NLB CONV XADC_XP4_XNL_MID VSS) nfet_01v8 w=(2u) l=150n m=(1)*(1)
XADC_XP4_XPI_XN (XADC_XP4_PH XADC_XP4_PHB VSS VSS) nfet_01v8 w=(1u) l=150n m=(1)*(1)
XADC_XP4_XPH_XN2 (XADC_XP4_XPH_MID B4 VSS VSS) nfet_01v8 w=(2u) l=150n m=(1)*(1)
XADC_XP4_XPH_XN1 (XADC_XP4_PHB CONV XADC_XP4_XPH_MID VSS) nfet_01v8 w=(2u) l=150n m=(1)*(1)
XADC_XP4_XAI_XN (XADC_XP4_ACQB ACQ VSS VSS) nfet_01v8 w=(1u) l=150n m=(1)*(1)
XADC_XP4_XBI_XN (XADC_XP4_BITB B4 VSS VSS) nfet_01v8 w=(1u) l=150n m=(1)*(1)
XADC_XN3_XNI_XN (XADC_XN3_NL XADC_XN3_NLB VSS VSS) nfet_01v8 w=(1u) l=150n m=(1)*(1)
XADC_XN3_XNL_XN2 (XADC_XN3_XNL_MID XADC_XN3_BITB VSS VSS) nfet_01v8 w=(2u) l=150n m=(1)*(1)
XADC_XN3_XNL_XN1 (XADC_XN3_NLB CONV XADC_XN3_XNL_MID VSS) nfet_01v8 w=(2u) l=150n m=(1)*(1)
XADC_XN3_XPI_XN (XADC_XN3_PH XADC_XN3_PHB VSS VSS) nfet_01v8 w=(1u) l=150n m=(1)*(1)
XADC_XN3_XPH_XN2 (XADC_XN3_XPH_MID B3 VSS VSS) nfet_01v8 w=(2u) l=150n m=(1)*(1)
XADC_XN3_XPH_XN1 (XADC_XN3_PHB CONV XADC_XN3_XPH_MID VSS) nfet_01v8 w=(2u) l=150n m=(1)*(1)
XADC_XN3_XAI_XN (XADC_XN3_ACQB ACQ VSS VSS) nfet_01v8 w=(1u) l=150n m=(1)*(1)
XADC_XN3_XBI_XN (XADC_XN3_BITB B3 VSS VSS) nfet_01v8 w=(1u) l=150n m=(1)*(1)
XADC_XP3_XNI_XN (XADC_XP3_NL XADC_XP3_NLB VSS VSS) nfet_01v8 w=(1u) l=150n m=(1)*(1)
XADC_XP3_XNL_XN2 (XADC_XP3_XNL_MID XADC_XP3_BITB VSS VSS) nfet_01v8 w=(2u) l=150n m=(1)*(1)
XADC_XP3_XNL_XN1 (XADC_XP3_NLB CONV XADC_XP3_XNL_MID VSS) nfet_01v8 w=(2u) l=150n m=(1)*(1)
XADC_XP3_XPI_XN (XADC_XP3_PH XADC_XP3_PHB VSS VSS) nfet_01v8 w=(1u) l=150n m=(1)*(1)
XADC_XP3_XPH_XN2 (XADC_XP3_XPH_MID B3 VSS VSS) nfet_01v8 w=(2u) l=150n m=(1)*(1)
XADC_XP3_XPH_XN1 (XADC_XP3_PHB CONV XADC_XP3_XPH_MID VSS) nfet_01v8 w=(2u) l=150n m=(1)*(1)
XADC_XP3_XAI_XN (XADC_XP3_ACQB ACQ VSS VSS) nfet_01v8 w=(1u) l=150n m=(1)*(1)
XADC_XP3_XBI_XN (XADC_XP3_BITB B3 VSS VSS) nfet_01v8 w=(1u) l=150n m=(1)*(1)
XADC_XN2_XNI_XN (XADC_XN2_NL XADC_XN2_NLB VSS VSS) nfet_01v8 w=(1u) l=150n m=(1)*(1)
XADC_XN2_XNL_XN2 (XADC_XN2_XNL_MID XADC_XN2_BITB VSS VSS) nfet_01v8 w=(2u) l=150n m=(1)*(1)
XADC_XN2_XNL_XN1 (XADC_XN2_NLB CONV XADC_XN2_XNL_MID VSS) nfet_01v8 w=(2u) l=150n m=(1)*(1)
XADC_XN2_XPI_XN (XADC_XN2_PH XADC_XN2_PHB VSS VSS) nfet_01v8 w=(1u) l=150n m=(1)*(1)
XADC_XN2_XPH_XN2 (XADC_XN2_XPH_MID B2 VSS VSS) nfet_01v8 w=(2u) l=150n m=(1)*(1)
XADC_XN2_XPH_XN1 (XADC_XN2_PHB CONV XADC_XN2_XPH_MID VSS) nfet_01v8 w=(2u) l=150n m=(1)*(1)
XADC_XN2_XAI_XN (XADC_XN2_ACQB ACQ VSS VSS) nfet_01v8 w=(1u) l=150n m=(1)*(1)
XADC_XN2_XBI_XN (XADC_XN2_BITB B2 VSS VSS) nfet_01v8 w=(1u) l=150n m=(1)*(1)
XADC_XP2_XNI_XN (XADC_XP2_NL XADC_XP2_NLB VSS VSS) nfet_01v8 w=(1u) l=150n m=(1)*(1)
XADC_XP2_XNL_XN2 (XADC_XP2_XNL_MID XADC_XP2_BITB VSS VSS) nfet_01v8 w=(2u) l=150n m=(1)*(1)
XADC_XP2_XNL_XN1 (XADC_XP2_NLB CONV XADC_XP2_XNL_MID VSS) nfet_01v8 w=(2u) l=150n m=(1)*(1)
XADC_XP2_XPI_XN (XADC_XP2_PH XADC_XP2_PHB VSS VSS) nfet_01v8 w=(1u) l=150n m=(1)*(1)
XADC_XP2_XPH_XN2 (XADC_XP2_XPH_MID B2 VSS VSS) nfet_01v8 w=(2u) l=150n m=(1)*(1)
XADC_XP2_XPH_XN1 (XADC_XP2_PHB CONV XADC_XP2_XPH_MID VSS) nfet_01v8 w=(2u) l=150n m=(1)*(1)
XADC_XP2_XAI_XN (XADC_XP2_ACQB ACQ VSS VSS) nfet_01v8 w=(1u) l=150n m=(1)*(1)
XADC_XP2_XBI_XN (XADC_XP2_BITB B2 VSS VSS) nfet_01v8 w=(1u) l=150n m=(1)*(1)
XADC_XN1_XNI_XN (XADC_XN1_NL XADC_XN1_NLB VSS VSS) nfet_01v8 w=(1u) l=150n m=(1)*(1)
XADC_XN1_XNL_XN2 (XADC_XN1_XNL_MID XADC_XN1_BITB VSS VSS) nfet_01v8 w=(2u) l=150n m=(1)*(1)
XADC_XN1_XNL_XN1 (XADC_XN1_NLB CONV XADC_XN1_XNL_MID VSS) nfet_01v8 w=(2u) l=150n m=(1)*(1)
XADC_XN1_XPI_XN (XADC_XN1_PH XADC_XN1_PHB VSS VSS) nfet_01v8 w=(1u) l=150n m=(1)*(1)
XADC_XN1_XPH_XN2 (XADC_XN1_XPH_MID B1 VSS VSS) nfet_01v8 w=(2u) l=150n m=(1)*(1)
XADC_XN1_XPH_XN1 (XADC_XN1_PHB CONV XADC_XN1_XPH_MID VSS) nfet_01v8 w=(2u) l=150n m=(1)*(1)
XADC_XN1_XAI_XN (XADC_XN1_ACQB ACQ VSS VSS) nfet_01v8 w=(1u) l=150n m=(1)*(1)
XADC_XN1_XBI_XN (XADC_XN1_BITB B1 VSS VSS) nfet_01v8 w=(1u) l=150n m=(1)*(1)
XADC_XP1_XNI_XN (XADC_XP1_NL XADC_XP1_NLB VSS VSS) nfet_01v8 w=(1u) l=150n m=(1)*(1)
XADC_XP1_XNL_XN2 (XADC_XP1_XNL_MID XADC_XP1_BITB VSS VSS) nfet_01v8 w=(2u) l=150n m=(1)*(1)
XADC_XP1_XNL_XN1 (XADC_XP1_NLB CONV XADC_XP1_XNL_MID VSS) nfet_01v8 w=(2u) l=150n m=(1)*(1)
XADC_XP1_XPI_XN (XADC_XP1_PH XADC_XP1_PHB VSS VSS) nfet_01v8 w=(1u) l=150n m=(1)*(1)
XADC_XP1_XPH_XN2 (XADC_XP1_XPH_MID B1 VSS VSS) nfet_01v8 w=(2u) l=150n m=(1)*(1)
XADC_XP1_XPH_XN1 (XADC_XP1_PHB CONV XADC_XP1_XPH_MID VSS) nfet_01v8 w=(2u) l=150n m=(1)*(1)
XADC_XP1_XAI_XN (XADC_XP1_ACQB ACQ VSS VSS) nfet_01v8 w=(1u) l=150n m=(1)*(1)
XADC_XP1_XBI_XN (XADC_XP1_BITB B1 VSS VSS) nfet_01v8 w=(1u) l=150n m=(1)*(1)
XADC_XN0_XNI_XN (XADC_XN0_NL XADC_XN0_NLB VSS VSS) nfet_01v8 w=(1u) l=150n m=(1)*(1)
XADC_XN0_XNL_XN2 (XADC_XN0_XNL_MID XADC_XN0_BITB VSS VSS) nfet_01v8 w=(2u) l=150n m=(1)*(1)
XADC_XN0_XNL_XN1 (XADC_XN0_NLB CONV XADC_XN0_XNL_MID VSS) nfet_01v8 w=(2u) l=150n m=(1)*(1)
XADC_XN0_XPI_XN (XADC_XN0_PH XADC_XN0_PHB VSS VSS) nfet_01v8 w=(1u) l=150n m=(1)*(1)
XADC_XN0_XPH_XN2 (XADC_XN0_XPH_MID B0 VSS VSS) nfet_01v8 w=(2u) l=150n m=(1)*(1)
XADC_XN0_XPH_XN1 (XADC_XN0_PHB CONV XADC_XN0_XPH_MID VSS) nfet_01v8 w=(2u) l=150n m=(1)*(1)
XADC_XN0_XAI_XN (XADC_XN0_ACQB ACQ VSS VSS) nfet_01v8 w=(1u) l=150n m=(1)*(1)
XADC_XN0_XBI_XN (XADC_XN0_BITB B0 VSS VSS) nfet_01v8 w=(1u) l=150n m=(1)*(1)
XADC_XP0_XNI_XN (XADC_XP0_NL XADC_XP0_NLB VSS VSS) nfet_01v8 w=(1u) l=150n m=(1)*(1)
XADC_XP0_XNL_XN2 (XADC_XP0_XNL_MID XADC_XP0_BITB VSS VSS) nfet_01v8 w=(2u) l=150n m=(1)*(1)
XADC_XP0_XNL_XN1 (XADC_XP0_NLB CONV XADC_XP0_XNL_MID VSS) nfet_01v8 w=(2u) l=150n m=(1)*(1)
XADC_XP0_XPI_XN (XADC_XP0_PH XADC_XP0_PHB VSS VSS) nfet_01v8 w=(1u) l=150n m=(1)*(1)
XADC_XP0_XPH_XN2 (XADC_XP0_XPH_MID B0 VSS VSS) nfet_01v8 w=(2u) l=150n m=(1)*(1)
XADC_XP0_XPH_XN1 (XADC_XP0_PHB CONV XADC_XP0_XPH_MID VSS) nfet_01v8 w=(2u) l=150n m=(1)*(1)
XADC_XP0_XAI_XN (XADC_XP0_ACQB ACQ VSS VSS) nfet_01v8 w=(1u) l=150n m=(1)*(1)
XADC_XP0_XBI_XN (XADC_XP0_BITB B0 VSS VSS) nfet_01v8 w=(1u) l=150n m=(1)*(1)
XADC_XCMP_XRESET_XN2 (XADC_XCMP_XRESET_MID Q VSS VSS) nfet_01v8 w=(2u) l=150n m=(1)*(1)
XADC_XCMP_XRESET_XN1 (QB XADC_XCMP_BP XADC_XCMP_XRESET_MID VSS) nfet_01v8 w=(2u) l=150n m=(1)*(1)
XADC_XCMP_XSET_XN2 (XADC_XCMP_XSET_MID QB VSS VSS) nfet_01v8 w=(2u) l=150n m=(1)*(1)
XADC_XCMP_XSET_XN1 (Q XADC_XCMP_BN XADC_XCMP_XSET_MID VSS) nfet_01v8 w=(2u) l=150n m=(1)*(1)
XADC_XCMP_XBN2_XN (XADC_XCMP_BN XADC_XCMP_BNB VSS VSS) nfet_01v8 w=(1u) l=150n m=(1)*(1)
XADC_XCMP_XBN1_XN (XADC_XCMP_BNB XADC_XCMP_DNEG VSS VSS) nfet_01v8 w=(1u) l=150n m=(1)*(1)
XADC_XCMP_XBP2_XN (XADC_XCMP_BP XADC_XCMP_BPB VSS VSS) nfet_01v8 w=(1u) l=150n m=(1)*(1)
XADC_XCMP_XBP1_XN (XADC_XCMP_BPB XADC_XCMP_DPOS VSS VSS) nfet_01v8 w=(1u) l=150n m=(1)*(1)
XADC_XCMP_XCORE_XLP (XADC_XCMP_DPOS XADC_XCMP_DNEG XADC_XCMP_XCORE_DN VSS) nfet_01v8 w=(4u) l=150n m=(1)*(1)
XADC_XCMP_XCORE_XLN (XADC_XCMP_DNEG XADC_XCMP_DPOS XADC_XCMP_XCORE_DP VSS) nfet_01v8 w=(4u) l=150n m=(1)*(1)
XADC_XCMP_XCORE_XT (XADC_XCMP_XCORE_TAIL EVAL VSS VSS) nfet_01v8 w=(16u) l=150n m=(1)*(1)
XADC_XCMP_XCORE_XIN (XADC_XCMP_XCORE_DN XADC_PREN XADC_XCMP_XCORE_TAIL VSS) nfet_01v8 w=(8.4u) l=500n m=(1)*(1)
XADC_XCMP_XCORE_XIP (XADC_XCMP_XCORE_DP XADC_PREP XADC_XCMP_XCORE_TAIL VSS) nfet_01v8 w=(8.4u) l=500n m=(1)*(1)
XADC_XPRE_XTAIL (XADC_XPRE_TAIL XADC_XPRE_BN VSS VSS) nfet_01v8 w=(32u) l=1u m=(1)*(1)
XADC_XPRE_XIN (XADC_PREP XADC_TP XADC_XPRE_TAIL VSS) nfet_01v8 w=(30u) l=1u m=(1)*(1)
XADC_XPRE_XIP (XADC_PREN XADC_TN XADC_XPRE_TAIL VSS) nfet_01v8 w=(30u) l=1u m=(1)*(1)
XADC_XPRE_XSTINJ (XADC_XPRE_BP XADC_XPRE_START VSS VSS) nfet_01v8 w=(500n) l=2u m=(1)*(1)
XADC_XPRE_XSTOFF (XADC_XPRE_START XADC_XPRE_BN VSS VSS) nfet_01v8 w=(20u) l=1u m=(1)*(1)
XADC_XPRE_XBN2 (XADC_XPRE_BP XADC_XPRE_BN XADC_XPRE_BRS VSS) nfet_01v8 w=(32u) l=1u m=(1)*(1)
XADC_XPRE_XBN1 (XADC_XPRE_BN XADC_XPRE_BN VSS VSS) nfet_01v8 w=(8u) l=1u m=(1)*(1)
XADC_XPRE_XRN_XR7_XR (XADC_XPRE_XRN_N7 XADC_PREN VSS) res_high_po_5p73 r=4.97951K l=86.99u w=5.73u
XADC_XPRE_XRN_XR6_XR_SEG_2 (XADC_XPRE_XRN_XR6_XR_SERIES_1 XADC_XPRE_XRN_N7 VSS) res_high_po_5p73 r=4.97951K l=86.99u w=5.73u
XADC_XPRE_XRN_XR6_XR_SEG_1 (XADC_XPRE_XRN_N6 XADC_XPRE_XRN_XR6_XR_SERIES_1 VSS) res_high_po_5p73 r=4.97951K l=86.99u w=5.73u
XADC_XPRE_XRN_XR5_XR_SEG_2 (XADC_XPRE_XRN_XR5_XR_SERIES_1 XADC_XPRE_XRN_N6 VSS) res_high_po_5p73 r=4.97951K l=86.99u w=5.73u
XADC_XPRE_XRN_XR5_XR_SEG_1 (XADC_XPRE_XRN_N5 XADC_XPRE_XRN_XR5_XR_SERIES_1 VSS) res_high_po_5p73 r=4.97951K l=86.99u w=5.73u
XADC_XPRE_XRN_XR4_XR_SEG_2 (XADC_XPRE_XRN_XR4_XR_SERIES_1 XADC_XPRE_XRN_N5 VSS) res_high_po_5p73 r=4.97951K l=86.99u w=5.73u
XADC_XPRE_XRN_XR4_XR_SEG_1 (XADC_XPRE_XRN_N4 XADC_XPRE_XRN_XR4_XR_SERIES_1 VSS) res_high_po_5p73 r=4.97951K l=86.99u w=5.73u
XADC_XPRE_XRN_XR3_XR_SEG_2 (XADC_XPRE_XRN_XR3_XR_SERIES_1 XADC_XPRE_XRN_N4 VSS) res_high_po_5p73 r=4.97951K l=86.99u w=5.73u
XADC_XPRE_XRN_XR3_XR_SEG_1 (XADC_XPRE_XRN_N3 XADC_XPRE_XRN_XR3_XR_SERIES_1 VSS) res_high_po_5p73 r=4.97951K l=86.99u w=5.73u
XADC_XPRE_XRN_XR2_XR_SEG_2 (XADC_XPRE_XRN_XR2_XR_SERIES_1 XADC_XPRE_XRN_N3 VSS) res_high_po_5p73 r=4.97951K l=86.99u w=5.73u
XADC_XPRE_XRN_XR2_XR_SEG_1 (XADC_XPRE_XRN_N2 XADC_XPRE_XRN_XR2_XR_SERIES_1 VSS) res_high_po_5p73 r=4.97951K l=86.99u w=5.73u
XADC_XPRE_XRN_XR1_XR_SEG_2 (XADC_XPRE_XRN_XR1_XR_SERIES_1 XADC_XPRE_XRN_N2 VSS) res_high_po_5p73 r=4.97951K l=86.99u w=5.73u
XADC_XPRE_XRN_XR1_XR_SEG_1 (XADC_XPRE_XRN_N1 XADC_XPRE_XRN_XR1_XR_SERIES_1 VSS) res_high_po_5p73 r=4.97951K l=86.99u w=5.73u
XADC_XPRE_XRN_XR0_XR_SEG_2 (XADC_XPRE_XRN_XR0_XR_SERIES_1 XADC_XPRE_XRN_N1 VSS) res_high_po_5p73 r=4.97951K l=86.99u w=5.73u
XADC_XPRE_XRN_XR0_XR_SEG_1 (VDD XADC_XPRE_XRN_XR0_XR_SERIES_1 VSS) res_high_po_5p73 r=4.97951K l=86.99u w=5.73u
XADC_XPRE_XRP_XR7_XR (XADC_XPRE_XRP_N7 XADC_PREP VSS) res_high_po_5p73 r=4.97951K l=86.99u w=5.73u
XADC_XPRE_XRP_XR6_XR_SEG_2 (XADC_XPRE_XRP_XR6_XR_SERIES_1 XADC_XPRE_XRP_N7 VSS) res_high_po_5p73 r=4.97951K l=86.99u w=5.73u
XADC_XPRE_XRP_XR6_XR_SEG_1 (XADC_XPRE_XRP_N6 XADC_XPRE_XRP_XR6_XR_SERIES_1 VSS) res_high_po_5p73 r=4.97951K l=86.99u w=5.73u
XADC_XPRE_XRP_XR5_XR_SEG_2 (XADC_XPRE_XRP_XR5_XR_SERIES_1 XADC_XPRE_XRP_N6 VSS) res_high_po_5p73 r=4.97951K l=86.99u w=5.73u
XADC_XPRE_XRP_XR5_XR_SEG_1 (XADC_XPRE_XRP_N5 XADC_XPRE_XRP_XR5_XR_SERIES_1 VSS) res_high_po_5p73 r=4.97951K l=86.99u w=5.73u
XADC_XPRE_XRP_XR4_XR_SEG_2 (XADC_XPRE_XRP_XR4_XR_SERIES_1 XADC_XPRE_XRP_N5 VSS) res_high_po_5p73 r=4.97951K l=86.99u w=5.73u
XADC_XPRE_XRP_XR4_XR_SEG_1 (XADC_XPRE_XRP_N4 XADC_XPRE_XRP_XR4_XR_SERIES_1 VSS) res_high_po_5p73 r=4.97951K l=86.99u w=5.73u
XADC_XPRE_XRP_XR3_XR_SEG_2 (XADC_XPRE_XRP_XR3_XR_SERIES_1 XADC_XPRE_XRP_N4 VSS) res_high_po_5p73 r=4.97951K l=86.99u w=5.73u
XADC_XPRE_XRP_XR3_XR_SEG_1 (XADC_XPRE_XRP_N3 XADC_XPRE_XRP_XR3_XR_SERIES_1 VSS) res_high_po_5p73 r=4.97951K l=86.99u w=5.73u
XADC_XPRE_XRP_XR2_XR_SEG_2 (XADC_XPRE_XRP_XR2_XR_SERIES_1 XADC_XPRE_XRP_N3 VSS) res_high_po_5p73 r=4.97951K l=86.99u w=5.73u
XADC_XPRE_XRP_XR2_XR_SEG_1 (XADC_XPRE_XRP_N2 XADC_XPRE_XRP_XR2_XR_SERIES_1 VSS) res_high_po_5p73 r=4.97951K l=86.99u w=5.73u
XADC_XPRE_XRP_XR1_XR_SEG_2 (XADC_XPRE_XRP_XR1_XR_SERIES_1 XADC_XPRE_XRP_N2 VSS) res_high_po_5p73 r=4.97951K l=86.99u w=5.73u
XADC_XPRE_XRP_XR1_XR_SEG_1 (XADC_XPRE_XRP_N1 XADC_XPRE_XRP_XR1_XR_SERIES_1 VSS) res_high_po_5p73 r=4.97951K l=86.99u w=5.73u
XADC_XPRE_XRP_XR0_XR_SEG_2 (XADC_XPRE_XRP_XR0_XR_SERIES_1 XADC_XPRE_XRP_N1 VSS) res_high_po_5p73 r=4.97951K l=86.99u w=5.73u
XADC_XPRE_XRP_XR0_XR_SEG_1 (VDD XADC_XPRE_XRP_XR0_XR_SERIES_1 VSS) res_high_po_5p73 r=4.97951K l=86.99u w=5.73u
XADC_XPRE_XRBIAS_XR_SEG_2 (XADC_XPRE_XRBIAS_XR_SERIES_1 VSS VSS) res_high_po_5p73 r=4.97951K l=86.99u w=5.73u
XADC_XPRE_XRBIAS_XR_SEG_1 (XADC_XPRE_BRS XADC_XPRE_XRBIAS_XR_SERIES_1 VSS) res_high_po_5p73 r=4.97951K l=86.99u w=5.73u
XADC_XCN_XD_XC (XADC_TN XADC_DN) cap_mim_m3_1 l=4u w=4u m=1
XADC_XCN_XC0_XC (XADC_TN XADC_BN0) cap_mim_m3_1 l=4u w=4u m=1
XADC_XCN_XC1_XC (XADC_TN XADC_BN1) cap_mim_m3_1 l=4u w=4u m=2
XADC_XCN_XC2_XC (XADC_TN XADC_BN2) cap_mim_m3_1 l=4u w=4u m=4
XADC_XCN_XC3_XC (XADC_TN XADC_BN3) cap_mim_m3_1 l=4u w=4u m=8
XADC_XCN_XC4_XC (XADC_TN XADC_BN4) cap_mim_m3_1 l=4u w=4u m=16
XADC_XCN_XC5_XC (XADC_TN XADC_BN5) cap_mim_m3_1 l=4u w=4u m=32
XADC_XCN_XC6_XC (XADC_TN XADC_BN6) cap_mim_m3_1 l=4u w=4u m=64
XADC_XCN_XC7_XC (XADC_TN XADC_BN7) cap_mim_m3_1 l=4u w=4u m=128
XADC_XCN_XC8_XC (XADC_TN XADC_BN8) cap_mim_m3_1 l=4u w=4u m=256
XADC_XCN_XC9_XC (XADC_TN XADC_BN9) cap_mim_m3_1 l=4u w=4u m=512
XADC_XCN_XC10_XC (XADC_TN XADC_BN10) cap_mim_m3_1 l=4u w=4u m=1024
XADC_XCN_XC11_XC (XADC_TN XADC_BN11) cap_mim_m3_1 l=4u w=4u m=2048
XADC_XCP_XD_XC (XADC_TP XADC_DP) cap_mim_m3_1 l=4u w=4u m=1
XADC_XCP_XC0_XC (XADC_TP XADC_BP0) cap_mim_m3_1 l=4u w=4u m=1
XADC_XCP_XC1_XC (XADC_TP XADC_BP1) cap_mim_m3_1 l=4u w=4u m=2
XADC_XCP_XC2_XC (XADC_TP XADC_BP2) cap_mim_m3_1 l=4u w=4u m=4
XADC_XCP_XC3_XC (XADC_TP XADC_BP3) cap_mim_m3_1 l=4u w=4u m=8
XADC_XCP_XC4_XC (XADC_TP XADC_BP4) cap_mim_m3_1 l=4u w=4u m=16
XADC_XCP_XC5_XC (XADC_TP XADC_BP5) cap_mim_m3_1 l=4u w=4u m=32
XADC_XCP_XC6_XC (XADC_TP XADC_BP6) cap_mim_m3_1 l=4u w=4u m=64
XADC_XCP_XC7_XC (XADC_TP XADC_BP7) cap_mim_m3_1 l=4u w=4u m=128
XADC_XCP_XC8_XC (XADC_TP XADC_BP8) cap_mim_m3_1 l=4u w=4u m=256
XADC_XCP_XC9_XC (XADC_TP XADC_BP9) cap_mim_m3_1 l=4u w=4u m=512
XADC_XCP_XC10_XC (XADC_TP XADC_BP10) cap_mim_m3_1 l=4u w=4u m=1024
XADC_XCP_XC11_XC (XADC_TP XADC_BP11) cap_mim_m3_1 l=4u w=4u m=2048
XADC_XCMP_XLOADN_XC (XADC_XCMP_DNEG VSS) cap_mim_m3_1 l=4u w=4u m=16
XADC_XCMP_XLOADP_XC (XADC_XCMP_DPOS VSS) cap_mim_m3_1 l=4u w=4u m=16
XADC_XPRE_XCN_XC (XADC_PREN VSS) cap_mim_m3_1 l=4u w=4u m=4
XADC_XPRE_XCP_XC (XADC_PREP VSS) cap_mim_m3_1 l=4u w=4u m=4

ends sensor_adc_candidate

subckt sensor_phases (SAMPLE_CMD TOP TOPB ACQ CONV VDD VSS)

// project1/p2adc_phase_school_r1/schematic
XPHASE_XTOPB_XN (TOPB TOP VSS VSS) nfet_01v8 w=(16u) l=150n m=(1)*(1)
XPHASE_XBTOP_XI2_XN (TOP XPHASE_XBTOP_B VSS VSS) nfet_01v8 w=(16u) l=150n m=(1)*(1)
XPHASE_XBTOP_XI1_XN (XPHASE_XBTOP_B XPHASE_TOP_RAW VSS VSS) nfet_01v8 w=(2u) l=150n m=(1)*(1)
XPHASE_XTOPI_XN (XPHASE_TOP_RAW XPHASE_TOP_RAW_B VSS VSS) nfet_01v8 w=(2u) l=150n m=(1)*(1)
XPHASE_XNTOP_XN2 (XPHASE_XNTOP_MID XPHASE_ACQ_DELAY VSS VSS) nfet_01v8 w=(4u) l=150n m=(1)*(1)
XPHASE_XNTOP_XN1 (XPHASE_TOP_RAW_B SAMPLE_CMD XPHASE_XNTOP_MID VSS) nfet_01v8 w=(4u) l=150n m=(1)*(1)
XPHASE_XBCONV_XI2_XN (CONV XPHASE_XBCONV_B VSS VSS) nfet_01v8 w=(16u) l=150n m=(1)*(1)
XPHASE_XBCONV_XI1_XN (XPHASE_XBCONV_B XPHASE_CONV_RAW VSS VSS) nfet_01v8 w=(2u) l=150n m=(1)*(1)
XPHASE_XBACQ_XI2_XN (ACQ XPHASE_XBACQ_B VSS VSS) nfet_01v8 w=(16u) l=150n m=(1)*(1)
XPHASE_XBACQ_XI1_XN (XPHASE_XBACQ_B XPHASE_ACQ_RAW VSS VSS) nfet_01v8 w=(2u) l=150n m=(1)*(1)
XPHASE_XNCONV_XN2 (XPHASE_CONV_RAW XPHASE_ACQ_DELAY VSS VSS) nfet_01v8 w=(2u) l=150n m=(1)*(1)
XPHASE_XNCONV_XN1 (XPHASE_CONV_RAW SAMPLE_CMD VSS VSS) nfet_01v8 w=(2u) l=150n m=(1)*(1)
XPHASE_XNACQ_XN2 (XPHASE_ACQ_RAW XPHASE_CONV_DELAY VSS VSS) nfet_01v8 w=(2u) l=150n m=(1)*(1)
XPHASE_XNACQ_XN1 (XPHASE_ACQ_RAW XPHASE_CMD_B_DELAY VSS VSS) nfet_01v8 w=(2u) l=150n m=(1)*(1)
XPHASE_XDCONV_XI2_XN (XPHASE_CONV_DELAY XPHASE_XDCONV_B VSS VSS) nfet_01v8 w=(2u) l=150n m=(1)*(1)
XPHASE_XDCONV_XI1_XN (XPHASE_XDCONV_B XPHASE_XDCONV_RC VSS VSS) nfet_01v8 w=(1u) l=150n m=(1)*(1)
XPHASE_XDACQ_XI2_XN (XPHASE_ACQ_DELAY XPHASE_XDACQ_B VSS VSS) nfet_01v8 w=(2u) l=150n m=(1)*(1)
XPHASE_XDACQ_XI1_XN (XPHASE_XDACQ_B XPHASE_XDACQ_RC VSS VSS) nfet_01v8 w=(1u) l=150n m=(1)*(1)
XPHASE_XDCMD_XI2_XN (XPHASE_CMD_B_DELAY XPHASE_XDCMD_B VSS VSS) nfet_01v8 w=(2u) l=150n m=(1)*(1)
XPHASE_XDCMD_XI1_XN (XPHASE_XDCMD_B XPHASE_XDCMD_RC VSS VSS) nfet_01v8 w=(1u) l=150n m=(1)*(1)
XPHASE_XCMDB_XN (XPHASE_CMD_B SAMPLE_CMD VSS VSS) nfet_01v8 w=(2u) l=150n m=(1)*(1)
XPHASE_XTOPB_XP (TOPB TOP VDD VDD) pfet_01v8 w=(32u) l=150n m=(1)*(1)
XPHASE_XBTOP_XI2_XP (TOP XPHASE_XBTOP_B VDD VDD) pfet_01v8 w=(32u) l=150n m=(1)*(1)
XPHASE_XBTOP_XI1_XP (XPHASE_XBTOP_B XPHASE_TOP_RAW VDD VDD) pfet_01v8 w=(4u) l=150n m=(1)*(1)
XPHASE_XTOPI_XP (XPHASE_TOP_RAW XPHASE_TOP_RAW_B VDD VDD) pfet_01v8 w=(4u) l=150n m=(1)*(1)
XPHASE_XNTOP_XP2 (XPHASE_TOP_RAW_B XPHASE_ACQ_DELAY VDD VDD) pfet_01v8 w=(2u) l=150n m=(1)*(1)
XPHASE_XNTOP_XP1 (XPHASE_TOP_RAW_B SAMPLE_CMD VDD VDD) pfet_01v8 w=(2u) l=150n m=(1)*(1)
XPHASE_XBCONV_XI2_XP (CONV XPHASE_XBCONV_B VDD VDD) pfet_01v8 w=(32u) l=150n m=(1)*(1)
XPHASE_XBCONV_XI1_XP (XPHASE_XBCONV_B XPHASE_CONV_RAW VDD VDD) pfet_01v8 w=(4u) l=150n m=(1)*(1)
XPHASE_XBACQ_XI2_XP (ACQ XPHASE_XBACQ_B VDD VDD) pfet_01v8 w=(32u) l=150n m=(1)*(1)
XPHASE_XBACQ_XI1_XP (XPHASE_XBACQ_B XPHASE_ACQ_RAW VDD VDD) pfet_01v8 w=(4u) l=150n m=(1)*(1)
XPHASE_XNCONV_XP2 (XPHASE_CONV_RAW XPHASE_ACQ_DELAY XPHASE_XNCONV_MID VDD) pfet_01v8 w=(4u) l=150n m=(1)*(1)
XPHASE_XNCONV_XP1 (XPHASE_XNCONV_MID SAMPLE_CMD VDD VDD) pfet_01v8 w=(4u) l=150n m=(1)*(1)
XPHASE_XNACQ_XP2 (XPHASE_ACQ_RAW XPHASE_CONV_DELAY XPHASE_XNACQ_MID VDD) pfet_01v8 w=(4u) l=150n m=(1)*(1)
XPHASE_XNACQ_XP1 (XPHASE_XNACQ_MID XPHASE_CMD_B_DELAY VDD VDD) pfet_01v8 w=(4u) l=150n m=(1)*(1)
XPHASE_XDCONV_XI2_XP (XPHASE_CONV_DELAY XPHASE_XDCONV_B VDD VDD) pfet_01v8 w=(4u) l=150n m=(1)*(1)
XPHASE_XDCONV_XI1_XP (XPHASE_XDCONV_B XPHASE_XDCONV_RC VDD VDD) pfet_01v8 w=(2u) l=150n m=(1)*(1)
XPHASE_XDACQ_XI2_XP (XPHASE_ACQ_DELAY XPHASE_XDACQ_B VDD VDD) pfet_01v8 w=(4u) l=150n m=(1)*(1)
XPHASE_XDACQ_XI1_XP (XPHASE_XDACQ_B XPHASE_XDACQ_RC VDD VDD) pfet_01v8 w=(2u) l=150n m=(1)*(1)
XPHASE_XDCMD_XI2_XP (XPHASE_CMD_B_DELAY XPHASE_XDCMD_B VDD VDD) pfet_01v8 w=(4u) l=150n m=(1)*(1)
XPHASE_XDCMD_XI1_XP (XPHASE_XDCMD_B XPHASE_XDCMD_RC VDD VDD) pfet_01v8 w=(2u) l=150n m=(1)*(1)
XPHASE_XCMDB_XP (XPHASE_CMD_B SAMPLE_CMD VDD VDD) pfet_01v8 w=(4u) l=150n m=(1)*(1)
XPHASE_XDCONV_XR (CONV XPHASE_XDCONV_RC VSS) res_high_po_1p41 r=14.9607K l=63.925u w=1.41u
XPHASE_XDACQ_XR (ACQ XPHASE_XDACQ_RC VSS) res_high_po_1p41 r=14.9607K l=63.925u w=1.41u
XPHASE_XDCMD_XR (XPHASE_CMD_B XPHASE_XDCMD_RC VSS) res_high_po_1p41 r=14.9607K l=63.925u w=1.41u
XPHASE_XDCONV_XC (XPHASE_XDCONV_RC VSS) cap_mim_m3_1 l=22.215u w=22.215u m=1
XPHASE_XDACQ_XC (XPHASE_XDACQ_RC VSS) cap_mim_m3_1 l=22.215u w=22.215u m=1
XPHASE_XDCMD_XC (XPHASE_XDCMD_RC VSS) cap_mim_m3_1 l=22.215u w=22.215u m=1

ends sensor_phases

subckt p1_frontend_school_r3 (IP IN FP FN SEL0 SEL1 VCM VDD VSS)

// project1/p2adc_frontend_school_r3/schematic
XPGA_XOTA_XCMT (XPGA_XOTA_CTAIL XPGA_XOTA_BN VSS VSS) nfet_01v8 w=(9.2u) l=1u m=(1)*(1)
XPGA_XOTA_XCMR (XPGA_XOTA_CMG VCM XPGA_XOTA_CR VSS) nfet_01v8 w=(20u) l=1u m=(1)*(1)
XPGA_XOTA_XCMS (XPGA_XOTA_DS XPGA_XOTA_CMS XPGA_XOTA_CS VSS) nfet_01v8 w=(20u) l=1u m=(1)*(1)
XPGA_XOTA_XMON (ON XPGA_XOTA_CMG VSS VSS) nfet_01v8 w=(9u) l=1u m=(1)*(1)
XPGA_XOTA_XMOP (OP XPGA_XOTA_CMG VSS VSS) nfet_01v8 w=(9u) l=1u m=(1)*(1)
XPGA_XOTA_XMTAIL (XPGA_XOTA_TAIL XPGA_XOTA_BN VSS VSS) nfet_01v8 w=(40u) l=1u m=(1)*(1)
XPGA_XOTA_XMIN (XPGA_XOTA_N2 XPGA_SUMNEG XPGA_XOTA_TAIL VSS) nfet_01v8 w=(40u) l=1u m=(1)*(2)
XPGA_XOTA_XMIP (XPGA_XOTA_N1 XPGA_SUMPOS XPGA_XOTA_TAIL VSS) nfet_01v8 w=(40u) l=1u m=(1)*(2)
XPGA_XOTA_XBIAS_XDBN (XPGA_XOTA_BN XPGA_XOTA_BN VSS VSS) nfet_01v8 w=(20u) l=1u m=(1)*(1)
XPGA_XFN16_XSW_XN (XPGA_SUMNEG XPGA_E16 XPGA_XFN16_N VSS) nfet_01v8 w=(12u) l=150n m=(1)*(1)
XPGA_XFP16_XSW_XN (XPGA_SUMPOS XPGA_E16 XPGA_XFP16_N VSS) nfet_01v8 w=(12u) l=150n m=(1)*(1)
XPGA_XFN4_XSW_XN (XPGA_SUMNEG XPGA_E4 XPGA_XFN4_N VSS) nfet_01v8 w=(12u) l=150n m=(1)*(1)
XPGA_XFP4_XSW_XN (XPGA_SUMPOS XPGA_E4 XPGA_XFP4_N VSS) nfet_01v8 w=(12u) l=150n m=(1)*(1)
XPGA_XFN1_XSW_XN (XPGA_SUMNEG XPGA_E1 XPGA_XFN1_N VSS) nfet_01v8 w=(12u) l=150n m=(1)*(1)
XPGA_XFP1_XSW_XN (XPGA_SUMPOS XPGA_E1 XPGA_XFP1_N VSS) nfet_01v8 w=(12u) l=150n m=(1)*(1)
XPGA_XIE16_XN (XPGA_E16 XPGA_E16B VSS VSS) nfet_01v8 w=(2u) l=150n m=(1)*(1)
XPGA_XIE4_XN (XPGA_E4 XPGA_E4B VSS VSS) nfet_01v8 w=(2u) l=150n m=(1)*(1)
XPGA_XIE1_XN (XPGA_E1 XPGA_E1B VSS VSS) nfet_01v8 w=(2u) l=150n m=(1)*(1)
XPGA_XN16_XN1 (XPGA_XN16_N SEL1 VSS VSS) nfet_01v8 w=(2u) l=150n m=(1)*(1)
XPGA_XN16_XN0 (XPGA_E16B XPGA_S0B XPGA_XN16_N VSS) nfet_01v8 w=(2u) l=150n m=(1)*(1)
XPGA_XN4_XN1 (XPGA_XN4_N XPGA_S1B VSS VSS) nfet_01v8 w=(2u) l=150n m=(1)*(1)
XPGA_XN4_XN0 (XPGA_E4B SEL0 XPGA_XN4_N VSS) nfet_01v8 w=(2u) l=150n m=(1)*(1)
XPGA_XN1_XN1 (XPGA_XN1_N XPGA_S1B VSS VSS) nfet_01v8 w=(2u) l=150n m=(1)*(1)
XPGA_XN1_XN0 (XPGA_E1B XPGA_S0B XPGA_XN1_N VSS) nfet_01v8 w=(2u) l=150n m=(1)*(1)
XPGA_XI1_XN (XPGA_S1B SEL1 VSS VSS) nfet_01v8 w=(2u) l=150n m=(1)*(1)
XPGA_XI0_XN (XPGA_S0B SEL0 VSS VSS) nfet_01v8 w=(2u) l=150n m=(1)*(1)
XPGA_XOTA_XMSN (ON XPGA_XOTA_N2 VDD VDD) pfet_01v8 w=(45u) l=1u m=(1)*(4)
XPGA_XOTA_XMSP (OP XPGA_XOTA_N1 VDD VDD) pfet_01v8 w=(45u) l=1u m=(1)*(4)
XPGA_XOTA_XMLN (XPGA_XOTA_N2 XPGA_XOTA_NCM VDD VDD) pfet_01v8 w=(32u) l=1u m=(1)*(2)
XPGA_XOTA_XMLP (XPGA_XOTA_N1 XPGA_XOTA_NCM VDD VDD) pfet_01v8 w=(32u) l=1u m=(1)*(2)
XPGA_XFN16_XSW_XP (XPGA_SUMNEG XPGA_E16B XPGA_XFN16_N VDD) pfet_01v8 w=(24u) l=150n m=(1)*(1)
XPGA_XFP16_XSW_XP (XPGA_SUMPOS XPGA_E16B XPGA_XFP16_N VDD) pfet_01v8 w=(24u) l=150n m=(1)*(1)
XPGA_XFN4_XSW_XP (XPGA_SUMNEG XPGA_E4B XPGA_XFN4_N VDD) pfet_01v8 w=(24u) l=150n m=(1)*(1)
XPGA_XFP4_XSW_XP (XPGA_SUMPOS XPGA_E4B XPGA_XFP4_N VDD) pfet_01v8 w=(24u) l=150n m=(1)*(1)
XPGA_XFN1_XSW_XP (XPGA_SUMNEG XPGA_E1B XPGA_XFN1_N VDD) pfet_01v8 w=(24u) l=150n m=(1)*(1)
XPGA_XFP1_XSW_XP (XPGA_SUMPOS XPGA_E1B XPGA_XFP1_N VDD) pfet_01v8 w=(24u) l=150n m=(1)*(1)
XPGA_XIE16_XP (XPGA_E16 XPGA_E16B VDD VDD) pfet_01v8 w=(4u) l=150n m=(1)*(1)
XPGA_XIE4_XP (XPGA_E4 XPGA_E4B VDD VDD) pfet_01v8 w=(4u) l=150n m=(1)*(1)
XPGA_XIE1_XP (XPGA_E1 XPGA_E1B VDD VDD) pfet_01v8 w=(4u) l=150n m=(1)*(1)
XPGA_XN16_XP1 (XPGA_E16B SEL1 VDD VDD) pfet_01v8 w=(4u) l=150n m=(1)*(1)
XPGA_XN16_XP0 (XPGA_E16B XPGA_S0B VDD VDD) pfet_01v8 w=(4u) l=150n m=(1)*(1)
XPGA_XN4_XP1 (XPGA_E4B XPGA_S1B VDD VDD) pfet_01v8 w=(4u) l=150n m=(1)*(1)
XPGA_XN4_XP0 (XPGA_E4B SEL0 VDD VDD) pfet_01v8 w=(4u) l=150n m=(1)*(1)
XPGA_XN1_XP1 (XPGA_E1B XPGA_S1B VDD VDD) pfet_01v8 w=(4u) l=150n m=(1)*(1)
XPGA_XN1_XP0 (XPGA_E1B XPGA_S0B VDD VDD) pfet_01v8 w=(4u) l=150n m=(1)*(1)
XPGA_XI1_XP (XPGA_S1B SEL1 VDD VDD) pfet_01v8 w=(4u) l=150n m=(1)*(1)
XPGA_XI0_XP (XPGA_S0B SEL0 VDD VDD) pfet_01v8 w=(4u) l=150n m=(1)*(1)
XRIN_XR (ON FN VSS) res_high_po_0p35 r=1.19625K l=545n w=350n
XRIP_XR (OP FP VSS) res_high_po_0p35 r=1.19625K l=545n w=350n
XPGA_XOTA_XRCMG_XR_SEG_02 (XPGA_XOTA_XRCMG_XR_SERIES_NODE_01 XPGA_XOTA_CMG VSS) res_high_po_0p35 r=58.3241K l=51.9u w=350n
XPGA_XOTA_XRCMG_XR_SEG_01 (VDD XPGA_XOTA_XRCMG_XR_SERIES_NODE_01 VSS) res_high_po_0p35 r=58.3241K l=51.9u w=350n
XPGA_XOTA_XRDS_XR_SEG_02 (XPGA_XOTA_XRDS_XR_SERIES_NODE_01 XPGA_XOTA_DS VSS) res_high_po_0p35 r=58.3241K l=51.9u w=350n
XPGA_XOTA_XRDS_XR_SEG_01 (VDD XPGA_XOTA_XRDS_XR_SERIES_NODE_01 VSS) res_high_po_0p35 r=58.3241K l=51.9u w=350n
XPGA_XOTA_XRSCR_XR (XPGA_XOTA_CR XPGA_XOTA_CTAIL VSS) res_high_po_0p35 r=10.7185K l=9.105u w=350n
XPGA_XOTA_XRSCS_XR (XPGA_XOTA_CS XPGA_XOTA_CTAIL VSS) res_high_po_0p35 r=10.7185K l=9.105u w=350n
XPGA_XOTA_XRCMN_XR (ON XPGA_XOTA_CMS VSS) res_high_po_0p35 r=111.536K l=99.735u w=350n
XPGA_XOTA_XRCMP_XR (OP XPGA_XOTA_CMS VSS) res_high_po_0p35 r=111.536K l=99.735u w=350n
XPGA_XOTA_XRN2_XR (XPGA_XOTA_N2 XPGA_XOTA_NCM VSS) res_high_po_0p35 r=111.536K l=99.735u w=350n
XPGA_XOTA_XRN1_XR (XPGA_XOTA_N1 XPGA_XOTA_NCM VSS) res_high_po_0p35 r=111.536K l=99.735u w=350n
XPGA_XOTA_XBIAS_XRBP_XR_SEG_11 (XPGA_XOTA_XBIAS_XRBP_XR_SERIES_NODE_10 XPGA_XOTA_BN VSS) res_high_po_0p35 r=101.352K l=90.58u w=350n
XPGA_XOTA_XBIAS_XRBP_XR_SEG_10 (XPGA_XOTA_XBIAS_XRBP_XR_SERIES_NODE_09 XPGA_XOTA_XBIAS_XRBP_XR_SERIES_NODE_10 VSS) res_high_po_0p35 r=101.352K l=90.58u w=350n
XPGA_XOTA_XBIAS_XRBP_XR_SEG_09 (XPGA_XOTA_XBIAS_XRBP_XR_SERIES_NODE_08 XPGA_XOTA_XBIAS_XRBP_XR_SERIES_NODE_09 VSS) res_high_po_0p35 r=101.352K l=90.58u w=350n
XPGA_XOTA_XBIAS_XRBP_XR_SEG_08 (XPGA_XOTA_XBIAS_XRBP_XR_SERIES_NODE_07 XPGA_XOTA_XBIAS_XRBP_XR_SERIES_NODE_08 VSS) res_high_po_0p35 r=101.352K l=90.58u w=350n
XPGA_XOTA_XBIAS_XRBP_XR_SEG_07 (XPGA_XOTA_XBIAS_XRBP_XR_SERIES_NODE_06 XPGA_XOTA_XBIAS_XRBP_XR_SERIES_NODE_07 VSS) res_high_po_0p35 r=101.352K l=90.58u w=350n
XPGA_XOTA_XBIAS_XRBP_XR_SEG_06 (XPGA_XOTA_XBIAS_XRBP_XR_SERIES_NODE_05 XPGA_XOTA_XBIAS_XRBP_XR_SERIES_NODE_06 VSS) res_high_po_0p35 r=101.352K l=90.58u w=350n
XPGA_XOTA_XBIAS_XRBP_XR_SEG_05 (XPGA_XOTA_XBIAS_XRBP_XR_SERIES_NODE_04 XPGA_XOTA_XBIAS_XRBP_XR_SERIES_NODE_05 VSS) res_high_po_0p35 r=101.352K l=90.58u w=350n
XPGA_XOTA_XBIAS_XRBP_XR_SEG_04 (XPGA_XOTA_XBIAS_XRBP_XR_SERIES_NODE_03 XPGA_XOTA_XBIAS_XRBP_XR_SERIES_NODE_04 VSS) res_high_po_0p35 r=101.352K l=90.58u w=350n
XPGA_XOTA_XBIAS_XRBP_XR_SEG_03 (XPGA_XOTA_XBIAS_XRBP_XR_SERIES_NODE_02 XPGA_XOTA_XBIAS_XRBP_XR_SERIES_NODE_03 VSS) res_high_po_0p35 r=101.352K l=90.58u w=350n
XPGA_XOTA_XBIAS_XRBP_XR_SEG_02 (XPGA_XOTA_XBIAS_XRBP_XR_SERIES_NODE_01 XPGA_XOTA_XBIAS_XRBP_XR_SERIES_NODE_02 VSS) res_high_po_0p35 r=101.352K l=90.58u w=350n
XPGA_XOTA_XBIAS_XRBP_XR_SEG_01 (XPGA_XOTA_BP XPGA_XOTA_XBIAS_XRBP_XR_SERIES_NODE_01 VSS) res_high_po_0p35 r=101.352K l=90.58u w=350n
XPGA_XOTA_XBIAS_XRBN_XR (VDD XPGA_XOTA_BN VSS) res_high_po_0p35 r=26.3979K l=23.2u w=350n
XPGA_XFN16_XR_XR_SEG_02 (XPGA_XFN16_XR_XR_SERIES_NODE_01 XPGA_XFN16_N VSS) res_high_po_0p35 r=88.9432K l=79.425u w=350n
XPGA_XFN16_XR_XR_SEG_01 (OP XPGA_XFN16_XR_XR_SERIES_NODE_01 VSS) res_high_po_0p35 r=88.9432K l=79.425u w=350n
XPGA_XFP16_XR_XR_SEG_02 (XPGA_XFP16_XR_XR_SERIES_NODE_01 XPGA_XFP16_N VSS) res_high_po_0p35 r=88.9432K l=79.425u w=350n
XPGA_XFP16_XR_XR_SEG_01 (ON XPGA_XFP16_XR_XR_SERIES_NODE_01 VSS) res_high_po_0p35 r=88.9432K l=79.425u w=350n
XPGA_XFN4_XR_XR (OP XPGA_XFN4_N VSS) res_high_po_0p35 r=43.9184K l=38.95u w=350n
XPGA_XFP4_XR_XR (ON XPGA_XFP4_N VSS) res_high_po_0p35 r=43.9184K l=38.95u w=350n
XPGA_XFN1_XR_XR (OP XPGA_XFN1_N VSS) res_high_po_0p35 r=10.4849K l=8.895u w=350n
XPGA_XFP1_XR_XR (ON XPGA_XFP1_N VSS) res_high_po_0p35 r=10.4849K l=8.895u w=350n
XPGA_XRINN_XR (IN XPGA_SUMNEG VSS) res_high_po_0p35 r=10.7185K l=9.105u w=350n
XPGA_XRINP_XR (IP XPGA_SUMPOS VSS) res_high_po_0p35 r=10.7185K l=9.105u w=350n
XCFN_XC3_XC (FN VSS) cap_mim_m3_1 l=22.215u w=22.215u m=1
XCFN_XC2_XC (FN VSS) cap_mim_m3_1 l=22.215u w=22.215u m=1
XCFN_XC1_XC (FN VSS) cap_mim_m3_1 l=22.215u w=22.215u m=1
XCFN_XC0_XC (FN VSS) cap_mim_m3_1 l=22.215u w=22.215u m=1
XCFP_XC3_XC (FP VSS) cap_mim_m3_1 l=22.215u w=22.215u m=1
XCFP_XC2_XC (FP VSS) cap_mim_m3_1 l=22.215u w=22.215u m=1
XCFP_XC1_XC (FP VSS) cap_mim_m3_1 l=22.215u w=22.215u m=1
XCFP_XC0_XC (FP VSS) cap_mim_m3_1 l=22.215u w=22.215u m=1
XPGA_XOTA_XCSMN_XC (ON XPGA_XOTA_CMS) cap_mim_m3_1 l=22.215u w=22.215u m=1
XPGA_XOTA_XCSMP_XC (OP XPGA_XOTA_CMS) cap_mim_m3_1 l=22.215u w=22.215u m=1
XPGA_XOTA_XCCN_XC1_XC3_XC (XPGA_XOTA_CZN ON) cap_mim_m3_1 l=22.215u w=22.215u m=1
XPGA_XOTA_XCCN_XC1_XC2_XC (XPGA_XOTA_CZN ON) cap_mim_m3_1 l=22.215u w=22.215u m=1
XPGA_XOTA_XCCN_XC1_XC1_XC (XPGA_XOTA_CZN ON) cap_mim_m3_1 l=22.215u w=22.215u m=1
XPGA_XOTA_XCCN_XC1_XC0_XC (XPGA_XOTA_CZN ON) cap_mim_m3_1 l=22.215u w=22.215u m=1
XPGA_XOTA_XCCN_XC0_XC3_XC (XPGA_XOTA_CZN ON) cap_mim_m3_1 l=22.215u w=22.215u m=1
XPGA_XOTA_XCCN_XC0_XC2_XC (XPGA_XOTA_CZN ON) cap_mim_m3_1 l=22.215u w=22.215u m=1
XPGA_XOTA_XCCN_XC0_XC1_XC (XPGA_XOTA_CZN ON) cap_mim_m3_1 l=22.215u w=22.215u m=1
XPGA_XOTA_XCCN_XC0_XC0_XC (XPGA_XOTA_CZN ON) cap_mim_m3_1 l=22.215u w=22.215u m=1
XPGA_XOTA_XCCP_XC1_XC3_XC (XPGA_XOTA_CZP OP) cap_mim_m3_1 l=22.215u w=22.215u m=1
XPGA_XOTA_XCCP_XC1_XC2_XC (XPGA_XOTA_CZP OP) cap_mim_m3_1 l=22.215u w=22.215u m=1
XPGA_XOTA_XCCP_XC1_XC1_XC (XPGA_XOTA_CZP OP) cap_mim_m3_1 l=22.215u w=22.215u m=1
XPGA_XOTA_XCCP_XC1_XC0_XC (XPGA_XOTA_CZP OP) cap_mim_m3_1 l=22.215u w=22.215u m=1
XPGA_XOTA_XCCP_XC0_XC3_XC (XPGA_XOTA_CZP OP) cap_mim_m3_1 l=22.215u w=22.215u m=1
XPGA_XOTA_XCCP_XC0_XC2_XC (XPGA_XOTA_CZP OP) cap_mim_m3_1 l=22.215u w=22.215u m=1
XPGA_XOTA_XCCP_XC0_XC1_XC (XPGA_XOTA_CZP OP) cap_mim_m3_1 l=22.215u w=22.215u m=1
XPGA_XOTA_XCCP_XC0_XC0_XC (XPGA_XOTA_CZP OP) cap_mim_m3_1 l=22.215u w=22.215u m=1
XPGA_XOTA_XCN2_XC (XPGA_XOTA_N2 XPGA_XOTA_NCM) cap_mim_m3_1 l=22.215u w=22.215u m=1
XPGA_XOTA_XCN1_XC (XPGA_XOTA_N1 XPGA_XOTA_NCM) cap_mim_m3_1 l=22.215u w=22.215u m=1
XPGA_XOTA_XRZN_XR (XPGA_XOTA_N2 XPGA_XOTA_CZN VSS) res_high_po_0p69 r=810.013 l=855n w=690n
XPGA_XOTA_XRZP_XR (XPGA_XOTA_N1 XPGA_XOTA_CZP VSS) res_high_po_0p69 r=810.013 l=855n w=690n

ends p1_frontend_school_r3
