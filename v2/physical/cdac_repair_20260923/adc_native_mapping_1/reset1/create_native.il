; Versioned new-cell generator. Refuses every existing target. No PDK writes.
procedure(p2Type(v)
 if(or(v==t v==nil) then "boolean" else
 case(type(v) (string "string") (fixnum "int") (flonum "float") (t nil))))
procedure(p2Set(inst props callbacks)
 let((cdfgData cdfgForm initProc p cb typ)
  cdfgData=cdfGetInstCDF(inst)
  unless(cdfgData error("CDF missing: %s" inst~>name))
  initProc=cdfgData->formInitProc
  when(and(stringp(initProc) strlen(initProc)>0)
   unless(errset(apply(concat(initProc) list(cdfgData)) t) error("CDF init failed")))
  foreach(pair props
   p=cdfFindParamByName(cdfgData car(pair))
   unless(p error("CDF parameter missing: %s/%s" inst~>name car(pair)))
   p->value=cadr(pair))
  foreach(name callbacks
   p=cdfFindParamByName(cdfgData name)
   cb=p->callback
   when(and(stringp(cb) strlen(cb)>0)
    unless(errset(evalstring(cb) t) error("CDF callback failed: %s/%s" inst~>name name))))
  foreach(p cdfgData->parameters
   typ=p2Type(p->value)
   when(typ dbReplaceProp(inst p->name typ p->value)))
  cdfgData=cdfGetInstCDF(inst)
  foreach(pair props
   p=cdfFindParamByName(cdfgData car(pair))
   unless(p error("CDF value disappeared"))
   if(car(pair)=="connection" then
    unless(p->value==cadr(pair) error("CDF connection changed"))
   else
    unless(abs(if(stringp(p->value) then cdfParseFloatString(p->value) else p->value)-if(stringp(cadr(pair)) then cdfParseFloatString(cadr(pair)) else cadr(pair)))<1e-15
     error("CDF changed requested parameter %s/%s requested=%L actual=%L" inst~>name car(pair) cadr(pair) p->value))))
  p2Readback=cons(list(inst~>name inst~>cellName
   foreach(mapcar p cdfgData->parameters list(p->name p->value))) p2Readback)))
procedure(p2Pin(inst name)
 let((term pin)
  term=dbFindTermByName(inst~>master name)
  unless(term error("Missing pin %s/%s" inst~>name name))
  pin=car(term~>pins)
  dbTransformPoint(centerBox(pin~>fig~>bBox) inst~>transform)))
procedure(p2Create(name objects ports)
 let((cv master inst pt finish wire idx checks pm port pinWire)
  when(ddGetObj("project1" name) error("Target exists; never overwrite %s" name))
  p2Readback=nil
  cv=dbOpenCellViewByType("project1" name "schematic" "schematic" "w")
  unless(cv error("Cannot create target"))
  dbReplaceProp(cv "p2Source" "string" "adc_reset1_school_r1_20260923")
  dbReplaceProp(cv "p2Qualification" "string" "UNVERIFIED_GENERATED")
  dbSave(cv)
  idx=0
  foreach(obj objects
   master=dbOpenCellViewByType(cadr(obj) caddr(obj) "symbol" "" "r")
   unless(master error("Missing master"))
   inst=dbCreateInst(cv master car(obj) list(mod(idx 6)*12 -floor(idx/6)*5) "R0")
   unless(inst error("Instance creation failed"))
   if(cadr(obj)=="sky130_fd_pr_main" then
    unless(errset(p2Set(inst nth(4 obj) nth(5 obj)) t)
     dbSave(cv) error("Sizing failed; partial target retained"))
   else foreach(pair nth(4 obj) dbReplaceProp(inst car(pair) p2Type(cadr(pair)) cadr(pair))))
   foreach(pair nth(3 obj)
    pt=p2Pin(inst car(pair))
    cond((member(car(pair) list("IN1" "IN2")) finish=list(xCoord(pt)-0.75 yCoord(pt)))
         (member(car(pair) list("OUT1" "OUT2")) finish=list(xCoord(pt)+0.75 yCoord(pt)))
         (car(pair)=="G" finish=list(xCoord(pt)-0.75 yCoord(pt)))
         (car(pair)=="B" finish=list(xCoord(pt)+0.75 yCoord(pt)))
         (member(car(pair) list("D" "S"))
          finish=list(xCoord(pt) yCoord(pt)+if(yCoord(pt)>yCoord(inst~>xy) 0.5 -0.5)))
         (car(pair)=="PLUS" finish=list(xCoord(pt) yCoord(pt)+0.5))
         (t finish=list(xCoord(pt) yCoord(pt)-0.5)))
    wire=schCreateWire(cv "draw" "full" list(pt finish) 0.0625 0.0625 0.0)
    unless(wire error("Wire failed"))
    if(cadr(pair)=="0" then
     dbCreateInst(cv dbOpenCellViewByType("analogLib" "gnd" "symbol" "" "r") nil finish "R0")
    else
     unless(schCreateWireLabel(cv car(wire) finish cadr(pair) "lowerLeft" "R0" "stick" 0.0625 nil)
      error("Net label failed"))))
   dbSave(cv) dbClose(master)
   idx=idx+1)
  pm=dbOpenCellViewByType("basic" "iopin" "symbol" "" "r")
  unless(pm error("Missing schematic pin master"))
  idx=0
  foreach(port ports
   pt=list(-4 2-idx*0.75)
   unless(schCreatePin(cv pm port "inputOutput" nil pt "R0") error("Schematic port failed"))
   finish=list(xCoord(pt)+0.5 yCoord(pt))
   pinWire=schCreateWire(cv "draw" "full" list(pt finish) 0.0625 0.0625 0.0)
   unless(pinWire error("Port wire failed"))
   unless(schCreateWireLabel(cv car(pinWire) finish port "lowerLeft" "R0" "stick" 0.0625 nil) error("Port label failed"))
   idx=idx+1)
  dbClose(pm)
  checks=schCheck(cv)
  dbSave(cv) dbClose(cv)
  list(name checks reverse(p2Readback))))

procedure(p2adcSymbol(name ports)
 let((cv pm idx pt height)
  when(ddGetObj("project1" name "symbol") error("Symbol exists; refuse overwrite"))
  cv=dbOpenCellViewByType("project1" name "symbol" "schematicSymbol" "w")
  unless(cv error("Symbol open failed"))
  pm=dbOpenCellViewByType("basic" "sympin" "symbolNN" "" "r")
  unless(pm error("Symbol pin master missing"))
  height=max(2.0 (length(ports)+1)*0.375)
  dbCreateRect(cv list("device" "drawing") list(list(0 0) list(5 height)))
  idx=0
  foreach(port ports
   pt=list(0 height-0.375-idx*0.375)
   unless(schCreateSymbolPin(cv pm port "inputOutput" pt "R0") error("Symbol pin failed"))
   dbCreateLabel(cv list("device" "drawing") list(0.125 yCoord(pt)) port "centerLeft" "R0" "stick" 0.1)
   idx=idx+1)
  dbCreateLabel(cv list("device" "drawing") list(2.5 height+0.25) name "centerCenter" "R0" "stick" 0.125)
  dbReplaceProp(cv "p2Source" "string" "adc_reset1_school_r1_20260923")
  dbSave(cv) dbClose(cv) dbClose(pm)
  t))

when(ddGetObj("project1" "p2adc_core_reset1_school_r1") error("Existing target; refuse overwrite"))
p2adcOne=p2Create("p2adc_core_reset1_school_r1" list(
 list("XADC_XSP_XN" "sky130_fd_pr_main" "nfet_01v8_lvt" list(list("D" "XADC_TP") list("G" "SAMPLE") list("S" "VCM") list("B" "VSS")) list(list("w" "4u") list("fw" "4u") list("l" "0.15u") list("fingers" "1") list("m" "1")) list("fingers" "l" "fw" "m"))
 list("XADC_XSP_XP" "sky130_fd_pr_main" "pfet_01v8_lvt" list(list("D" "XADC_TP") list("G" "SAMPLEB") list("S" "VCM") list("B" "VDD")) list(list("w" "8u") list("fw" "8u") list("l" "0.35u") list("fingers" "1") list("m" "1")) list("fingers" "l" "fw" "m"))
 list("XADC_XSP_XND" "sky130_fd_pr_main" "nfet_01v8_lvt" list(list("D" "XADC_TP") list("G" "SAMPLEB") list("S" "XADC_TP") list("B" "VSS")) list(list("w" "2u") list("fw" "2u") list("l" "0.15u") list("fingers" "1") list("m" "1")) list("fingers" "l" "fw" "m"))
 list("XADC_XSP_XPD" "sky130_fd_pr_main" "pfet_01v8_lvt" list(list("D" "XADC_TP") list("G" "SAMPLE") list("S" "XADC_TP") list("B" "VDD")) list(list("w" "4u") list("fw" "4u") list("l" "0.35u") list("fingers" "1") list("m" "1")) list("fingers" "l" "fw" "m"))
 list("XADC_XSN_XN" "sky130_fd_pr_main" "nfet_01v8_lvt" list(list("D" "XADC_TN") list("G" "SAMPLE") list("S" "VCM") list("B" "VSS")) list(list("w" "4u") list("fw" "4u") list("l" "0.15u") list("fingers" "1") list("m" "1")) list("fingers" "l" "fw" "m"))
 list("XADC_XSN_XP" "sky130_fd_pr_main" "pfet_01v8_lvt" list(list("D" "XADC_TN") list("G" "SAMPLEB") list("S" "VCM") list("B" "VDD")) list(list("w" "8u") list("fw" "8u") list("l" "0.35u") list("fingers" "1") list("m" "1")) list("fingers" "l" "fw" "m"))
 list("XADC_XSN_XND" "sky130_fd_pr_main" "nfet_01v8_lvt" list(list("D" "XADC_TN") list("G" "SAMPLEB") list("S" "XADC_TN") list("B" "VSS")) list(list("w" "2u") list("fw" "2u") list("l" "0.15u") list("fingers" "1") list("m" "1")) list("fingers" "l" "fw" "m"))
 list("XADC_XSN_XPD" "sky130_fd_pr_main" "pfet_01v8_lvt" list(list("D" "XADC_TN") list("G" "SAMPLE") list("S" "XADC_TN") list("B" "VDD")) list(list("w" "4u") list("fw" "4u") list("l" "0.35u") list("fingers" "1") list("m" "1")) list("fingers" "l" "fw" "m"))
 list("XADC_XPRE_XBP1" "sky130_fd_pr_main" "pfet_01v8" list(list("D" "XADC_XPRE_BP") list("G" "XADC_XPRE_BP") list("S" "VDD") list("B" "VDD")) list(list("w" "10u") list("fw" "10u") list("l" "1u") list("fingers" "1") list("m" "1")) list("fingers" "l" "fw" "m"))
 list("XADC_XPRE_XBP2" "sky130_fd_pr_main" "pfet_01v8" list(list("D" "XADC_XPRE_BN") list("G" "XADC_XPRE_BP") list("S" "VDD") list("B" "VDD")) list(list("w" "10u") list("fw" "10u") list("l" "1u") list("fingers" "1") list("m" "1")) list("fingers" "l" "fw" "m"))
 list("XADC_XPRE_XBN1" "sky130_fd_pr_main" "nfet_01v8" list(list("D" "XADC_XPRE_BN") list("G" "XADC_XPRE_BN") list("S" "VSS") list("B" "VSS")) list(list("w" "8u") list("fw" "8u") list("l" "1u") list("fingers" "1") list("m" "1")) list("fingers" "l" "fw" "m"))
 list("XADC_XPRE_XBN2" "sky130_fd_pr_main" "nfet_01v8" list(list("D" "XADC_XPRE_BP") list("G" "XADC_XPRE_BN") list("S" "XADC_XPRE_BRS") list("B" "VSS")) list(list("w" "32u") list("fw" "32u") list("l" "1u") list("fingers" "1") list("m" "1")) list("fingers" "l" "fw" "m"))
 list("XADC_XPRE_XRBIAS_XR_SEG_1" "sky130_fd_pr_main" "res_high_po_5p73" list(list("PLUS" "XADC_XPRE_BRS") list("MINUS" "XADC_XPRE_XRBIAS_XR_SERIES_1") list("B" "VSS")) list(list("segL" "86.99u") list("segW" "5.73u") list("segments" 1) list("connection" "Series")) list("segL"))
 list("XADC_XPRE_XRBIAS_XR_SEG_2" "sky130_fd_pr_main" "res_high_po_5p73" list(list("PLUS" "XADC_XPRE_XRBIAS_XR_SERIES_1") list("MINUS" "VSS") list("B" "VSS")) list(list("segL" "86.99u") list("segW" "5.73u") list("segments" 1) list("connection" "Series")) list("segL"))
 list("XADC_XPRE_XSTPU" "sky130_fd_pr_main" "pfet_01v8" list(list("D" "XADC_XPRE_START") list("G" "VSS") list("S" "VDD") list("B" "VDD")) list(list("w" "0.55u") list("fw" "0.55u") list("l" "10u") list("fingers" "1") list("m" "1")) list("fingers" "l" "fw" "m"))
 list("XADC_XPRE_XSTOFF" "sky130_fd_pr_main" "nfet_01v8" list(list("D" "XADC_XPRE_START") list("G" "XADC_XPRE_BN") list("S" "VSS") list("B" "VSS")) list(list("w" "20u") list("fw" "20u") list("l" "1u") list("fingers" "1") list("m" "1")) list("fingers" "l" "fw" "m"))
 list("XADC_XPRE_XSTINJ" "sky130_fd_pr_main" "nfet_01v8" list(list("D" "XADC_XPRE_BP") list("G" "XADC_XPRE_START") list("S" "VSS") list("B" "VSS")) list(list("w" "0.5u") list("fw" "0.5u") list("l" "2u") list("fingers" "1") list("m" "1")) list("fingers" "l" "fw" "m"))
 list("XADC_XPRE_XIP" "sky130_fd_pr_main" "nfet_01v8" list(list("D" "XADC_PREN") list("G" "XADC_TN") list("S" "XADC_XPRE_TAIL") list("B" "VSS")) list(list("w" "30u") list("fw" "30u") list("l" "1u") list("fingers" "1") list("m" "1")) list("fingers" "l" "fw" "m"))
 list("XADC_XPRE_XIN" "sky130_fd_pr_main" "nfet_01v8" list(list("D" "XADC_PREP") list("G" "XADC_TP") list("S" "XADC_XPRE_TAIL") list("B" "VSS")) list(list("w" "30u") list("fw" "30u") list("l" "1u") list("fingers" "1") list("m" "1")) list("fingers" "l" "fw" "m"))
 list("XADC_XPRE_XTAIL" "sky130_fd_pr_main" "nfet_01v8" list(list("D" "XADC_XPRE_TAIL") list("G" "XADC_XPRE_BN") list("S" "VSS") list("B" "VSS")) list(list("w" "32u") list("fw" "32u") list("l" "1u") list("fingers" "1") list("m" "1")) list("fingers" "l" "fw" "m"))
 list("XADC_XPRE_XRP_XR0_XR_SEG_1" "sky130_fd_pr_main" "res_high_po_5p73" list(list("PLUS" "VDD") list("MINUS" "XADC_XPRE_XRP_XR0_XR_SERIES_1") list("B" "VSS")) list(list("segL" "86.99u") list("segW" "5.73u") list("segments" 1) list("connection" "Series")) list("segL"))
 list("XADC_XPRE_XRP_XR0_XR_SEG_2" "sky130_fd_pr_main" "res_high_po_5p73" list(list("PLUS" "XADC_XPRE_XRP_XR0_XR_SERIES_1") list("MINUS" "XADC_XPRE_XRP_N1") list("B" "VSS")) list(list("segL" "86.99u") list("segW" "5.73u") list("segments" 1) list("connection" "Series")) list("segL"))
 list("XADC_XPRE_XRP_XR1_XR_SEG_1" "sky130_fd_pr_main" "res_high_po_5p73" list(list("PLUS" "XADC_XPRE_XRP_N1") list("MINUS" "XADC_XPRE_XRP_XR1_XR_SERIES_1") list("B" "VSS")) list(list("segL" "86.99u") list("segW" "5.73u") list("segments" 1) list("connection" "Series")) list("segL"))
 list("XADC_XPRE_XRP_XR1_XR_SEG_2" "sky130_fd_pr_main" "res_high_po_5p73" list(list("PLUS" "XADC_XPRE_XRP_XR1_XR_SERIES_1") list("MINUS" "XADC_XPRE_XRP_N2") list("B" "VSS")) list(list("segL" "86.99u") list("segW" "5.73u") list("segments" 1) list("connection" "Series")) list("segL"))
 list("XADC_XPRE_XRP_XR2_XR_SEG_1" "sky130_fd_pr_main" "res_high_po_5p73" list(list("PLUS" "XADC_XPRE_XRP_N2") list("MINUS" "XADC_XPRE_XRP_XR2_XR_SERIES_1") list("B" "VSS")) list(list("segL" "86.99u") list("segW" "5.73u") list("segments" 1) list("connection" "Series")) list("segL"))
 list("XADC_XPRE_XRP_XR2_XR_SEG_2" "sky130_fd_pr_main" "res_high_po_5p73" list(list("PLUS" "XADC_XPRE_XRP_XR2_XR_SERIES_1") list("MINUS" "XADC_XPRE_XRP_N3") list("B" "VSS")) list(list("segL" "86.99u") list("segW" "5.73u") list("segments" 1) list("connection" "Series")) list("segL"))
 list("XADC_XPRE_XRP_XR3_XR_SEG_1" "sky130_fd_pr_main" "res_high_po_5p73" list(list("PLUS" "XADC_XPRE_XRP_N3") list("MINUS" "XADC_XPRE_XRP_XR3_XR_SERIES_1") list("B" "VSS")) list(list("segL" "86.99u") list("segW" "5.73u") list("segments" 1) list("connection" "Series")) list("segL"))
 list("XADC_XPRE_XRP_XR3_XR_SEG_2" "sky130_fd_pr_main" "res_high_po_5p73" list(list("PLUS" "XADC_XPRE_XRP_XR3_XR_SERIES_1") list("MINUS" "XADC_XPRE_XRP_N4") list("B" "VSS")) list(list("segL" "86.99u") list("segW" "5.73u") list("segments" 1) list("connection" "Series")) list("segL"))
 list("XADC_XPRE_XRP_XR4_XR_SEG_1" "sky130_fd_pr_main" "res_high_po_5p73" list(list("PLUS" "XADC_XPRE_XRP_N4") list("MINUS" "XADC_XPRE_XRP_XR4_XR_SERIES_1") list("B" "VSS")) list(list("segL" "86.99u") list("segW" "5.73u") list("segments" 1) list("connection" "Series")) list("segL"))
 list("XADC_XPRE_XRP_XR4_XR_SEG_2" "sky130_fd_pr_main" "res_high_po_5p73" list(list("PLUS" "XADC_XPRE_XRP_XR4_XR_SERIES_1") list("MINUS" "XADC_XPRE_XRP_N5") list("B" "VSS")) list(list("segL" "86.99u") list("segW" "5.73u") list("segments" 1) list("connection" "Series")) list("segL"))
 list("XADC_XPRE_XRP_XR5_XR_SEG_1" "sky130_fd_pr_main" "res_high_po_5p73" list(list("PLUS" "XADC_XPRE_XRP_N5") list("MINUS" "XADC_XPRE_XRP_XR5_XR_SERIES_1") list("B" "VSS")) list(list("segL" "86.99u") list("segW" "5.73u") list("segments" 1) list("connection" "Series")) list("segL"))
 list("XADC_XPRE_XRP_XR5_XR_SEG_2" "sky130_fd_pr_main" "res_high_po_5p73" list(list("PLUS" "XADC_XPRE_XRP_XR5_XR_SERIES_1") list("MINUS" "XADC_XPRE_XRP_N6") list("B" "VSS")) list(list("segL" "86.99u") list("segW" "5.73u") list("segments" 1) list("connection" "Series")) list("segL"))
 list("XADC_XPRE_XRP_XR6_XR_SEG_1" "sky130_fd_pr_main" "res_high_po_5p73" list(list("PLUS" "XADC_XPRE_XRP_N6") list("MINUS" "XADC_XPRE_XRP_XR6_XR_SERIES_1") list("B" "VSS")) list(list("segL" "86.99u") list("segW" "5.73u") list("segments" 1) list("connection" "Series")) list("segL"))
 list("XADC_XPRE_XRP_XR6_XR_SEG_2" "sky130_fd_pr_main" "res_high_po_5p73" list(list("PLUS" "XADC_XPRE_XRP_XR6_XR_SERIES_1") list("MINUS" "XADC_XPRE_XRP_N7") list("B" "VSS")) list(list("segL" "86.99u") list("segW" "5.73u") list("segments" 1) list("connection" "Series")) list("segL"))
 list("XADC_XPRE_XRP_XR7_XR" "sky130_fd_pr_main" "res_high_po_5p73" list(list("PLUS" "XADC_XPRE_XRP_N7") list("MINUS" "XADC_PREP") list("B" "VSS")) list(list("segL" "86.99u") list("segW" "5.73u") list("segments" 1) list("connection" "Series")) list("segL"))
 list("XADC_XPRE_XRN_XR0_XR_SEG_1" "sky130_fd_pr_main" "res_high_po_5p73" list(list("PLUS" "VDD") list("MINUS" "XADC_XPRE_XRN_XR0_XR_SERIES_1") list("B" "VSS")) list(list("segL" "86.99u") list("segW" "5.73u") list("segments" 1) list("connection" "Series")) list("segL"))
 list("XADC_XPRE_XRN_XR0_XR_SEG_2" "sky130_fd_pr_main" "res_high_po_5p73" list(list("PLUS" "XADC_XPRE_XRN_XR0_XR_SERIES_1") list("MINUS" "XADC_XPRE_XRN_N1") list("B" "VSS")) list(list("segL" "86.99u") list("segW" "5.73u") list("segments" 1) list("connection" "Series")) list("segL"))
 list("XADC_XPRE_XRN_XR1_XR_SEG_1" "sky130_fd_pr_main" "res_high_po_5p73" list(list("PLUS" "XADC_XPRE_XRN_N1") list("MINUS" "XADC_XPRE_XRN_XR1_XR_SERIES_1") list("B" "VSS")) list(list("segL" "86.99u") list("segW" "5.73u") list("segments" 1) list("connection" "Series")) list("segL"))
 list("XADC_XPRE_XRN_XR1_XR_SEG_2" "sky130_fd_pr_main" "res_high_po_5p73" list(list("PLUS" "XADC_XPRE_XRN_XR1_XR_SERIES_1") list("MINUS" "XADC_XPRE_XRN_N2") list("B" "VSS")) list(list("segL" "86.99u") list("segW" "5.73u") list("segments" 1) list("connection" "Series")) list("segL"))
 list("XADC_XPRE_XRN_XR2_XR_SEG_1" "sky130_fd_pr_main" "res_high_po_5p73" list(list("PLUS" "XADC_XPRE_XRN_N2") list("MINUS" "XADC_XPRE_XRN_XR2_XR_SERIES_1") list("B" "VSS")) list(list("segL" "86.99u") list("segW" "5.73u") list("segments" 1) list("connection" "Series")) list("segL"))
 list("XADC_XPRE_XRN_XR2_XR_SEG_2" "sky130_fd_pr_main" "res_high_po_5p73" list(list("PLUS" "XADC_XPRE_XRN_XR2_XR_SERIES_1") list("MINUS" "XADC_XPRE_XRN_N3") list("B" "VSS")) list(list("segL" "86.99u") list("segW" "5.73u") list("segments" 1) list("connection" "Series")) list("segL"))
 list("XADC_XPRE_XRN_XR3_XR_SEG_1" "sky130_fd_pr_main" "res_high_po_5p73" list(list("PLUS" "XADC_XPRE_XRN_N3") list("MINUS" "XADC_XPRE_XRN_XR3_XR_SERIES_1") list("B" "VSS")) list(list("segL" "86.99u") list("segW" "5.73u") list("segments" 1) list("connection" "Series")) list("segL"))
 list("XADC_XPRE_XRN_XR3_XR_SEG_2" "sky130_fd_pr_main" "res_high_po_5p73" list(list("PLUS" "XADC_XPRE_XRN_XR3_XR_SERIES_1") list("MINUS" "XADC_XPRE_XRN_N4") list("B" "VSS")) list(list("segL" "86.99u") list("segW" "5.73u") list("segments" 1) list("connection" "Series")) list("segL"))
 list("XADC_XPRE_XRN_XR4_XR_SEG_1" "sky130_fd_pr_main" "res_high_po_5p73" list(list("PLUS" "XADC_XPRE_XRN_N4") list("MINUS" "XADC_XPRE_XRN_XR4_XR_SERIES_1") list("B" "VSS")) list(list("segL" "86.99u") list("segW" "5.73u") list("segments" 1) list("connection" "Series")) list("segL"))
 list("XADC_XPRE_XRN_XR4_XR_SEG_2" "sky130_fd_pr_main" "res_high_po_5p73" list(list("PLUS" "XADC_XPRE_XRN_XR4_XR_SERIES_1") list("MINUS" "XADC_XPRE_XRN_N5") list("B" "VSS")) list(list("segL" "86.99u") list("segW" "5.73u") list("segments" 1) list("connection" "Series")) list("segL"))
 list("XADC_XPRE_XRN_XR5_XR_SEG_1" "sky130_fd_pr_main" "res_high_po_5p73" list(list("PLUS" "XADC_XPRE_XRN_N5") list("MINUS" "XADC_XPRE_XRN_XR5_XR_SERIES_1") list("B" "VSS")) list(list("segL" "86.99u") list("segW" "5.73u") list("segments" 1) list("connection" "Series")) list("segL"))
 list("XADC_XPRE_XRN_XR5_XR_SEG_2" "sky130_fd_pr_main" "res_high_po_5p73" list(list("PLUS" "XADC_XPRE_XRN_XR5_XR_SERIES_1") list("MINUS" "XADC_XPRE_XRN_N6") list("B" "VSS")) list(list("segL" "86.99u") list("segW" "5.73u") list("segments" 1) list("connection" "Series")) list("segL"))
 list("XADC_XPRE_XRN_XR6_XR_SEG_1" "sky130_fd_pr_main" "res_high_po_5p73" list(list("PLUS" "XADC_XPRE_XRN_N6") list("MINUS" "XADC_XPRE_XRN_XR6_XR_SERIES_1") list("B" "VSS")) list(list("segL" "86.99u") list("segW" "5.73u") list("segments" 1) list("connection" "Series")) list("segL"))
 list("XADC_XPRE_XRN_XR6_XR_SEG_2" "sky130_fd_pr_main" "res_high_po_5p73" list(list("PLUS" "XADC_XPRE_XRN_XR6_XR_SERIES_1") list("MINUS" "XADC_XPRE_XRN_N7") list("B" "VSS")) list(list("segL" "86.99u") list("segW" "5.73u") list("segments" 1) list("connection" "Series")) list("segL"))
 list("XADC_XPRE_XRN_XR7_XR" "sky130_fd_pr_main" "res_high_po_5p73" list(list("PLUS" "XADC_XPRE_XRN_N7") list("MINUS" "XADC_PREN") list("B" "VSS")) list(list("segL" "86.99u") list("segW" "5.73u") list("segments" 1) list("connection" "Series")) list("segL"))
 list("XADC_XPRE_XCP_XC" "sky130_fd_pr_main" "cap_mim_m3__base" list(list("PLUS" "XADC_PREP") list("MINUS" "VSS")) list(list("w" "4u") list("l" "4u") list("m" "4")) list("w" "l" "m"))
 list("XADC_XPRE_XCN_XC" "sky130_fd_pr_main" "cap_mim_m3__base" list(list("PLUS" "XADC_PREN") list("MINUS" "VSS")) list(list("w" "4u") list("l" "4u") list("m" "4")) list("w" "l" "m"))
 list("XADC_XCMP_XCORE_XIP" "sky130_fd_pr_main" "nfet_01v8" list(list("D" "XADC_XCMP_XCORE_DP") list("G" "XADC_PREP") list("S" "XADC_XCMP_XCORE_TAIL") list("B" "VSS")) list(list("w" "8.4u") list("fw" "8.4u") list("l" "0.5u") list("fingers" "1") list("m" "1")) list("fingers" "l" "fw" "m"))
 list("XADC_XCMP_XCORE_XIN" "sky130_fd_pr_main" "nfet_01v8" list(list("D" "XADC_XCMP_XCORE_DN") list("G" "XADC_PREN") list("S" "XADC_XCMP_XCORE_TAIL") list("B" "VSS")) list(list("w" "8.4u") list("fw" "8.4u") list("l" "0.5u") list("fingers" "1") list("m" "1")) list("fingers" "l" "fw" "m"))
 list("XADC_XCMP_XCORE_XT" "sky130_fd_pr_main" "nfet_01v8" list(list("D" "XADC_XCMP_XCORE_TAIL") list("G" "EVAL") list("S" "VSS") list("B" "VSS")) list(list("w" "16u") list("fw" "16u") list("l" "0.15u") list("fingers" "1") list("m" "1")) list("fingers" "l" "fw" "m"))
 list("XADC_XCMP_XCORE_XLN" "sky130_fd_pr_main" "nfet_01v8" list(list("D" "XADC_XCMP_DNEG") list("G" "XADC_XCMP_DPOS") list("S" "XADC_XCMP_XCORE_DP") list("B" "VSS")) list(list("w" "4u") list("fw" "4u") list("l" "0.15u") list("fingers" "1") list("m" "1")) list("fingers" "l" "fw" "m"))
 list("XADC_XCMP_XCORE_XLP" "sky130_fd_pr_main" "nfet_01v8" list(list("D" "XADC_XCMP_DPOS") list("G" "XADC_XCMP_DNEG") list("S" "XADC_XCMP_XCORE_DN") list("B" "VSS")) list(list("w" "4u") list("fw" "4u") list("l" "0.15u") list("fingers" "1") list("m" "1")) list("fingers" "l" "fw" "m"))
 list("XADC_XCMP_XCORE_XPN" "sky130_fd_pr_main" "pfet_01v8" list(list("D" "XADC_XCMP_DNEG") list("G" "XADC_XCMP_DPOS") list("S" "VDD") list("B" "VDD")) list(list("w" "8u") list("fw" "8u") list("l" "0.15u") list("fingers" "1") list("m" "1")) list("fingers" "l" "fw" "m"))
 list("XADC_XCMP_XCORE_XPP" "sky130_fd_pr_main" "pfet_01v8" list(list("D" "XADC_XCMP_DPOS") list("G" "XADC_XCMP_DNEG") list("S" "VDD") list("B" "VDD")) list(list("w" "8u") list("fw" "8u") list("l" "0.15u") list("fingers" "1") list("m" "1")) list("fingers" "l" "fw" "m"))
 list("XADC_XCMP_XCORE_XRN" "sky130_fd_pr_main" "pfet_01v8" list(list("D" "XADC_XCMP_DNEG") list("G" "EVAL") list("S" "VDD") list("B" "VDD")) list(list("w" "2u") list("fw" "2u") list("l" "0.15u") list("fingers" "1") list("m" "1")) list("fingers" "l" "fw" "m"))
 list("XADC_XCMP_XCORE_XRP" "sky130_fd_pr_main" "pfet_01v8" list(list("D" "XADC_XCMP_DPOS") list("G" "EVAL") list("S" "VDD") list("B" "VDD")) list(list("w" "2u") list("fw" "2u") list("l" "0.15u") list("fingers" "1") list("m" "1")) list("fingers" "l" "fw" "m"))
 list("XADC_XCMP_XCORE_XRDN" "sky130_fd_pr_main" "pfet_01v8" list(list("D" "XADC_XCMP_XCORE_DP") list("G" "EVAL") list("S" "VDD") list("B" "VDD")) list(list("w" "2u") list("fw" "2u") list("l" "0.15u") list("fingers" "1") list("m" "1")) list("fingers" "l" "fw" "m"))
 list("XADC_XCMP_XCORE_XRDP" "sky130_fd_pr_main" "pfet_01v8" list(list("D" "XADC_XCMP_XCORE_DN") list("G" "EVAL") list("S" "VDD") list("B" "VDD")) list(list("w" "2u") list("fw" "2u") list("l" "0.15u") list("fingers" "1") list("m" "1")) list("fingers" "l" "fw" "m"))
 list("XADC_XCMP_XLOADP_XC" "sky130_fd_pr_main" "cap_mim_m3__base" list(list("PLUS" "XADC_XCMP_DPOS") list("MINUS" "VSS")) list(list("w" "4u") list("l" "4u") list("m" "16")) list("w" "l" "m"))
 list("XADC_XCMP_XLOADN_XC" "sky130_fd_pr_main" "cap_mim_m3__base" list(list("PLUS" "XADC_XCMP_DNEG") list("MINUS" "VSS")) list(list("w" "4u") list("l" "4u") list("m" "16")) list("w" "l" "m"))
 list("XADC_XCMP_XBP1_XP" "sky130_fd_pr_main" "pfet_01v8" list(list("D" "XADC_XCMP_BPB") list("G" "XADC_XCMP_DPOS") list("S" "VDD") list("B" "VDD")) list(list("w" "2u") list("fw" "2u") list("l" "0.15u") list("fingers" "1") list("m" "1")) list("fingers" "l" "fw" "m"))
 list("XADC_XCMP_XBP1_XN" "sky130_fd_pr_main" "nfet_01v8" list(list("D" "XADC_XCMP_BPB") list("G" "XADC_XCMP_DPOS") list("S" "VSS") list("B" "VSS")) list(list("w" "1u") list("fw" "1u") list("l" "0.15u") list("fingers" "1") list("m" "1")) list("fingers" "l" "fw" "m"))
 list("XADC_XCMP_XBP2_XP" "sky130_fd_pr_main" "pfet_01v8" list(list("D" "XADC_XCMP_BP") list("G" "XADC_XCMP_BPB") list("S" "VDD") list("B" "VDD")) list(list("w" "2u") list("fw" "2u") list("l" "0.15u") list("fingers" "1") list("m" "1")) list("fingers" "l" "fw" "m"))
 list("XADC_XCMP_XBP2_XN" "sky130_fd_pr_main" "nfet_01v8" list(list("D" "XADC_XCMP_BP") list("G" "XADC_XCMP_BPB") list("S" "VSS") list("B" "VSS")) list(list("w" "1u") list("fw" "1u") list("l" "0.15u") list("fingers" "1") list("m" "1")) list("fingers" "l" "fw" "m"))
 list("XADC_XCMP_XBN1_XP" "sky130_fd_pr_main" "pfet_01v8" list(list("D" "XADC_XCMP_BNB") list("G" "XADC_XCMP_DNEG") list("S" "VDD") list("B" "VDD")) list(list("w" "2u") list("fw" "2u") list("l" "0.15u") list("fingers" "1") list("m" "1")) list("fingers" "l" "fw" "m"))
 list("XADC_XCMP_XBN1_XN" "sky130_fd_pr_main" "nfet_01v8" list(list("D" "XADC_XCMP_BNB") list("G" "XADC_XCMP_DNEG") list("S" "VSS") list("B" "VSS")) list(list("w" "1u") list("fw" "1u") list("l" "0.15u") list("fingers" "1") list("m" "1")) list("fingers" "l" "fw" "m"))
 list("XADC_XCMP_XBN2_XP" "sky130_fd_pr_main" "pfet_01v8" list(list("D" "XADC_XCMP_BN") list("G" "XADC_XCMP_BNB") list("S" "VDD") list("B" "VDD")) list(list("w" "2u") list("fw" "2u") list("l" "0.15u") list("fingers" "1") list("m" "1")) list("fingers" "l" "fw" "m"))
 list("XADC_XCMP_XBN2_XN" "sky130_fd_pr_main" "nfet_01v8" list(list("D" "XADC_XCMP_BN") list("G" "XADC_XCMP_BNB") list("S" "VSS") list("B" "VSS")) list(list("w" "1u") list("fw" "1u") list("l" "0.15u") list("fingers" "1") list("m" "1")) list("fingers" "l" "fw" "m"))
 list("XADC_XCMP_XSET_XP1" "sky130_fd_pr_main" "pfet_01v8" list(list("D" "Q") list("G" "XADC_XCMP_S_BAR") list("S" "VDD") list("B" "VDD")) list(list("w" "2u") list("fw" "2u") list("l" "0.15u") list("fingers" "1") list("m" "1")) list("fingers" "l" "fw" "m"))
 list("XADC_XCMP_XSET_XP2" "sky130_fd_pr_main" "pfet_01v8" list(list("D" "Q") list("G" "QB") list("S" "VDD") list("B" "VDD")) list(list("w" "2u") list("fw" "2u") list("l" "0.15u") list("fingers" "1") list("m" "1")) list("fingers" "l" "fw" "m"))
 list("XADC_XCMP_XSET_XN1" "sky130_fd_pr_main" "nfet_01v8" list(list("D" "Q") list("G" "XADC_XCMP_S_BAR") list("S" "XADC_XCMP_XSET_MID") list("B" "VSS")) list(list("w" "2u") list("fw" "2u") list("l" "0.15u") list("fingers" "1") list("m" "1")) list("fingers" "l" "fw" "m"))
 list("XADC_XCMP_XSET_XN2" "sky130_fd_pr_main" "nfet_01v8" list(list("D" "XADC_XCMP_XSET_MID") list("G" "QB") list("S" "VSS") list("B" "VSS")) list(list("w" "2u") list("fw" "2u") list("l" "0.15u") list("fingers" "1") list("m" "1")) list("fingers" "l" "fw" "m"))
 list("XADC_XCMP_XRESET_XP1" "sky130_fd_pr_main" "pfet_01v8" list(list("D" "QB") list("G" "XADC_XCMP_R_BAR") list("S" "VDD") list("B" "VDD")) list(list("w" "2u") list("fw" "2u") list("l" "0.15u") list("fingers" "1") list("m" "1")) list("fingers" "l" "fw" "m"))
 list("XADC_XCMP_XRESET_XP2" "sky130_fd_pr_main" "pfet_01v8" list(list("D" "QB") list("G" "Q") list("S" "VDD") list("B" "VDD")) list(list("w" "2u") list("fw" "2u") list("l" "0.15u") list("fingers" "1") list("m" "1")) list("fingers" "l" "fw" "m"))
 list("XADC_XCMP_XRESET_XN1" "sky130_fd_pr_main" "nfet_01v8" list(list("D" "QB") list("G" "XADC_XCMP_R_BAR") list("S" "XADC_XCMP_XRESET_MID") list("B" "VSS")) list(list("w" "2u") list("fw" "2u") list("l" "0.15u") list("fingers" "1") list("m" "1")) list("fingers" "l" "fw" "m"))
 list("XADC_XCMP_XRESET_XN2" "sky130_fd_pr_main" "nfet_01v8" list(list("D" "XADC_XCMP_XRESET_MID") list("G" "Q") list("S" "VSS") list("B" "VSS")) list(list("w" "2u") list("fw" "2u") list("l" "0.15u") list("fingers" "1") list("m" "1")) list("fingers" "l" "fw" "m"))
 list("XADC_XP0_XBI_XP" "sky130_fd_pr_main" "pfet_01v8" list(list("D" "XADC_XP0_BITB") list("G" "B0") list("S" "VDD") list("B" "VDD")) list(list("w" "2u") list("fw" "2u") list("l" "0.15u") list("fingers" "1") list("m" "1")) list("fingers" "l" "fw" "m"))
 list("XADC_XP0_XBI_XN" "sky130_fd_pr_main" "nfet_01v8" list(list("D" "XADC_XP0_BITB") list("G" "B0") list("S" "VSS") list("B" "VSS")) list(list("w" "1u") list("fw" "1u") list("l" "0.15u") list("fingers" "1") list("m" "1")) list("fingers" "l" "fw" "m"))
 list("XADC_XP0_XAI_XP" "sky130_fd_pr_main" "pfet_01v8" list(list("D" "XADC_XP0_ACQB") list("G" "ACQ") list("S" "VDD") list("B" "VDD")) list(list("w" "2u") list("fw" "2u") list("l" "0.15u") list("fingers" "1") list("m" "1")) list("fingers" "l" "fw" "m"))
 list("XADC_XP0_XAI_XN" "sky130_fd_pr_main" "nfet_01v8" list(list("D" "XADC_XP0_ACQB") list("G" "ACQ") list("S" "VSS") list("B" "VSS")) list(list("w" "1u") list("fw" "1u") list("l" "0.15u") list("fingers" "1") list("m" "1")) list("fingers" "l" "fw" "m"))
 list("XADC_XP0_XPH_XP1" "sky130_fd_pr_main" "pfet_01v8" list(list("D" "XADC_XP0_PHB") list("G" "CONV") list("S" "VDD") list("B" "VDD")) list(list("w" "2u") list("fw" "2u") list("l" "0.15u") list("fingers" "1") list("m" "1")) list("fingers" "l" "fw" "m"))
 list("XADC_XP0_XPH_XP2" "sky130_fd_pr_main" "pfet_01v8" list(list("D" "XADC_XP0_PHB") list("G" "B0") list("S" "VDD") list("B" "VDD")) list(list("w" "2u") list("fw" "2u") list("l" "0.15u") list("fingers" "1") list("m" "1")) list("fingers" "l" "fw" "m"))
 list("XADC_XP0_XPH_XN1" "sky130_fd_pr_main" "nfet_01v8" list(list("D" "XADC_XP0_PHB") list("G" "CONV") list("S" "XADC_XP0_XPH_MID") list("B" "VSS")) list(list("w" "2u") list("fw" "2u") list("l" "0.15u") list("fingers" "1") list("m" "1")) list("fingers" "l" "fw" "m"))
 list("XADC_XP0_XPH_XN2" "sky130_fd_pr_main" "nfet_01v8" list(list("D" "XADC_XP0_XPH_MID") list("G" "B0") list("S" "VSS") list("B" "VSS")) list(list("w" "2u") list("fw" "2u") list("l" "0.15u") list("fingers" "1") list("m" "1")) list("fingers" "l" "fw" "m"))
 list("XADC_XP0_XPI_XP" "sky130_fd_pr_main" "pfet_01v8" list(list("D" "XADC_XP0_PH") list("G" "XADC_XP0_PHB") list("S" "VDD") list("B" "VDD")) list(list("w" "2u") list("fw" "2u") list("l" "0.15u") list("fingers" "1") list("m" "1")) list("fingers" "l" "fw" "m"))
 list("XADC_XP0_XPI_XN" "sky130_fd_pr_main" "nfet_01v8" list(list("D" "XADC_XP0_PH") list("G" "XADC_XP0_PHB") list("S" "VSS") list("B" "VSS")) list(list("w" "1u") list("fw" "1u") list("l" "0.15u") list("fingers" "1") list("m" "1")) list("fingers" "l" "fw" "m"))
 list("XADC_XP0_XNL_XP1" "sky130_fd_pr_main" "pfet_01v8" list(list("D" "XADC_XP0_NLB") list("G" "CONV") list("S" "VDD") list("B" "VDD")) list(list("w" "2u") list("fw" "2u") list("l" "0.15u") list("fingers" "1") list("m" "1")) list("fingers" "l" "fw" "m"))
 list("XADC_XP0_XNL_XP2" "sky130_fd_pr_main" "pfet_01v8" list(list("D" "XADC_XP0_NLB") list("G" "XADC_XP0_BITB") list("S" "VDD") list("B" "VDD")) list(list("w" "2u") list("fw" "2u") list("l" "0.15u") list("fingers" "1") list("m" "1")) list("fingers" "l" "fw" "m"))
 list("XADC_XP0_XNL_XN1" "sky130_fd_pr_main" "nfet_01v8" list(list("D" "XADC_XP0_NLB") list("G" "CONV") list("S" "XADC_XP0_XNL_MID") list("B" "VSS")) list(list("w" "2u") list("fw" "2u") list("l" "0.15u") list("fingers" "1") list("m" "1")) list("fingers" "l" "fw" "m"))
 list("XADC_XP0_XNL_XN2" "sky130_fd_pr_main" "nfet_01v8" list(list("D" "XADC_XP0_XNL_MID") list("G" "XADC_XP0_BITB") list("S" "VSS") list("B" "VSS")) list(list("w" "2u") list("fw" "2u") list("l" "0.15u") list("fingers" "1") list("m" "1")) list("fingers" "l" "fw" "m"))
 list("XADC_XP0_XNI_XP" "sky130_fd_pr_main" "pfet_01v8" list(list("D" "XADC_XP0_NL") list("G" "XADC_XP0_NLB") list("S" "VDD") list("B" "VDD")) list(list("w" "2u") list("fw" "2u") list("l" "0.15u") list("fingers" "1") list("m" "1")) list("fingers" "l" "fw" "m"))
 list("XADC_XP0_XNI_XN" "sky130_fd_pr_main" "nfet_01v8" list(list("D" "XADC_XP0_NL") list("G" "XADC_XP0_NLB") list("S" "VSS") list("B" "VSS")) list(list("w" "1u") list("fw" "1u") list("l" "0.15u") list("fingers" "1") list("m" "1")) list("fingers" "l" "fw" "m"))
 list("XADC_XP0_XCM_XN" "sky130_fd_pr_main" "nfet_01v8_lvt" list(list("D" "INP") list("G" "ACQ") list("S" "XADC_BP0") list("B" "VSS")) list(list("w" "0.84u") list("fw" "0.84u") list("l" "0.15u") list("fingers" "1") list("m" "1")) list("fingers" "l" "fw" "m"))
 list("XADC_XP0_XCM_XP" "sky130_fd_pr_main" "pfet_01v8_lvt" list(list("D" "INP") list("G" "XADC_XP0_ACQB") list("S" "XADC_BP0") list("B" "VDD")) list(list("w" "1.68u") list("fw" "1.68u") list("l" "0.35u") list("fingers" "1") list("m" "1")) list("fingers" "l" "fw" "m"))
 list("XADC_XP0_XRP_XN" "sky130_fd_pr_main" "nfet_01v8_lvt" list(list("D" "RP") list("G" "XADC_XP0_PH") list("S" "XADC_BP0") list("B" "VSS")) list(list("w" "0.84u") list("fw" "0.84u") list("l" "0.15u") list("fingers" "1") list("m" "1")) list("fingers" "l" "fw" "m"))
 list("XADC_XP0_XRP_XP" "sky130_fd_pr_main" "pfet_01v8_lvt" list(list("D" "RP") list("G" "XADC_XP0_PHB") list("S" "XADC_BP0") list("B" "VDD")) list(list("w" "1.68u") list("fw" "1.68u") list("l" "0.35u") list("fingers" "1") list("m" "1")) list("fingers" "l" "fw" "m"))
 list("XADC_XP0_XRN_XN" "sky130_fd_pr_main" "nfet_01v8_lvt" list(list("D" "RN") list("G" "XADC_XP0_NL") list("S" "XADC_BP0") list("B" "VSS")) list(list("w" "0.84u") list("fw" "0.84u") list("l" "0.15u") list("fingers" "1") list("m" "1")) list("fingers" "l" "fw" "m"))
 list("XADC_XP0_XRN_XP" "sky130_fd_pr_main" "pfet_01v8_lvt" list(list("D" "RN") list("G" "XADC_XP0_NLB") list("S" "XADC_BP0") list("B" "VDD")) list(list("w" "1.68u") list("fw" "1.68u") list("l" "0.35u") list("fingers" "1") list("m" "1")) list("fingers" "l" "fw" "m"))
 list("XADC_XN0_XBI_XP" "sky130_fd_pr_main" "pfet_01v8" list(list("D" "XADC_XN0_BITB") list("G" "B0") list("S" "VDD") list("B" "VDD")) list(list("w" "2u") list("fw" "2u") list("l" "0.15u") list("fingers" "1") list("m" "1")) list("fingers" "l" "fw" "m"))
 list("XADC_XN0_XBI_XN" "sky130_fd_pr_main" "nfet_01v8" list(list("D" "XADC_XN0_BITB") list("G" "B0") list("S" "VSS") list("B" "VSS")) list(list("w" "1u") list("fw" "1u") list("l" "0.15u") list("fingers" "1") list("m" "1")) list("fingers" "l" "fw" "m"))
 list("XADC_XN0_XAI_XP" "sky130_fd_pr_main" "pfet_01v8" list(list("D" "XADC_XN0_ACQB") list("G" "ACQ") list("S" "VDD") list("B" "VDD")) list(list("w" "2u") list("fw" "2u") list("l" "0.15u") list("fingers" "1") list("m" "1")) list("fingers" "l" "fw" "m"))
 list("XADC_XN0_XAI_XN" "sky130_fd_pr_main" "nfet_01v8" list(list("D" "XADC_XN0_ACQB") list("G" "ACQ") list("S" "VSS") list("B" "VSS")) list(list("w" "1u") list("fw" "1u") list("l" "0.15u") list("fingers" "1") list("m" "1")) list("fingers" "l" "fw" "m"))
 list("XADC_XN0_XPH_XP1" "sky130_fd_pr_main" "pfet_01v8" list(list("D" "XADC_XN0_PHB") list("G" "CONV") list("S" "VDD") list("B" "VDD")) list(list("w" "2u") list("fw" "2u") list("l" "0.15u") list("fingers" "1") list("m" "1")) list("fingers" "l" "fw" "m"))
 list("XADC_XN0_XPH_XP2" "sky130_fd_pr_main" "pfet_01v8" list(list("D" "XADC_XN0_PHB") list("G" "B0") list("S" "VDD") list("B" "VDD")) list(list("w" "2u") list("fw" "2u") list("l" "0.15u") list("fingers" "1") list("m" "1")) list("fingers" "l" "fw" "m"))
 list("XADC_XN0_XPH_XN1" "sky130_fd_pr_main" "nfet_01v8" list(list("D" "XADC_XN0_PHB") list("G" "CONV") list("S" "XADC_XN0_XPH_MID") list("B" "VSS")) list(list("w" "2u") list("fw" "2u") list("l" "0.15u") list("fingers" "1") list("m" "1")) list("fingers" "l" "fw" "m"))
 list("XADC_XN0_XPH_XN2" "sky130_fd_pr_main" "nfet_01v8" list(list("D" "XADC_XN0_XPH_MID") list("G" "B0") list("S" "VSS") list("B" "VSS")) list(list("w" "2u") list("fw" "2u") list("l" "0.15u") list("fingers" "1") list("m" "1")) list("fingers" "l" "fw" "m"))
 list("XADC_XN0_XPI_XP" "sky130_fd_pr_main" "pfet_01v8" list(list("D" "XADC_XN0_PH") list("G" "XADC_XN0_PHB") list("S" "VDD") list("B" "VDD")) list(list("w" "2u") list("fw" "2u") list("l" "0.15u") list("fingers" "1") list("m" "1")) list("fingers" "l" "fw" "m"))
 list("XADC_XN0_XPI_XN" "sky130_fd_pr_main" "nfet_01v8" list(list("D" "XADC_XN0_PH") list("G" "XADC_XN0_PHB") list("S" "VSS") list("B" "VSS")) list(list("w" "1u") list("fw" "1u") list("l" "0.15u") list("fingers" "1") list("m" "1")) list("fingers" "l" "fw" "m"))
 list("XADC_XN0_XNL_XP1" "sky130_fd_pr_main" "pfet_01v8" list(list("D" "XADC_XN0_NLB") list("G" "CONV") list("S" "VDD") list("B" "VDD")) list(list("w" "2u") list("fw" "2u") list("l" "0.15u") list("fingers" "1") list("m" "1")) list("fingers" "l" "fw" "m"))
 list("XADC_XN0_XNL_XP2" "sky130_fd_pr_main" "pfet_01v8" list(list("D" "XADC_XN0_NLB") list("G" "XADC_XN0_BITB") list("S" "VDD") list("B" "VDD")) list(list("w" "2u") list("fw" "2u") list("l" "0.15u") list("fingers" "1") list("m" "1")) list("fingers" "l" "fw" "m"))
 list("XADC_XN0_XNL_XN1" "sky130_fd_pr_main" "nfet_01v8" list(list("D" "XADC_XN0_NLB") list("G" "CONV") list("S" "XADC_XN0_XNL_MID") list("B" "VSS")) list(list("w" "2u") list("fw" "2u") list("l" "0.15u") list("fingers" "1") list("m" "1")) list("fingers" "l" "fw" "m"))
 list("XADC_XN0_XNL_XN2" "sky130_fd_pr_main" "nfet_01v8" list(list("D" "XADC_XN0_XNL_MID") list("G" "XADC_XN0_BITB") list("S" "VSS") list("B" "VSS")) list(list("w" "2u") list("fw" "2u") list("l" "0.15u") list("fingers" "1") list("m" "1")) list("fingers" "l" "fw" "m"))
 list("XADC_XN0_XNI_XP" "sky130_fd_pr_main" "pfet_01v8" list(list("D" "XADC_XN0_NL") list("G" "XADC_XN0_NLB") list("S" "VDD") list("B" "VDD")) list(list("w" "2u") list("fw" "2u") list("l" "0.15u") list("fingers" "1") list("m" "1")) list("fingers" "l" "fw" "m"))
 list("XADC_XN0_XNI_XN" "sky130_fd_pr_main" "nfet_01v8" list(list("D" "XADC_XN0_NL") list("G" "XADC_XN0_NLB") list("S" "VSS") list("B" "VSS")) list(list("w" "1u") list("fw" "1u") list("l" "0.15u") list("fingers" "1") list("m" "1")) list("fingers" "l" "fw" "m"))
 list("XADC_XN0_XCM_XN" "sky130_fd_pr_main" "nfet_01v8_lvt" list(list("D" "INN") list("G" "ACQ") list("S" "XADC_BN0") list("B" "VSS")) list(list("w" "0.84u") list("fw" "0.84u") list("l" "0.15u") list("fingers" "1") list("m" "1")) list("fingers" "l" "fw" "m"))
 list("XADC_XN0_XCM_XP" "sky130_fd_pr_main" "pfet_01v8_lvt" list(list("D" "INN") list("G" "XADC_XN0_ACQB") list("S" "XADC_BN0") list("B" "VDD")) list(list("w" "1.68u") list("fw" "1.68u") list("l" "0.35u") list("fingers" "1") list("m" "1")) list("fingers" "l" "fw" "m"))
 list("XADC_XN0_XRP_XN" "sky130_fd_pr_main" "nfet_01v8_lvt" list(list("D" "RN") list("G" "XADC_XN0_PH") list("S" "XADC_BN0") list("B" "VSS")) list(list("w" "0.84u") list("fw" "0.84u") list("l" "0.15u") list("fingers" "1") list("m" "1")) list("fingers" "l" "fw" "m"))
 list("XADC_XN0_XRP_XP" "sky130_fd_pr_main" "pfet_01v8_lvt" list(list("D" "RN") list("G" "XADC_XN0_PHB") list("S" "XADC_BN0") list("B" "VDD")) list(list("w" "1.68u") list("fw" "1.68u") list("l" "0.35u") list("fingers" "1") list("m" "1")) list("fingers" "l" "fw" "m"))
 list("XADC_XN0_XRN_XN" "sky130_fd_pr_main" "nfet_01v8_lvt" list(list("D" "RP") list("G" "XADC_XN0_NL") list("S" "XADC_BN0") list("B" "VSS")) list(list("w" "0.84u") list("fw" "0.84u") list("l" "0.15u") list("fingers" "1") list("m" "1")) list("fingers" "l" "fw" "m"))
 list("XADC_XN0_XRN_XP" "sky130_fd_pr_main" "pfet_01v8_lvt" list(list("D" "RP") list("G" "XADC_XN0_NLB") list("S" "XADC_BN0") list("B" "VDD")) list(list("w" "1.68u") list("fw" "1.68u") list("l" "0.35u") list("fingers" "1") list("m" "1")) list("fingers" "l" "fw" "m"))
 list("XADC_XP1_XBI_XP" "sky130_fd_pr_main" "pfet_01v8" list(list("D" "XADC_XP1_BITB") list("G" "B1") list("S" "VDD") list("B" "VDD")) list(list("w" "2u") list("fw" "2u") list("l" "0.15u") list("fingers" "1") list("m" "1")) list("fingers" "l" "fw" "m"))
 list("XADC_XP1_XBI_XN" "sky130_fd_pr_main" "nfet_01v8" list(list("D" "XADC_XP1_BITB") list("G" "B1") list("S" "VSS") list("B" "VSS")) list(list("w" "1u") list("fw" "1u") list("l" "0.15u") list("fingers" "1") list("m" "1")) list("fingers" "l" "fw" "m"))
 list("XADC_XP1_XAI_XP" "sky130_fd_pr_main" "pfet_01v8" list(list("D" "XADC_XP1_ACQB") list("G" "ACQ") list("S" "VDD") list("B" "VDD")) list(list("w" "2u") list("fw" "2u") list("l" "0.15u") list("fingers" "1") list("m" "1")) list("fingers" "l" "fw" "m"))
 list("XADC_XP1_XAI_XN" "sky130_fd_pr_main" "nfet_01v8" list(list("D" "XADC_XP1_ACQB") list("G" "ACQ") list("S" "VSS") list("B" "VSS")) list(list("w" "1u") list("fw" "1u") list("l" "0.15u") list("fingers" "1") list("m" "1")) list("fingers" "l" "fw" "m"))
 list("XADC_XP1_XPH_XP1" "sky130_fd_pr_main" "pfet_01v8" list(list("D" "XADC_XP1_PHB") list("G" "CONV") list("S" "VDD") list("B" "VDD")) list(list("w" "2u") list("fw" "2u") list("l" "0.15u") list("fingers" "1") list("m" "1")) list("fingers" "l" "fw" "m"))
 list("XADC_XP1_XPH_XP2" "sky130_fd_pr_main" "pfet_01v8" list(list("D" "XADC_XP1_PHB") list("G" "B1") list("S" "VDD") list("B" "VDD")) list(list("w" "2u") list("fw" "2u") list("l" "0.15u") list("fingers" "1") list("m" "1")) list("fingers" "l" "fw" "m"))
 list("XADC_XP1_XPH_XN1" "sky130_fd_pr_main" "nfet_01v8" list(list("D" "XADC_XP1_PHB") list("G" "CONV") list("S" "XADC_XP1_XPH_MID") list("B" "VSS")) list(list("w" "2u") list("fw" "2u") list("l" "0.15u") list("fingers" "1") list("m" "1")) list("fingers" "l" "fw" "m"))
 list("XADC_XP1_XPH_XN2" "sky130_fd_pr_main" "nfet_01v8" list(list("D" "XADC_XP1_XPH_MID") list("G" "B1") list("S" "VSS") list("B" "VSS")) list(list("w" "2u") list("fw" "2u") list("l" "0.15u") list("fingers" "1") list("m" "1")) list("fingers" "l" "fw" "m"))
 list("XADC_XP1_XPI_XP" "sky130_fd_pr_main" "pfet_01v8" list(list("D" "XADC_XP1_PH") list("G" "XADC_XP1_PHB") list("S" "VDD") list("B" "VDD")) list(list("w" "2u") list("fw" "2u") list("l" "0.15u") list("fingers" "1") list("m" "1")) list("fingers" "l" "fw" "m"))
 list("XADC_XP1_XPI_XN" "sky130_fd_pr_main" "nfet_01v8" list(list("D" "XADC_XP1_PH") list("G" "XADC_XP1_PHB") list("S" "VSS") list("B" "VSS")) list(list("w" "1u") list("fw" "1u") list("l" "0.15u") list("fingers" "1") list("m" "1")) list("fingers" "l" "fw" "m"))
 list("XADC_XP1_XNL_XP1" "sky130_fd_pr_main" "pfet_01v8" list(list("D" "XADC_XP1_NLB") list("G" "CONV") list("S" "VDD") list("B" "VDD")) list(list("w" "2u") list("fw" "2u") list("l" "0.15u") list("fingers" "1") list("m" "1")) list("fingers" "l" "fw" "m"))
 list("XADC_XP1_XNL_XP2" "sky130_fd_pr_main" "pfet_01v8" list(list("D" "XADC_XP1_NLB") list("G" "XADC_XP1_BITB") list("S" "VDD") list("B" "VDD")) list(list("w" "2u") list("fw" "2u") list("l" "0.15u") list("fingers" "1") list("m" "1")) list("fingers" "l" "fw" "m"))
 list("XADC_XP1_XNL_XN1" "sky130_fd_pr_main" "nfet_01v8" list(list("D" "XADC_XP1_NLB") list("G" "CONV") list("S" "XADC_XP1_XNL_MID") list("B" "VSS")) list(list("w" "2u") list("fw" "2u") list("l" "0.15u") list("fingers" "1") list("m" "1")) list("fingers" "l" "fw" "m"))
 list("XADC_XP1_XNL_XN2" "sky130_fd_pr_main" "nfet_01v8" list(list("D" "XADC_XP1_XNL_MID") list("G" "XADC_XP1_BITB") list("S" "VSS") list("B" "VSS")) list(list("w" "2u") list("fw" "2u") list("l" "0.15u") list("fingers" "1") list("m" "1")) list("fingers" "l" "fw" "m"))
 list("XADC_XP1_XNI_XP" "sky130_fd_pr_main" "pfet_01v8" list(list("D" "XADC_XP1_NL") list("G" "XADC_XP1_NLB") list("S" "VDD") list("B" "VDD")) list(list("w" "2u") list("fw" "2u") list("l" "0.15u") list("fingers" "1") list("m" "1")) list("fingers" "l" "fw" "m"))
 list("XADC_XP1_XNI_XN" "sky130_fd_pr_main" "nfet_01v8" list(list("D" "XADC_XP1_NL") list("G" "XADC_XP1_NLB") list("S" "VSS") list("B" "VSS")) list(list("w" "1u") list("fw" "1u") list("l" "0.15u") list("fingers" "1") list("m" "1")) list("fingers" "l" "fw" "m"))
 list("XADC_XP1_XCM_XN" "sky130_fd_pr_main" "nfet_01v8_lvt" list(list("D" "INP") list("G" "ACQ") list("S" "XADC_BP1") list("B" "VSS")) list(list("w" "1.19u") list("fw" "1.19u") list("l" "0.15u") list("fingers" "1") list("m" "1")) list("fingers" "l" "fw" "m"))
 list("XADC_XP1_XCM_XP" "sky130_fd_pr_main" "pfet_01v8_lvt" list(list("D" "INP") list("G" "XADC_XP1_ACQB") list("S" "XADC_BP1") list("B" "VDD")) list(list("w" "2.375u") list("fw" "2.375u") list("l" "0.35u") list("fingers" "1") list("m" "1")) list("fingers" "l" "fw" "m"))
 list("XADC_XP1_XRP_XN" "sky130_fd_pr_main" "nfet_01v8_lvt" list(list("D" "RP") list("G" "XADC_XP1_PH") list("S" "XADC_BP1") list("B" "VSS")) list(list("w" "1.19u") list("fw" "1.19u") list("l" "0.15u") list("fingers" "1") list("m" "1")) list("fingers" "l" "fw" "m"))
 list("XADC_XP1_XRP_XP" "sky130_fd_pr_main" "pfet_01v8_lvt" list(list("D" "RP") list("G" "XADC_XP1_PHB") list("S" "XADC_BP1") list("B" "VDD")) list(list("w" "2.375u") list("fw" "2.375u") list("l" "0.35u") list("fingers" "1") list("m" "1")) list("fingers" "l" "fw" "m"))
 list("XADC_XP1_XRN_XN" "sky130_fd_pr_main" "nfet_01v8_lvt" list(list("D" "RN") list("G" "XADC_XP1_NL") list("S" "XADC_BP1") list("B" "VSS")) list(list("w" "1.19u") list("fw" "1.19u") list("l" "0.15u") list("fingers" "1") list("m" "1")) list("fingers" "l" "fw" "m"))
 list("XADC_XP1_XRN_XP" "sky130_fd_pr_main" "pfet_01v8_lvt" list(list("D" "RN") list("G" "XADC_XP1_NLB") list("S" "XADC_BP1") list("B" "VDD")) list(list("w" "2.375u") list("fw" "2.375u") list("l" "0.35u") list("fingers" "1") list("m" "1")) list("fingers" "l" "fw" "m"))
 list("XADC_XN1_XBI_XP" "sky130_fd_pr_main" "pfet_01v8" list(list("D" "XADC_XN1_BITB") list("G" "B1") list("S" "VDD") list("B" "VDD")) list(list("w" "2u") list("fw" "2u") list("l" "0.15u") list("fingers" "1") list("m" "1")) list("fingers" "l" "fw" "m"))
 list("XADC_XN1_XBI_XN" "sky130_fd_pr_main" "nfet_01v8" list(list("D" "XADC_XN1_BITB") list("G" "B1") list("S" "VSS") list("B" "VSS")) list(list("w" "1u") list("fw" "1u") list("l" "0.15u") list("fingers" "1") list("m" "1")) list("fingers" "l" "fw" "m"))
 list("XADC_XN1_XAI_XP" "sky130_fd_pr_main" "pfet_01v8" list(list("D" "XADC_XN1_ACQB") list("G" "ACQ") list("S" "VDD") list("B" "VDD")) list(list("w" "2u") list("fw" "2u") list("l" "0.15u") list("fingers" "1") list("m" "1")) list("fingers" "l" "fw" "m"))
 list("XADC_XN1_XAI_XN" "sky130_fd_pr_main" "nfet_01v8" list(list("D" "XADC_XN1_ACQB") list("G" "ACQ") list("S" "VSS") list("B" "VSS")) list(list("w" "1u") list("fw" "1u") list("l" "0.15u") list("fingers" "1") list("m" "1")) list("fingers" "l" "fw" "m"))
 list("XADC_XN1_XPH_XP1" "sky130_fd_pr_main" "pfet_01v8" list(list("D" "XADC_XN1_PHB") list("G" "CONV") list("S" "VDD") list("B" "VDD")) list(list("w" "2u") list("fw" "2u") list("l" "0.15u") list("fingers" "1") list("m" "1")) list("fingers" "l" "fw" "m"))
 list("XADC_XN1_XPH_XP2" "sky130_fd_pr_main" "pfet_01v8" list(list("D" "XADC_XN1_PHB") list("G" "B1") list("S" "VDD") list("B" "VDD")) list(list("w" "2u") list("fw" "2u") list("l" "0.15u") list("fingers" "1") list("m" "1")) list("fingers" "l" "fw" "m"))
 list("XADC_XN1_XPH_XN1" "sky130_fd_pr_main" "nfet_01v8" list(list("D" "XADC_XN1_PHB") list("G" "CONV") list("S" "XADC_XN1_XPH_MID") list("B" "VSS")) list(list("w" "2u") list("fw" "2u") list("l" "0.15u") list("fingers" "1") list("m" "1")) list("fingers" "l" "fw" "m"))
 list("XADC_XN1_XPH_XN2" "sky130_fd_pr_main" "nfet_01v8" list(list("D" "XADC_XN1_XPH_MID") list("G" "B1") list("S" "VSS") list("B" "VSS")) list(list("w" "2u") list("fw" "2u") list("l" "0.15u") list("fingers" "1") list("m" "1")) list("fingers" "l" "fw" "m"))
 list("XADC_XN1_XPI_XP" "sky130_fd_pr_main" "pfet_01v8" list(list("D" "XADC_XN1_PH") list("G" "XADC_XN1_PHB") list("S" "VDD") list("B" "VDD")) list(list("w" "2u") list("fw" "2u") list("l" "0.15u") list("fingers" "1") list("m" "1")) list("fingers" "l" "fw" "m"))
 list("XADC_XN1_XPI_XN" "sky130_fd_pr_main" "nfet_01v8" list(list("D" "XADC_XN1_PH") list("G" "XADC_XN1_PHB") list("S" "VSS") list("B" "VSS")) list(list("w" "1u") list("fw" "1u") list("l" "0.15u") list("fingers" "1") list("m" "1")) list("fingers" "l" "fw" "m"))
 list("XADC_XN1_XNL_XP1" "sky130_fd_pr_main" "pfet_01v8" list(list("D" "XADC_XN1_NLB") list("G" "CONV") list("S" "VDD") list("B" "VDD")) list(list("w" "2u") list("fw" "2u") list("l" "0.15u") list("fingers" "1") list("m" "1")) list("fingers" "l" "fw" "m"))
 list("XADC_XN1_XNL_XP2" "sky130_fd_pr_main" "pfet_01v8" list(list("D" "XADC_XN1_NLB") list("G" "XADC_XN1_BITB") list("S" "VDD") list("B" "VDD")) list(list("w" "2u") list("fw" "2u") list("l" "0.15u") list("fingers" "1") list("m" "1")) list("fingers" "l" "fw" "m"))
 list("XADC_XN1_XNL_XN1" "sky130_fd_pr_main" "nfet_01v8" list(list("D" "XADC_XN1_NLB") list("G" "CONV") list("S" "XADC_XN1_XNL_MID") list("B" "VSS")) list(list("w" "2u") list("fw" "2u") list("l" "0.15u") list("fingers" "1") list("m" "1")) list("fingers" "l" "fw" "m"))
 list("XADC_XN1_XNL_XN2" "sky130_fd_pr_main" "nfet_01v8" list(list("D" "XADC_XN1_XNL_MID") list("G" "XADC_XN1_BITB") list("S" "VSS") list("B" "VSS")) list(list("w" "2u") list("fw" "2u") list("l" "0.15u") list("fingers" "1") list("m" "1")) list("fingers" "l" "fw" "m"))
 list("XADC_XN1_XNI_XP" "sky130_fd_pr_main" "pfet_01v8" list(list("D" "XADC_XN1_NL") list("G" "XADC_XN1_NLB") list("S" "VDD") list("B" "VDD")) list(list("w" "2u") list("fw" "2u") list("l" "0.15u") list("fingers" "1") list("m" "1")) list("fingers" "l" "fw" "m"))
 list("XADC_XN1_XNI_XN" "sky130_fd_pr_main" "nfet_01v8" list(list("D" "XADC_XN1_NL") list("G" "XADC_XN1_NLB") list("S" "VSS") list("B" "VSS")) list(list("w" "1u") list("fw" "1u") list("l" "0.15u") list("fingers" "1") list("m" "1")) list("fingers" "l" "fw" "m"))
 list("XADC_XN1_XCM_XN" "sky130_fd_pr_main" "nfet_01v8_lvt" list(list("D" "INN") list("G" "ACQ") list("S" "XADC_BN1") list("B" "VSS")) list(list("w" "1.19u") list("fw" "1.19u") list("l" "0.15u") list("fingers" "1") list("m" "1")) list("fingers" "l" "fw" "m"))
 list("XADC_XN1_XCM_XP" "sky130_fd_pr_main" "pfet_01v8_lvt" list(list("D" "INN") list("G" "XADC_XN1_ACQB") list("S" "XADC_BN1") list("B" "VDD")) list(list("w" "2.375u") list("fw" "2.375u") list("l" "0.35u") list("fingers" "1") list("m" "1")) list("fingers" "l" "fw" "m"))
 list("XADC_XN1_XRP_XN" "sky130_fd_pr_main" "nfet_01v8_lvt" list(list("D" "RN") list("G" "XADC_XN1_PH") list("S" "XADC_BN1") list("B" "VSS")) list(list("w" "1.19u") list("fw" "1.19u") list("l" "0.15u") list("fingers" "1") list("m" "1")) list("fingers" "l" "fw" "m"))
 list("XADC_XN1_XRP_XP" "sky130_fd_pr_main" "pfet_01v8_lvt" list(list("D" "RN") list("G" "XADC_XN1_PHB") list("S" "XADC_BN1") list("B" "VDD")) list(list("w" "2.375u") list("fw" "2.375u") list("l" "0.35u") list("fingers" "1") list("m" "1")) list("fingers" "l" "fw" "m"))
 list("XADC_XN1_XRN_XN" "sky130_fd_pr_main" "nfet_01v8_lvt" list(list("D" "RP") list("G" "XADC_XN1_NL") list("S" "XADC_BN1") list("B" "VSS")) list(list("w" "1.19u") list("fw" "1.19u") list("l" "0.15u") list("fingers" "1") list("m" "1")) list("fingers" "l" "fw" "m"))
 list("XADC_XN1_XRN_XP" "sky130_fd_pr_main" "pfet_01v8_lvt" list(list("D" "RP") list("G" "XADC_XN1_NLB") list("S" "XADC_BN1") list("B" "VDD")) list(list("w" "2.375u") list("fw" "2.375u") list("l" "0.35u") list("fingers" "1") list("m" "1")) list("fingers" "l" "fw" "m"))
 list("XADC_XP2_XBI_XP" "sky130_fd_pr_main" "pfet_01v8" list(list("D" "XADC_XP2_BITB") list("G" "B2") list("S" "VDD") list("B" "VDD")) list(list("w" "2u") list("fw" "2u") list("l" "0.15u") list("fingers" "1") list("m" "1")) list("fingers" "l" "fw" "m"))
 list("XADC_XP2_XBI_XN" "sky130_fd_pr_main" "nfet_01v8" list(list("D" "XADC_XP2_BITB") list("G" "B2") list("S" "VSS") list("B" "VSS")) list(list("w" "1u") list("fw" "1u") list("l" "0.15u") list("fingers" "1") list("m" "1")) list("fingers" "l" "fw" "m"))
 list("XADC_XP2_XAI_XP" "sky130_fd_pr_main" "pfet_01v8" list(list("D" "XADC_XP2_ACQB") list("G" "ACQ") list("S" "VDD") list("B" "VDD")) list(list("w" "2u") list("fw" "2u") list("l" "0.15u") list("fingers" "1") list("m" "1")) list("fingers" "l" "fw" "m"))
 list("XADC_XP2_XAI_XN" "sky130_fd_pr_main" "nfet_01v8" list(list("D" "XADC_XP2_ACQB") list("G" "ACQ") list("S" "VSS") list("B" "VSS")) list(list("w" "1u") list("fw" "1u") list("l" "0.15u") list("fingers" "1") list("m" "1")) list("fingers" "l" "fw" "m"))
 list("XADC_XP2_XPH_XP1" "sky130_fd_pr_main" "pfet_01v8" list(list("D" "XADC_XP2_PHB") list("G" "CONV") list("S" "VDD") list("B" "VDD")) list(list("w" "2u") list("fw" "2u") list("l" "0.15u") list("fingers" "1") list("m" "1")) list("fingers" "l" "fw" "m"))
 list("XADC_XP2_XPH_XP2" "sky130_fd_pr_main" "pfet_01v8" list(list("D" "XADC_XP2_PHB") list("G" "B2") list("S" "VDD") list("B" "VDD")) list(list("w" "2u") list("fw" "2u") list("l" "0.15u") list("fingers" "1") list("m" "1")) list("fingers" "l" "fw" "m"))
 list("XADC_XP2_XPH_XN1" "sky130_fd_pr_main" "nfet_01v8" list(list("D" "XADC_XP2_PHB") list("G" "CONV") list("S" "XADC_XP2_XPH_MID") list("B" "VSS")) list(list("w" "2u") list("fw" "2u") list("l" "0.15u") list("fingers" "1") list("m" "1")) list("fingers" "l" "fw" "m"))
 list("XADC_XP2_XPH_XN2" "sky130_fd_pr_main" "nfet_01v8" list(list("D" "XADC_XP2_XPH_MID") list("G" "B2") list("S" "VSS") list("B" "VSS")) list(list("w" "2u") list("fw" "2u") list("l" "0.15u") list("fingers" "1") list("m" "1")) list("fingers" "l" "fw" "m"))
 list("XADC_XP2_XPI_XP" "sky130_fd_pr_main" "pfet_01v8" list(list("D" "XADC_XP2_PH") list("G" "XADC_XP2_PHB") list("S" "VDD") list("B" "VDD")) list(list("w" "2u") list("fw" "2u") list("l" "0.15u") list("fingers" "1") list("m" "1")) list("fingers" "l" "fw" "m"))
 list("XADC_XP2_XPI_XN" "sky130_fd_pr_main" "nfet_01v8" list(list("D" "XADC_XP2_PH") list("G" "XADC_XP2_PHB") list("S" "VSS") list("B" "VSS")) list(list("w" "1u") list("fw" "1u") list("l" "0.15u") list("fingers" "1") list("m" "1")) list("fingers" "l" "fw" "m"))
 list("XADC_XP2_XNL_XP1" "sky130_fd_pr_main" "pfet_01v8" list(list("D" "XADC_XP2_NLB") list("G" "CONV") list("S" "VDD") list("B" "VDD")) list(list("w" "2u") list("fw" "2u") list("l" "0.15u") list("fingers" "1") list("m" "1")) list("fingers" "l" "fw" "m"))
 list("XADC_XP2_XNL_XP2" "sky130_fd_pr_main" "pfet_01v8" list(list("D" "XADC_XP2_NLB") list("G" "XADC_XP2_BITB") list("S" "VDD") list("B" "VDD")) list(list("w" "2u") list("fw" "2u") list("l" "0.15u") list("fingers" "1") list("m" "1")) list("fingers" "l" "fw" "m"))
 list("XADC_XP2_XNL_XN1" "sky130_fd_pr_main" "nfet_01v8" list(list("D" "XADC_XP2_NLB") list("G" "CONV") list("S" "XADC_XP2_XNL_MID") list("B" "VSS")) list(list("w" "2u") list("fw" "2u") list("l" "0.15u") list("fingers" "1") list("m" "1")) list("fingers" "l" "fw" "m"))
 list("XADC_XP2_XNL_XN2" "sky130_fd_pr_main" "nfet_01v8" list(list("D" "XADC_XP2_XNL_MID") list("G" "XADC_XP2_BITB") list("S" "VSS") list("B" "VSS")) list(list("w" "2u") list("fw" "2u") list("l" "0.15u") list("fingers" "1") list("m" "1")) list("fingers" "l" "fw" "m"))
 list("XADC_XP2_XNI_XP" "sky130_fd_pr_main" "pfet_01v8" list(list("D" "XADC_XP2_NL") list("G" "XADC_XP2_NLB") list("S" "VDD") list("B" "VDD")) list(list("w" "2u") list("fw" "2u") list("l" "0.15u") list("fingers" "1") list("m" "1")) list("fingers" "l" "fw" "m"))
 list("XADC_XP2_XNI_XN" "sky130_fd_pr_main" "nfet_01v8" list(list("D" "XADC_XP2_NL") list("G" "XADC_XP2_NLB") list("S" "VSS") list("B" "VSS")) list(list("w" "1u") list("fw" "1u") list("l" "0.15u") list("fingers" "1") list("m" "1")) list("fingers" "l" "fw" "m"))
 list("XADC_XP2_XCM_XN" "sky130_fd_pr_main" "nfet_01v8_lvt" list(list("D" "INP") list("G" "ACQ") list("S" "XADC_BP2") list("B" "VSS")) list(list("w" "1.68u") list("fw" "1.68u") list("l" "0.15u") list("fingers" "1") list("m" "1")) list("fingers" "l" "fw" "m"))
 list("XADC_XP2_XCM_XP" "sky130_fd_pr_main" "pfet_01v8_lvt" list(list("D" "INP") list("G" "XADC_XP2_ACQB") list("S" "XADC_BP2") list("B" "VDD")) list(list("w" "3.36u") list("fw" "3.36u") list("l" "0.35u") list("fingers" "1") list("m" "1")) list("fingers" "l" "fw" "m"))
 list("XADC_XP2_XRP_XN" "sky130_fd_pr_main" "nfet_01v8_lvt" list(list("D" "RP") list("G" "XADC_XP2_PH") list("S" "XADC_BP2") list("B" "VSS")) list(list("w" "1.68u") list("fw" "1.68u") list("l" "0.15u") list("fingers" "1") list("m" "1")) list("fingers" "l" "fw" "m"))
 list("XADC_XP2_XRP_XP" "sky130_fd_pr_main" "pfet_01v8_lvt" list(list("D" "RP") list("G" "XADC_XP2_PHB") list("S" "XADC_BP2") list("B" "VDD")) list(list("w" "3.36u") list("fw" "3.36u") list("l" "0.35u") list("fingers" "1") list("m" "1")) list("fingers" "l" "fw" "m"))
 list("XADC_XP2_XRN_XN" "sky130_fd_pr_main" "nfet_01v8_lvt" list(list("D" "RN") list("G" "XADC_XP2_NL") list("S" "XADC_BP2") list("B" "VSS")) list(list("w" "1.68u") list("fw" "1.68u") list("l" "0.15u") list("fingers" "1") list("m" "1")) list("fingers" "l" "fw" "m"))
 list("XADC_XP2_XRN_XP" "sky130_fd_pr_main" "pfet_01v8_lvt" list(list("D" "RN") list("G" "XADC_XP2_NLB") list("S" "XADC_BP2") list("B" "VDD")) list(list("w" "3.36u") list("fw" "3.36u") list("l" "0.35u") list("fingers" "1") list("m" "1")) list("fingers" "l" "fw" "m"))
 list("XADC_XN2_XBI_XP" "sky130_fd_pr_main" "pfet_01v8" list(list("D" "XADC_XN2_BITB") list("G" "B2") list("S" "VDD") list("B" "VDD")) list(list("w" "2u") list("fw" "2u") list("l" "0.15u") list("fingers" "1") list("m" "1")) list("fingers" "l" "fw" "m"))
 list("XADC_XN2_XBI_XN" "sky130_fd_pr_main" "nfet_01v8" list(list("D" "XADC_XN2_BITB") list("G" "B2") list("S" "VSS") list("B" "VSS")) list(list("w" "1u") list("fw" "1u") list("l" "0.15u") list("fingers" "1") list("m" "1")) list("fingers" "l" "fw" "m"))
 list("XADC_XN2_XAI_XP" "sky130_fd_pr_main" "pfet_01v8" list(list("D" "XADC_XN2_ACQB") list("G" "ACQ") list("S" "VDD") list("B" "VDD")) list(list("w" "2u") list("fw" "2u") list("l" "0.15u") list("fingers" "1") list("m" "1")) list("fingers" "l" "fw" "m"))
 list("XADC_XN2_XAI_XN" "sky130_fd_pr_main" "nfet_01v8" list(list("D" "XADC_XN2_ACQB") list("G" "ACQ") list("S" "VSS") list("B" "VSS")) list(list("w" "1u") list("fw" "1u") list("l" "0.15u") list("fingers" "1") list("m" "1")) list("fingers" "l" "fw" "m"))
 list("XADC_XN2_XPH_XP1" "sky130_fd_pr_main" "pfet_01v8" list(list("D" "XADC_XN2_PHB") list("G" "CONV") list("S" "VDD") list("B" "VDD")) list(list("w" "2u") list("fw" "2u") list("l" "0.15u") list("fingers" "1") list("m" "1")) list("fingers" "l" "fw" "m"))
 list("XADC_XN2_XPH_XP2" "sky130_fd_pr_main" "pfet_01v8" list(list("D" "XADC_XN2_PHB") list("G" "B2") list("S" "VDD") list("B" "VDD")) list(list("w" "2u") list("fw" "2u") list("l" "0.15u") list("fingers" "1") list("m" "1")) list("fingers" "l" "fw" "m"))
 list("XADC_XN2_XPH_XN1" "sky130_fd_pr_main" "nfet_01v8" list(list("D" "XADC_XN2_PHB") list("G" "CONV") list("S" "XADC_XN2_XPH_MID") list("B" "VSS")) list(list("w" "2u") list("fw" "2u") list("l" "0.15u") list("fingers" "1") list("m" "1")) list("fingers" "l" "fw" "m"))
 list("XADC_XN2_XPH_XN2" "sky130_fd_pr_main" "nfet_01v8" list(list("D" "XADC_XN2_XPH_MID") list("G" "B2") list("S" "VSS") list("B" "VSS")) list(list("w" "2u") list("fw" "2u") list("l" "0.15u") list("fingers" "1") list("m" "1")) list("fingers" "l" "fw" "m"))
 list("XADC_XN2_XPI_XP" "sky130_fd_pr_main" "pfet_01v8" list(list("D" "XADC_XN2_PH") list("G" "XADC_XN2_PHB") list("S" "VDD") list("B" "VDD")) list(list("w" "2u") list("fw" "2u") list("l" "0.15u") list("fingers" "1") list("m" "1")) list("fingers" "l" "fw" "m"))
 list("XADC_XN2_XPI_XN" "sky130_fd_pr_main" "nfet_01v8" list(list("D" "XADC_XN2_PH") list("G" "XADC_XN2_PHB") list("S" "VSS") list("B" "VSS")) list(list("w" "1u") list("fw" "1u") list("l" "0.15u") list("fingers" "1") list("m" "1")) list("fingers" "l" "fw" "m"))
 list("XADC_XN2_XNL_XP1" "sky130_fd_pr_main" "pfet_01v8" list(list("D" "XADC_XN2_NLB") list("G" "CONV") list("S" "VDD") list("B" "VDD")) list(list("w" "2u") list("fw" "2u") list("l" "0.15u") list("fingers" "1") list("m" "1")) list("fingers" "l" "fw" "m"))
 list("XADC_XN2_XNL_XP2" "sky130_fd_pr_main" "pfet_01v8" list(list("D" "XADC_XN2_NLB") list("G" "XADC_XN2_BITB") list("S" "VDD") list("B" "VDD")) list(list("w" "2u") list("fw" "2u") list("l" "0.15u") list("fingers" "1") list("m" "1")) list("fingers" "l" "fw" "m"))
 list("XADC_XN2_XNL_XN1" "sky130_fd_pr_main" "nfet_01v8" list(list("D" "XADC_XN2_NLB") list("G" "CONV") list("S" "XADC_XN2_XNL_MID") list("B" "VSS")) list(list("w" "2u") list("fw" "2u") list("l" "0.15u") list("fingers" "1") list("m" "1")) list("fingers" "l" "fw" "m"))
 list("XADC_XN2_XNL_XN2" "sky130_fd_pr_main" "nfet_01v8" list(list("D" "XADC_XN2_XNL_MID") list("G" "XADC_XN2_BITB") list("S" "VSS") list("B" "VSS")) list(list("w" "2u") list("fw" "2u") list("l" "0.15u") list("fingers" "1") list("m" "1")) list("fingers" "l" "fw" "m"))
 list("XADC_XN2_XNI_XP" "sky130_fd_pr_main" "pfet_01v8" list(list("D" "XADC_XN2_NL") list("G" "XADC_XN2_NLB") list("S" "VDD") list("B" "VDD")) list(list("w" "2u") list("fw" "2u") list("l" "0.15u") list("fingers" "1") list("m" "1")) list("fingers" "l" "fw" "m"))
 list("XADC_XN2_XNI_XN" "sky130_fd_pr_main" "nfet_01v8" list(list("D" "XADC_XN2_NL") list("G" "XADC_XN2_NLB") list("S" "VSS") list("B" "VSS")) list(list("w" "1u") list("fw" "1u") list("l" "0.15u") list("fingers" "1") list("m" "1")) list("fingers" "l" "fw" "m"))
 list("XADC_XN2_XCM_XN" "sky130_fd_pr_main" "nfet_01v8_lvt" list(list("D" "INN") list("G" "ACQ") list("S" "XADC_BN2") list("B" "VSS")) list(list("w" "1.68u") list("fw" "1.68u") list("l" "0.15u") list("fingers" "1") list("m" "1")) list("fingers" "l" "fw" "m"))
 list("XADC_XN2_XCM_XP" "sky130_fd_pr_main" "pfet_01v8_lvt" list(list("D" "INN") list("G" "XADC_XN2_ACQB") list("S" "XADC_BN2") list("B" "VDD")) list(list("w" "3.36u") list("fw" "3.36u") list("l" "0.35u") list("fingers" "1") list("m" "1")) list("fingers" "l" "fw" "m"))
 list("XADC_XN2_XRP_XN" "sky130_fd_pr_main" "nfet_01v8_lvt" list(list("D" "RN") list("G" "XADC_XN2_PH") list("S" "XADC_BN2") list("B" "VSS")) list(list("w" "1.68u") list("fw" "1.68u") list("l" "0.15u") list("fingers" "1") list("m" "1")) list("fingers" "l" "fw" "m"))
 list("XADC_XN2_XRP_XP" "sky130_fd_pr_main" "pfet_01v8_lvt" list(list("D" "RN") list("G" "XADC_XN2_PHB") list("S" "XADC_BN2") list("B" "VDD")) list(list("w" "3.36u") list("fw" "3.36u") list("l" "0.35u") list("fingers" "1") list("m" "1")) list("fingers" "l" "fw" "m"))
 list("XADC_XN2_XRN_XN" "sky130_fd_pr_main" "nfet_01v8_lvt" list(list("D" "RP") list("G" "XADC_XN2_NL") list("S" "XADC_BN2") list("B" "VSS")) list(list("w" "1.68u") list("fw" "1.68u") list("l" "0.15u") list("fingers" "1") list("m" "1")) list("fingers" "l" "fw" "m"))
 list("XADC_XN2_XRN_XP" "sky130_fd_pr_main" "pfet_01v8_lvt" list(list("D" "RP") list("G" "XADC_XN2_NLB") list("S" "XADC_BN2") list("B" "VDD")) list(list("w" "3.36u") list("fw" "3.36u") list("l" "0.35u") list("fingers" "1") list("m" "1")) list("fingers" "l" "fw" "m"))
 list("XADC_XP3_XBI_XP" "sky130_fd_pr_main" "pfet_01v8" list(list("D" "XADC_XP3_BITB") list("G" "B3") list("S" "VDD") list("B" "VDD")) list(list("w" "2u") list("fw" "2u") list("l" "0.15u") list("fingers" "1") list("m" "1")) list("fingers" "l" "fw" "m"))
 list("XADC_XP3_XBI_XN" "sky130_fd_pr_main" "nfet_01v8" list(list("D" "XADC_XP3_BITB") list("G" "B3") list("S" "VSS") list("B" "VSS")) list(list("w" "1u") list("fw" "1u") list("l" "0.15u") list("fingers" "1") list("m" "1")) list("fingers" "l" "fw" "m"))
 list("XADC_XP3_XAI_XP" "sky130_fd_pr_main" "pfet_01v8" list(list("D" "XADC_XP3_ACQB") list("G" "ACQ") list("S" "VDD") list("B" "VDD")) list(list("w" "2u") list("fw" "2u") list("l" "0.15u") list("fingers" "1") list("m" "1")) list("fingers" "l" "fw" "m"))
 list("XADC_XP3_XAI_XN" "sky130_fd_pr_main" "nfet_01v8" list(list("D" "XADC_XP3_ACQB") list("G" "ACQ") list("S" "VSS") list("B" "VSS")) list(list("w" "1u") list("fw" "1u") list("l" "0.15u") list("fingers" "1") list("m" "1")) list("fingers" "l" "fw" "m"))
 list("XADC_XP3_XPH_XP1" "sky130_fd_pr_main" "pfet_01v8" list(list("D" "XADC_XP3_PHB") list("G" "CONV") list("S" "VDD") list("B" "VDD")) list(list("w" "2u") list("fw" "2u") list("l" "0.15u") list("fingers" "1") list("m" "1")) list("fingers" "l" "fw" "m"))
 list("XADC_XP3_XPH_XP2" "sky130_fd_pr_main" "pfet_01v8" list(list("D" "XADC_XP3_PHB") list("G" "B3") list("S" "VDD") list("B" "VDD")) list(list("w" "2u") list("fw" "2u") list("l" "0.15u") list("fingers" "1") list("m" "1")) list("fingers" "l" "fw" "m"))
 list("XADC_XP3_XPH_XN1" "sky130_fd_pr_main" "nfet_01v8" list(list("D" "XADC_XP3_PHB") list("G" "CONV") list("S" "XADC_XP3_XPH_MID") list("B" "VSS")) list(list("w" "2u") list("fw" "2u") list("l" "0.15u") list("fingers" "1") list("m" "1")) list("fingers" "l" "fw" "m"))
 list("XADC_XP3_XPH_XN2" "sky130_fd_pr_main" "nfet_01v8" list(list("D" "XADC_XP3_XPH_MID") list("G" "B3") list("S" "VSS") list("B" "VSS")) list(list("w" "2u") list("fw" "2u") list("l" "0.15u") list("fingers" "1") list("m" "1")) list("fingers" "l" "fw" "m"))
 list("XADC_XP3_XPI_XP" "sky130_fd_pr_main" "pfet_01v8" list(list("D" "XADC_XP3_PH") list("G" "XADC_XP3_PHB") list("S" "VDD") list("B" "VDD")) list(list("w" "2u") list("fw" "2u") list("l" "0.15u") list("fingers" "1") list("m" "1")) list("fingers" "l" "fw" "m"))
 list("XADC_XP3_XPI_XN" "sky130_fd_pr_main" "nfet_01v8" list(list("D" "XADC_XP3_PH") list("G" "XADC_XP3_PHB") list("S" "VSS") list("B" "VSS")) list(list("w" "1u") list("fw" "1u") list("l" "0.15u") list("fingers" "1") list("m" "1")) list("fingers" "l" "fw" "m"))
 list("XADC_XP3_XNL_XP1" "sky130_fd_pr_main" "pfet_01v8" list(list("D" "XADC_XP3_NLB") list("G" "CONV") list("S" "VDD") list("B" "VDD")) list(list("w" "2u") list("fw" "2u") list("l" "0.15u") list("fingers" "1") list("m" "1")) list("fingers" "l" "fw" "m"))
 list("XADC_XP3_XNL_XP2" "sky130_fd_pr_main" "pfet_01v8" list(list("D" "XADC_XP3_NLB") list("G" "XADC_XP3_BITB") list("S" "VDD") list("B" "VDD")) list(list("w" "2u") list("fw" "2u") list("l" "0.15u") list("fingers" "1") list("m" "1")) list("fingers" "l" "fw" "m"))
 list("XADC_XP3_XNL_XN1" "sky130_fd_pr_main" "nfet_01v8" list(list("D" "XADC_XP3_NLB") list("G" "CONV") list("S" "XADC_XP3_XNL_MID") list("B" "VSS")) list(list("w" "2u") list("fw" "2u") list("l" "0.15u") list("fingers" "1") list("m" "1")) list("fingers" "l" "fw" "m"))
 list("XADC_XP3_XNL_XN2" "sky130_fd_pr_main" "nfet_01v8" list(list("D" "XADC_XP3_XNL_MID") list("G" "XADC_XP3_BITB") list("S" "VSS") list("B" "VSS")) list(list("w" "2u") list("fw" "2u") list("l" "0.15u") list("fingers" "1") list("m" "1")) list("fingers" "l" "fw" "m"))
 list("XADC_XP3_XNI_XP" "sky130_fd_pr_main" "pfet_01v8" list(list("D" "XADC_XP3_NL") list("G" "XADC_XP3_NLB") list("S" "VDD") list("B" "VDD")) list(list("w" "2u") list("fw" "2u") list("l" "0.15u") list("fingers" "1") list("m" "1")) list("fingers" "l" "fw" "m"))
 list("XADC_XP3_XNI_XN" "sky130_fd_pr_main" "nfet_01v8" list(list("D" "XADC_XP3_NL") list("G" "XADC_XP3_NLB") list("S" "VSS") list("B" "VSS")) list(list("w" "1u") list("fw" "1u") list("l" "0.15u") list("fingers" "1") list("m" "1")) list("fingers" "l" "fw" "m"))
 list("XADC_XP3_XCM_XN" "sky130_fd_pr_main" "nfet_01v8_lvt" list(list("D" "INP") list("G" "ACQ") list("S" "XADC_BP3") list("B" "VSS")) list(list("w" "2.375u") list("fw" "2.375u") list("l" "0.15u") list("fingers" "1") list("m" "1")) list("fingers" "l" "fw" "m"))
 list("XADC_XP3_XCM_XP" "sky130_fd_pr_main" "pfet_01v8_lvt" list(list("D" "INP") list("G" "XADC_XP3_ACQB") list("S" "XADC_BP3") list("B" "VDD")) list(list("w" "4.75u") list("fw" "4.75u") list("l" "0.35u") list("fingers" "1") list("m" "1")) list("fingers" "l" "fw" "m"))
 list("XADC_XP3_XRP_XN" "sky130_fd_pr_main" "nfet_01v8_lvt" list(list("D" "RP") list("G" "XADC_XP3_PH") list("S" "XADC_BP3") list("B" "VSS")) list(list("w" "2.375u") list("fw" "2.375u") list("l" "0.15u") list("fingers" "1") list("m" "1")) list("fingers" "l" "fw" "m"))
 list("XADC_XP3_XRP_XP" "sky130_fd_pr_main" "pfet_01v8_lvt" list(list("D" "RP") list("G" "XADC_XP3_PHB") list("S" "XADC_BP3") list("B" "VDD")) list(list("w" "4.75u") list("fw" "4.75u") list("l" "0.35u") list("fingers" "1") list("m" "1")) list("fingers" "l" "fw" "m"))
 list("XADC_XP3_XRN_XN" "sky130_fd_pr_main" "nfet_01v8_lvt" list(list("D" "RN") list("G" "XADC_XP3_NL") list("S" "XADC_BP3") list("B" "VSS")) list(list("w" "2.375u") list("fw" "2.375u") list("l" "0.15u") list("fingers" "1") list("m" "1")) list("fingers" "l" "fw" "m"))
 list("XADC_XP3_XRN_XP" "sky130_fd_pr_main" "pfet_01v8_lvt" list(list("D" "RN") list("G" "XADC_XP3_NLB") list("S" "XADC_BP3") list("B" "VDD")) list(list("w" "4.75u") list("fw" "4.75u") list("l" "0.35u") list("fingers" "1") list("m" "1")) list("fingers" "l" "fw" "m"))
 list("XADC_XN3_XBI_XP" "sky130_fd_pr_main" "pfet_01v8" list(list("D" "XADC_XN3_BITB") list("G" "B3") list("S" "VDD") list("B" "VDD")) list(list("w" "2u") list("fw" "2u") list("l" "0.15u") list("fingers" "1") list("m" "1")) list("fingers" "l" "fw" "m"))
 list("XADC_XN3_XBI_XN" "sky130_fd_pr_main" "nfet_01v8" list(list("D" "XADC_XN3_BITB") list("G" "B3") list("S" "VSS") list("B" "VSS")) list(list("w" "1u") list("fw" "1u") list("l" "0.15u") list("fingers" "1") list("m" "1")) list("fingers" "l" "fw" "m"))
 list("XADC_XN3_XAI_XP" "sky130_fd_pr_main" "pfet_01v8" list(list("D" "XADC_XN3_ACQB") list("G" "ACQ") list("S" "VDD") list("B" "VDD")) list(list("w" "2u") list("fw" "2u") list("l" "0.15u") list("fingers" "1") list("m" "1")) list("fingers" "l" "fw" "m"))
 list("XADC_XN3_XAI_XN" "sky130_fd_pr_main" "nfet_01v8" list(list("D" "XADC_XN3_ACQB") list("G" "ACQ") list("S" "VSS") list("B" "VSS")) list(list("w" "1u") list("fw" "1u") list("l" "0.15u") list("fingers" "1") list("m" "1")) list("fingers" "l" "fw" "m"))
 list("XADC_XN3_XPH_XP1" "sky130_fd_pr_main" "pfet_01v8" list(list("D" "XADC_XN3_PHB") list("G" "CONV") list("S" "VDD") list("B" "VDD")) list(list("w" "2u") list("fw" "2u") list("l" "0.15u") list("fingers" "1") list("m" "1")) list("fingers" "l" "fw" "m"))
 list("XADC_XN3_XPH_XP2" "sky130_fd_pr_main" "pfet_01v8" list(list("D" "XADC_XN3_PHB") list("G" "B3") list("S" "VDD") list("B" "VDD")) list(list("w" "2u") list("fw" "2u") list("l" "0.15u") list("fingers" "1") list("m" "1")) list("fingers" "l" "fw" "m"))
 list("XADC_XN3_XPH_XN1" "sky130_fd_pr_main" "nfet_01v8" list(list("D" "XADC_XN3_PHB") list("G" "CONV") list("S" "XADC_XN3_XPH_MID") list("B" "VSS")) list(list("w" "2u") list("fw" "2u") list("l" "0.15u") list("fingers" "1") list("m" "1")) list("fingers" "l" "fw" "m"))
 list("XADC_XN3_XPH_XN2" "sky130_fd_pr_main" "nfet_01v8" list(list("D" "XADC_XN3_XPH_MID") list("G" "B3") list("S" "VSS") list("B" "VSS")) list(list("w" "2u") list("fw" "2u") list("l" "0.15u") list("fingers" "1") list("m" "1")) list("fingers" "l" "fw" "m"))
 list("XADC_XN3_XPI_XP" "sky130_fd_pr_main" "pfet_01v8" list(list("D" "XADC_XN3_PH") list("G" "XADC_XN3_PHB") list("S" "VDD") list("B" "VDD")) list(list("w" "2u") list("fw" "2u") list("l" "0.15u") list("fingers" "1") list("m" "1")) list("fingers" "l" "fw" "m"))
 list("XADC_XN3_XPI_XN" "sky130_fd_pr_main" "nfet_01v8" list(list("D" "XADC_XN3_PH") list("G" "XADC_XN3_PHB") list("S" "VSS") list("B" "VSS")) list(list("w" "1u") list("fw" "1u") list("l" "0.15u") list("fingers" "1") list("m" "1")) list("fingers" "l" "fw" "m"))
 list("XADC_XN3_XNL_XP1" "sky130_fd_pr_main" "pfet_01v8" list(list("D" "XADC_XN3_NLB") list("G" "CONV") list("S" "VDD") list("B" "VDD")) list(list("w" "2u") list("fw" "2u") list("l" "0.15u") list("fingers" "1") list("m" "1")) list("fingers" "l" "fw" "m"))
 list("XADC_XN3_XNL_XP2" "sky130_fd_pr_main" "pfet_01v8" list(list("D" "XADC_XN3_NLB") list("G" "XADC_XN3_BITB") list("S" "VDD") list("B" "VDD")) list(list("w" "2u") list("fw" "2u") list("l" "0.15u") list("fingers" "1") list("m" "1")) list("fingers" "l" "fw" "m"))
 list("XADC_XN3_XNL_XN1" "sky130_fd_pr_main" "nfet_01v8" list(list("D" "XADC_XN3_NLB") list("G" "CONV") list("S" "XADC_XN3_XNL_MID") list("B" "VSS")) list(list("w" "2u") list("fw" "2u") list("l" "0.15u") list("fingers" "1") list("m" "1")) list("fingers" "l" "fw" "m"))
 list("XADC_XN3_XNL_XN2" "sky130_fd_pr_main" "nfet_01v8" list(list("D" "XADC_XN3_XNL_MID") list("G" "XADC_XN3_BITB") list("S" "VSS") list("B" "VSS")) list(list("w" "2u") list("fw" "2u") list("l" "0.15u") list("fingers" "1") list("m" "1")) list("fingers" "l" "fw" "m"))
 list("XADC_XN3_XNI_XP" "sky130_fd_pr_main" "pfet_01v8" list(list("D" "XADC_XN3_NL") list("G" "XADC_XN3_NLB") list("S" "VDD") list("B" "VDD")) list(list("w" "2u") list("fw" "2u") list("l" "0.15u") list("fingers" "1") list("m" "1")) list("fingers" "l" "fw" "m"))
 list("XADC_XN3_XNI_XN" "sky130_fd_pr_main" "nfet_01v8" list(list("D" "XADC_XN3_NL") list("G" "XADC_XN3_NLB") list("S" "VSS") list("B" "VSS")) list(list("w" "1u") list("fw" "1u") list("l" "0.15u") list("fingers" "1") list("m" "1")) list("fingers" "l" "fw" "m"))
 list("XADC_XN3_XCM_XN" "sky130_fd_pr_main" "nfet_01v8_lvt" list(list("D" "INN") list("G" "ACQ") list("S" "XADC_BN3") list("B" "VSS")) list(list("w" "2.375u") list("fw" "2.375u") list("l" "0.15u") list("fingers" "1") list("m" "1")) list("fingers" "l" "fw" "m"))
 list("XADC_XN3_XCM_XP" "sky130_fd_pr_main" "pfet_01v8_lvt" list(list("D" "INN") list("G" "XADC_XN3_ACQB") list("S" "XADC_BN3") list("B" "VDD")) list(list("w" "4.75u") list("fw" "4.75u") list("l" "0.35u") list("fingers" "1") list("m" "1")) list("fingers" "l" "fw" "m"))
 list("XADC_XN3_XRP_XN" "sky130_fd_pr_main" "nfet_01v8_lvt" list(list("D" "RN") list("G" "XADC_XN3_PH") list("S" "XADC_BN3") list("B" "VSS")) list(list("w" "2.375u") list("fw" "2.375u") list("l" "0.15u") list("fingers" "1") list("m" "1")) list("fingers" "l" "fw" "m"))
 list("XADC_XN3_XRP_XP" "sky130_fd_pr_main" "pfet_01v8_lvt" list(list("D" "RN") list("G" "XADC_XN3_PHB") list("S" "XADC_BN3") list("B" "VDD")) list(list("w" "4.75u") list("fw" "4.75u") list("l" "0.35u") list("fingers" "1") list("m" "1")) list("fingers" "l" "fw" "m"))
 list("XADC_XN3_XRN_XN" "sky130_fd_pr_main" "nfet_01v8_lvt" list(list("D" "RP") list("G" "XADC_XN3_NL") list("S" "XADC_BN3") list("B" "VSS")) list(list("w" "2.375u") list("fw" "2.375u") list("l" "0.15u") list("fingers" "1") list("m" "1")) list("fingers" "l" "fw" "m"))
 list("XADC_XN3_XRN_XP" "sky130_fd_pr_main" "pfet_01v8_lvt" list(list("D" "RP") list("G" "XADC_XN3_NLB") list("S" "XADC_BN3") list("B" "VDD")) list(list("w" "4.75u") list("fw" "4.75u") list("l" "0.35u") list("fingers" "1") list("m" "1")) list("fingers" "l" "fw" "m"))
 list("XADC_XP4_XBI_XP" "sky130_fd_pr_main" "pfet_01v8" list(list("D" "XADC_XP4_BITB") list("G" "B4") list("S" "VDD") list("B" "VDD")) list(list("w" "2u") list("fw" "2u") list("l" "0.15u") list("fingers" "1") list("m" "1")) list("fingers" "l" "fw" "m"))
 list("XADC_XP4_XBI_XN" "sky130_fd_pr_main" "nfet_01v8" list(list("D" "XADC_XP4_BITB") list("G" "B4") list("S" "VSS") list("B" "VSS")) list(list("w" "1u") list("fw" "1u") list("l" "0.15u") list("fingers" "1") list("m" "1")) list("fingers" "l" "fw" "m"))
 list("XADC_XP4_XAI_XP" "sky130_fd_pr_main" "pfet_01v8" list(list("D" "XADC_XP4_ACQB") list("G" "ACQ") list("S" "VDD") list("B" "VDD")) list(list("w" "2u") list("fw" "2u") list("l" "0.15u") list("fingers" "1") list("m" "1")) list("fingers" "l" "fw" "m"))
 list("XADC_XP4_XAI_XN" "sky130_fd_pr_main" "nfet_01v8" list(list("D" "XADC_XP4_ACQB") list("G" "ACQ") list("S" "VSS") list("B" "VSS")) list(list("w" "1u") list("fw" "1u") list("l" "0.15u") list("fingers" "1") list("m" "1")) list("fingers" "l" "fw" "m"))
 list("XADC_XP4_XPH_XP1" "sky130_fd_pr_main" "pfet_01v8" list(list("D" "XADC_XP4_PHB") list("G" "CONV") list("S" "VDD") list("B" "VDD")) list(list("w" "2u") list("fw" "2u") list("l" "0.15u") list("fingers" "1") list("m" "1")) list("fingers" "l" "fw" "m"))
 list("XADC_XP4_XPH_XP2" "sky130_fd_pr_main" "pfet_01v8" list(list("D" "XADC_XP4_PHB") list("G" "B4") list("S" "VDD") list("B" "VDD")) list(list("w" "2u") list("fw" "2u") list("l" "0.15u") list("fingers" "1") list("m" "1")) list("fingers" "l" "fw" "m"))
 list("XADC_XP4_XPH_XN1" "sky130_fd_pr_main" "nfet_01v8" list(list("D" "XADC_XP4_PHB") list("G" "CONV") list("S" "XADC_XP4_XPH_MID") list("B" "VSS")) list(list("w" "2u") list("fw" "2u") list("l" "0.15u") list("fingers" "1") list("m" "1")) list("fingers" "l" "fw" "m"))
 list("XADC_XP4_XPH_XN2" "sky130_fd_pr_main" "nfet_01v8" list(list("D" "XADC_XP4_XPH_MID") list("G" "B4") list("S" "VSS") list("B" "VSS")) list(list("w" "2u") list("fw" "2u") list("l" "0.15u") list("fingers" "1") list("m" "1")) list("fingers" "l" "fw" "m"))
 list("XADC_XP4_XPI_XP" "sky130_fd_pr_main" "pfet_01v8" list(list("D" "XADC_XP4_PH") list("G" "XADC_XP4_PHB") list("S" "VDD") list("B" "VDD")) list(list("w" "2u") list("fw" "2u") list("l" "0.15u") list("fingers" "1") list("m" "1")) list("fingers" "l" "fw" "m"))
 list("XADC_XP4_XPI_XN" "sky130_fd_pr_main" "nfet_01v8" list(list("D" "XADC_XP4_PH") list("G" "XADC_XP4_PHB") list("S" "VSS") list("B" "VSS")) list(list("w" "1u") list("fw" "1u") list("l" "0.15u") list("fingers" "1") list("m" "1")) list("fingers" "l" "fw" "m"))
 list("XADC_XP4_XNL_XP1" "sky130_fd_pr_main" "pfet_01v8" list(list("D" "XADC_XP4_NLB") list("G" "CONV") list("S" "VDD") list("B" "VDD")) list(list("w" "2u") list("fw" "2u") list("l" "0.15u") list("fingers" "1") list("m" "1")) list("fingers" "l" "fw" "m"))
 list("XADC_XP4_XNL_XP2" "sky130_fd_pr_main" "pfet_01v8" list(list("D" "XADC_XP4_NLB") list("G" "XADC_XP4_BITB") list("S" "VDD") list("B" "VDD")) list(list("w" "2u") list("fw" "2u") list("l" "0.15u") list("fingers" "1") list("m" "1")) list("fingers" "l" "fw" "m"))
 list("XADC_XP4_XNL_XN1" "sky130_fd_pr_main" "nfet_01v8" list(list("D" "XADC_XP4_NLB") list("G" "CONV") list("S" "XADC_XP4_XNL_MID") list("B" "VSS")) list(list("w" "2u") list("fw" "2u") list("l" "0.15u") list("fingers" "1") list("m" "1")) list("fingers" "l" "fw" "m"))
 list("XADC_XP4_XNL_XN2" "sky130_fd_pr_main" "nfet_01v8" list(list("D" "XADC_XP4_XNL_MID") list("G" "XADC_XP4_BITB") list("S" "VSS") list("B" "VSS")) list(list("w" "2u") list("fw" "2u") list("l" "0.15u") list("fingers" "1") list("m" "1")) list("fingers" "l" "fw" "m"))
 list("XADC_XP4_XNI_XP" "sky130_fd_pr_main" "pfet_01v8" list(list("D" "XADC_XP4_NL") list("G" "XADC_XP4_NLB") list("S" "VDD") list("B" "VDD")) list(list("w" "2u") list("fw" "2u") list("l" "0.15u") list("fingers" "1") list("m" "1")) list("fingers" "l" "fw" "m"))
 list("XADC_XP4_XNI_XN" "sky130_fd_pr_main" "nfet_01v8" list(list("D" "XADC_XP4_NL") list("G" "XADC_XP4_NLB") list("S" "VSS") list("B" "VSS")) list(list("w" "1u") list("fw" "1u") list("l" "0.15u") list("fingers" "1") list("m" "1")) list("fingers" "l" "fw" "m"))
 list("XADC_XP4_XCM_XN" "sky130_fd_pr_main" "nfet_01v8_lvt" list(list("D" "INP") list("G" "ACQ") list("S" "XADC_BP4") list("B" "VSS")) list(list("w" "3.36u") list("fw" "3.36u") list("l" "0.15u") list("fingers" "1") list("m" "1")) list("fingers" "l" "fw" "m"))
 list("XADC_XP4_XCM_XP" "sky130_fd_pr_main" "pfet_01v8_lvt" list(list("D" "INP") list("G" "XADC_XP4_ACQB") list("S" "XADC_BP4") list("B" "VDD")) list(list("w" "6.72u") list("fw" "6.72u") list("l" "0.35u") list("fingers" "1") list("m" "1")) list("fingers" "l" "fw" "m"))
 list("XADC_XP4_XRP_XN" "sky130_fd_pr_main" "nfet_01v8_lvt" list(list("D" "RP") list("G" "XADC_XP4_PH") list("S" "XADC_BP4") list("B" "VSS")) list(list("w" "3.36u") list("fw" "3.36u") list("l" "0.15u") list("fingers" "1") list("m" "1")) list("fingers" "l" "fw" "m"))
 list("XADC_XP4_XRP_XP" "sky130_fd_pr_main" "pfet_01v8_lvt" list(list("D" "RP") list("G" "XADC_XP4_PHB") list("S" "XADC_BP4") list("B" "VDD")) list(list("w" "6.72u") list("fw" "6.72u") list("l" "0.35u") list("fingers" "1") list("m" "1")) list("fingers" "l" "fw" "m"))
 list("XADC_XP4_XRN_XN" "sky130_fd_pr_main" "nfet_01v8_lvt" list(list("D" "RN") list("G" "XADC_XP4_NL") list("S" "XADC_BP4") list("B" "VSS")) list(list("w" "3.36u") list("fw" "3.36u") list("l" "0.15u") list("fingers" "1") list("m" "1")) list("fingers" "l" "fw" "m"))
 list("XADC_XP4_XRN_XP" "sky130_fd_pr_main" "pfet_01v8_lvt" list(list("D" "RN") list("G" "XADC_XP4_NLB") list("S" "XADC_BP4") list("B" "VDD")) list(list("w" "6.72u") list("fw" "6.72u") list("l" "0.35u") list("fingers" "1") list("m" "1")) list("fingers" "l" "fw" "m"))
 list("XADC_XN4_XBI_XP" "sky130_fd_pr_main" "pfet_01v8" list(list("D" "XADC_XN4_BITB") list("G" "B4") list("S" "VDD") list("B" "VDD")) list(list("w" "2u") list("fw" "2u") list("l" "0.15u") list("fingers" "1") list("m" "1")) list("fingers" "l" "fw" "m"))
 list("XADC_XN4_XBI_XN" "sky130_fd_pr_main" "nfet_01v8" list(list("D" "XADC_XN4_BITB") list("G" "B4") list("S" "VSS") list("B" "VSS")) list(list("w" "1u") list("fw" "1u") list("l" "0.15u") list("fingers" "1") list("m" "1")) list("fingers" "l" "fw" "m"))
 list("XADC_XN4_XAI_XP" "sky130_fd_pr_main" "pfet_01v8" list(list("D" "XADC_XN4_ACQB") list("G" "ACQ") list("S" "VDD") list("B" "VDD")) list(list("w" "2u") list("fw" "2u") list("l" "0.15u") list("fingers" "1") list("m" "1")) list("fingers" "l" "fw" "m"))
 list("XADC_XN4_XAI_XN" "sky130_fd_pr_main" "nfet_01v8" list(list("D" "XADC_XN4_ACQB") list("G" "ACQ") list("S" "VSS") list("B" "VSS")) list(list("w" "1u") list("fw" "1u") list("l" "0.15u") list("fingers" "1") list("m" "1")) list("fingers" "l" "fw" "m"))
 list("XADC_XN4_XPH_XP1" "sky130_fd_pr_main" "pfet_01v8" list(list("D" "XADC_XN4_PHB") list("G" "CONV") list("S" "VDD") list("B" "VDD")) list(list("w" "2u") list("fw" "2u") list("l" "0.15u") list("fingers" "1") list("m" "1")) list("fingers" "l" "fw" "m"))
 list("XADC_XN4_XPH_XP2" "sky130_fd_pr_main" "pfet_01v8" list(list("D" "XADC_XN4_PHB") list("G" "B4") list("S" "VDD") list("B" "VDD")) list(list("w" "2u") list("fw" "2u") list("l" "0.15u") list("fingers" "1") list("m" "1")) list("fingers" "l" "fw" "m"))
 list("XADC_XN4_XPH_XN1" "sky130_fd_pr_main" "nfet_01v8" list(list("D" "XADC_XN4_PHB") list("G" "CONV") list("S" "XADC_XN4_XPH_MID") list("B" "VSS")) list(list("w" "2u") list("fw" "2u") list("l" "0.15u") list("fingers" "1") list("m" "1")) list("fingers" "l" "fw" "m"))
 list("XADC_XN4_XPH_XN2" "sky130_fd_pr_main" "nfet_01v8" list(list("D" "XADC_XN4_XPH_MID") list("G" "B4") list("S" "VSS") list("B" "VSS")) list(list("w" "2u") list("fw" "2u") list("l" "0.15u") list("fingers" "1") list("m" "1")) list("fingers" "l" "fw" "m"))
 list("XADC_XN4_XPI_XP" "sky130_fd_pr_main" "pfet_01v8" list(list("D" "XADC_XN4_PH") list("G" "XADC_XN4_PHB") list("S" "VDD") list("B" "VDD")) list(list("w" "2u") list("fw" "2u") list("l" "0.15u") list("fingers" "1") list("m" "1")) list("fingers" "l" "fw" "m"))
 list("XADC_XN4_XPI_XN" "sky130_fd_pr_main" "nfet_01v8" list(list("D" "XADC_XN4_PH") list("G" "XADC_XN4_PHB") list("S" "VSS") list("B" "VSS")) list(list("w" "1u") list("fw" "1u") list("l" "0.15u") list("fingers" "1") list("m" "1")) list("fingers" "l" "fw" "m"))
 list("XADC_XN4_XNL_XP1" "sky130_fd_pr_main" "pfet_01v8" list(list("D" "XADC_XN4_NLB") list("G" "CONV") list("S" "VDD") list("B" "VDD")) list(list("w" "2u") list("fw" "2u") list("l" "0.15u") list("fingers" "1") list("m" "1")) list("fingers" "l" "fw" "m"))
 list("XADC_XN4_XNL_XP2" "sky130_fd_pr_main" "pfet_01v8" list(list("D" "XADC_XN4_NLB") list("G" "XADC_XN4_BITB") list("S" "VDD") list("B" "VDD")) list(list("w" "2u") list("fw" "2u") list("l" "0.15u") list("fingers" "1") list("m" "1")) list("fingers" "l" "fw" "m"))
 list("XADC_XN4_XNL_XN1" "sky130_fd_pr_main" "nfet_01v8" list(list("D" "XADC_XN4_NLB") list("G" "CONV") list("S" "XADC_XN4_XNL_MID") list("B" "VSS")) list(list("w" "2u") list("fw" "2u") list("l" "0.15u") list("fingers" "1") list("m" "1")) list("fingers" "l" "fw" "m"))
 list("XADC_XN4_XNL_XN2" "sky130_fd_pr_main" "nfet_01v8" list(list("D" "XADC_XN4_XNL_MID") list("G" "XADC_XN4_BITB") list("S" "VSS") list("B" "VSS")) list(list("w" "2u") list("fw" "2u") list("l" "0.15u") list("fingers" "1") list("m" "1")) list("fingers" "l" "fw" "m"))
 list("XADC_XN4_XNI_XP" "sky130_fd_pr_main" "pfet_01v8" list(list("D" "XADC_XN4_NL") list("G" "XADC_XN4_NLB") list("S" "VDD") list("B" "VDD")) list(list("w" "2u") list("fw" "2u") list("l" "0.15u") list("fingers" "1") list("m" "1")) list("fingers" "l" "fw" "m"))
 list("XADC_XN4_XNI_XN" "sky130_fd_pr_main" "nfet_01v8" list(list("D" "XADC_XN4_NL") list("G" "XADC_XN4_NLB") list("S" "VSS") list("B" "VSS")) list(list("w" "1u") list("fw" "1u") list("l" "0.15u") list("fingers" "1") list("m" "1")) list("fingers" "l" "fw" "m"))
 list("XADC_XN4_XCM_XN" "sky130_fd_pr_main" "nfet_01v8_lvt" list(list("D" "INN") list("G" "ACQ") list("S" "XADC_BN4") list("B" "VSS")) list(list("w" "3.36u") list("fw" "3.36u") list("l" "0.15u") list("fingers" "1") list("m" "1")) list("fingers" "l" "fw" "m"))
 list("XADC_XN4_XCM_XP" "sky130_fd_pr_main" "pfet_01v8_lvt" list(list("D" "INN") list("G" "XADC_XN4_ACQB") list("S" "XADC_BN4") list("B" "VDD")) list(list("w" "6.72u") list("fw" "6.72u") list("l" "0.35u") list("fingers" "1") list("m" "1")) list("fingers" "l" "fw" "m"))
 list("XADC_XN4_XRP_XN" "sky130_fd_pr_main" "nfet_01v8_lvt" list(list("D" "RN") list("G" "XADC_XN4_PH") list("S" "XADC_BN4") list("B" "VSS")) list(list("w" "3.36u") list("fw" "3.36u") list("l" "0.15u") list("fingers" "1") list("m" "1")) list("fingers" "l" "fw" "m"))
 list("XADC_XN4_XRP_XP" "sky130_fd_pr_main" "pfet_01v8_lvt" list(list("D" "RN") list("G" "XADC_XN4_PHB") list("S" "XADC_BN4") list("B" "VDD")) list(list("w" "6.72u") list("fw" "6.72u") list("l" "0.35u") list("fingers" "1") list("m" "1")) list("fingers" "l" "fw" "m"))
 list("XADC_XN4_XRN_XN" "sky130_fd_pr_main" "nfet_01v8_lvt" list(list("D" "RP") list("G" "XADC_XN4_NL") list("S" "XADC_BN4") list("B" "VSS")) list(list("w" "3.36u") list("fw" "3.36u") list("l" "0.15u") list("fingers" "1") list("m" "1")) list("fingers" "l" "fw" "m"))
 list("XADC_XN4_XRN_XP" "sky130_fd_pr_main" "pfet_01v8_lvt" list(list("D" "RP") list("G" "XADC_XN4_NLB") list("S" "XADC_BN4") list("B" "VDD")) list(list("w" "6.72u") list("fw" "6.72u") list("l" "0.35u") list("fingers" "1") list("m" "1")) list("fingers" "l" "fw" "m"))
 list("XADC_XP5_XBI_XP" "sky130_fd_pr_main" "pfet_01v8" list(list("D" "XADC_XP5_BITB") list("G" "B5") list("S" "VDD") list("B" "VDD")) list(list("w" "2u") list("fw" "2u") list("l" "0.15u") list("fingers" "1") list("m" "1")) list("fingers" "l" "fw" "m"))
 list("XADC_XP5_XBI_XN" "sky130_fd_pr_main" "nfet_01v8" list(list("D" "XADC_XP5_BITB") list("G" "B5") list("S" "VSS") list("B" "VSS")) list(list("w" "1u") list("fw" "1u") list("l" "0.15u") list("fingers" "1") list("m" "1")) list("fingers" "l" "fw" "m"))
 list("XADC_XP5_XAI_XP" "sky130_fd_pr_main" "pfet_01v8" list(list("D" "XADC_XP5_ACQB") list("G" "ACQ") list("S" "VDD") list("B" "VDD")) list(list("w" "2u") list("fw" "2u") list("l" "0.15u") list("fingers" "1") list("m" "1")) list("fingers" "l" "fw" "m"))
 list("XADC_XP5_XAI_XN" "sky130_fd_pr_main" "nfet_01v8" list(list("D" "XADC_XP5_ACQB") list("G" "ACQ") list("S" "VSS") list("B" "VSS")) list(list("w" "1u") list("fw" "1u") list("l" "0.15u") list("fingers" "1") list("m" "1")) list("fingers" "l" "fw" "m"))
 list("XADC_XP5_XPH_XP1" "sky130_fd_pr_main" "pfet_01v8" list(list("D" "XADC_XP5_PHB") list("G" "CONV") list("S" "VDD") list("B" "VDD")) list(list("w" "2u") list("fw" "2u") list("l" "0.15u") list("fingers" "1") list("m" "1")) list("fingers" "l" "fw" "m"))
 list("XADC_XP5_XPH_XP2" "sky130_fd_pr_main" "pfet_01v8" list(list("D" "XADC_XP5_PHB") list("G" "B5") list("S" "VDD") list("B" "VDD")) list(list("w" "2u") list("fw" "2u") list("l" "0.15u") list("fingers" "1") list("m" "1")) list("fingers" "l" "fw" "m"))
 list("XADC_XP5_XPH_XN1" "sky130_fd_pr_main" "nfet_01v8" list(list("D" "XADC_XP5_PHB") list("G" "CONV") list("S" "XADC_XP5_XPH_MID") list("B" "VSS")) list(list("w" "2u") list("fw" "2u") list("l" "0.15u") list("fingers" "1") list("m" "1")) list("fingers" "l" "fw" "m"))
 list("XADC_XP5_XPH_XN2" "sky130_fd_pr_main" "nfet_01v8" list(list("D" "XADC_XP5_XPH_MID") list("G" "B5") list("S" "VSS") list("B" "VSS")) list(list("w" "2u") list("fw" "2u") list("l" "0.15u") list("fingers" "1") list("m" "1")) list("fingers" "l" "fw" "m"))
 list("XADC_XP5_XPI_XP" "sky130_fd_pr_main" "pfet_01v8" list(list("D" "XADC_XP5_PH") list("G" "XADC_XP5_PHB") list("S" "VDD") list("B" "VDD")) list(list("w" "2u") list("fw" "2u") list("l" "0.15u") list("fingers" "1") list("m" "1")) list("fingers" "l" "fw" "m"))
 list("XADC_XP5_XPI_XN" "sky130_fd_pr_main" "nfet_01v8" list(list("D" "XADC_XP5_PH") list("G" "XADC_XP5_PHB") list("S" "VSS") list("B" "VSS")) list(list("w" "1u") list("fw" "1u") list("l" "0.15u") list("fingers" "1") list("m" "1")) list("fingers" "l" "fw" "m"))
 list("XADC_XP5_XNL_XP1" "sky130_fd_pr_main" "pfet_01v8" list(list("D" "XADC_XP5_NLB") list("G" "CONV") list("S" "VDD") list("B" "VDD")) list(list("w" "2u") list("fw" "2u") list("l" "0.15u") list("fingers" "1") list("m" "1")) list("fingers" "l" "fw" "m"))
 list("XADC_XP5_XNL_XP2" "sky130_fd_pr_main" "pfet_01v8" list(list("D" "XADC_XP5_NLB") list("G" "XADC_XP5_BITB") list("S" "VDD") list("B" "VDD")) list(list("w" "2u") list("fw" "2u") list("l" "0.15u") list("fingers" "1") list("m" "1")) list("fingers" "l" "fw" "m"))
 list("XADC_XP5_XNL_XN1" "sky130_fd_pr_main" "nfet_01v8" list(list("D" "XADC_XP5_NLB") list("G" "CONV") list("S" "XADC_XP5_XNL_MID") list("B" "VSS")) list(list("w" "2u") list("fw" "2u") list("l" "0.15u") list("fingers" "1") list("m" "1")) list("fingers" "l" "fw" "m"))
 list("XADC_XP5_XNL_XN2" "sky130_fd_pr_main" "nfet_01v8" list(list("D" "XADC_XP5_XNL_MID") list("G" "XADC_XP5_BITB") list("S" "VSS") list("B" "VSS")) list(list("w" "2u") list("fw" "2u") list("l" "0.15u") list("fingers" "1") list("m" "1")) list("fingers" "l" "fw" "m"))
 list("XADC_XP5_XNI_XP" "sky130_fd_pr_main" "pfet_01v8" list(list("D" "XADC_XP5_NL") list("G" "XADC_XP5_NLB") list("S" "VDD") list("B" "VDD")) list(list("w" "2u") list("fw" "2u") list("l" "0.15u") list("fingers" "1") list("m" "1")) list("fingers" "l" "fw" "m"))
 list("XADC_XP5_XNI_XN" "sky130_fd_pr_main" "nfet_01v8" list(list("D" "XADC_XP5_NL") list("G" "XADC_XP5_NLB") list("S" "VSS") list("B" "VSS")) list(list("w" "1u") list("fw" "1u") list("l" "0.15u") list("fingers" "1") list("m" "1")) list("fingers" "l" "fw" "m"))
 list("XADC_XP5_XCM_XN" "sky130_fd_pr_main" "nfet_01v8_lvt" list(list("D" "INP") list("G" "ACQ") list("S" "XADC_BP5") list("B" "VSS")) list(list("w" "4.75u") list("fw" "4.75u") list("l" "0.15u") list("fingers" "1") list("m" "1")) list("fingers" "l" "fw" "m"))
 list("XADC_XP5_XCM_XP" "sky130_fd_pr_main" "pfet_01v8_lvt" list(list("D" "INP") list("G" "XADC_XP5_ACQB") list("S" "XADC_BP5") list("B" "VDD")) list(list("w" "9.505u") list("fw" "9.505u") list("l" "0.35u") list("fingers" "1") list("m" "1")) list("fingers" "l" "fw" "m"))
 list("XADC_XP5_XRP_XN" "sky130_fd_pr_main" "nfet_01v8_lvt" list(list("D" "RP") list("G" "XADC_XP5_PH") list("S" "XADC_BP5") list("B" "VSS")) list(list("w" "4.75u") list("fw" "4.75u") list("l" "0.15u") list("fingers" "1") list("m" "1")) list("fingers" "l" "fw" "m"))
 list("XADC_XP5_XRP_XP" "sky130_fd_pr_main" "pfet_01v8_lvt" list(list("D" "RP") list("G" "XADC_XP5_PHB") list("S" "XADC_BP5") list("B" "VDD")) list(list("w" "9.505u") list("fw" "9.505u") list("l" "0.35u") list("fingers" "1") list("m" "1")) list("fingers" "l" "fw" "m"))
 list("XADC_XP5_XRN_XN" "sky130_fd_pr_main" "nfet_01v8_lvt" list(list("D" "RN") list("G" "XADC_XP5_NL") list("S" "XADC_BP5") list("B" "VSS")) list(list("w" "4.75u") list("fw" "4.75u") list("l" "0.15u") list("fingers" "1") list("m" "1")) list("fingers" "l" "fw" "m"))
 list("XADC_XP5_XRN_XP" "sky130_fd_pr_main" "pfet_01v8_lvt" list(list("D" "RN") list("G" "XADC_XP5_NLB") list("S" "XADC_BP5") list("B" "VDD")) list(list("w" "9.505u") list("fw" "9.505u") list("l" "0.35u") list("fingers" "1") list("m" "1")) list("fingers" "l" "fw" "m"))
 list("XADC_XN5_XBI_XP" "sky130_fd_pr_main" "pfet_01v8" list(list("D" "XADC_XN5_BITB") list("G" "B5") list("S" "VDD") list("B" "VDD")) list(list("w" "2u") list("fw" "2u") list("l" "0.15u") list("fingers" "1") list("m" "1")) list("fingers" "l" "fw" "m"))
 list("XADC_XN5_XBI_XN" "sky130_fd_pr_main" "nfet_01v8" list(list("D" "XADC_XN5_BITB") list("G" "B5") list("S" "VSS") list("B" "VSS")) list(list("w" "1u") list("fw" "1u") list("l" "0.15u") list("fingers" "1") list("m" "1")) list("fingers" "l" "fw" "m"))
 list("XADC_XN5_XAI_XP" "sky130_fd_pr_main" "pfet_01v8" list(list("D" "XADC_XN5_ACQB") list("G" "ACQ") list("S" "VDD") list("B" "VDD")) list(list("w" "2u") list("fw" "2u") list("l" "0.15u") list("fingers" "1") list("m" "1")) list("fingers" "l" "fw" "m"))
 list("XADC_XN5_XAI_XN" "sky130_fd_pr_main" "nfet_01v8" list(list("D" "XADC_XN5_ACQB") list("G" "ACQ") list("S" "VSS") list("B" "VSS")) list(list("w" "1u") list("fw" "1u") list("l" "0.15u") list("fingers" "1") list("m" "1")) list("fingers" "l" "fw" "m"))
 list("XADC_XN5_XPH_XP1" "sky130_fd_pr_main" "pfet_01v8" list(list("D" "XADC_XN5_PHB") list("G" "CONV") list("S" "VDD") list("B" "VDD")) list(list("w" "2u") list("fw" "2u") list("l" "0.15u") list("fingers" "1") list("m" "1")) list("fingers" "l" "fw" "m"))
 list("XADC_XN5_XPH_XP2" "sky130_fd_pr_main" "pfet_01v8" list(list("D" "XADC_XN5_PHB") list("G" "B5") list("S" "VDD") list("B" "VDD")) list(list("w" "2u") list("fw" "2u") list("l" "0.15u") list("fingers" "1") list("m" "1")) list("fingers" "l" "fw" "m"))
 list("XADC_XN5_XPH_XN1" "sky130_fd_pr_main" "nfet_01v8" list(list("D" "XADC_XN5_PHB") list("G" "CONV") list("S" "XADC_XN5_XPH_MID") list("B" "VSS")) list(list("w" "2u") list("fw" "2u") list("l" "0.15u") list("fingers" "1") list("m" "1")) list("fingers" "l" "fw" "m"))
 list("XADC_XN5_XPH_XN2" "sky130_fd_pr_main" "nfet_01v8" list(list("D" "XADC_XN5_XPH_MID") list("G" "B5") list("S" "VSS") list("B" "VSS")) list(list("w" "2u") list("fw" "2u") list("l" "0.15u") list("fingers" "1") list("m" "1")) list("fingers" "l" "fw" "m"))
 list("XADC_XN5_XPI_XP" "sky130_fd_pr_main" "pfet_01v8" list(list("D" "XADC_XN5_PH") list("G" "XADC_XN5_PHB") list("S" "VDD") list("B" "VDD")) list(list("w" "2u") list("fw" "2u") list("l" "0.15u") list("fingers" "1") list("m" "1")) list("fingers" "l" "fw" "m"))
 list("XADC_XN5_XPI_XN" "sky130_fd_pr_main" "nfet_01v8" list(list("D" "XADC_XN5_PH") list("G" "XADC_XN5_PHB") list("S" "VSS") list("B" "VSS")) list(list("w" "1u") list("fw" "1u") list("l" "0.15u") list("fingers" "1") list("m" "1")) list("fingers" "l" "fw" "m"))
 list("XADC_XN5_XNL_XP1" "sky130_fd_pr_main" "pfet_01v8" list(list("D" "XADC_XN5_NLB") list("G" "CONV") list("S" "VDD") list("B" "VDD")) list(list("w" "2u") list("fw" "2u") list("l" "0.15u") list("fingers" "1") list("m" "1")) list("fingers" "l" "fw" "m"))
 list("XADC_XN5_XNL_XP2" "sky130_fd_pr_main" "pfet_01v8" list(list("D" "XADC_XN5_NLB") list("G" "XADC_XN5_BITB") list("S" "VDD") list("B" "VDD")) list(list("w" "2u") list("fw" "2u") list("l" "0.15u") list("fingers" "1") list("m" "1")) list("fingers" "l" "fw" "m"))
 list("XADC_XN5_XNL_XN1" "sky130_fd_pr_main" "nfet_01v8" list(list("D" "XADC_XN5_NLB") list("G" "CONV") list("S" "XADC_XN5_XNL_MID") list("B" "VSS")) list(list("w" "2u") list("fw" "2u") list("l" "0.15u") list("fingers" "1") list("m" "1")) list("fingers" "l" "fw" "m"))
 list("XADC_XN5_XNL_XN2" "sky130_fd_pr_main" "nfet_01v8" list(list("D" "XADC_XN5_XNL_MID") list("G" "XADC_XN5_BITB") list("S" "VSS") list("B" "VSS")) list(list("w" "2u") list("fw" "2u") list("l" "0.15u") list("fingers" "1") list("m" "1")) list("fingers" "l" "fw" "m"))
 list("XADC_XN5_XNI_XP" "sky130_fd_pr_main" "pfet_01v8" list(list("D" "XADC_XN5_NL") list("G" "XADC_XN5_NLB") list("S" "VDD") list("B" "VDD")) list(list("w" "2u") list("fw" "2u") list("l" "0.15u") list("fingers" "1") list("m" "1")) list("fingers" "l" "fw" "m"))
 list("XADC_XN5_XNI_XN" "sky130_fd_pr_main" "nfet_01v8" list(list("D" "XADC_XN5_NL") list("G" "XADC_XN5_NLB") list("S" "VSS") list("B" "VSS")) list(list("w" "1u") list("fw" "1u") list("l" "0.15u") list("fingers" "1") list("m" "1")) list("fingers" "l" "fw" "m"))
 list("XADC_XN5_XCM_XN" "sky130_fd_pr_main" "nfet_01v8_lvt" list(list("D" "INN") list("G" "ACQ") list("S" "XADC_BN5") list("B" "VSS")) list(list("w" "4.75u") list("fw" "4.75u") list("l" "0.15u") list("fingers" "1") list("m" "1")) list("fingers" "l" "fw" "m"))
 list("XADC_XN5_XCM_XP" "sky130_fd_pr_main" "pfet_01v8_lvt" list(list("D" "INN") list("G" "XADC_XN5_ACQB") list("S" "XADC_BN5") list("B" "VDD")) list(list("w" "9.505u") list("fw" "9.505u") list("l" "0.35u") list("fingers" "1") list("m" "1")) list("fingers" "l" "fw" "m"))
 list("XADC_XN5_XRP_XN" "sky130_fd_pr_main" "nfet_01v8_lvt" list(list("D" "RN") list("G" "XADC_XN5_PH") list("S" "XADC_BN5") list("B" "VSS")) list(list("w" "4.75u") list("fw" "4.75u") list("l" "0.15u") list("fingers" "1") list("m" "1")) list("fingers" "l" "fw" "m"))
 list("XADC_XN5_XRP_XP" "sky130_fd_pr_main" "pfet_01v8_lvt" list(list("D" "RN") list("G" "XADC_XN5_PHB") list("S" "XADC_BN5") list("B" "VDD")) list(list("w" "9.505u") list("fw" "9.505u") list("l" "0.35u") list("fingers" "1") list("m" "1")) list("fingers" "l" "fw" "m"))
 list("XADC_XN5_XRN_XN" "sky130_fd_pr_main" "nfet_01v8_lvt" list(list("D" "RP") list("G" "XADC_XN5_NL") list("S" "XADC_BN5") list("B" "VSS")) list(list("w" "4.75u") list("fw" "4.75u") list("l" "0.15u") list("fingers" "1") list("m" "1")) list("fingers" "l" "fw" "m"))
 list("XADC_XN5_XRN_XP" "sky130_fd_pr_main" "pfet_01v8_lvt" list(list("D" "RP") list("G" "XADC_XN5_NLB") list("S" "XADC_BN5") list("B" "VDD")) list(list("w" "9.505u") list("fw" "9.505u") list("l" "0.35u") list("fingers" "1") list("m" "1")) list("fingers" "l" "fw" "m"))
 list("XADC_XP6_XBI_XP" "sky130_fd_pr_main" "pfet_01v8" list(list("D" "XADC_XP6_BITB") list("G" "B6") list("S" "VDD") list("B" "VDD")) list(list("w" "2u") list("fw" "2u") list("l" "0.15u") list("fingers" "1") list("m" "1")) list("fingers" "l" "fw" "m"))
 list("XADC_XP6_XBI_XN" "sky130_fd_pr_main" "nfet_01v8" list(list("D" "XADC_XP6_BITB") list("G" "B6") list("S" "VSS") list("B" "VSS")) list(list("w" "1u") list("fw" "1u") list("l" "0.15u") list("fingers" "1") list("m" "1")) list("fingers" "l" "fw" "m"))
 list("XADC_XP6_XAI_XP" "sky130_fd_pr_main" "pfet_01v8" list(list("D" "XADC_XP6_ACQB") list("G" "ACQ") list("S" "VDD") list("B" "VDD")) list(list("w" "2u") list("fw" "2u") list("l" "0.15u") list("fingers" "1") list("m" "1")) list("fingers" "l" "fw" "m"))
 list("XADC_XP6_XAI_XN" "sky130_fd_pr_main" "nfet_01v8" list(list("D" "XADC_XP6_ACQB") list("G" "ACQ") list("S" "VSS") list("B" "VSS")) list(list("w" "1u") list("fw" "1u") list("l" "0.15u") list("fingers" "1") list("m" "1")) list("fingers" "l" "fw" "m"))
 list("XADC_XP6_XPH_XP1" "sky130_fd_pr_main" "pfet_01v8" list(list("D" "XADC_XP6_PHB") list("G" "CONV") list("S" "VDD") list("B" "VDD")) list(list("w" "2u") list("fw" "2u") list("l" "0.15u") list("fingers" "1") list("m" "1")) list("fingers" "l" "fw" "m"))
 list("XADC_XP6_XPH_XP2" "sky130_fd_pr_main" "pfet_01v8" list(list("D" "XADC_XP6_PHB") list("G" "B6") list("S" "VDD") list("B" "VDD")) list(list("w" "2u") list("fw" "2u") list("l" "0.15u") list("fingers" "1") list("m" "1")) list("fingers" "l" "fw" "m"))
 list("XADC_XP6_XPH_XN1" "sky130_fd_pr_main" "nfet_01v8" list(list("D" "XADC_XP6_PHB") list("G" "CONV") list("S" "XADC_XP6_XPH_MID") list("B" "VSS")) list(list("w" "2u") list("fw" "2u") list("l" "0.15u") list("fingers" "1") list("m" "1")) list("fingers" "l" "fw" "m"))
 list("XADC_XP6_XPH_XN2" "sky130_fd_pr_main" "nfet_01v8" list(list("D" "XADC_XP6_XPH_MID") list("G" "B6") list("S" "VSS") list("B" "VSS")) list(list("w" "2u") list("fw" "2u") list("l" "0.15u") list("fingers" "1") list("m" "1")) list("fingers" "l" "fw" "m"))
 list("XADC_XP6_XPI_XP" "sky130_fd_pr_main" "pfet_01v8" list(list("D" "XADC_XP6_PH") list("G" "XADC_XP6_PHB") list("S" "VDD") list("B" "VDD")) list(list("w" "2u") list("fw" "2u") list("l" "0.15u") list("fingers" "1") list("m" "1")) list("fingers" "l" "fw" "m"))
 list("XADC_XP6_XPI_XN" "sky130_fd_pr_main" "nfet_01v8" list(list("D" "XADC_XP6_PH") list("G" "XADC_XP6_PHB") list("S" "VSS") list("B" "VSS")) list(list("w" "1u") list("fw" "1u") list("l" "0.15u") list("fingers" "1") list("m" "1")) list("fingers" "l" "fw" "m"))
 list("XADC_XP6_XNL_XP1" "sky130_fd_pr_main" "pfet_01v8" list(list("D" "XADC_XP6_NLB") list("G" "CONV") list("S" "VDD") list("B" "VDD")) list(list("w" "2u") list("fw" "2u") list("l" "0.15u") list("fingers" "1") list("m" "1")) list("fingers" "l" "fw" "m"))
 list("XADC_XP6_XNL_XP2" "sky130_fd_pr_main" "pfet_01v8" list(list("D" "XADC_XP6_NLB") list("G" "XADC_XP6_BITB") list("S" "VDD") list("B" "VDD")) list(list("w" "2u") list("fw" "2u") list("l" "0.15u") list("fingers" "1") list("m" "1")) list("fingers" "l" "fw" "m"))
 list("XADC_XP6_XNL_XN1" "sky130_fd_pr_main" "nfet_01v8" list(list("D" "XADC_XP6_NLB") list("G" "CONV") list("S" "XADC_XP6_XNL_MID") list("B" "VSS")) list(list("w" "2u") list("fw" "2u") list("l" "0.15u") list("fingers" "1") list("m" "1")) list("fingers" "l" "fw" "m"))
 list("XADC_XP6_XNL_XN2" "sky130_fd_pr_main" "nfet_01v8" list(list("D" "XADC_XP6_XNL_MID") list("G" "XADC_XP6_BITB") list("S" "VSS") list("B" "VSS")) list(list("w" "2u") list("fw" "2u") list("l" "0.15u") list("fingers" "1") list("m" "1")) list("fingers" "l" "fw" "m"))
 list("XADC_XP6_XNI_XP" "sky130_fd_pr_main" "pfet_01v8" list(list("D" "XADC_XP6_NL") list("G" "XADC_XP6_NLB") list("S" "VDD") list("B" "VDD")) list(list("w" "2u") list("fw" "2u") list("l" "0.15u") list("fingers" "1") list("m" "1")) list("fingers" "l" "fw" "m"))
 list("XADC_XP6_XNI_XN" "sky130_fd_pr_main" "nfet_01v8" list(list("D" "XADC_XP6_NL") list("G" "XADC_XP6_NLB") list("S" "VSS") list("B" "VSS")) list(list("w" "1u") list("fw" "1u") list("l" "0.15u") list("fingers" "1") list("m" "1")) list("fingers" "l" "fw" "m"))
 list("XADC_XP6_XCM_XN" "sky130_fd_pr_main" "nfet_01v8_lvt" list(list("D" "INP") list("G" "ACQ") list("S" "XADC_BP6") list("B" "VSS")) list(list("w" "6.72u") list("fw" "6.72u") list("l" "0.15u") list("fingers" "1") list("m" "1")) list("fingers" "l" "fw" "m"))
 list("XADC_XP6_XCM_XP" "sky130_fd_pr_main" "pfet_01v8_lvt" list(list("D" "INP") list("G" "XADC_XP6_ACQB") list("S" "XADC_BP6") list("B" "VDD")) list(list("w" "13.44u") list("fw" "13.44u") list("l" "0.35u") list("fingers" "1") list("m" "1")) list("fingers" "l" "fw" "m"))
 list("XADC_XP6_XRP_XN" "sky130_fd_pr_main" "nfet_01v8_lvt" list(list("D" "RP") list("G" "XADC_XP6_PH") list("S" "XADC_BP6") list("B" "VSS")) list(list("w" "6.72u") list("fw" "6.72u") list("l" "0.15u") list("fingers" "1") list("m" "1")) list("fingers" "l" "fw" "m"))
 list("XADC_XP6_XRP_XP" "sky130_fd_pr_main" "pfet_01v8_lvt" list(list("D" "RP") list("G" "XADC_XP6_PHB") list("S" "XADC_BP6") list("B" "VDD")) list(list("w" "13.44u") list("fw" "13.44u") list("l" "0.35u") list("fingers" "1") list("m" "1")) list("fingers" "l" "fw" "m"))
 list("XADC_XP6_XRN_XN" "sky130_fd_pr_main" "nfet_01v8_lvt" list(list("D" "RN") list("G" "XADC_XP6_NL") list("S" "XADC_BP6") list("B" "VSS")) list(list("w" "6.72u") list("fw" "6.72u") list("l" "0.15u") list("fingers" "1") list("m" "1")) list("fingers" "l" "fw" "m"))
 list("XADC_XP6_XRN_XP" "sky130_fd_pr_main" "pfet_01v8_lvt" list(list("D" "RN") list("G" "XADC_XP6_NLB") list("S" "XADC_BP6") list("B" "VDD")) list(list("w" "13.44u") list("fw" "13.44u") list("l" "0.35u") list("fingers" "1") list("m" "1")) list("fingers" "l" "fw" "m"))
 list("XADC_XN6_XBI_XP" "sky130_fd_pr_main" "pfet_01v8" list(list("D" "XADC_XN6_BITB") list("G" "B6") list("S" "VDD") list("B" "VDD")) list(list("w" "2u") list("fw" "2u") list("l" "0.15u") list("fingers" "1") list("m" "1")) list("fingers" "l" "fw" "m"))
 list("XADC_XN6_XBI_XN" "sky130_fd_pr_main" "nfet_01v8" list(list("D" "XADC_XN6_BITB") list("G" "B6") list("S" "VSS") list("B" "VSS")) list(list("w" "1u") list("fw" "1u") list("l" "0.15u") list("fingers" "1") list("m" "1")) list("fingers" "l" "fw" "m"))
 list("XADC_XN6_XAI_XP" "sky130_fd_pr_main" "pfet_01v8" list(list("D" "XADC_XN6_ACQB") list("G" "ACQ") list("S" "VDD") list("B" "VDD")) list(list("w" "2u") list("fw" "2u") list("l" "0.15u") list("fingers" "1") list("m" "1")) list("fingers" "l" "fw" "m"))
 list("XADC_XN6_XAI_XN" "sky130_fd_pr_main" "nfet_01v8" list(list("D" "XADC_XN6_ACQB") list("G" "ACQ") list("S" "VSS") list("B" "VSS")) list(list("w" "1u") list("fw" "1u") list("l" "0.15u") list("fingers" "1") list("m" "1")) list("fingers" "l" "fw" "m"))
 list("XADC_XN6_XPH_XP1" "sky130_fd_pr_main" "pfet_01v8" list(list("D" "XADC_XN6_PHB") list("G" "CONV") list("S" "VDD") list("B" "VDD")) list(list("w" "2u") list("fw" "2u") list("l" "0.15u") list("fingers" "1") list("m" "1")) list("fingers" "l" "fw" "m"))
 list("XADC_XN6_XPH_XP2" "sky130_fd_pr_main" "pfet_01v8" list(list("D" "XADC_XN6_PHB") list("G" "B6") list("S" "VDD") list("B" "VDD")) list(list("w" "2u") list("fw" "2u") list("l" "0.15u") list("fingers" "1") list("m" "1")) list("fingers" "l" "fw" "m"))
 list("XADC_XN6_XPH_XN1" "sky130_fd_pr_main" "nfet_01v8" list(list("D" "XADC_XN6_PHB") list("G" "CONV") list("S" "XADC_XN6_XPH_MID") list("B" "VSS")) list(list("w" "2u") list("fw" "2u") list("l" "0.15u") list("fingers" "1") list("m" "1")) list("fingers" "l" "fw" "m"))
 list("XADC_XN6_XPH_XN2" "sky130_fd_pr_main" "nfet_01v8" list(list("D" "XADC_XN6_XPH_MID") list("G" "B6") list("S" "VSS") list("B" "VSS")) list(list("w" "2u") list("fw" "2u") list("l" "0.15u") list("fingers" "1") list("m" "1")) list("fingers" "l" "fw" "m"))
 list("XADC_XN6_XPI_XP" "sky130_fd_pr_main" "pfet_01v8" list(list("D" "XADC_XN6_PH") list("G" "XADC_XN6_PHB") list("S" "VDD") list("B" "VDD")) list(list("w" "2u") list("fw" "2u") list("l" "0.15u") list("fingers" "1") list("m" "1")) list("fingers" "l" "fw" "m"))
 list("XADC_XN6_XPI_XN" "sky130_fd_pr_main" "nfet_01v8" list(list("D" "XADC_XN6_PH") list("G" "XADC_XN6_PHB") list("S" "VSS") list("B" "VSS")) list(list("w" "1u") list("fw" "1u") list("l" "0.15u") list("fingers" "1") list("m" "1")) list("fingers" "l" "fw" "m"))
 list("XADC_XN6_XNL_XP1" "sky130_fd_pr_main" "pfet_01v8" list(list("D" "XADC_XN6_NLB") list("G" "CONV") list("S" "VDD") list("B" "VDD")) list(list("w" "2u") list("fw" "2u") list("l" "0.15u") list("fingers" "1") list("m" "1")) list("fingers" "l" "fw" "m"))
 list("XADC_XN6_XNL_XP2" "sky130_fd_pr_main" "pfet_01v8" list(list("D" "XADC_XN6_NLB") list("G" "XADC_XN6_BITB") list("S" "VDD") list("B" "VDD")) list(list("w" "2u") list("fw" "2u") list("l" "0.15u") list("fingers" "1") list("m" "1")) list("fingers" "l" "fw" "m"))
 list("XADC_XN6_XNL_XN1" "sky130_fd_pr_main" "nfet_01v8" list(list("D" "XADC_XN6_NLB") list("G" "CONV") list("S" "XADC_XN6_XNL_MID") list("B" "VSS")) list(list("w" "2u") list("fw" "2u") list("l" "0.15u") list("fingers" "1") list("m" "1")) list("fingers" "l" "fw" "m"))
 list("XADC_XN6_XNL_XN2" "sky130_fd_pr_main" "nfet_01v8" list(list("D" "XADC_XN6_XNL_MID") list("G" "XADC_XN6_BITB") list("S" "VSS") list("B" "VSS")) list(list("w" "2u") list("fw" "2u") list("l" "0.15u") list("fingers" "1") list("m" "1")) list("fingers" "l" "fw" "m"))
 list("XADC_XN6_XNI_XP" "sky130_fd_pr_main" "pfet_01v8" list(list("D" "XADC_XN6_NL") list("G" "XADC_XN6_NLB") list("S" "VDD") list("B" "VDD")) list(list("w" "2u") list("fw" "2u") list("l" "0.15u") list("fingers" "1") list("m" "1")) list("fingers" "l" "fw" "m"))
 list("XADC_XN6_XNI_XN" "sky130_fd_pr_main" "nfet_01v8" list(list("D" "XADC_XN6_NL") list("G" "XADC_XN6_NLB") list("S" "VSS") list("B" "VSS")) list(list("w" "1u") list("fw" "1u") list("l" "0.15u") list("fingers" "1") list("m" "1")) list("fingers" "l" "fw" "m"))
 list("XADC_XN6_XCM_XN" "sky130_fd_pr_main" "nfet_01v8_lvt" list(list("D" "INN") list("G" "ACQ") list("S" "XADC_BN6") list("B" "VSS")) list(list("w" "6.72u") list("fw" "6.72u") list("l" "0.15u") list("fingers" "1") list("m" "1")) list("fingers" "l" "fw" "m"))
 list("XADC_XN6_XCM_XP" "sky130_fd_pr_main" "pfet_01v8_lvt" list(list("D" "INN") list("G" "XADC_XN6_ACQB") list("S" "XADC_BN6") list("B" "VDD")) list(list("w" "13.44u") list("fw" "13.44u") list("l" "0.35u") list("fingers" "1") list("m" "1")) list("fingers" "l" "fw" "m"))
 list("XADC_XN6_XRP_XN" "sky130_fd_pr_main" "nfet_01v8_lvt" list(list("D" "RN") list("G" "XADC_XN6_PH") list("S" "XADC_BN6") list("B" "VSS")) list(list("w" "6.72u") list("fw" "6.72u") list("l" "0.15u") list("fingers" "1") list("m" "1")) list("fingers" "l" "fw" "m"))
 list("XADC_XN6_XRP_XP" "sky130_fd_pr_main" "pfet_01v8_lvt" list(list("D" "RN") list("G" "XADC_XN6_PHB") list("S" "XADC_BN6") list("B" "VDD")) list(list("w" "13.44u") list("fw" "13.44u") list("l" "0.35u") list("fingers" "1") list("m" "1")) list("fingers" "l" "fw" "m"))
 list("XADC_XN6_XRN_XN" "sky130_fd_pr_main" "nfet_01v8_lvt" list(list("D" "RP") list("G" "XADC_XN6_NL") list("S" "XADC_BN6") list("B" "VSS")) list(list("w" "6.72u") list("fw" "6.72u") list("l" "0.15u") list("fingers" "1") list("m" "1")) list("fingers" "l" "fw" "m"))
 list("XADC_XN6_XRN_XP" "sky130_fd_pr_main" "pfet_01v8_lvt" list(list("D" "RP") list("G" "XADC_XN6_NLB") list("S" "XADC_BN6") list("B" "VDD")) list(list("w" "13.44u") list("fw" "13.44u") list("l" "0.35u") list("fingers" "1") list("m" "1")) list("fingers" "l" "fw" "m"))
 list("XADC_XP7_XBI_XP" "sky130_fd_pr_main" "pfet_01v8" list(list("D" "XADC_XP7_BITB") list("G" "B7") list("S" "VDD") list("B" "VDD")) list(list("w" "2u") list("fw" "2u") list("l" "0.15u") list("fingers" "1") list("m" "1")) list("fingers" "l" "fw" "m"))
 list("XADC_XP7_XBI_XN" "sky130_fd_pr_main" "nfet_01v8" list(list("D" "XADC_XP7_BITB") list("G" "B7") list("S" "VSS") list("B" "VSS")) list(list("w" "1u") list("fw" "1u") list("l" "0.15u") list("fingers" "1") list("m" "1")) list("fingers" "l" "fw" "m"))
 list("XADC_XP7_XAI_XP" "sky130_fd_pr_main" "pfet_01v8" list(list("D" "XADC_XP7_ACQB") list("G" "ACQ") list("S" "VDD") list("B" "VDD")) list(list("w" "2u") list("fw" "2u") list("l" "0.15u") list("fingers" "1") list("m" "1")) list("fingers" "l" "fw" "m"))
 list("XADC_XP7_XAI_XN" "sky130_fd_pr_main" "nfet_01v8" list(list("D" "XADC_XP7_ACQB") list("G" "ACQ") list("S" "VSS") list("B" "VSS")) list(list("w" "1u") list("fw" "1u") list("l" "0.15u") list("fingers" "1") list("m" "1")) list("fingers" "l" "fw" "m"))
 list("XADC_XP7_XPH_XP1" "sky130_fd_pr_main" "pfet_01v8" list(list("D" "XADC_XP7_PHB") list("G" "CONV") list("S" "VDD") list("B" "VDD")) list(list("w" "2u") list("fw" "2u") list("l" "0.15u") list("fingers" "1") list("m" "1")) list("fingers" "l" "fw" "m"))
 list("XADC_XP7_XPH_XP2" "sky130_fd_pr_main" "pfet_01v8" list(list("D" "XADC_XP7_PHB") list("G" "B7") list("S" "VDD") list("B" "VDD")) list(list("w" "2u") list("fw" "2u") list("l" "0.15u") list("fingers" "1") list("m" "1")) list("fingers" "l" "fw" "m"))
 list("XADC_XP7_XPH_XN1" "sky130_fd_pr_main" "nfet_01v8" list(list("D" "XADC_XP7_PHB") list("G" "CONV") list("S" "XADC_XP7_XPH_MID") list("B" "VSS")) list(list("w" "2u") list("fw" "2u") list("l" "0.15u") list("fingers" "1") list("m" "1")) list("fingers" "l" "fw" "m"))
 list("XADC_XP7_XPH_XN2" "sky130_fd_pr_main" "nfet_01v8" list(list("D" "XADC_XP7_XPH_MID") list("G" "B7") list("S" "VSS") list("B" "VSS")) list(list("w" "2u") list("fw" "2u") list("l" "0.15u") list("fingers" "1") list("m" "1")) list("fingers" "l" "fw" "m"))
 list("XADC_XP7_XPI_XP" "sky130_fd_pr_main" "pfet_01v8" list(list("D" "XADC_XP7_PH") list("G" "XADC_XP7_PHB") list("S" "VDD") list("B" "VDD")) list(list("w" "2u") list("fw" "2u") list("l" "0.15u") list("fingers" "1") list("m" "1")) list("fingers" "l" "fw" "m"))
 list("XADC_XP7_XPI_XN" "sky130_fd_pr_main" "nfet_01v8" list(list("D" "XADC_XP7_PH") list("G" "XADC_XP7_PHB") list("S" "VSS") list("B" "VSS")) list(list("w" "1u") list("fw" "1u") list("l" "0.15u") list("fingers" "1") list("m" "1")) list("fingers" "l" "fw" "m"))
 list("XADC_XP7_XNL_XP1" "sky130_fd_pr_main" "pfet_01v8" list(list("D" "XADC_XP7_NLB") list("G" "CONV") list("S" "VDD") list("B" "VDD")) list(list("w" "2u") list("fw" "2u") list("l" "0.15u") list("fingers" "1") list("m" "1")) list("fingers" "l" "fw" "m"))
 list("XADC_XP7_XNL_XP2" "sky130_fd_pr_main" "pfet_01v8" list(list("D" "XADC_XP7_NLB") list("G" "XADC_XP7_BITB") list("S" "VDD") list("B" "VDD")) list(list("w" "2u") list("fw" "2u") list("l" "0.15u") list("fingers" "1") list("m" "1")) list("fingers" "l" "fw" "m"))
 list("XADC_XP7_XNL_XN1" "sky130_fd_pr_main" "nfet_01v8" list(list("D" "XADC_XP7_NLB") list("G" "CONV") list("S" "XADC_XP7_XNL_MID") list("B" "VSS")) list(list("w" "2u") list("fw" "2u") list("l" "0.15u") list("fingers" "1") list("m" "1")) list("fingers" "l" "fw" "m"))
 list("XADC_XP7_XNL_XN2" "sky130_fd_pr_main" "nfet_01v8" list(list("D" "XADC_XP7_XNL_MID") list("G" "XADC_XP7_BITB") list("S" "VSS") list("B" "VSS")) list(list("w" "2u") list("fw" "2u") list("l" "0.15u") list("fingers" "1") list("m" "1")) list("fingers" "l" "fw" "m"))
 list("XADC_XP7_XNI_XP" "sky130_fd_pr_main" "pfet_01v8" list(list("D" "XADC_XP7_NL") list("G" "XADC_XP7_NLB") list("S" "VDD") list("B" "VDD")) list(list("w" "2u") list("fw" "2u") list("l" "0.15u") list("fingers" "1") list("m" "1")) list("fingers" "l" "fw" "m"))
 list("XADC_XP7_XNI_XN" "sky130_fd_pr_main" "nfet_01v8" list(list("D" "XADC_XP7_NL") list("G" "XADC_XP7_NLB") list("S" "VSS") list("B" "VSS")) list(list("w" "1u") list("fw" "1u") list("l" "0.15u") list("fingers" "1") list("m" "1")) list("fingers" "l" "fw" "m"))
 list("XADC_XP7_XCM_XN" "sky130_fd_pr_main" "nfet_01v8_lvt" list(list("D" "INP") list("G" "ACQ") list("S" "XADC_BP7") list("B" "VSS")) list(list("w" "9.505u") list("fw" "9.505u") list("l" "0.15u") list("fingers" "1") list("m" "1")) list("fingers" "l" "fw" "m"))
 list("XADC_XP7_XCM_XP" "sky130_fd_pr_main" "pfet_01v8_lvt" list(list("D" "INP") list("G" "XADC_XP7_ACQB") list("S" "XADC_BP7") list("B" "VDD")) list(list("w" "19.005u") list("fw" "19.005u") list("l" "0.35u") list("fingers" "1") list("m" "1")) list("fingers" "l" "fw" "m"))
 list("XADC_XP7_XRP_XN" "sky130_fd_pr_main" "nfet_01v8_lvt" list(list("D" "RP") list("G" "XADC_XP7_PH") list("S" "XADC_BP7") list("B" "VSS")) list(list("w" "9.505u") list("fw" "9.505u") list("l" "0.15u") list("fingers" "1") list("m" "1")) list("fingers" "l" "fw" "m"))
 list("XADC_XP7_XRP_XP" "sky130_fd_pr_main" "pfet_01v8_lvt" list(list("D" "RP") list("G" "XADC_XP7_PHB") list("S" "XADC_BP7") list("B" "VDD")) list(list("w" "19.005u") list("fw" "19.005u") list("l" "0.35u") list("fingers" "1") list("m" "1")) list("fingers" "l" "fw" "m"))
 list("XADC_XP7_XRN_XN" "sky130_fd_pr_main" "nfet_01v8_lvt" list(list("D" "RN") list("G" "XADC_XP7_NL") list("S" "XADC_BP7") list("B" "VSS")) list(list("w" "9.505u") list("fw" "9.505u") list("l" "0.15u") list("fingers" "1") list("m" "1")) list("fingers" "l" "fw" "m"))
 list("XADC_XP7_XRN_XP" "sky130_fd_pr_main" "pfet_01v8_lvt" list(list("D" "RN") list("G" "XADC_XP7_NLB") list("S" "XADC_BP7") list("B" "VDD")) list(list("w" "19.005u") list("fw" "19.005u") list("l" "0.35u") list("fingers" "1") list("m" "1")) list("fingers" "l" "fw" "m"))
 list("XADC_XN7_XBI_XP" "sky130_fd_pr_main" "pfet_01v8" list(list("D" "XADC_XN7_BITB") list("G" "B7") list("S" "VDD") list("B" "VDD")) list(list("w" "2u") list("fw" "2u") list("l" "0.15u") list("fingers" "1") list("m" "1")) list("fingers" "l" "fw" "m"))
 list("XADC_XN7_XBI_XN" "sky130_fd_pr_main" "nfet_01v8" list(list("D" "XADC_XN7_BITB") list("G" "B7") list("S" "VSS") list("B" "VSS")) list(list("w" "1u") list("fw" "1u") list("l" "0.15u") list("fingers" "1") list("m" "1")) list("fingers" "l" "fw" "m"))
 list("XADC_XN7_XAI_XP" "sky130_fd_pr_main" "pfet_01v8" list(list("D" "XADC_XN7_ACQB") list("G" "ACQ") list("S" "VDD") list("B" "VDD")) list(list("w" "2u") list("fw" "2u") list("l" "0.15u") list("fingers" "1") list("m" "1")) list("fingers" "l" "fw" "m"))
 list("XADC_XN7_XAI_XN" "sky130_fd_pr_main" "nfet_01v8" list(list("D" "XADC_XN7_ACQB") list("G" "ACQ") list("S" "VSS") list("B" "VSS")) list(list("w" "1u") list("fw" "1u") list("l" "0.15u") list("fingers" "1") list("m" "1")) list("fingers" "l" "fw" "m"))
 list("XADC_XN7_XPH_XP1" "sky130_fd_pr_main" "pfet_01v8" list(list("D" "XADC_XN7_PHB") list("G" "CONV") list("S" "VDD") list("B" "VDD")) list(list("w" "2u") list("fw" "2u") list("l" "0.15u") list("fingers" "1") list("m" "1")) list("fingers" "l" "fw" "m"))
 list("XADC_XN7_XPH_XP2" "sky130_fd_pr_main" "pfet_01v8" list(list("D" "XADC_XN7_PHB") list("G" "B7") list("S" "VDD") list("B" "VDD")) list(list("w" "2u") list("fw" "2u") list("l" "0.15u") list("fingers" "1") list("m" "1")) list("fingers" "l" "fw" "m"))
 list("XADC_XN7_XPH_XN1" "sky130_fd_pr_main" "nfet_01v8" list(list("D" "XADC_XN7_PHB") list("G" "CONV") list("S" "XADC_XN7_XPH_MID") list("B" "VSS")) list(list("w" "2u") list("fw" "2u") list("l" "0.15u") list("fingers" "1") list("m" "1")) list("fingers" "l" "fw" "m"))
 list("XADC_XN7_XPH_XN2" "sky130_fd_pr_main" "nfet_01v8" list(list("D" "XADC_XN7_XPH_MID") list("G" "B7") list("S" "VSS") list("B" "VSS")) list(list("w" "2u") list("fw" "2u") list("l" "0.15u") list("fingers" "1") list("m" "1")) list("fingers" "l" "fw" "m"))
 list("XADC_XN7_XPI_XP" "sky130_fd_pr_main" "pfet_01v8" list(list("D" "XADC_XN7_PH") list("G" "XADC_XN7_PHB") list("S" "VDD") list("B" "VDD")) list(list("w" "2u") list("fw" "2u") list("l" "0.15u") list("fingers" "1") list("m" "1")) list("fingers" "l" "fw" "m"))
 list("XADC_XN7_XPI_XN" "sky130_fd_pr_main" "nfet_01v8" list(list("D" "XADC_XN7_PH") list("G" "XADC_XN7_PHB") list("S" "VSS") list("B" "VSS")) list(list("w" "1u") list("fw" "1u") list("l" "0.15u") list("fingers" "1") list("m" "1")) list("fingers" "l" "fw" "m"))
 list("XADC_XN7_XNL_XP1" "sky130_fd_pr_main" "pfet_01v8" list(list("D" "XADC_XN7_NLB") list("G" "CONV") list("S" "VDD") list("B" "VDD")) list(list("w" "2u") list("fw" "2u") list("l" "0.15u") list("fingers" "1") list("m" "1")) list("fingers" "l" "fw" "m"))
 list("XADC_XN7_XNL_XP2" "sky130_fd_pr_main" "pfet_01v8" list(list("D" "XADC_XN7_NLB") list("G" "XADC_XN7_BITB") list("S" "VDD") list("B" "VDD")) list(list("w" "2u") list("fw" "2u") list("l" "0.15u") list("fingers" "1") list("m" "1")) list("fingers" "l" "fw" "m"))
 list("XADC_XN7_XNL_XN1" "sky130_fd_pr_main" "nfet_01v8" list(list("D" "XADC_XN7_NLB") list("G" "CONV") list("S" "XADC_XN7_XNL_MID") list("B" "VSS")) list(list("w" "2u") list("fw" "2u") list("l" "0.15u") list("fingers" "1") list("m" "1")) list("fingers" "l" "fw" "m"))
 list("XADC_XN7_XNL_XN2" "sky130_fd_pr_main" "nfet_01v8" list(list("D" "XADC_XN7_XNL_MID") list("G" "XADC_XN7_BITB") list("S" "VSS") list("B" "VSS")) list(list("w" "2u") list("fw" "2u") list("l" "0.15u") list("fingers" "1") list("m" "1")) list("fingers" "l" "fw" "m"))
 list("XADC_XN7_XNI_XP" "sky130_fd_pr_main" "pfet_01v8" list(list("D" "XADC_XN7_NL") list("G" "XADC_XN7_NLB") list("S" "VDD") list("B" "VDD")) list(list("w" "2u") list("fw" "2u") list("l" "0.15u") list("fingers" "1") list("m" "1")) list("fingers" "l" "fw" "m"))
 list("XADC_XN7_XNI_XN" "sky130_fd_pr_main" "nfet_01v8" list(list("D" "XADC_XN7_NL") list("G" "XADC_XN7_NLB") list("S" "VSS") list("B" "VSS")) list(list("w" "1u") list("fw" "1u") list("l" "0.15u") list("fingers" "1") list("m" "1")) list("fingers" "l" "fw" "m"))
 list("XADC_XN7_XCM_XN" "sky130_fd_pr_main" "nfet_01v8_lvt" list(list("D" "INN") list("G" "ACQ") list("S" "XADC_BN7") list("B" "VSS")) list(list("w" "9.505u") list("fw" "9.505u") list("l" "0.15u") list("fingers" "1") list("m" "1")) list("fingers" "l" "fw" "m"))
 list("XADC_XN7_XCM_XP" "sky130_fd_pr_main" "pfet_01v8_lvt" list(list("D" "INN") list("G" "XADC_XN7_ACQB") list("S" "XADC_BN7") list("B" "VDD")) list(list("w" "19.005u") list("fw" "19.005u") list("l" "0.35u") list("fingers" "1") list("m" "1")) list("fingers" "l" "fw" "m"))
 list("XADC_XN7_XRP_XN" "sky130_fd_pr_main" "nfet_01v8_lvt" list(list("D" "RN") list("G" "XADC_XN7_PH") list("S" "XADC_BN7") list("B" "VSS")) list(list("w" "9.505u") list("fw" "9.505u") list("l" "0.15u") list("fingers" "1") list("m" "1")) list("fingers" "l" "fw" "m"))
 list("XADC_XN7_XRP_XP" "sky130_fd_pr_main" "pfet_01v8_lvt" list(list("D" "RN") list("G" "XADC_XN7_PHB") list("S" "XADC_BN7") list("B" "VDD")) list(list("w" "19.005u") list("fw" "19.005u") list("l" "0.35u") list("fingers" "1") list("m" "1")) list("fingers" "l" "fw" "m"))
 list("XADC_XN7_XRN_XN" "sky130_fd_pr_main" "nfet_01v8_lvt" list(list("D" "RP") list("G" "XADC_XN7_NL") list("S" "XADC_BN7") list("B" "VSS")) list(list("w" "9.505u") list("fw" "9.505u") list("l" "0.15u") list("fingers" "1") list("m" "1")) list("fingers" "l" "fw" "m"))
 list("XADC_XN7_XRN_XP" "sky130_fd_pr_main" "pfet_01v8_lvt" list(list("D" "RP") list("G" "XADC_XN7_NLB") list("S" "XADC_BN7") list("B" "VDD")) list(list("w" "19.005u") list("fw" "19.005u") list("l" "0.35u") list("fingers" "1") list("m" "1")) list("fingers" "l" "fw" "m"))
 list("XADC_XP8_XBI_XP" "sky130_fd_pr_main" "pfet_01v8" list(list("D" "XADC_XP8_BITB") list("G" "B8") list("S" "VDD") list("B" "VDD")) list(list("w" "2u") list("fw" "2u") list("l" "0.15u") list("fingers" "1") list("m" "1")) list("fingers" "l" "fw" "m"))
 list("XADC_XP8_XBI_XN" "sky130_fd_pr_main" "nfet_01v8" list(list("D" "XADC_XP8_BITB") list("G" "B8") list("S" "VSS") list("B" "VSS")) list(list("w" "1u") list("fw" "1u") list("l" "0.15u") list("fingers" "1") list("m" "1")) list("fingers" "l" "fw" "m"))
 list("XADC_XP8_XAI_XP" "sky130_fd_pr_main" "pfet_01v8" list(list("D" "XADC_XP8_ACQB") list("G" "ACQ") list("S" "VDD") list("B" "VDD")) list(list("w" "2u") list("fw" "2u") list("l" "0.15u") list("fingers" "1") list("m" "1")) list("fingers" "l" "fw" "m"))
 list("XADC_XP8_XAI_XN" "sky130_fd_pr_main" "nfet_01v8" list(list("D" "XADC_XP8_ACQB") list("G" "ACQ") list("S" "VSS") list("B" "VSS")) list(list("w" "1u") list("fw" "1u") list("l" "0.15u") list("fingers" "1") list("m" "1")) list("fingers" "l" "fw" "m"))
 list("XADC_XP8_XPH_XP1" "sky130_fd_pr_main" "pfet_01v8" list(list("D" "XADC_XP8_PHB") list("G" "CONV") list("S" "VDD") list("B" "VDD")) list(list("w" "2u") list("fw" "2u") list("l" "0.15u") list("fingers" "1") list("m" "1")) list("fingers" "l" "fw" "m"))
 list("XADC_XP8_XPH_XP2" "sky130_fd_pr_main" "pfet_01v8" list(list("D" "XADC_XP8_PHB") list("G" "B8") list("S" "VDD") list("B" "VDD")) list(list("w" "2u") list("fw" "2u") list("l" "0.15u") list("fingers" "1") list("m" "1")) list("fingers" "l" "fw" "m"))
 list("XADC_XP8_XPH_XN1" "sky130_fd_pr_main" "nfet_01v8" list(list("D" "XADC_XP8_PHB") list("G" "CONV") list("S" "XADC_XP8_XPH_MID") list("B" "VSS")) list(list("w" "2u") list("fw" "2u") list("l" "0.15u") list("fingers" "1") list("m" "1")) list("fingers" "l" "fw" "m"))
 list("XADC_XP8_XPH_XN2" "sky130_fd_pr_main" "nfet_01v8" list(list("D" "XADC_XP8_XPH_MID") list("G" "B8") list("S" "VSS") list("B" "VSS")) list(list("w" "2u") list("fw" "2u") list("l" "0.15u") list("fingers" "1") list("m" "1")) list("fingers" "l" "fw" "m"))
 list("XADC_XP8_XPI_XP" "sky130_fd_pr_main" "pfet_01v8" list(list("D" "XADC_XP8_PH") list("G" "XADC_XP8_PHB") list("S" "VDD") list("B" "VDD")) list(list("w" "2u") list("fw" "2u") list("l" "0.15u") list("fingers" "1") list("m" "1")) list("fingers" "l" "fw" "m"))
 list("XADC_XP8_XPI_XN" "sky130_fd_pr_main" "nfet_01v8" list(list("D" "XADC_XP8_PH") list("G" "XADC_XP8_PHB") list("S" "VSS") list("B" "VSS")) list(list("w" "1u") list("fw" "1u") list("l" "0.15u") list("fingers" "1") list("m" "1")) list("fingers" "l" "fw" "m"))
 list("XADC_XP8_XNL_XP1" "sky130_fd_pr_main" "pfet_01v8" list(list("D" "XADC_XP8_NLB") list("G" "CONV") list("S" "VDD") list("B" "VDD")) list(list("w" "2u") list("fw" "2u") list("l" "0.15u") list("fingers" "1") list("m" "1")) list("fingers" "l" "fw" "m"))
 list("XADC_XP8_XNL_XP2" "sky130_fd_pr_main" "pfet_01v8" list(list("D" "XADC_XP8_NLB") list("G" "XADC_XP8_BITB") list("S" "VDD") list("B" "VDD")) list(list("w" "2u") list("fw" "2u") list("l" "0.15u") list("fingers" "1") list("m" "1")) list("fingers" "l" "fw" "m"))
 list("XADC_XP8_XNL_XN1" "sky130_fd_pr_main" "nfet_01v8" list(list("D" "XADC_XP8_NLB") list("G" "CONV") list("S" "XADC_XP8_XNL_MID") list("B" "VSS")) list(list("w" "2u") list("fw" "2u") list("l" "0.15u") list("fingers" "1") list("m" "1")) list("fingers" "l" "fw" "m"))
 list("XADC_XP8_XNL_XN2" "sky130_fd_pr_main" "nfet_01v8" list(list("D" "XADC_XP8_XNL_MID") list("G" "XADC_XP8_BITB") list("S" "VSS") list("B" "VSS")) list(list("w" "2u") list("fw" "2u") list("l" "0.15u") list("fingers" "1") list("m" "1")) list("fingers" "l" "fw" "m"))
 list("XADC_XP8_XNI_XP" "sky130_fd_pr_main" "pfet_01v8" list(list("D" "XADC_XP8_NL") list("G" "XADC_XP8_NLB") list("S" "VDD") list("B" "VDD")) list(list("w" "2u") list("fw" "2u") list("l" "0.15u") list("fingers" "1") list("m" "1")) list("fingers" "l" "fw" "m"))
 list("XADC_XP8_XNI_XN" "sky130_fd_pr_main" "nfet_01v8" list(list("D" "XADC_XP8_NL") list("G" "XADC_XP8_NLB") list("S" "VSS") list("B" "VSS")) list(list("w" "1u") list("fw" "1u") list("l" "0.15u") list("fingers" "1") list("m" "1")) list("fingers" "l" "fw" "m"))
 list("XADC_XP8_XCM_XN" "sky130_fd_pr_main" "nfet_01v8_lvt" list(list("D" "INP") list("G" "ACQ") list("S" "XADC_BP8") list("B" "VSS")) list(list("w" "13.44u") list("fw" "13.44u") list("l" "0.15u") list("fingers" "1") list("m" "1")) list("fingers" "l" "fw" "m"))
 list("XADC_XP8_XCM_XP" "sky130_fd_pr_main" "pfet_01v8_lvt" list(list("D" "INP") list("G" "XADC_XP8_ACQB") list("S" "XADC_BP8") list("B" "VDD")) list(list("w" "26.88u") list("fw" "26.88u") list("l" "0.35u") list("fingers" "1") list("m" "1")) list("fingers" "l" "fw" "m"))
 list("XADC_XP8_XRP_XN" "sky130_fd_pr_main" "nfet_01v8_lvt" list(list("D" "RP") list("G" "XADC_XP8_PH") list("S" "XADC_BP8") list("B" "VSS")) list(list("w" "13.44u") list("fw" "13.44u") list("l" "0.15u") list("fingers" "1") list("m" "1")) list("fingers" "l" "fw" "m"))
 list("XADC_XP8_XRP_XP" "sky130_fd_pr_main" "pfet_01v8_lvt" list(list("D" "RP") list("G" "XADC_XP8_PHB") list("S" "XADC_BP8") list("B" "VDD")) list(list("w" "26.88u") list("fw" "26.88u") list("l" "0.35u") list("fingers" "1") list("m" "1")) list("fingers" "l" "fw" "m"))
 list("XADC_XP8_XRN_XN" "sky130_fd_pr_main" "nfet_01v8_lvt" list(list("D" "RN") list("G" "XADC_XP8_NL") list("S" "XADC_BP8") list("B" "VSS")) list(list("w" "13.44u") list("fw" "13.44u") list("l" "0.15u") list("fingers" "1") list("m" "1")) list("fingers" "l" "fw" "m"))
 list("XADC_XP8_XRN_XP" "sky130_fd_pr_main" "pfet_01v8_lvt" list(list("D" "RN") list("G" "XADC_XP8_NLB") list("S" "XADC_BP8") list("B" "VDD")) list(list("w" "26.88u") list("fw" "26.88u") list("l" "0.35u") list("fingers" "1") list("m" "1")) list("fingers" "l" "fw" "m"))
 list("XADC_XN8_XBI_XP" "sky130_fd_pr_main" "pfet_01v8" list(list("D" "XADC_XN8_BITB") list("G" "B8") list("S" "VDD") list("B" "VDD")) list(list("w" "2u") list("fw" "2u") list("l" "0.15u") list("fingers" "1") list("m" "1")) list("fingers" "l" "fw" "m"))
 list("XADC_XN8_XBI_XN" "sky130_fd_pr_main" "nfet_01v8" list(list("D" "XADC_XN8_BITB") list("G" "B8") list("S" "VSS") list("B" "VSS")) list(list("w" "1u") list("fw" "1u") list("l" "0.15u") list("fingers" "1") list("m" "1")) list("fingers" "l" "fw" "m"))
 list("XADC_XN8_XAI_XP" "sky130_fd_pr_main" "pfet_01v8" list(list("D" "XADC_XN8_ACQB") list("G" "ACQ") list("S" "VDD") list("B" "VDD")) list(list("w" "2u") list("fw" "2u") list("l" "0.15u") list("fingers" "1") list("m" "1")) list("fingers" "l" "fw" "m"))
 list("XADC_XN8_XAI_XN" "sky130_fd_pr_main" "nfet_01v8" list(list("D" "XADC_XN8_ACQB") list("G" "ACQ") list("S" "VSS") list("B" "VSS")) list(list("w" "1u") list("fw" "1u") list("l" "0.15u") list("fingers" "1") list("m" "1")) list("fingers" "l" "fw" "m"))
 list("XADC_XN8_XPH_XP1" "sky130_fd_pr_main" "pfet_01v8" list(list("D" "XADC_XN8_PHB") list("G" "CONV") list("S" "VDD") list("B" "VDD")) list(list("w" "2u") list("fw" "2u") list("l" "0.15u") list("fingers" "1") list("m" "1")) list("fingers" "l" "fw" "m"))
 list("XADC_XN8_XPH_XP2" "sky130_fd_pr_main" "pfet_01v8" list(list("D" "XADC_XN8_PHB") list("G" "B8") list("S" "VDD") list("B" "VDD")) list(list("w" "2u") list("fw" "2u") list("l" "0.15u") list("fingers" "1") list("m" "1")) list("fingers" "l" "fw" "m"))
 list("XADC_XN8_XPH_XN1" "sky130_fd_pr_main" "nfet_01v8" list(list("D" "XADC_XN8_PHB") list("G" "CONV") list("S" "XADC_XN8_XPH_MID") list("B" "VSS")) list(list("w" "2u") list("fw" "2u") list("l" "0.15u") list("fingers" "1") list("m" "1")) list("fingers" "l" "fw" "m"))
 list("XADC_XN8_XPH_XN2" "sky130_fd_pr_main" "nfet_01v8" list(list("D" "XADC_XN8_XPH_MID") list("G" "B8") list("S" "VSS") list("B" "VSS")) list(list("w" "2u") list("fw" "2u") list("l" "0.15u") list("fingers" "1") list("m" "1")) list("fingers" "l" "fw" "m"))
 list("XADC_XN8_XPI_XP" "sky130_fd_pr_main" "pfet_01v8" list(list("D" "XADC_XN8_PH") list("G" "XADC_XN8_PHB") list("S" "VDD") list("B" "VDD")) list(list("w" "2u") list("fw" "2u") list("l" "0.15u") list("fingers" "1") list("m" "1")) list("fingers" "l" "fw" "m"))
 list("XADC_XN8_XPI_XN" "sky130_fd_pr_main" "nfet_01v8" list(list("D" "XADC_XN8_PH") list("G" "XADC_XN8_PHB") list("S" "VSS") list("B" "VSS")) list(list("w" "1u") list("fw" "1u") list("l" "0.15u") list("fingers" "1") list("m" "1")) list("fingers" "l" "fw" "m"))
 list("XADC_XN8_XNL_XP1" "sky130_fd_pr_main" "pfet_01v8" list(list("D" "XADC_XN8_NLB") list("G" "CONV") list("S" "VDD") list("B" "VDD")) list(list("w" "2u") list("fw" "2u") list("l" "0.15u") list("fingers" "1") list("m" "1")) list("fingers" "l" "fw" "m"))
 list("XADC_XN8_XNL_XP2" "sky130_fd_pr_main" "pfet_01v8" list(list("D" "XADC_XN8_NLB") list("G" "XADC_XN8_BITB") list("S" "VDD") list("B" "VDD")) list(list("w" "2u") list("fw" "2u") list("l" "0.15u") list("fingers" "1") list("m" "1")) list("fingers" "l" "fw" "m"))
 list("XADC_XN8_XNL_XN1" "sky130_fd_pr_main" "nfet_01v8" list(list("D" "XADC_XN8_NLB") list("G" "CONV") list("S" "XADC_XN8_XNL_MID") list("B" "VSS")) list(list("w" "2u") list("fw" "2u") list("l" "0.15u") list("fingers" "1") list("m" "1")) list("fingers" "l" "fw" "m"))
 list("XADC_XN8_XNL_XN2" "sky130_fd_pr_main" "nfet_01v8" list(list("D" "XADC_XN8_XNL_MID") list("G" "XADC_XN8_BITB") list("S" "VSS") list("B" "VSS")) list(list("w" "2u") list("fw" "2u") list("l" "0.15u") list("fingers" "1") list("m" "1")) list("fingers" "l" "fw" "m"))
 list("XADC_XN8_XNI_XP" "sky130_fd_pr_main" "pfet_01v8" list(list("D" "XADC_XN8_NL") list("G" "XADC_XN8_NLB") list("S" "VDD") list("B" "VDD")) list(list("w" "2u") list("fw" "2u") list("l" "0.15u") list("fingers" "1") list("m" "1")) list("fingers" "l" "fw" "m"))
 list("XADC_XN8_XNI_XN" "sky130_fd_pr_main" "nfet_01v8" list(list("D" "XADC_XN8_NL") list("G" "XADC_XN8_NLB") list("S" "VSS") list("B" "VSS")) list(list("w" "1u") list("fw" "1u") list("l" "0.15u") list("fingers" "1") list("m" "1")) list("fingers" "l" "fw" "m"))
 list("XADC_XN8_XCM_XN" "sky130_fd_pr_main" "nfet_01v8_lvt" list(list("D" "INN") list("G" "ACQ") list("S" "XADC_BN8") list("B" "VSS")) list(list("w" "13.44u") list("fw" "13.44u") list("l" "0.15u") list("fingers" "1") list("m" "1")) list("fingers" "l" "fw" "m"))
 list("XADC_XN8_XCM_XP" "sky130_fd_pr_main" "pfet_01v8_lvt" list(list("D" "INN") list("G" "XADC_XN8_ACQB") list("S" "XADC_BN8") list("B" "VDD")) list(list("w" "26.88u") list("fw" "26.88u") list("l" "0.35u") list("fingers" "1") list("m" "1")) list("fingers" "l" "fw" "m"))
 list("XADC_XN8_XRP_XN" "sky130_fd_pr_main" "nfet_01v8_lvt" list(list("D" "RN") list("G" "XADC_XN8_PH") list("S" "XADC_BN8") list("B" "VSS")) list(list("w" "13.44u") list("fw" "13.44u") list("l" "0.15u") list("fingers" "1") list("m" "1")) list("fingers" "l" "fw" "m"))
 list("XADC_XN8_XRP_XP" "sky130_fd_pr_main" "pfet_01v8_lvt" list(list("D" "RN") list("G" "XADC_XN8_PHB") list("S" "XADC_BN8") list("B" "VDD")) list(list("w" "26.88u") list("fw" "26.88u") list("l" "0.35u") list("fingers" "1") list("m" "1")) list("fingers" "l" "fw" "m"))
 list("XADC_XN8_XRN_XN" "sky130_fd_pr_main" "nfet_01v8_lvt" list(list("D" "RP") list("G" "XADC_XN8_NL") list("S" "XADC_BN8") list("B" "VSS")) list(list("w" "13.44u") list("fw" "13.44u") list("l" "0.15u") list("fingers" "1") list("m" "1")) list("fingers" "l" "fw" "m"))
 list("XADC_XN8_XRN_XP" "sky130_fd_pr_main" "pfet_01v8_lvt" list(list("D" "RP") list("G" "XADC_XN8_NLB") list("S" "XADC_BN8") list("B" "VDD")) list(list("w" "26.88u") list("fw" "26.88u") list("l" "0.35u") list("fingers" "1") list("m" "1")) list("fingers" "l" "fw" "m"))
 list("XADC_XP9_XBI_XP" "sky130_fd_pr_main" "pfet_01v8" list(list("D" "XADC_XP9_BITB") list("G" "B9") list("S" "VDD") list("B" "VDD")) list(list("w" "2u") list("fw" "2u") list("l" "0.15u") list("fingers" "1") list("m" "1")) list("fingers" "l" "fw" "m"))
 list("XADC_XP9_XBI_XN" "sky130_fd_pr_main" "nfet_01v8" list(list("D" "XADC_XP9_BITB") list("G" "B9") list("S" "VSS") list("B" "VSS")) list(list("w" "1u") list("fw" "1u") list("l" "0.15u") list("fingers" "1") list("m" "1")) list("fingers" "l" "fw" "m"))
 list("XADC_XP9_XAI_XP" "sky130_fd_pr_main" "pfet_01v8" list(list("D" "XADC_XP9_ACQB") list("G" "ACQ") list("S" "VDD") list("B" "VDD")) list(list("w" "2u") list("fw" "2u") list("l" "0.15u") list("fingers" "1") list("m" "1")) list("fingers" "l" "fw" "m"))
 list("XADC_XP9_XAI_XN" "sky130_fd_pr_main" "nfet_01v8" list(list("D" "XADC_XP9_ACQB") list("G" "ACQ") list("S" "VSS") list("B" "VSS")) list(list("w" "1u") list("fw" "1u") list("l" "0.15u") list("fingers" "1") list("m" "1")) list("fingers" "l" "fw" "m"))
 list("XADC_XP9_XPH_XP1" "sky130_fd_pr_main" "pfet_01v8" list(list("D" "XADC_XP9_PHB") list("G" "CONV") list("S" "VDD") list("B" "VDD")) list(list("w" "2u") list("fw" "2u") list("l" "0.15u") list("fingers" "1") list("m" "1")) list("fingers" "l" "fw" "m"))
 list("XADC_XP9_XPH_XP2" "sky130_fd_pr_main" "pfet_01v8" list(list("D" "XADC_XP9_PHB") list("G" "B9") list("S" "VDD") list("B" "VDD")) list(list("w" "2u") list("fw" "2u") list("l" "0.15u") list("fingers" "1") list("m" "1")) list("fingers" "l" "fw" "m"))
 list("XADC_XP9_XPH_XN1" "sky130_fd_pr_main" "nfet_01v8" list(list("D" "XADC_XP9_PHB") list("G" "CONV") list("S" "XADC_XP9_XPH_MID") list("B" "VSS")) list(list("w" "2u") list("fw" "2u") list("l" "0.15u") list("fingers" "1") list("m" "1")) list("fingers" "l" "fw" "m"))
 list("XADC_XP9_XPH_XN2" "sky130_fd_pr_main" "nfet_01v8" list(list("D" "XADC_XP9_XPH_MID") list("G" "B9") list("S" "VSS") list("B" "VSS")) list(list("w" "2u") list("fw" "2u") list("l" "0.15u") list("fingers" "1") list("m" "1")) list("fingers" "l" "fw" "m"))
 list("XADC_XP9_XPI_XP" "sky130_fd_pr_main" "pfet_01v8" list(list("D" "XADC_XP9_PH") list("G" "XADC_XP9_PHB") list("S" "VDD") list("B" "VDD")) list(list("w" "2u") list("fw" "2u") list("l" "0.15u") list("fingers" "1") list("m" "1")) list("fingers" "l" "fw" "m"))
 list("XADC_XP9_XPI_XN" "sky130_fd_pr_main" "nfet_01v8" list(list("D" "XADC_XP9_PH") list("G" "XADC_XP9_PHB") list("S" "VSS") list("B" "VSS")) list(list("w" "1u") list("fw" "1u") list("l" "0.15u") list("fingers" "1") list("m" "1")) list("fingers" "l" "fw" "m"))
 list("XADC_XP9_XNL_XP1" "sky130_fd_pr_main" "pfet_01v8" list(list("D" "XADC_XP9_NLB") list("G" "CONV") list("S" "VDD") list("B" "VDD")) list(list("w" "2u") list("fw" "2u") list("l" "0.15u") list("fingers" "1") list("m" "1")) list("fingers" "l" "fw" "m"))
 list("XADC_XP9_XNL_XP2" "sky130_fd_pr_main" "pfet_01v8" list(list("D" "XADC_XP9_NLB") list("G" "XADC_XP9_BITB") list("S" "VDD") list("B" "VDD")) list(list("w" "2u") list("fw" "2u") list("l" "0.15u") list("fingers" "1") list("m" "1")) list("fingers" "l" "fw" "m"))
 list("XADC_XP9_XNL_XN1" "sky130_fd_pr_main" "nfet_01v8" list(list("D" "XADC_XP9_NLB") list("G" "CONV") list("S" "XADC_XP9_XNL_MID") list("B" "VSS")) list(list("w" "2u") list("fw" "2u") list("l" "0.15u") list("fingers" "1") list("m" "1")) list("fingers" "l" "fw" "m"))
 list("XADC_XP9_XNL_XN2" "sky130_fd_pr_main" "nfet_01v8" list(list("D" "XADC_XP9_XNL_MID") list("G" "XADC_XP9_BITB") list("S" "VSS") list("B" "VSS")) list(list("w" "2u") list("fw" "2u") list("l" "0.15u") list("fingers" "1") list("m" "1")) list("fingers" "l" "fw" "m"))
 list("XADC_XP9_XNI_XP" "sky130_fd_pr_main" "pfet_01v8" list(list("D" "XADC_XP9_NL") list("G" "XADC_XP9_NLB") list("S" "VDD") list("B" "VDD")) list(list("w" "2u") list("fw" "2u") list("l" "0.15u") list("fingers" "1") list("m" "1")) list("fingers" "l" "fw" "m"))
 list("XADC_XP9_XNI_XN" "sky130_fd_pr_main" "nfet_01v8" list(list("D" "XADC_XP9_NL") list("G" "XADC_XP9_NLB") list("S" "VSS") list("B" "VSS")) list(list("w" "1u") list("fw" "1u") list("l" "0.15u") list("fingers" "1") list("m" "1")) list("fingers" "l" "fw" "m"))
 list("XADC_XP9_XCM_XN" "sky130_fd_pr_main" "nfet_01v8_lvt" list(list("D" "INP") list("G" "ACQ") list("S" "XADC_BP9") list("B" "VSS")) list(list("w" "13.44u") list("fw" "13.44u") list("l" "0.15u") list("fingers" "1") list("m" "1")) list("fingers" "l" "fw" "m"))
 list("XADC_XP9_XCM_XP" "sky130_fd_pr_main" "pfet_01v8_lvt" list(list("D" "INP") list("G" "XADC_XP9_ACQB") list("S" "XADC_BP9") list("B" "VDD")) list(list("w" "26.88u") list("fw" "26.88u") list("l" "0.35u") list("fingers" "1") list("m" "1")) list("fingers" "l" "fw" "m"))
 list("XADC_XP9_XRP_XN" "sky130_fd_pr_main" "nfet_01v8_lvt" list(list("D" "RP") list("G" "XADC_XP9_PH") list("S" "XADC_BP9") list("B" "VSS")) list(list("w" "13.44u") list("fw" "13.44u") list("l" "0.15u") list("fingers" "1") list("m" "1")) list("fingers" "l" "fw" "m"))
 list("XADC_XP9_XRP_XP" "sky130_fd_pr_main" "pfet_01v8_lvt" list(list("D" "RP") list("G" "XADC_XP9_PHB") list("S" "XADC_BP9") list("B" "VDD")) list(list("w" "26.88u") list("fw" "26.88u") list("l" "0.35u") list("fingers" "1") list("m" "1")) list("fingers" "l" "fw" "m"))
 list("XADC_XP9_XRN_XN" "sky130_fd_pr_main" "nfet_01v8_lvt" list(list("D" "RN") list("G" "XADC_XP9_NL") list("S" "XADC_BP9") list("B" "VSS")) list(list("w" "13.44u") list("fw" "13.44u") list("l" "0.15u") list("fingers" "1") list("m" "1")) list("fingers" "l" "fw" "m"))
 list("XADC_XP9_XRN_XP" "sky130_fd_pr_main" "pfet_01v8_lvt" list(list("D" "RN") list("G" "XADC_XP9_NLB") list("S" "XADC_BP9") list("B" "VDD")) list(list("w" "26.88u") list("fw" "26.88u") list("l" "0.35u") list("fingers" "1") list("m" "1")) list("fingers" "l" "fw" "m"))
 list("XADC_XN9_XBI_XP" "sky130_fd_pr_main" "pfet_01v8" list(list("D" "XADC_XN9_BITB") list("G" "B9") list("S" "VDD") list("B" "VDD")) list(list("w" "2u") list("fw" "2u") list("l" "0.15u") list("fingers" "1") list("m" "1")) list("fingers" "l" "fw" "m"))
 list("XADC_XN9_XBI_XN" "sky130_fd_pr_main" "nfet_01v8" list(list("D" "XADC_XN9_BITB") list("G" "B9") list("S" "VSS") list("B" "VSS")) list(list("w" "1u") list("fw" "1u") list("l" "0.15u") list("fingers" "1") list("m" "1")) list("fingers" "l" "fw" "m"))
 list("XADC_XN9_XAI_XP" "sky130_fd_pr_main" "pfet_01v8" list(list("D" "XADC_XN9_ACQB") list("G" "ACQ") list("S" "VDD") list("B" "VDD")) list(list("w" "2u") list("fw" "2u") list("l" "0.15u") list("fingers" "1") list("m" "1")) list("fingers" "l" "fw" "m"))
 list("XADC_XN9_XAI_XN" "sky130_fd_pr_main" "nfet_01v8" list(list("D" "XADC_XN9_ACQB") list("G" "ACQ") list("S" "VSS") list("B" "VSS")) list(list("w" "1u") list("fw" "1u") list("l" "0.15u") list("fingers" "1") list("m" "1")) list("fingers" "l" "fw" "m"))
 list("XADC_XN9_XPH_XP1" "sky130_fd_pr_main" "pfet_01v8" list(list("D" "XADC_XN9_PHB") list("G" "CONV") list("S" "VDD") list("B" "VDD")) list(list("w" "2u") list("fw" "2u") list("l" "0.15u") list("fingers" "1") list("m" "1")) list("fingers" "l" "fw" "m"))
 list("XADC_XN9_XPH_XP2" "sky130_fd_pr_main" "pfet_01v8" list(list("D" "XADC_XN9_PHB") list("G" "B9") list("S" "VDD") list("B" "VDD")) list(list("w" "2u") list("fw" "2u") list("l" "0.15u") list("fingers" "1") list("m" "1")) list("fingers" "l" "fw" "m"))
 list("XADC_XN9_XPH_XN1" "sky130_fd_pr_main" "nfet_01v8" list(list("D" "XADC_XN9_PHB") list("G" "CONV") list("S" "XADC_XN9_XPH_MID") list("B" "VSS")) list(list("w" "2u") list("fw" "2u") list("l" "0.15u") list("fingers" "1") list("m" "1")) list("fingers" "l" "fw" "m"))
 list("XADC_XN9_XPH_XN2" "sky130_fd_pr_main" "nfet_01v8" list(list("D" "XADC_XN9_XPH_MID") list("G" "B9") list("S" "VSS") list("B" "VSS")) list(list("w" "2u") list("fw" "2u") list("l" "0.15u") list("fingers" "1") list("m" "1")) list("fingers" "l" "fw" "m"))
 list("XADC_XN9_XPI_XP" "sky130_fd_pr_main" "pfet_01v8" list(list("D" "XADC_XN9_PH") list("G" "XADC_XN9_PHB") list("S" "VDD") list("B" "VDD")) list(list("w" "2u") list("fw" "2u") list("l" "0.15u") list("fingers" "1") list("m" "1")) list("fingers" "l" "fw" "m"))
 list("XADC_XN9_XPI_XN" "sky130_fd_pr_main" "nfet_01v8" list(list("D" "XADC_XN9_PH") list("G" "XADC_XN9_PHB") list("S" "VSS") list("B" "VSS")) list(list("w" "1u") list("fw" "1u") list("l" "0.15u") list("fingers" "1") list("m" "1")) list("fingers" "l" "fw" "m"))
 list("XADC_XN9_XNL_XP1" "sky130_fd_pr_main" "pfet_01v8" list(list("D" "XADC_XN9_NLB") list("G" "CONV") list("S" "VDD") list("B" "VDD")) list(list("w" "2u") list("fw" "2u") list("l" "0.15u") list("fingers" "1") list("m" "1")) list("fingers" "l" "fw" "m"))
 list("XADC_XN9_XNL_XP2" "sky130_fd_pr_main" "pfet_01v8" list(list("D" "XADC_XN9_NLB") list("G" "XADC_XN9_BITB") list("S" "VDD") list("B" "VDD")) list(list("w" "2u") list("fw" "2u") list("l" "0.15u") list("fingers" "1") list("m" "1")) list("fingers" "l" "fw" "m"))
 list("XADC_XN9_XNL_XN1" "sky130_fd_pr_main" "nfet_01v8" list(list("D" "XADC_XN9_NLB") list("G" "CONV") list("S" "XADC_XN9_XNL_MID") list("B" "VSS")) list(list("w" "2u") list("fw" "2u") list("l" "0.15u") list("fingers" "1") list("m" "1")) list("fingers" "l" "fw" "m"))
 list("XADC_XN9_XNL_XN2" "sky130_fd_pr_main" "nfet_01v8" list(list("D" "XADC_XN9_XNL_MID") list("G" "XADC_XN9_BITB") list("S" "VSS") list("B" "VSS")) list(list("w" "2u") list("fw" "2u") list("l" "0.15u") list("fingers" "1") list("m" "1")) list("fingers" "l" "fw" "m"))
 list("XADC_XN9_XNI_XP" "sky130_fd_pr_main" "pfet_01v8" list(list("D" "XADC_XN9_NL") list("G" "XADC_XN9_NLB") list("S" "VDD") list("B" "VDD")) list(list("w" "2u") list("fw" "2u") list("l" "0.15u") list("fingers" "1") list("m" "1")) list("fingers" "l" "fw" "m"))
 list("XADC_XN9_XNI_XN" "sky130_fd_pr_main" "nfet_01v8" list(list("D" "XADC_XN9_NL") list("G" "XADC_XN9_NLB") list("S" "VSS") list("B" "VSS")) list(list("w" "1u") list("fw" "1u") list("l" "0.15u") list("fingers" "1") list("m" "1")) list("fingers" "l" "fw" "m"))
 list("XADC_XN9_XCM_XN" "sky130_fd_pr_main" "nfet_01v8_lvt" list(list("D" "INN") list("G" "ACQ") list("S" "XADC_BN9") list("B" "VSS")) list(list("w" "13.44u") list("fw" "13.44u") list("l" "0.15u") list("fingers" "1") list("m" "1")) list("fingers" "l" "fw" "m"))
 list("XADC_XN9_XCM_XP" "sky130_fd_pr_main" "pfet_01v8_lvt" list(list("D" "INN") list("G" "XADC_XN9_ACQB") list("S" "XADC_BN9") list("B" "VDD")) list(list("w" "26.88u") list("fw" "26.88u") list("l" "0.35u") list("fingers" "1") list("m" "1")) list("fingers" "l" "fw" "m"))
 list("XADC_XN9_XRP_XN" "sky130_fd_pr_main" "nfet_01v8_lvt" list(list("D" "RN") list("G" "XADC_XN9_PH") list("S" "XADC_BN9") list("B" "VSS")) list(list("w" "13.44u") list("fw" "13.44u") list("l" "0.15u") list("fingers" "1") list("m" "1")) list("fingers" "l" "fw" "m"))
 list("XADC_XN9_XRP_XP" "sky130_fd_pr_main" "pfet_01v8_lvt" list(list("D" "RN") list("G" "XADC_XN9_PHB") list("S" "XADC_BN9") list("B" "VDD")) list(list("w" "26.88u") list("fw" "26.88u") list("l" "0.35u") list("fingers" "1") list("m" "1")) list("fingers" "l" "fw" "m"))
 list("XADC_XN9_XRN_XN" "sky130_fd_pr_main" "nfet_01v8_lvt" list(list("D" "RP") list("G" "XADC_XN9_NL") list("S" "XADC_BN9") list("B" "VSS")) list(list("w" "13.44u") list("fw" "13.44u") list("l" "0.15u") list("fingers" "1") list("m" "1")) list("fingers" "l" "fw" "m"))
 list("XADC_XN9_XRN_XP" "sky130_fd_pr_main" "pfet_01v8_lvt" list(list("D" "RP") list("G" "XADC_XN9_NLB") list("S" "XADC_BN9") list("B" "VDD")) list(list("w" "26.88u") list("fw" "26.88u") list("l" "0.35u") list("fingers" "1") list("m" "1")) list("fingers" "l" "fw" "m"))
 list("XADC_XP10_XBI_XP" "sky130_fd_pr_main" "pfet_01v8" list(list("D" "XADC_XP10_BITB") list("G" "B10") list("S" "VDD") list("B" "VDD")) list(list("w" "2u") list("fw" "2u") list("l" "0.15u") list("fingers" "1") list("m" "1")) list("fingers" "l" "fw" "m"))
 list("XADC_XP10_XBI_XN" "sky130_fd_pr_main" "nfet_01v8" list(list("D" "XADC_XP10_BITB") list("G" "B10") list("S" "VSS") list("B" "VSS")) list(list("w" "1u") list("fw" "1u") list("l" "0.15u") list("fingers" "1") list("m" "1")) list("fingers" "l" "fw" "m"))
 list("XADC_XP10_XAI_XP" "sky130_fd_pr_main" "pfet_01v8" list(list("D" "XADC_XP10_ACQB") list("G" "ACQ") list("S" "VDD") list("B" "VDD")) list(list("w" "2u") list("fw" "2u") list("l" "0.15u") list("fingers" "1") list("m" "1")) list("fingers" "l" "fw" "m"))
 list("XADC_XP10_XAI_XN" "sky130_fd_pr_main" "nfet_01v8" list(list("D" "XADC_XP10_ACQB") list("G" "ACQ") list("S" "VSS") list("B" "VSS")) list(list("w" "1u") list("fw" "1u") list("l" "0.15u") list("fingers" "1") list("m" "1")) list("fingers" "l" "fw" "m"))
 list("XADC_XP10_XPH_XP1" "sky130_fd_pr_main" "pfet_01v8" list(list("D" "XADC_XP10_PHB") list("G" "CONV") list("S" "VDD") list("B" "VDD")) list(list("w" "2u") list("fw" "2u") list("l" "0.15u") list("fingers" "1") list("m" "1")) list("fingers" "l" "fw" "m"))
 list("XADC_XP10_XPH_XP2" "sky130_fd_pr_main" "pfet_01v8" list(list("D" "XADC_XP10_PHB") list("G" "B10") list("S" "VDD") list("B" "VDD")) list(list("w" "2u") list("fw" "2u") list("l" "0.15u") list("fingers" "1") list("m" "1")) list("fingers" "l" "fw" "m"))
 list("XADC_XP10_XPH_XN1" "sky130_fd_pr_main" "nfet_01v8" list(list("D" "XADC_XP10_PHB") list("G" "CONV") list("S" "XADC_XP10_XPH_MID") list("B" "VSS")) list(list("w" "2u") list("fw" "2u") list("l" "0.15u") list("fingers" "1") list("m" "1")) list("fingers" "l" "fw" "m"))
 list("XADC_XP10_XPH_XN2" "sky130_fd_pr_main" "nfet_01v8" list(list("D" "XADC_XP10_XPH_MID") list("G" "B10") list("S" "VSS") list("B" "VSS")) list(list("w" "2u") list("fw" "2u") list("l" "0.15u") list("fingers" "1") list("m" "1")) list("fingers" "l" "fw" "m"))
 list("XADC_XP10_XPI_XP" "sky130_fd_pr_main" "pfet_01v8" list(list("D" "XADC_XP10_PH") list("G" "XADC_XP10_PHB") list("S" "VDD") list("B" "VDD")) list(list("w" "2u") list("fw" "2u") list("l" "0.15u") list("fingers" "1") list("m" "1")) list("fingers" "l" "fw" "m"))
 list("XADC_XP10_XPI_XN" "sky130_fd_pr_main" "nfet_01v8" list(list("D" "XADC_XP10_PH") list("G" "XADC_XP10_PHB") list("S" "VSS") list("B" "VSS")) list(list("w" "1u") list("fw" "1u") list("l" "0.15u") list("fingers" "1") list("m" "1")) list("fingers" "l" "fw" "m"))
 list("XADC_XP10_XNL_XP1" "sky130_fd_pr_main" "pfet_01v8" list(list("D" "XADC_XP10_NLB") list("G" "CONV") list("S" "VDD") list("B" "VDD")) list(list("w" "2u") list("fw" "2u") list("l" "0.15u") list("fingers" "1") list("m" "1")) list("fingers" "l" "fw" "m"))
 list("XADC_XP10_XNL_XP2" "sky130_fd_pr_main" "pfet_01v8" list(list("D" "XADC_XP10_NLB") list("G" "XADC_XP10_BITB") list("S" "VDD") list("B" "VDD")) list(list("w" "2u") list("fw" "2u") list("l" "0.15u") list("fingers" "1") list("m" "1")) list("fingers" "l" "fw" "m"))
 list("XADC_XP10_XNL_XN1" "sky130_fd_pr_main" "nfet_01v8" list(list("D" "XADC_XP10_NLB") list("G" "CONV") list("S" "XADC_XP10_XNL_MID") list("B" "VSS")) list(list("w" "2u") list("fw" "2u") list("l" "0.15u") list("fingers" "1") list("m" "1")) list("fingers" "l" "fw" "m"))
 list("XADC_XP10_XNL_XN2" "sky130_fd_pr_main" "nfet_01v8" list(list("D" "XADC_XP10_XNL_MID") list("G" "XADC_XP10_BITB") list("S" "VSS") list("B" "VSS")) list(list("w" "2u") list("fw" "2u") list("l" "0.15u") list("fingers" "1") list("m" "1")) list("fingers" "l" "fw" "m"))
 list("XADC_XP10_XNI_XP" "sky130_fd_pr_main" "pfet_01v8" list(list("D" "XADC_XP10_NL") list("G" "XADC_XP10_NLB") list("S" "VDD") list("B" "VDD")) list(list("w" "2u") list("fw" "2u") list("l" "0.15u") list("fingers" "1") list("m" "1")) list("fingers" "l" "fw" "m"))
 list("XADC_XP10_XNI_XN" "sky130_fd_pr_main" "nfet_01v8" list(list("D" "XADC_XP10_NL") list("G" "XADC_XP10_NLB") list("S" "VSS") list("B" "VSS")) list(list("w" "1u") list("fw" "1u") list("l" "0.15u") list("fingers" "1") list("m" "1")) list("fingers" "l" "fw" "m"))
 list("XADC_XP10_XCM_XN" "sky130_fd_pr_main" "nfet_01v8_lvt" list(list("D" "INP") list("G" "ACQ") list("S" "XADC_BP10") list("B" "VSS")) list(list("w" "13.44u") list("fw" "13.44u") list("l" "0.15u") list("fingers" "1") list("m" "1")) list("fingers" "l" "fw" "m"))
 list("XADC_XP10_XCM_XP" "sky130_fd_pr_main" "pfet_01v8_lvt" list(list("D" "INP") list("G" "XADC_XP10_ACQB") list("S" "XADC_BP10") list("B" "VDD")) list(list("w" "26.88u") list("fw" "26.88u") list("l" "0.35u") list("fingers" "1") list("m" "1")) list("fingers" "l" "fw" "m"))
 list("XADC_XP10_XRP_XN" "sky130_fd_pr_main" "nfet_01v8_lvt" list(list("D" "RP") list("G" "XADC_XP10_PH") list("S" "XADC_BP10") list("B" "VSS")) list(list("w" "13.44u") list("fw" "13.44u") list("l" "0.15u") list("fingers" "1") list("m" "1")) list("fingers" "l" "fw" "m"))
 list("XADC_XP10_XRP_XP" "sky130_fd_pr_main" "pfet_01v8_lvt" list(list("D" "RP") list("G" "XADC_XP10_PHB") list("S" "XADC_BP10") list("B" "VDD")) list(list("w" "26.88u") list("fw" "26.88u") list("l" "0.35u") list("fingers" "1") list("m" "1")) list("fingers" "l" "fw" "m"))
 list("XADC_XP10_XRN_XN" "sky130_fd_pr_main" "nfet_01v8_lvt" list(list("D" "RN") list("G" "XADC_XP10_NL") list("S" "XADC_BP10") list("B" "VSS")) list(list("w" "13.44u") list("fw" "13.44u") list("l" "0.15u") list("fingers" "1") list("m" "1")) list("fingers" "l" "fw" "m"))
 list("XADC_XP10_XRN_XP" "sky130_fd_pr_main" "pfet_01v8_lvt" list(list("D" "RN") list("G" "XADC_XP10_NLB") list("S" "XADC_BP10") list("B" "VDD")) list(list("w" "26.88u") list("fw" "26.88u") list("l" "0.35u") list("fingers" "1") list("m" "1")) list("fingers" "l" "fw" "m"))
 list("XADC_XN10_XBI_XP" "sky130_fd_pr_main" "pfet_01v8" list(list("D" "XADC_XN10_BITB") list("G" "B10") list("S" "VDD") list("B" "VDD")) list(list("w" "2u") list("fw" "2u") list("l" "0.15u") list("fingers" "1") list("m" "1")) list("fingers" "l" "fw" "m"))
 list("XADC_XN10_XBI_XN" "sky130_fd_pr_main" "nfet_01v8" list(list("D" "XADC_XN10_BITB") list("G" "B10") list("S" "VSS") list("B" "VSS")) list(list("w" "1u") list("fw" "1u") list("l" "0.15u") list("fingers" "1") list("m" "1")) list("fingers" "l" "fw" "m"))
 list("XADC_XN10_XAI_XP" "sky130_fd_pr_main" "pfet_01v8" list(list("D" "XADC_XN10_ACQB") list("G" "ACQ") list("S" "VDD") list("B" "VDD")) list(list("w" "2u") list("fw" "2u") list("l" "0.15u") list("fingers" "1") list("m" "1")) list("fingers" "l" "fw" "m"))
 list("XADC_XN10_XAI_XN" "sky130_fd_pr_main" "nfet_01v8" list(list("D" "XADC_XN10_ACQB") list("G" "ACQ") list("S" "VSS") list("B" "VSS")) list(list("w" "1u") list("fw" "1u") list("l" "0.15u") list("fingers" "1") list("m" "1")) list("fingers" "l" "fw" "m"))
 list("XADC_XN10_XPH_XP1" "sky130_fd_pr_main" "pfet_01v8" list(list("D" "XADC_XN10_PHB") list("G" "CONV") list("S" "VDD") list("B" "VDD")) list(list("w" "2u") list("fw" "2u") list("l" "0.15u") list("fingers" "1") list("m" "1")) list("fingers" "l" "fw" "m"))
 list("XADC_XN10_XPH_XP2" "sky130_fd_pr_main" "pfet_01v8" list(list("D" "XADC_XN10_PHB") list("G" "B10") list("S" "VDD") list("B" "VDD")) list(list("w" "2u") list("fw" "2u") list("l" "0.15u") list("fingers" "1") list("m" "1")) list("fingers" "l" "fw" "m"))
 list("XADC_XN10_XPH_XN1" "sky130_fd_pr_main" "nfet_01v8" list(list("D" "XADC_XN10_PHB") list("G" "CONV") list("S" "XADC_XN10_XPH_MID") list("B" "VSS")) list(list("w" "2u") list("fw" "2u") list("l" "0.15u") list("fingers" "1") list("m" "1")) list("fingers" "l" "fw" "m"))
 list("XADC_XN10_XPH_XN2" "sky130_fd_pr_main" "nfet_01v8" list(list("D" "XADC_XN10_XPH_MID") list("G" "B10") list("S" "VSS") list("B" "VSS")) list(list("w" "2u") list("fw" "2u") list("l" "0.15u") list("fingers" "1") list("m" "1")) list("fingers" "l" "fw" "m"))
 list("XADC_XN10_XPI_XP" "sky130_fd_pr_main" "pfet_01v8" list(list("D" "XADC_XN10_PH") list("G" "XADC_XN10_PHB") list("S" "VDD") list("B" "VDD")) list(list("w" "2u") list("fw" "2u") list("l" "0.15u") list("fingers" "1") list("m" "1")) list("fingers" "l" "fw" "m"))
 list("XADC_XN10_XPI_XN" "sky130_fd_pr_main" "nfet_01v8" list(list("D" "XADC_XN10_PH") list("G" "XADC_XN10_PHB") list("S" "VSS") list("B" "VSS")) list(list("w" "1u") list("fw" "1u") list("l" "0.15u") list("fingers" "1") list("m" "1")) list("fingers" "l" "fw" "m"))
 list("XADC_XN10_XNL_XP1" "sky130_fd_pr_main" "pfet_01v8" list(list("D" "XADC_XN10_NLB") list("G" "CONV") list("S" "VDD") list("B" "VDD")) list(list("w" "2u") list("fw" "2u") list("l" "0.15u") list("fingers" "1") list("m" "1")) list("fingers" "l" "fw" "m"))
 list("XADC_XN10_XNL_XP2" "sky130_fd_pr_main" "pfet_01v8" list(list("D" "XADC_XN10_NLB") list("G" "XADC_XN10_BITB") list("S" "VDD") list("B" "VDD")) list(list("w" "2u") list("fw" "2u") list("l" "0.15u") list("fingers" "1") list("m" "1")) list("fingers" "l" "fw" "m"))
 list("XADC_XN10_XNL_XN1" "sky130_fd_pr_main" "nfet_01v8" list(list("D" "XADC_XN10_NLB") list("G" "CONV") list("S" "XADC_XN10_XNL_MID") list("B" "VSS")) list(list("w" "2u") list("fw" "2u") list("l" "0.15u") list("fingers" "1") list("m" "1")) list("fingers" "l" "fw" "m"))
 list("XADC_XN10_XNL_XN2" "sky130_fd_pr_main" "nfet_01v8" list(list("D" "XADC_XN10_XNL_MID") list("G" "XADC_XN10_BITB") list("S" "VSS") list("B" "VSS")) list(list("w" "2u") list("fw" "2u") list("l" "0.15u") list("fingers" "1") list("m" "1")) list("fingers" "l" "fw" "m"))
 list("XADC_XN10_XNI_XP" "sky130_fd_pr_main" "pfet_01v8" list(list("D" "XADC_XN10_NL") list("G" "XADC_XN10_NLB") list("S" "VDD") list("B" "VDD")) list(list("w" "2u") list("fw" "2u") list("l" "0.15u") list("fingers" "1") list("m" "1")) list("fingers" "l" "fw" "m"))
 list("XADC_XN10_XNI_XN" "sky130_fd_pr_main" "nfet_01v8" list(list("D" "XADC_XN10_NL") list("G" "XADC_XN10_NLB") list("S" "VSS") list("B" "VSS")) list(list("w" "1u") list("fw" "1u") list("l" "0.15u") list("fingers" "1") list("m" "1")) list("fingers" "l" "fw" "m"))
 list("XADC_XN10_XCM_XN" "sky130_fd_pr_main" "nfet_01v8_lvt" list(list("D" "INN") list("G" "ACQ") list("S" "XADC_BN10") list("B" "VSS")) list(list("w" "13.44u") list("fw" "13.44u") list("l" "0.15u") list("fingers" "1") list("m" "1")) list("fingers" "l" "fw" "m"))
 list("XADC_XN10_XCM_XP" "sky130_fd_pr_main" "pfet_01v8_lvt" list(list("D" "INN") list("G" "XADC_XN10_ACQB") list("S" "XADC_BN10") list("B" "VDD")) list(list("w" "26.88u") list("fw" "26.88u") list("l" "0.35u") list("fingers" "1") list("m" "1")) list("fingers" "l" "fw" "m"))
 list("XADC_XN10_XRP_XN" "sky130_fd_pr_main" "nfet_01v8_lvt" list(list("D" "RN") list("G" "XADC_XN10_PH") list("S" "XADC_BN10") list("B" "VSS")) list(list("w" "13.44u") list("fw" "13.44u") list("l" "0.15u") list("fingers" "1") list("m" "1")) list("fingers" "l" "fw" "m"))
 list("XADC_XN10_XRP_XP" "sky130_fd_pr_main" "pfet_01v8_lvt" list(list("D" "RN") list("G" "XADC_XN10_PHB") list("S" "XADC_BN10") list("B" "VDD")) list(list("w" "26.88u") list("fw" "26.88u") list("l" "0.35u") list("fingers" "1") list("m" "1")) list("fingers" "l" "fw" "m"))
 list("XADC_XN10_XRN_XN" "sky130_fd_pr_main" "nfet_01v8_lvt" list(list("D" "RP") list("G" "XADC_XN10_NL") list("S" "XADC_BN10") list("B" "VSS")) list(list("w" "13.44u") list("fw" "13.44u") list("l" "0.15u") list("fingers" "1") list("m" "1")) list("fingers" "l" "fw" "m"))
 list("XADC_XN10_XRN_XP" "sky130_fd_pr_main" "pfet_01v8_lvt" list(list("D" "RP") list("G" "XADC_XN10_NLB") list("S" "XADC_BN10") list("B" "VDD")) list(list("w" "26.88u") list("fw" "26.88u") list("l" "0.35u") list("fingers" "1") list("m" "1")) list("fingers" "l" "fw" "m"))
 list("XADC_XP11_XBI_XP" "sky130_fd_pr_main" "pfet_01v8" list(list("D" "XADC_XP11_BITB") list("G" "B11") list("S" "VDD") list("B" "VDD")) list(list("w" "2u") list("fw" "2u") list("l" "0.15u") list("fingers" "1") list("m" "1")) list("fingers" "l" "fw" "m"))
 list("XADC_XP11_XBI_XN" "sky130_fd_pr_main" "nfet_01v8" list(list("D" "XADC_XP11_BITB") list("G" "B11") list("S" "VSS") list("B" "VSS")) list(list("w" "1u") list("fw" "1u") list("l" "0.15u") list("fingers" "1") list("m" "1")) list("fingers" "l" "fw" "m"))
 list("XADC_XP11_XAI_XP" "sky130_fd_pr_main" "pfet_01v8" list(list("D" "XADC_XP11_ACQB") list("G" "ACQ") list("S" "VDD") list("B" "VDD")) list(list("w" "2u") list("fw" "2u") list("l" "0.15u") list("fingers" "1") list("m" "1")) list("fingers" "l" "fw" "m"))
 list("XADC_XP11_XAI_XN" "sky130_fd_pr_main" "nfet_01v8" list(list("D" "XADC_XP11_ACQB") list("G" "ACQ") list("S" "VSS") list("B" "VSS")) list(list("w" "1u") list("fw" "1u") list("l" "0.15u") list("fingers" "1") list("m" "1")) list("fingers" "l" "fw" "m"))
 list("XADC_XP11_XPH_XP1" "sky130_fd_pr_main" "pfet_01v8" list(list("D" "XADC_XP11_PHB") list("G" "CONV") list("S" "VDD") list("B" "VDD")) list(list("w" "2u") list("fw" "2u") list("l" "0.15u") list("fingers" "1") list("m" "1")) list("fingers" "l" "fw" "m"))
 list("XADC_XP11_XPH_XP2" "sky130_fd_pr_main" "pfet_01v8" list(list("D" "XADC_XP11_PHB") list("G" "B11") list("S" "VDD") list("B" "VDD")) list(list("w" "2u") list("fw" "2u") list("l" "0.15u") list("fingers" "1") list("m" "1")) list("fingers" "l" "fw" "m"))
 list("XADC_XP11_XPH_XN1" "sky130_fd_pr_main" "nfet_01v8" list(list("D" "XADC_XP11_PHB") list("G" "CONV") list("S" "XADC_XP11_XPH_MID") list("B" "VSS")) list(list("w" "2u") list("fw" "2u") list("l" "0.15u") list("fingers" "1") list("m" "1")) list("fingers" "l" "fw" "m"))
 list("XADC_XP11_XPH_XN2" "sky130_fd_pr_main" "nfet_01v8" list(list("D" "XADC_XP11_XPH_MID") list("G" "B11") list("S" "VSS") list("B" "VSS")) list(list("w" "2u") list("fw" "2u") list("l" "0.15u") list("fingers" "1") list("m" "1")) list("fingers" "l" "fw" "m"))
 list("XADC_XP11_XPI_XP" "sky130_fd_pr_main" "pfet_01v8" list(list("D" "XADC_XP11_PH") list("G" "XADC_XP11_PHB") list("S" "VDD") list("B" "VDD")) list(list("w" "2u") list("fw" "2u") list("l" "0.15u") list("fingers" "1") list("m" "1")) list("fingers" "l" "fw" "m"))
 list("XADC_XP11_XPI_XN" "sky130_fd_pr_main" "nfet_01v8" list(list("D" "XADC_XP11_PH") list("G" "XADC_XP11_PHB") list("S" "VSS") list("B" "VSS")) list(list("w" "1u") list("fw" "1u") list("l" "0.15u") list("fingers" "1") list("m" "1")) list("fingers" "l" "fw" "m"))
 list("XADC_XP11_XNL_XP1" "sky130_fd_pr_main" "pfet_01v8" list(list("D" "XADC_XP11_NLB") list("G" "CONV") list("S" "VDD") list("B" "VDD")) list(list("w" "2u") list("fw" "2u") list("l" "0.15u") list("fingers" "1") list("m" "1")) list("fingers" "l" "fw" "m"))
 list("XADC_XP11_XNL_XP2" "sky130_fd_pr_main" "pfet_01v8" list(list("D" "XADC_XP11_NLB") list("G" "XADC_XP11_BITB") list("S" "VDD") list("B" "VDD")) list(list("w" "2u") list("fw" "2u") list("l" "0.15u") list("fingers" "1") list("m" "1")) list("fingers" "l" "fw" "m"))
 list("XADC_XP11_XNL_XN1" "sky130_fd_pr_main" "nfet_01v8" list(list("D" "XADC_XP11_NLB") list("G" "CONV") list("S" "XADC_XP11_XNL_MID") list("B" "VSS")) list(list("w" "2u") list("fw" "2u") list("l" "0.15u") list("fingers" "1") list("m" "1")) list("fingers" "l" "fw" "m"))
 list("XADC_XP11_XNL_XN2" "sky130_fd_pr_main" "nfet_01v8" list(list("D" "XADC_XP11_XNL_MID") list("G" "XADC_XP11_BITB") list("S" "VSS") list("B" "VSS")) list(list("w" "2u") list("fw" "2u") list("l" "0.15u") list("fingers" "1") list("m" "1")) list("fingers" "l" "fw" "m"))
 list("XADC_XP11_XNI_XP" "sky130_fd_pr_main" "pfet_01v8" list(list("D" "XADC_XP11_NL") list("G" "XADC_XP11_NLB") list("S" "VDD") list("B" "VDD")) list(list("w" "2u") list("fw" "2u") list("l" "0.15u") list("fingers" "1") list("m" "1")) list("fingers" "l" "fw" "m"))
 list("XADC_XP11_XNI_XN" "sky130_fd_pr_main" "nfet_01v8" list(list("D" "XADC_XP11_NL") list("G" "XADC_XP11_NLB") list("S" "VSS") list("B" "VSS")) list(list("w" "1u") list("fw" "1u") list("l" "0.15u") list("fingers" "1") list("m" "1")) list("fingers" "l" "fw" "m"))
 list("XADC_XP11_XCM_XN" "sky130_fd_pr_main" "nfet_01v8_lvt" list(list("D" "INP") list("G" "ACQ") list("S" "XADC_BP11") list("B" "VSS")) list(list("w" "13.44u") list("fw" "13.44u") list("l" "0.15u") list("fingers" "1") list("m" "1")) list("fingers" "l" "fw" "m"))
 list("XADC_XP11_XCM_XP" "sky130_fd_pr_main" "pfet_01v8_lvt" list(list("D" "INP") list("G" "XADC_XP11_ACQB") list("S" "XADC_BP11") list("B" "VDD")) list(list("w" "26.88u") list("fw" "26.88u") list("l" "0.35u") list("fingers" "1") list("m" "1")) list("fingers" "l" "fw" "m"))
 list("XADC_XP11_XRP_XN" "sky130_fd_pr_main" "nfet_01v8_lvt" list(list("D" "RP") list("G" "XADC_XP11_PH") list("S" "XADC_BP11") list("B" "VSS")) list(list("w" "13.44u") list("fw" "13.44u") list("l" "0.15u") list("fingers" "1") list("m" "1")) list("fingers" "l" "fw" "m"))
 list("XADC_XP11_XRP_XP" "sky130_fd_pr_main" "pfet_01v8_lvt" list(list("D" "RP") list("G" "XADC_XP11_PHB") list("S" "XADC_BP11") list("B" "VDD")) list(list("w" "26.88u") list("fw" "26.88u") list("l" "0.35u") list("fingers" "1") list("m" "1")) list("fingers" "l" "fw" "m"))
 list("XADC_XP11_XRN_XN" "sky130_fd_pr_main" "nfet_01v8_lvt" list(list("D" "RN") list("G" "XADC_XP11_NL") list("S" "XADC_BP11") list("B" "VSS")) list(list("w" "13.44u") list("fw" "13.44u") list("l" "0.15u") list("fingers" "1") list("m" "1")) list("fingers" "l" "fw" "m"))
 list("XADC_XP11_XRN_XP" "sky130_fd_pr_main" "pfet_01v8_lvt" list(list("D" "RN") list("G" "XADC_XP11_NLB") list("S" "XADC_BP11") list("B" "VDD")) list(list("w" "26.88u") list("fw" "26.88u") list("l" "0.35u") list("fingers" "1") list("m" "1")) list("fingers" "l" "fw" "m"))
 list("XADC_XN11_XBI_XP" "sky130_fd_pr_main" "pfet_01v8" list(list("D" "XADC_XN11_BITB") list("G" "B11") list("S" "VDD") list("B" "VDD")) list(list("w" "2u") list("fw" "2u") list("l" "0.15u") list("fingers" "1") list("m" "1")) list("fingers" "l" "fw" "m"))
 list("XADC_XN11_XBI_XN" "sky130_fd_pr_main" "nfet_01v8" list(list("D" "XADC_XN11_BITB") list("G" "B11") list("S" "VSS") list("B" "VSS")) list(list("w" "1u") list("fw" "1u") list("l" "0.15u") list("fingers" "1") list("m" "1")) list("fingers" "l" "fw" "m"))
 list("XADC_XN11_XAI_XP" "sky130_fd_pr_main" "pfet_01v8" list(list("D" "XADC_XN11_ACQB") list("G" "ACQ") list("S" "VDD") list("B" "VDD")) list(list("w" "2u") list("fw" "2u") list("l" "0.15u") list("fingers" "1") list("m" "1")) list("fingers" "l" "fw" "m"))
 list("XADC_XN11_XAI_XN" "sky130_fd_pr_main" "nfet_01v8" list(list("D" "XADC_XN11_ACQB") list("G" "ACQ") list("S" "VSS") list("B" "VSS")) list(list("w" "1u") list("fw" "1u") list("l" "0.15u") list("fingers" "1") list("m" "1")) list("fingers" "l" "fw" "m"))
 list("XADC_XN11_XPH_XP1" "sky130_fd_pr_main" "pfet_01v8" list(list("D" "XADC_XN11_PHB") list("G" "CONV") list("S" "VDD") list("B" "VDD")) list(list("w" "2u") list("fw" "2u") list("l" "0.15u") list("fingers" "1") list("m" "1")) list("fingers" "l" "fw" "m"))
 list("XADC_XN11_XPH_XP2" "sky130_fd_pr_main" "pfet_01v8" list(list("D" "XADC_XN11_PHB") list("G" "B11") list("S" "VDD") list("B" "VDD")) list(list("w" "2u") list("fw" "2u") list("l" "0.15u") list("fingers" "1") list("m" "1")) list("fingers" "l" "fw" "m"))
 list("XADC_XN11_XPH_XN1" "sky130_fd_pr_main" "nfet_01v8" list(list("D" "XADC_XN11_PHB") list("G" "CONV") list("S" "XADC_XN11_XPH_MID") list("B" "VSS")) list(list("w" "2u") list("fw" "2u") list("l" "0.15u") list("fingers" "1") list("m" "1")) list("fingers" "l" "fw" "m"))
 list("XADC_XN11_XPH_XN2" "sky130_fd_pr_main" "nfet_01v8" list(list("D" "XADC_XN11_XPH_MID") list("G" "B11") list("S" "VSS") list("B" "VSS")) list(list("w" "2u") list("fw" "2u") list("l" "0.15u") list("fingers" "1") list("m" "1")) list("fingers" "l" "fw" "m"))
 list("XADC_XN11_XPI_XP" "sky130_fd_pr_main" "pfet_01v8" list(list("D" "XADC_XN11_PH") list("G" "XADC_XN11_PHB") list("S" "VDD") list("B" "VDD")) list(list("w" "2u") list("fw" "2u") list("l" "0.15u") list("fingers" "1") list("m" "1")) list("fingers" "l" "fw" "m"))
 list("XADC_XN11_XPI_XN" "sky130_fd_pr_main" "nfet_01v8" list(list("D" "XADC_XN11_PH") list("G" "XADC_XN11_PHB") list("S" "VSS") list("B" "VSS")) list(list("w" "1u") list("fw" "1u") list("l" "0.15u") list("fingers" "1") list("m" "1")) list("fingers" "l" "fw" "m"))
 list("XADC_XN11_XNL_XP1" "sky130_fd_pr_main" "pfet_01v8" list(list("D" "XADC_XN11_NLB") list("G" "CONV") list("S" "VDD") list("B" "VDD")) list(list("w" "2u") list("fw" "2u") list("l" "0.15u") list("fingers" "1") list("m" "1")) list("fingers" "l" "fw" "m"))
 list("XADC_XN11_XNL_XP2" "sky130_fd_pr_main" "pfet_01v8" list(list("D" "XADC_XN11_NLB") list("G" "XADC_XN11_BITB") list("S" "VDD") list("B" "VDD")) list(list("w" "2u") list("fw" "2u") list("l" "0.15u") list("fingers" "1") list("m" "1")) list("fingers" "l" "fw" "m"))
 list("XADC_XN11_XNL_XN1" "sky130_fd_pr_main" "nfet_01v8" list(list("D" "XADC_XN11_NLB") list("G" "CONV") list("S" "XADC_XN11_XNL_MID") list("B" "VSS")) list(list("w" "2u") list("fw" "2u") list("l" "0.15u") list("fingers" "1") list("m" "1")) list("fingers" "l" "fw" "m"))
 list("XADC_XN11_XNL_XN2" "sky130_fd_pr_main" "nfet_01v8" list(list("D" "XADC_XN11_XNL_MID") list("G" "XADC_XN11_BITB") list("S" "VSS") list("B" "VSS")) list(list("w" "2u") list("fw" "2u") list("l" "0.15u") list("fingers" "1") list("m" "1")) list("fingers" "l" "fw" "m"))
 list("XADC_XN11_XNI_XP" "sky130_fd_pr_main" "pfet_01v8" list(list("D" "XADC_XN11_NL") list("G" "XADC_XN11_NLB") list("S" "VDD") list("B" "VDD")) list(list("w" "2u") list("fw" "2u") list("l" "0.15u") list("fingers" "1") list("m" "1")) list("fingers" "l" "fw" "m"))
 list("XADC_XN11_XNI_XN" "sky130_fd_pr_main" "nfet_01v8" list(list("D" "XADC_XN11_NL") list("G" "XADC_XN11_NLB") list("S" "VSS") list("B" "VSS")) list(list("w" "1u") list("fw" "1u") list("l" "0.15u") list("fingers" "1") list("m" "1")) list("fingers" "l" "fw" "m"))
 list("XADC_XN11_XCM_XN" "sky130_fd_pr_main" "nfet_01v8_lvt" list(list("D" "INN") list("G" "ACQ") list("S" "XADC_BN11") list("B" "VSS")) list(list("w" "13.44u") list("fw" "13.44u") list("l" "0.15u") list("fingers" "1") list("m" "1")) list("fingers" "l" "fw" "m"))
 list("XADC_XN11_XCM_XP" "sky130_fd_pr_main" "pfet_01v8_lvt" list(list("D" "INN") list("G" "XADC_XN11_ACQB") list("S" "XADC_BN11") list("B" "VDD")) list(list("w" "26.88u") list("fw" "26.88u") list("l" "0.35u") list("fingers" "1") list("m" "1")) list("fingers" "l" "fw" "m"))
 list("XADC_XN11_XRP_XN" "sky130_fd_pr_main" "nfet_01v8_lvt" list(list("D" "RN") list("G" "XADC_XN11_PH") list("S" "XADC_BN11") list("B" "VSS")) list(list("w" "13.44u") list("fw" "13.44u") list("l" "0.15u") list("fingers" "1") list("m" "1")) list("fingers" "l" "fw" "m"))
 list("XADC_XN11_XRP_XP" "sky130_fd_pr_main" "pfet_01v8_lvt" list(list("D" "RN") list("G" "XADC_XN11_PHB") list("S" "XADC_BN11") list("B" "VDD")) list(list("w" "26.88u") list("fw" "26.88u") list("l" "0.35u") list("fingers" "1") list("m" "1")) list("fingers" "l" "fw" "m"))
 list("XADC_XN11_XRN_XN" "sky130_fd_pr_main" "nfet_01v8_lvt" list(list("D" "RP") list("G" "XADC_XN11_NL") list("S" "XADC_BN11") list("B" "VSS")) list(list("w" "13.44u") list("fw" "13.44u") list("l" "0.15u") list("fingers" "1") list("m" "1")) list("fingers" "l" "fw" "m"))
 list("XADC_XN11_XRN_XP" "sky130_fd_pr_main" "pfet_01v8_lvt" list(list("D" "RP") list("G" "XADC_XN11_NLB") list("S" "XADC_BN11") list("B" "VDD")) list(list("w" "26.88u") list("fw" "26.88u") list("l" "0.35u") list("fingers" "1") list("m" "1")) list("fingers" "l" "fw" "m"))
 list("XADC_XDP_XBI_XP" "sky130_fd_pr_main" "pfet_01v8" list(list("D" "XADC_XDP_BITB") list("G" "VSS") list("S" "VDD") list("B" "VDD")) list(list("w" "2u") list("fw" "2u") list("l" "0.15u") list("fingers" "1") list("m" "1")) list("fingers" "l" "fw" "m"))
 list("XADC_XDP_XBI_XN" "sky130_fd_pr_main" "nfet_01v8" list(list("D" "XADC_XDP_BITB") list("G" "VSS") list("S" "VSS") list("B" "VSS")) list(list("w" "1u") list("fw" "1u") list("l" "0.15u") list("fingers" "1") list("m" "1")) list("fingers" "l" "fw" "m"))
 list("XADC_XDP_XAI_XP" "sky130_fd_pr_main" "pfet_01v8" list(list("D" "XADC_XDP_ACQB") list("G" "ACQ") list("S" "VDD") list("B" "VDD")) list(list("w" "2u") list("fw" "2u") list("l" "0.15u") list("fingers" "1") list("m" "1")) list("fingers" "l" "fw" "m"))
 list("XADC_XDP_XAI_XN" "sky130_fd_pr_main" "nfet_01v8" list(list("D" "XADC_XDP_ACQB") list("G" "ACQ") list("S" "VSS") list("B" "VSS")) list(list("w" "1u") list("fw" "1u") list("l" "0.15u") list("fingers" "1") list("m" "1")) list("fingers" "l" "fw" "m"))
 list("XADC_XDP_XPH_XP1" "sky130_fd_pr_main" "pfet_01v8" list(list("D" "XADC_XDP_PHB") list("G" "CONV") list("S" "VDD") list("B" "VDD")) list(list("w" "2u") list("fw" "2u") list("l" "0.15u") list("fingers" "1") list("m" "1")) list("fingers" "l" "fw" "m"))
 list("XADC_XDP_XPH_XP2" "sky130_fd_pr_main" "pfet_01v8" list(list("D" "XADC_XDP_PHB") list("G" "VSS") list("S" "VDD") list("B" "VDD")) list(list("w" "2u") list("fw" "2u") list("l" "0.15u") list("fingers" "1") list("m" "1")) list("fingers" "l" "fw" "m"))
 list("XADC_XDP_XPH_XN1" "sky130_fd_pr_main" "nfet_01v8" list(list("D" "XADC_XDP_PHB") list("G" "CONV") list("S" "XADC_XDP_XPH_MID") list("B" "VSS")) list(list("w" "2u") list("fw" "2u") list("l" "0.15u") list("fingers" "1") list("m" "1")) list("fingers" "l" "fw" "m"))
 list("XADC_XDP_XPH_XN2" "sky130_fd_pr_main" "nfet_01v8" list(list("D" "XADC_XDP_XPH_MID") list("G" "VSS") list("S" "VSS") list("B" "VSS")) list(list("w" "2u") list("fw" "2u") list("l" "0.15u") list("fingers" "1") list("m" "1")) list("fingers" "l" "fw" "m"))
 list("XADC_XDP_XPI_XP" "sky130_fd_pr_main" "pfet_01v8" list(list("D" "XADC_XDP_PH") list("G" "XADC_XDP_PHB") list("S" "VDD") list("B" "VDD")) list(list("w" "2u") list("fw" "2u") list("l" "0.15u") list("fingers" "1") list("m" "1")) list("fingers" "l" "fw" "m"))
 list("XADC_XDP_XPI_XN" "sky130_fd_pr_main" "nfet_01v8" list(list("D" "XADC_XDP_PH") list("G" "XADC_XDP_PHB") list("S" "VSS") list("B" "VSS")) list(list("w" "1u") list("fw" "1u") list("l" "0.15u") list("fingers" "1") list("m" "1")) list("fingers" "l" "fw" "m"))
 list("XADC_XDP_XNL_XP1" "sky130_fd_pr_main" "pfet_01v8" list(list("D" "XADC_XDP_NLB") list("G" "CONV") list("S" "VDD") list("B" "VDD")) list(list("w" "2u") list("fw" "2u") list("l" "0.15u") list("fingers" "1") list("m" "1")) list("fingers" "l" "fw" "m"))
 list("XADC_XDP_XNL_XP2" "sky130_fd_pr_main" "pfet_01v8" list(list("D" "XADC_XDP_NLB") list("G" "XADC_XDP_BITB") list("S" "VDD") list("B" "VDD")) list(list("w" "2u") list("fw" "2u") list("l" "0.15u") list("fingers" "1") list("m" "1")) list("fingers" "l" "fw" "m"))
 list("XADC_XDP_XNL_XN1" "sky130_fd_pr_main" "nfet_01v8" list(list("D" "XADC_XDP_NLB") list("G" "CONV") list("S" "XADC_XDP_XNL_MID") list("B" "VSS")) list(list("w" "2u") list("fw" "2u") list("l" "0.15u") list("fingers" "1") list("m" "1")) list("fingers" "l" "fw" "m"))
 list("XADC_XDP_XNL_XN2" "sky130_fd_pr_main" "nfet_01v8" list(list("D" "XADC_XDP_XNL_MID") list("G" "XADC_XDP_BITB") list("S" "VSS") list("B" "VSS")) list(list("w" "2u") list("fw" "2u") list("l" "0.15u") list("fingers" "1") list("m" "1")) list("fingers" "l" "fw" "m"))
 list("XADC_XDP_XNI_XP" "sky130_fd_pr_main" "pfet_01v8" list(list("D" "XADC_XDP_NL") list("G" "XADC_XDP_NLB") list("S" "VDD") list("B" "VDD")) list(list("w" "2u") list("fw" "2u") list("l" "0.15u") list("fingers" "1") list("m" "1")) list("fingers" "l" "fw" "m"))
 list("XADC_XDP_XNI_XN" "sky130_fd_pr_main" "nfet_01v8" list(list("D" "XADC_XDP_NL") list("G" "XADC_XDP_NLB") list("S" "VSS") list("B" "VSS")) list(list("w" "1u") list("fw" "1u") list("l" "0.15u") list("fingers" "1") list("m" "1")) list("fingers" "l" "fw" "m"))
 list("XADC_XDP_XCM_XN" "sky130_fd_pr_main" "nfet_01v8_lvt" list(list("D" "INP") list("G" "ACQ") list("S" "XADC_DP") list("B" "VSS")) list(list("w" "0.84u") list("fw" "0.84u") list("l" "0.15u") list("fingers" "1") list("m" "1")) list("fingers" "l" "fw" "m"))
 list("XADC_XDP_XCM_XP" "sky130_fd_pr_main" "pfet_01v8_lvt" list(list("D" "INP") list("G" "XADC_XDP_ACQB") list("S" "XADC_DP") list("B" "VDD")) list(list("w" "1.68u") list("fw" "1.68u") list("l" "0.35u") list("fingers" "1") list("m" "1")) list("fingers" "l" "fw" "m"))
 list("XADC_XDP_XRP_XN" "sky130_fd_pr_main" "nfet_01v8_lvt" list(list("D" "RP") list("G" "XADC_XDP_PH") list("S" "XADC_DP") list("B" "VSS")) list(list("w" "0.84u") list("fw" "0.84u") list("l" "0.15u") list("fingers" "1") list("m" "1")) list("fingers" "l" "fw" "m"))
 list("XADC_XDP_XRP_XP" "sky130_fd_pr_main" "pfet_01v8_lvt" list(list("D" "RP") list("G" "XADC_XDP_PHB") list("S" "XADC_DP") list("B" "VDD")) list(list("w" "1.68u") list("fw" "1.68u") list("l" "0.35u") list("fingers" "1") list("m" "1")) list("fingers" "l" "fw" "m"))
 list("XADC_XDP_XRN_XN" "sky130_fd_pr_main" "nfet_01v8_lvt" list(list("D" "RN") list("G" "XADC_XDP_NL") list("S" "XADC_DP") list("B" "VSS")) list(list("w" "0.84u") list("fw" "0.84u") list("l" "0.15u") list("fingers" "1") list("m" "1")) list("fingers" "l" "fw" "m"))
 list("XADC_XDP_XRN_XP" "sky130_fd_pr_main" "pfet_01v8_lvt" list(list("D" "RN") list("G" "XADC_XDP_NLB") list("S" "XADC_DP") list("B" "VDD")) list(list("w" "1.68u") list("fw" "1.68u") list("l" "0.35u") list("fingers" "1") list("m" "1")) list("fingers" "l" "fw" "m"))
 list("XADC_XDN_XBI_XP" "sky130_fd_pr_main" "pfet_01v8" list(list("D" "XADC_XDN_BITB") list("G" "VDD") list("S" "VDD") list("B" "VDD")) list(list("w" "2u") list("fw" "2u") list("l" "0.15u") list("fingers" "1") list("m" "1")) list("fingers" "l" "fw" "m"))
 list("XADC_XDN_XBI_XN" "sky130_fd_pr_main" "nfet_01v8" list(list("D" "XADC_XDN_BITB") list("G" "VDD") list("S" "VSS") list("B" "VSS")) list(list("w" "1u") list("fw" "1u") list("l" "0.15u") list("fingers" "1") list("m" "1")) list("fingers" "l" "fw" "m"))
 list("XADC_XDN_XAI_XP" "sky130_fd_pr_main" "pfet_01v8" list(list("D" "XADC_XDN_ACQB") list("G" "ACQ") list("S" "VDD") list("B" "VDD")) list(list("w" "2u") list("fw" "2u") list("l" "0.15u") list("fingers" "1") list("m" "1")) list("fingers" "l" "fw" "m"))
 list("XADC_XDN_XAI_XN" "sky130_fd_pr_main" "nfet_01v8" list(list("D" "XADC_XDN_ACQB") list("G" "ACQ") list("S" "VSS") list("B" "VSS")) list(list("w" "1u") list("fw" "1u") list("l" "0.15u") list("fingers" "1") list("m" "1")) list("fingers" "l" "fw" "m"))
 list("XADC_XDN_XPH_XP1" "sky130_fd_pr_main" "pfet_01v8" list(list("D" "XADC_XDN_PHB") list("G" "CONV") list("S" "VDD") list("B" "VDD")) list(list("w" "2u") list("fw" "2u") list("l" "0.15u") list("fingers" "1") list("m" "1")) list("fingers" "l" "fw" "m"))
 list("XADC_XDN_XPH_XP2" "sky130_fd_pr_main" "pfet_01v8" list(list("D" "XADC_XDN_PHB") list("G" "VDD") list("S" "VDD") list("B" "VDD")) list(list("w" "2u") list("fw" "2u") list("l" "0.15u") list("fingers" "1") list("m" "1")) list("fingers" "l" "fw" "m"))
 list("XADC_XDN_XPH_XN1" "sky130_fd_pr_main" "nfet_01v8" list(list("D" "XADC_XDN_PHB") list("G" "CONV") list("S" "XADC_XDN_XPH_MID") list("B" "VSS")) list(list("w" "2u") list("fw" "2u") list("l" "0.15u") list("fingers" "1") list("m" "1")) list("fingers" "l" "fw" "m"))
 list("XADC_XDN_XPH_XN2" "sky130_fd_pr_main" "nfet_01v8" list(list("D" "XADC_XDN_XPH_MID") list("G" "VDD") list("S" "VSS") list("B" "VSS")) list(list("w" "2u") list("fw" "2u") list("l" "0.15u") list("fingers" "1") list("m" "1")) list("fingers" "l" "fw" "m"))
 list("XADC_XDN_XPI_XP" "sky130_fd_pr_main" "pfet_01v8" list(list("D" "XADC_XDN_PH") list("G" "XADC_XDN_PHB") list("S" "VDD") list("B" "VDD")) list(list("w" "2u") list("fw" "2u") list("l" "0.15u") list("fingers" "1") list("m" "1")) list("fingers" "l" "fw" "m"))
 list("XADC_XDN_XPI_XN" "sky130_fd_pr_main" "nfet_01v8" list(list("D" "XADC_XDN_PH") list("G" "XADC_XDN_PHB") list("S" "VSS") list("B" "VSS")) list(list("w" "1u") list("fw" "1u") list("l" "0.15u") list("fingers" "1") list("m" "1")) list("fingers" "l" "fw" "m"))
 list("XADC_XDN_XNL_XP1" "sky130_fd_pr_main" "pfet_01v8" list(list("D" "XADC_XDN_NLB") list("G" "CONV") list("S" "VDD") list("B" "VDD")) list(list("w" "2u") list("fw" "2u") list("l" "0.15u") list("fingers" "1") list("m" "1")) list("fingers" "l" "fw" "m"))
 list("XADC_XDN_XNL_XP2" "sky130_fd_pr_main" "pfet_01v8" list(list("D" "XADC_XDN_NLB") list("G" "XADC_XDN_BITB") list("S" "VDD") list("B" "VDD")) list(list("w" "2u") list("fw" "2u") list("l" "0.15u") list("fingers" "1") list("m" "1")) list("fingers" "l" "fw" "m"))
 list("XADC_XDN_XNL_XN1" "sky130_fd_pr_main" "nfet_01v8" list(list("D" "XADC_XDN_NLB") list("G" "CONV") list("S" "XADC_XDN_XNL_MID") list("B" "VSS")) list(list("w" "2u") list("fw" "2u") list("l" "0.15u") list("fingers" "1") list("m" "1")) list("fingers" "l" "fw" "m"))
 list("XADC_XDN_XNL_XN2" "sky130_fd_pr_main" "nfet_01v8" list(list("D" "XADC_XDN_XNL_MID") list("G" "XADC_XDN_BITB") list("S" "VSS") list("B" "VSS")) list(list("w" "2u") list("fw" "2u") list("l" "0.15u") list("fingers" "1") list("m" "1")) list("fingers" "l" "fw" "m"))
 list("XADC_XDN_XNI_XP" "sky130_fd_pr_main" "pfet_01v8" list(list("D" "XADC_XDN_NL") list("G" "XADC_XDN_NLB") list("S" "VDD") list("B" "VDD")) list(list("w" "2u") list("fw" "2u") list("l" "0.15u") list("fingers" "1") list("m" "1")) list("fingers" "l" "fw" "m"))
 list("XADC_XDN_XNI_XN" "sky130_fd_pr_main" "nfet_01v8" list(list("D" "XADC_XDN_NL") list("G" "XADC_XDN_NLB") list("S" "VSS") list("B" "VSS")) list(list("w" "1u") list("fw" "1u") list("l" "0.15u") list("fingers" "1") list("m" "1")) list("fingers" "l" "fw" "m"))
 list("XADC_XDN_XCM_XN" "sky130_fd_pr_main" "nfet_01v8_lvt" list(list("D" "INN") list("G" "ACQ") list("S" "XADC_DN") list("B" "VSS")) list(list("w" "0.84u") list("fw" "0.84u") list("l" "0.15u") list("fingers" "1") list("m" "1")) list("fingers" "l" "fw" "m"))
 list("XADC_XDN_XCM_XP" "sky130_fd_pr_main" "pfet_01v8_lvt" list(list("D" "INN") list("G" "XADC_XDN_ACQB") list("S" "XADC_DN") list("B" "VDD")) list(list("w" "1.68u") list("fw" "1.68u") list("l" "0.35u") list("fingers" "1") list("m" "1")) list("fingers" "l" "fw" "m"))
 list("XADC_XDN_XRP_XN" "sky130_fd_pr_main" "nfet_01v8_lvt" list(list("D" "RP") list("G" "XADC_XDN_PH") list("S" "XADC_DN") list("B" "VSS")) list(list("w" "0.84u") list("fw" "0.84u") list("l" "0.15u") list("fingers" "1") list("m" "1")) list("fingers" "l" "fw" "m"))
 list("XADC_XDN_XRP_XP" "sky130_fd_pr_main" "pfet_01v8_lvt" list(list("D" "RP") list("G" "XADC_XDN_PHB") list("S" "XADC_DN") list("B" "VDD")) list(list("w" "1.68u") list("fw" "1.68u") list("l" "0.35u") list("fingers" "1") list("m" "1")) list("fingers" "l" "fw" "m"))
 list("XADC_XDN_XRN_XN" "sky130_fd_pr_main" "nfet_01v8_lvt" list(list("D" "RN") list("G" "XADC_XDN_NL") list("S" "XADC_DN") list("B" "VSS")) list(list("w" "0.84u") list("fw" "0.84u") list("l" "0.15u") list("fingers" "1") list("m" "1")) list("fingers" "l" "fw" "m"))
 list("XADC_XDN_XRN_XP" "sky130_fd_pr_main" "pfet_01v8_lvt" list(list("D" "RN") list("G" "XADC_XDN_NLB") list("S" "XADC_DN") list("B" "VDD")) list(list("w" "1.68u") list("fw" "1.68u") list("l" "0.35u") list("fingers" "1") list("m" "1")) list("fingers" "l" "fw" "m"))
 list("XADC_XCP_XC11_XC" "sky130_fd_pr_main" "cap_mim_m3__base" list(list("PLUS" "XADC_TP") list("MINUS" "XADC_BP11")) list(list("w" "4u") list("l" "4u") list("m" "2048")) list("w" "l" "m"))
 list("XADC_XCP_XC10_XC" "sky130_fd_pr_main" "cap_mim_m3__base" list(list("PLUS" "XADC_TP") list("MINUS" "XADC_BP10")) list(list("w" "4u") list("l" "4u") list("m" "1024")) list("w" "l" "m"))
 list("XADC_XCP_XC9_XC" "sky130_fd_pr_main" "cap_mim_m3__base" list(list("PLUS" "XADC_TP") list("MINUS" "XADC_BP9")) list(list("w" "4u") list("l" "4u") list("m" "512")) list("w" "l" "m"))
 list("XADC_XCP_XC8_XC" "sky130_fd_pr_main" "cap_mim_m3__base" list(list("PLUS" "XADC_TP") list("MINUS" "XADC_BP8")) list(list("w" "4u") list("l" "4u") list("m" "256")) list("w" "l" "m"))
 list("XADC_XCP_XC7_XC" "sky130_fd_pr_main" "cap_mim_m3__base" list(list("PLUS" "XADC_TP") list("MINUS" "XADC_BP7")) list(list("w" "4u") list("l" "4u") list("m" "128")) list("w" "l" "m"))
 list("XADC_XCP_XC6_XC" "sky130_fd_pr_main" "cap_mim_m3__base" list(list("PLUS" "XADC_TP") list("MINUS" "XADC_BP6")) list(list("w" "4u") list("l" "4u") list("m" "64")) list("w" "l" "m"))
 list("XADC_XCP_XC5_XC" "sky130_fd_pr_main" "cap_mim_m3__base" list(list("PLUS" "XADC_TP") list("MINUS" "XADC_BP5")) list(list("w" "4u") list("l" "4u") list("m" "32")) list("w" "l" "m"))
 list("XADC_XCP_XC4_XC" "sky130_fd_pr_main" "cap_mim_m3__base" list(list("PLUS" "XADC_TP") list("MINUS" "XADC_BP4")) list(list("w" "4u") list("l" "4u") list("m" "16")) list("w" "l" "m"))
 list("XADC_XCP_XC3_XC" "sky130_fd_pr_main" "cap_mim_m3__base" list(list("PLUS" "XADC_TP") list("MINUS" "XADC_BP3")) list(list("w" "4u") list("l" "4u") list("m" "8")) list("w" "l" "m"))
 list("XADC_XCP_XC2_XC" "sky130_fd_pr_main" "cap_mim_m3__base" list(list("PLUS" "XADC_TP") list("MINUS" "XADC_BP2")) list(list("w" "4u") list("l" "4u") list("m" "4")) list("w" "l" "m"))
 list("XADC_XCP_XC1_XC" "sky130_fd_pr_main" "cap_mim_m3__base" list(list("PLUS" "XADC_TP") list("MINUS" "XADC_BP1")) list(list("w" "4u") list("l" "4u") list("m" "2")) list("w" "l" "m"))
 list("XADC_XCP_XC0_XC" "sky130_fd_pr_main" "cap_mim_m3__base" list(list("PLUS" "XADC_TP") list("MINUS" "XADC_BP0")) list(list("w" "4u") list("l" "4u") list("m" "1")) list("w" "l" "m"))
 list("XADC_XCP_XD_XC" "sky130_fd_pr_main" "cap_mim_m3__base" list(list("PLUS" "XADC_TP") list("MINUS" "XADC_DP")) list(list("w" "4u") list("l" "4u") list("m" "1")) list("w" "l" "m"))
 list("XADC_XCN_XC11_XC" "sky130_fd_pr_main" "cap_mim_m3__base" list(list("PLUS" "XADC_TN") list("MINUS" "XADC_BN11")) list(list("w" "4u") list("l" "4u") list("m" "2048")) list("w" "l" "m"))
 list("XADC_XCN_XC10_XC" "sky130_fd_pr_main" "cap_mim_m3__base" list(list("PLUS" "XADC_TN") list("MINUS" "XADC_BN10")) list(list("w" "4u") list("l" "4u") list("m" "1024")) list("w" "l" "m"))
 list("XADC_XCN_XC9_XC" "sky130_fd_pr_main" "cap_mim_m3__base" list(list("PLUS" "XADC_TN") list("MINUS" "XADC_BN9")) list(list("w" "4u") list("l" "4u") list("m" "512")) list("w" "l" "m"))
 list("XADC_XCN_XC8_XC" "sky130_fd_pr_main" "cap_mim_m3__base" list(list("PLUS" "XADC_TN") list("MINUS" "XADC_BN8")) list(list("w" "4u") list("l" "4u") list("m" "256")) list("w" "l" "m"))
 list("XADC_XCN_XC7_XC" "sky130_fd_pr_main" "cap_mim_m3__base" list(list("PLUS" "XADC_TN") list("MINUS" "XADC_BN7")) list(list("w" "4u") list("l" "4u") list("m" "128")) list("w" "l" "m"))
 list("XADC_XCN_XC6_XC" "sky130_fd_pr_main" "cap_mim_m3__base" list(list("PLUS" "XADC_TN") list("MINUS" "XADC_BN6")) list(list("w" "4u") list("l" "4u") list("m" "64")) list("w" "l" "m"))
 list("XADC_XCN_XC5_XC" "sky130_fd_pr_main" "cap_mim_m3__base" list(list("PLUS" "XADC_TN") list("MINUS" "XADC_BN5")) list(list("w" "4u") list("l" "4u") list("m" "32")) list("w" "l" "m"))
 list("XADC_XCN_XC4_XC" "sky130_fd_pr_main" "cap_mim_m3__base" list(list("PLUS" "XADC_TN") list("MINUS" "XADC_BN4")) list(list("w" "4u") list("l" "4u") list("m" "16")) list("w" "l" "m"))
 list("XADC_XCN_XC3_XC" "sky130_fd_pr_main" "cap_mim_m3__base" list(list("PLUS" "XADC_TN") list("MINUS" "XADC_BN3")) list(list("w" "4u") list("l" "4u") list("m" "8")) list("w" "l" "m"))
 list("XADC_XCN_XC2_XC" "sky130_fd_pr_main" "cap_mim_m3__base" list(list("PLUS" "XADC_TN") list("MINUS" "XADC_BN2")) list(list("w" "4u") list("l" "4u") list("m" "4")) list("w" "l" "m"))
 list("XADC_XCN_XC1_XC" "sky130_fd_pr_main" "cap_mim_m3__base" list(list("PLUS" "XADC_TN") list("MINUS" "XADC_BN1")) list(list("w" "4u") list("l" "4u") list("m" "2")) list("w" "l" "m"))
 list("XADC_XCN_XC0_XC" "sky130_fd_pr_main" "cap_mim_m3__base" list(list("PLUS" "XADC_TN") list("MINUS" "XADC_BN0")) list(list("w" "4u") list("l" "4u") list("m" "1")) list("w" "l" "m"))
 list("XADC_XCN_XD_XC" "sky130_fd_pr_main" "cap_mim_m3__base" list(list("PLUS" "XADC_TN") list("MINUS" "XADC_DN")) list(list("w" "4u") list("l" "4u") list("m" "1")) list("w" "l" "m"))
 list("XADC_XCMP_XRSTB_XP" "sky130_fd_pr_main" "pfet_01v8" list(list("D" "XADC_XCMP_RST_B") list("G" "RST_N") list("S" "VDD") list("B" "VDD")) list(list("w" "2u") list("fw" "2u") list("l" "0.15u") list("fingers" "1") list("m" "1")) list("fingers" "l" "fw" "m"))
 list("XADC_XCMP_XRSTB_XN" "sky130_fd_pr_main" "nfet_01v8" list(list("D" "XADC_XCMP_RST_B") list("G" "RST_N") list("S" "VSS") list("B" "VSS")) list(list("w" "1u") list("fw" "1u") list("l" "0.15u") list("fingers" "1") list("m" "1")) list("fingers" "l" "fw" "m"))
 list("XADC_XCMP_XSOR_XNOR_XN1" "sky130_fd_pr_main" "nfet_01v8" list(list("D" "XADC_XCMP_S_NOR") list("G" "XADC_XCMP_BN") list("S" "VSS") list("B" "VSS")) list(list("w" "2u") list("fw" "2u") list("l" "0.15u") list("fingers" "1") list("m" "1")) list("fingers" "l" "fw" "m"))
 list("XADC_XCMP_XSOR_XNOR_XN2" "sky130_fd_pr_main" "nfet_01v8" list(list("D" "XADC_XCMP_S_NOR") list("G" "XADC_XCMP_RST_B") list("S" "VSS") list("B" "VSS")) list(list("w" "2u") list("fw" "2u") list("l" "0.15u") list("fingers" "1") list("m" "1")) list("fingers" "l" "fw" "m"))
 list("XADC_XCMP_XSOR_XNOR_XP1" "sky130_fd_pr_main" "pfet_01v8" list(list("D" "XADC_XCMP_XSOR_XNOR_MID") list("G" "XADC_XCMP_BN") list("S" "VDD") list("B" "VDD")) list(list("w" "4u") list("fw" "4u") list("l" "0.15u") list("fingers" "1") list("m" "1")) list("fingers" "l" "fw" "m"))
 list("XADC_XCMP_XSOR_XNOR_XP2" "sky130_fd_pr_main" "pfet_01v8" list(list("D" "XADC_XCMP_S_NOR") list("G" "XADC_XCMP_RST_B") list("S" "XADC_XCMP_XSOR_XNOR_MID") list("B" "VDD")) list(list("w" "4u") list("fw" "4u") list("l" "0.15u") list("fingers" "1") list("m" "1")) list("fingers" "l" "fw" "m"))
 list("XADC_XCMP_XSOR_XINV_XP" "sky130_fd_pr_main" "pfet_01v8" list(list("D" "XADC_XCMP_S_BAR") list("G" "XADC_XCMP_S_NOR") list("S" "VDD") list("B" "VDD")) list(list("w" "2u") list("fw" "2u") list("l" "0.15u") list("fingers" "1") list("m" "1")) list("fingers" "l" "fw" "m"))
 list("XADC_XCMP_XSOR_XINV_XN" "sky130_fd_pr_main" "nfet_01v8" list(list("D" "XADC_XCMP_S_BAR") list("G" "XADC_XCMP_S_NOR") list("S" "VSS") list("B" "VSS")) list(list("w" "1u") list("fw" "1u") list("l" "0.15u") list("fingers" "1") list("m" "1")) list("fingers" "l" "fw" "m"))
 list("XADC_XCMP_XRAND_XNAND_XP1" "sky130_fd_pr_main" "pfet_01v8" list(list("D" "XADC_XCMP_R_NAND") list("G" "XADC_XCMP_BP") list("S" "VDD") list("B" "VDD")) list(list("w" "2u") list("fw" "2u") list("l" "0.15u") list("fingers" "1") list("m" "1")) list("fingers" "l" "fw" "m"))
 list("XADC_XCMP_XRAND_XNAND_XP2" "sky130_fd_pr_main" "pfet_01v8" list(list("D" "XADC_XCMP_R_NAND") list("G" "RST_N") list("S" "VDD") list("B" "VDD")) list(list("w" "2u") list("fw" "2u") list("l" "0.15u") list("fingers" "1") list("m" "1")) list("fingers" "l" "fw" "m"))
 list("XADC_XCMP_XRAND_XNAND_XN1" "sky130_fd_pr_main" "nfet_01v8" list(list("D" "XADC_XCMP_R_NAND") list("G" "XADC_XCMP_BP") list("S" "XADC_XCMP_XRAND_XNAND_MID") list("B" "VSS")) list(list("w" "2u") list("fw" "2u") list("l" "0.15u") list("fingers" "1") list("m" "1")) list("fingers" "l" "fw" "m"))
 list("XADC_XCMP_XRAND_XNAND_XN2" "sky130_fd_pr_main" "nfet_01v8" list(list("D" "XADC_XCMP_XRAND_XNAND_MID") list("G" "RST_N") list("S" "VSS") list("B" "VSS")) list(list("w" "2u") list("fw" "2u") list("l" "0.15u") list("fingers" "1") list("m" "1")) list("fingers" "l" "fw" "m"))
 list("XADC_XCMP_XRAND_XINV_XP" "sky130_fd_pr_main" "pfet_01v8" list(list("D" "XADC_XCMP_R_BAR") list("G" "XADC_XCMP_R_NAND") list("S" "VDD") list("B" "VDD")) list(list("w" "2u") list("fw" "2u") list("l" "0.15u") list("fingers" "1") list("m" "1")) list("fingers" "l" "fw" "m"))
 list("XADC_XCMP_XRAND_XINV_XN" "sky130_fd_pr_main" "nfet_01v8" list(list("D" "XADC_XCMP_R_BAR") list("G" "XADC_XCMP_R_NAND") list("S" "VSS") list("B" "VSS")) list(list("w" "1u") list("fw" "1u") list("l" "0.15u") list("fingers" "1") list("m" "1")) list("fingers" "l" "fw" "m"))
) list("INP" "INN" "Q" "QB" "SAMPLE" "SAMPLEB" "ACQ" "CONV" "EVAL" "B11" "B10" "B9" "B8" "B7" "B6" "B5" "B4" "B3" "B2" "B1" "B0" "RP" "RN" "VCM" "VDD" "VSS" "RST_N"))
p2adcSymbol("p2adc_core_reset1_school_r1" list("INP" "INN" "Q" "QB" "SAMPLE" "SAMPLEB" "ACQ" "CONV" "EVAL" "B11" "B10" "B9" "B8" "B7" "B6" "B5" "B4" "B3" "B2" "B1" "B0" "RP" "RN" "VCM" "VDD" "VSS" "RST_N"))
p2adcOne
