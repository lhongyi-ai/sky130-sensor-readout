simulator lang=spectre
subckt p1_actual_cmp_reset1 (XADC_TN XADC_TP Q QB EVAL VDD VSS RST_N)
XADC_XCMP_XRAND_XINV_XP (XADC_XCMP_R_BAR XADC_XCMP_R_NAND VDD VDD)  pfet_01v8 w=(2u) l=150n as=530f ad=530f ps=4.53u pd=4.53u  m=(1)*(1)
XADC_XCMP_XRAND_XNAND_XP2 (XADC_XCMP_R_NAND RST_N VDD VDD) pfet_01v8  w=(2u) l=150n as=530f ad=530f ps=4.53u pd=4.53u m=(1)*(1)
XADC_XCMP_XRAND_XNAND_XP1 (XADC_XCMP_R_NAND XADC_XCMP_BP VDD VDD)  pfet_01v8 w=(2u) l=150n as=530f ad=530f ps=4.53u pd=4.53u  m=(1)*(1)
XADC_XCMP_XSOR_XINV_XP (XADC_XCMP_S_BAR XADC_XCMP_S_NOR VDD VDD) pfet_01v8  w=(2u) l=150n as=530f ad=530f ps=4.53u pd=4.53u m=(1)*(1)
XADC_XCMP_XSOR_XNOR_XP2 (XADC_XCMP_S_NOR XADC_XCMP_RST_B  XADC_XCMP_XSOR_XNOR_MID VDD) pfet_01v8 w=(4u) l=150n as=1.06p  ad=1.06p ps=8.53u pd=8.53u m=(1)*(1)
XADC_XCMP_XSOR_XNOR_XP1 (XADC_XCMP_XSOR_XNOR_MID XADC_XCMP_BN VDD VDD)  pfet_01v8 w=(4u) l=150n as=1.06p ad=1.06p ps=8.53u pd=8.53u  m=(1)*(1)
XADC_XCMP_XRSTB_XP (XADC_XCMP_RST_B RST_N VDD VDD) pfet_01v8 w=(2u) l=150n  as=530f ad=530f ps=4.53u pd=4.53u m=(1)*(1)
XADC_XCMP_XRESET_XP2 (QB Q VDD VDD) pfet_01v8 w=(2u) l=150n as=530f  ad=530f ps=4.53u pd=4.53u m=(1)*(1)
XADC_XCMP_XRESET_XP1 (QB XADC_XCMP_R_BAR VDD VDD) pfet_01v8 w=(2u) l=150n  as=530f ad=530f ps=4.53u pd=4.53u m=(1)*(1)
XADC_XCMP_XSET_XP2 (Q QB VDD VDD) pfet_01v8 w=(2u) l=150n as=530f ad=530f  ps=4.53u pd=4.53u m=(1)*(1)
XADC_XCMP_XSET_XP1 (Q XADC_XCMP_S_BAR VDD VDD) pfet_01v8 w=(2u) l=150n  as=530f ad=530f ps=4.53u pd=4.53u m=(1)*(1)
XADC_XCMP_XBN2_XP (XADC_XCMP_BN XADC_XCMP_BNB VDD VDD) pfet_01v8 w=(2u)  l=150n as=530f ad=530f ps=4.53u pd=4.53u m=(1)*(1)
XADC_XCMP_XBN1_XP (XADC_XCMP_BNB XADC_XCMP_DNEG VDD VDD) pfet_01v8 w=(2u)  l=150n as=530f ad=530f ps=4.53u pd=4.53u m=(1)*(1)
XADC_XCMP_XBP2_XP (XADC_XCMP_BP XADC_XCMP_BPB VDD VDD) pfet_01v8 w=(2u)  l=150n as=530f ad=530f ps=4.53u pd=4.53u m=(1)*(1)
XADC_XCMP_XBP1_XP (XADC_XCMP_BPB XADC_XCMP_DPOS VDD VDD) pfet_01v8 w=(2u)  l=150n as=530f ad=530f ps=4.53u pd=4.53u m=(1)*(1)
XADC_XCMP_XCORE_XRDP (XADC_XCMP_XCORE_DN EVAL VDD VDD) pfet_01v8 w=(2u)  l=150n as=530f ad=530f ps=4.53u pd=4.53u m=(1)*(1)
XADC_XCMP_XCORE_XRDN (XADC_XCMP_XCORE_DP EVAL VDD VDD) pfet_01v8 w=(2u)  l=150n as=530f ad=530f ps=4.53u pd=4.53u m=(1)*(1)
XADC_XCMP_XCORE_XRP (XADC_XCMP_DPOS EVAL VDD VDD) pfet_01v8 w=(2u) l=150n  as=530f ad=530f ps=4.53u pd=4.53u m=(1)*(1)
XADC_XCMP_XCORE_XRN (XADC_XCMP_DNEG EVAL VDD VDD) pfet_01v8 w=(2u) l=150n  as=530f ad=530f ps=4.53u pd=4.53u m=(1)*(1)
XADC_XCMP_XCORE_XPP (XADC_XCMP_DPOS XADC_XCMP_DNEG VDD VDD) pfet_01v8  w=(8u) l=150n as=2.12p ad=2.12p ps=16.53u pd=16.53u m=(1)*(1)
XADC_XCMP_XCORE_XPN (XADC_XCMP_DNEG XADC_XCMP_DPOS VDD VDD) pfet_01v8  w=(8u) l=150n as=2.12p ad=2.12p ps=16.53u pd=16.53u m=(1)*(1)
XADC_XPRE_XSTPU (XADC_XPRE_START VSS VDD VDD) pfet_01v8 w=(550n) l=10u  as=145.75f ad=145.75f ps=1.63u pd=1.63u m=(1)*(1)
XADC_XPRE_XBP2 (XADC_XPRE_BN XADC_XPRE_BP VDD VDD) pfet_01v8 w=(10u) l=1u  as=2.65p ad=2.65p ps=20.53u pd=20.53u m=(1)*(1)
XADC_XPRE_XBP1 (XADC_XPRE_BP XADC_XPRE_BP VDD VDD) pfet_01v8 w=(10u) l=1u  as=2.65p ad=2.65p ps=20.53u pd=20.53u m=(1)*(1)
XADC_XCMP_XRAND_XINV_XN (XADC_XCMP_R_BAR XADC_XCMP_R_NAND VSS VSS)  nfet_01v8 w=(1u) l=150n as=265f ad=265f ps=2.53u pd=2.53u  m=(1)*(1)
XADC_XCMP_XRAND_XNAND_XN2 (XADC_XCMP_XRAND_XNAND_MID RST_N VSS VSS)  nfet_01v8 w=(2u) l=150n as=530f ad=530f ps=4.53u pd=4.53u  m=(1)*(1)
XADC_XCMP_XRAND_XNAND_XN1 (XADC_XCMP_R_NAND XADC_XCMP_BP  XADC_XCMP_XRAND_XNAND_MID VSS) nfet_01v8 w=(2u) l=150n as=530f  ad=530f ps=4.53u pd=4.53u m=(1)*(1)
XADC_XCMP_XSOR_XINV_XN (XADC_XCMP_S_BAR XADC_XCMP_S_NOR VSS VSS) nfet_01v8  w=(1u) l=150n as=265f ad=265f ps=2.53u pd=2.53u m=(1)*(1)
XADC_XCMP_XSOR_XNOR_XN2 (XADC_XCMP_S_NOR XADC_XCMP_RST_B VSS VSS)  nfet_01v8 w=(2u) l=150n as=530f ad=530f ps=4.53u pd=4.53u  m=(1)*(1)
XADC_XCMP_XSOR_XNOR_XN1 (XADC_XCMP_S_NOR XADC_XCMP_BN VSS VSS) nfet_01v8  w=(2u) l=150n as=530f ad=530f ps=4.53u pd=4.53u m=(1)*(1)
XADC_XCMP_XRSTB_XN (XADC_XCMP_RST_B RST_N VSS VSS) nfet_01v8 w=(1u) l=150n  as=265f ad=265f ps=2.53u pd=2.53u m=(1)*(1)
XADC_XCMP_XRESET_XN2 (XADC_XCMP_XRESET_MID Q VSS VSS) nfet_01v8 w=(2u)  l=150n as=530f ad=530f ps=4.53u pd=4.53u m=(1)*(1)
XADC_XCMP_XRESET_XN1 (QB XADC_XCMP_R_BAR XADC_XCMP_XRESET_MID VSS)  nfet_01v8 w=(2u) l=150n as=530f ad=530f ps=4.53u pd=4.53u  m=(1)*(1)
XADC_XCMP_XSET_XN2 (XADC_XCMP_XSET_MID QB VSS VSS) nfet_01v8 w=(2u) l=150n  as=530f ad=530f ps=4.53u pd=4.53u m=(1)*(1)
XADC_XCMP_XSET_XN1 (Q XADC_XCMP_S_BAR XADC_XCMP_XSET_MID VSS) nfet_01v8  w=(2u) l=150n as=530f ad=530f ps=4.53u pd=4.53u m=(1)*(1)
XADC_XCMP_XBN2_XN (XADC_XCMP_BN XADC_XCMP_BNB VSS VSS) nfet_01v8 w=(1u)  l=150n as=265f ad=265f ps=2.53u pd=2.53u m=(1)*(1)
XADC_XCMP_XBN1_XN (XADC_XCMP_BNB XADC_XCMP_DNEG VSS VSS) nfet_01v8 w=(1u)  l=150n as=265f ad=265f ps=2.53u pd=2.53u m=(1)*(1)
XADC_XCMP_XBP2_XN (XADC_XCMP_BP XADC_XCMP_BPB VSS VSS) nfet_01v8 w=(1u)  l=150n as=265f ad=265f ps=2.53u pd=2.53u m=(1)*(1)
XADC_XCMP_XBP1_XN (XADC_XCMP_BPB XADC_XCMP_DPOS VSS VSS) nfet_01v8 w=(1u)  l=150n as=265f ad=265f ps=2.53u pd=2.53u m=(1)*(1)
XADC_XCMP_XCORE_XLP (XADC_XCMP_DPOS XADC_XCMP_DNEG XADC_XCMP_XCORE_DN VSS)  nfet_01v8 w=(4u) l=150n as=1.06p ad=1.06p ps=8.53u pd=8.53u  m=(1)*(1)
XADC_XCMP_XCORE_XLN (XADC_XCMP_DNEG XADC_XCMP_DPOS XADC_XCMP_XCORE_DP VSS)  nfet_01v8 w=(4u) l=150n as=1.06p ad=1.06p ps=8.53u pd=8.53u  m=(1)*(1)
XADC_XCMP_XCORE_XT (XADC_XCMP_XCORE_TAIL EVAL VSS VSS) nfet_01v8 w=(16u)  l=150n as=4.24p ad=4.24p ps=32.53u pd=32.53u m=(1)*(1)
XADC_XCMP_XCORE_XIN (XADC_XCMP_XCORE_DN XADC_PREN XADC_XCMP_XCORE_TAIL  VSS) nfet_01v8 w=(8.4u) l=500n as=2.226p ad=2.226p ps=17.33u  pd=17.33u m=(1)*(1)
XADC_XCMP_XCORE_XIP (XADC_XCMP_XCORE_DP XADC_PREP XADC_XCMP_XCORE_TAIL  VSS) nfet_01v8 w=(8.4u) l=500n as=2.226p ad=2.226p ps=17.33u  pd=17.33u m=(1)*(1)
XADC_XPRE_XTAIL (XADC_XPRE_TAIL XADC_XPRE_BN VSS VSS) nfet_01v8 w=(32u)  l=1u as=8.48p ad=8.48p ps=64.53u pd=64.53u m=(1)*(1)
XADC_XPRE_XIN (XADC_PREP XADC_TP XADC_XPRE_TAIL VSS) nfet_01v8 w=(30u)  l=1u as=7.95p ad=7.95p ps=60.53u pd=60.53u m=(1)*(1)
XADC_XPRE_XIP (XADC_PREN XADC_TN XADC_XPRE_TAIL VSS) nfet_01v8 w=(30u)  l=1u as=7.95p ad=7.95p ps=60.53u pd=60.53u m=(1)*(1)
XADC_XPRE_XSTINJ (XADC_XPRE_BP XADC_XPRE_START VSS VSS) nfet_01v8 w=(500n)  l=2u as=132.5f ad=132.5f ps=1.53u pd=1.53u m=(1)*(1)
XADC_XPRE_XSTOFF (XADC_XPRE_START XADC_XPRE_BN VSS VSS) nfet_01v8 w=(20u)  l=1u as=5.3p ad=5.3p ps=40.53u pd=40.53u m=(1)*(1)
XADC_XPRE_XBN2 (XADC_XPRE_BP XADC_XPRE_BN XADC_XPRE_BRS VSS) nfet_01v8  w=(32u) l=1u as=8.48p ad=8.48p ps=64.53u pd=64.53u m=(1)*(1)
XADC_XPRE_XBN1 (XADC_XPRE_BN XADC_XPRE_BN VSS VSS) nfet_01v8 w=(8u) l=1u  as=2.12p ad=2.12p ps=16.53u pd=16.53u m=(1)*(1)
XADC_XPRE_XRN_XR7_XR (XADC_XPRE_XRN_N7 XADC_PREN VSS) res_high_po_5p73  r=4.97951K l=86.99u w=5.73u
XADC_XPRE_XRN_XR6_XR_SEG_2 (XADC_XPRE_XRN_XR6_XR_SERIES_1 XADC_XPRE_XRN_N7  VSS) res_high_po_5p73 r=4.97951K l=86.99u w=5.73u
XADC_XPRE_XRN_XR6_XR_SEG_1 (XADC_XPRE_XRN_N6 XADC_XPRE_XRN_XR6_XR_SERIES_1  VSS) res_high_po_5p73 r=4.97951K l=86.99u w=5.73u
XADC_XPRE_XRN_XR5_XR_SEG_2 (XADC_XPRE_XRN_XR5_XR_SERIES_1 XADC_XPRE_XRN_N6  VSS) res_high_po_5p73 r=4.97951K l=86.99u w=5.73u
XADC_XPRE_XRN_XR5_XR_SEG_1 (XADC_XPRE_XRN_N5 XADC_XPRE_XRN_XR5_XR_SERIES_1  VSS) res_high_po_5p73 r=4.97951K l=86.99u w=5.73u
XADC_XPRE_XRN_XR4_XR_SEG_2 (XADC_XPRE_XRN_XR4_XR_SERIES_1 XADC_XPRE_XRN_N5  VSS) res_high_po_5p73 r=4.97951K l=86.99u w=5.73u
XADC_XPRE_XRN_XR4_XR_SEG_1 (XADC_XPRE_XRN_N4 XADC_XPRE_XRN_XR4_XR_SERIES_1  VSS) res_high_po_5p73 r=4.97951K l=86.99u w=5.73u
XADC_XPRE_XRN_XR3_XR_SEG_2 (XADC_XPRE_XRN_XR3_XR_SERIES_1 XADC_XPRE_XRN_N4  VSS) res_high_po_5p73 r=4.97951K l=86.99u w=5.73u
XADC_XPRE_XRN_XR3_XR_SEG_1 (XADC_XPRE_XRN_N3 XADC_XPRE_XRN_XR3_XR_SERIES_1  VSS) res_high_po_5p73 r=4.97951K l=86.99u w=5.73u
XADC_XPRE_XRN_XR2_XR_SEG_2 (XADC_XPRE_XRN_XR2_XR_SERIES_1 XADC_XPRE_XRN_N3  VSS) res_high_po_5p73 r=4.97951K l=86.99u w=5.73u
XADC_XPRE_XRN_XR2_XR_SEG_1 (XADC_XPRE_XRN_N2 XADC_XPRE_XRN_XR2_XR_SERIES_1  VSS) res_high_po_5p73 r=4.97951K l=86.99u w=5.73u
XADC_XPRE_XRN_XR1_XR_SEG_2 (XADC_XPRE_XRN_XR1_XR_SERIES_1 XADC_XPRE_XRN_N2  VSS) res_high_po_5p73 r=4.97951K l=86.99u w=5.73u
XADC_XPRE_XRN_XR1_XR_SEG_1 (XADC_XPRE_XRN_N1 XADC_XPRE_XRN_XR1_XR_SERIES_1  VSS) res_high_po_5p73 r=4.97951K l=86.99u w=5.73u
XADC_XPRE_XRN_XR0_XR_SEG_2 (XADC_XPRE_XRN_XR0_XR_SERIES_1 XADC_XPRE_XRN_N1  VSS) res_high_po_5p73 r=4.97951K l=86.99u w=5.73u
XADC_XPRE_XRN_XR0_XR_SEG_1 (VDD XADC_XPRE_XRN_XR0_XR_SERIES_1 VSS)  res_high_po_5p73 r=4.97951K l=86.99u w=5.73u
XADC_XPRE_XRP_XR7_XR (XADC_XPRE_XRP_N7 XADC_PREP VSS) res_high_po_5p73  r=4.97951K l=86.99u w=5.73u
XADC_XPRE_XRP_XR6_XR_SEG_2 (XADC_XPRE_XRP_XR6_XR_SERIES_1 XADC_XPRE_XRP_N7  VSS) res_high_po_5p73 r=4.97951K l=86.99u w=5.73u
XADC_XPRE_XRP_XR6_XR_SEG_1 (XADC_XPRE_XRP_N6 XADC_XPRE_XRP_XR6_XR_SERIES_1  VSS) res_high_po_5p73 r=4.97951K l=86.99u w=5.73u
XADC_XPRE_XRP_XR5_XR_SEG_2 (XADC_XPRE_XRP_XR5_XR_SERIES_1 XADC_XPRE_XRP_N6  VSS) res_high_po_5p73 r=4.97951K l=86.99u w=5.73u
XADC_XPRE_XRP_XR5_XR_SEG_1 (XADC_XPRE_XRP_N5 XADC_XPRE_XRP_XR5_XR_SERIES_1  VSS) res_high_po_5p73 r=4.97951K l=86.99u w=5.73u
XADC_XPRE_XRP_XR4_XR_SEG_2 (XADC_XPRE_XRP_XR4_XR_SERIES_1 XADC_XPRE_XRP_N5  VSS) res_high_po_5p73 r=4.97951K l=86.99u w=5.73u
XADC_XPRE_XRP_XR4_XR_SEG_1 (XADC_XPRE_XRP_N4 XADC_XPRE_XRP_XR4_XR_SERIES_1  VSS) res_high_po_5p73 r=4.97951K l=86.99u w=5.73u
XADC_XPRE_XRP_XR3_XR_SEG_2 (XADC_XPRE_XRP_XR3_XR_SERIES_1 XADC_XPRE_XRP_N4  VSS) res_high_po_5p73 r=4.97951K l=86.99u w=5.73u
XADC_XPRE_XRP_XR3_XR_SEG_1 (XADC_XPRE_XRP_N3 XADC_XPRE_XRP_XR3_XR_SERIES_1  VSS) res_high_po_5p73 r=4.97951K l=86.99u w=5.73u
XADC_XPRE_XRP_XR2_XR_SEG_2 (XADC_XPRE_XRP_XR2_XR_SERIES_1 XADC_XPRE_XRP_N3  VSS) res_high_po_5p73 r=4.97951K l=86.99u w=5.73u
XADC_XPRE_XRP_XR2_XR_SEG_1 (XADC_XPRE_XRP_N2 XADC_XPRE_XRP_XR2_XR_SERIES_1  VSS) res_high_po_5p73 r=4.97951K l=86.99u w=5.73u
XADC_XPRE_XRP_XR1_XR_SEG_2 (XADC_XPRE_XRP_XR1_XR_SERIES_1 XADC_XPRE_XRP_N2  VSS) res_high_po_5p73 r=4.97951K l=86.99u w=5.73u
XADC_XPRE_XRP_XR1_XR_SEG_1 (XADC_XPRE_XRP_N1 XADC_XPRE_XRP_XR1_XR_SERIES_1  VSS) res_high_po_5p73 r=4.97951K l=86.99u w=5.73u
XADC_XPRE_XRP_XR0_XR_SEG_2 (XADC_XPRE_XRP_XR0_XR_SERIES_1 XADC_XPRE_XRP_N1  VSS) res_high_po_5p73 r=4.97951K l=86.99u w=5.73u
XADC_XPRE_XRP_XR0_XR_SEG_1 (VDD XADC_XPRE_XRP_XR0_XR_SERIES_1 VSS)  res_high_po_5p73 r=4.97951K l=86.99u w=5.73u
XADC_XPRE_XRBIAS_XR_SEG_2 (XADC_XPRE_XRBIAS_XR_SERIES_1 VSS VSS)  res_high_po_5p73 r=4.97951K l=86.99u w=5.73u
XADC_XPRE_XRBIAS_XR_SEG_1 (XADC_XPRE_BRS XADC_XPRE_XRBIAS_XR_SERIES_1 VSS)  res_high_po_5p73 r=4.97951K l=86.99u w=5.73u
XADC_XCMP_XLOADN_XC (XADC_XCMP_DNEG VSS) cap_mim_m3_1 l=4u w=4u m=16
XADC_XCMP_XLOADP_XC (XADC_XCMP_DPOS VSS) cap_mim_m3_1 l=4u w=4u m=16
XADC_XPRE_XCN_XC (XADC_PREN VSS) cap_mim_m3_1 l=4u w=4u m=4
XADC_XPRE_XCP_XC (XADC_PREP VSS) cap_mim_m3_1 l=4u w=4u m=4
ends p1_actual_cmp_reset1
