; Versioned new-cell generator. Refuses every existing target. No PDK writes.
procedure(p2Type(v)
 if(or(v==t v==nil) then "boolean" else
 case(type(v) (string "string") (fixnum "int") (flonum "float") (t nil))))
procedure(p2Set(inst props callbacks)
 let((cdfgData cdfgForm initProc p cb typ)
  cdfgData=cdfGetInstCDF(inst)
  unless(cdfgData error("CDF missing: %s" inst~>name))
  initProc=cdfgData->formInitProc
  when(and(stringp(initProc) strlen(initProc)>0)
   unless(errset(apply(concat(initProc) list(cdfgData)) t) error("CDF init failed")))
  foreach(pair props
   p=cdfFindParamByName(cdfgData car(pair))
   unless(p error("CDF parameter missing: %s/%s" inst~>name car(pair)))
   p->value=cadr(pair))
  foreach(name callbacks
   p=cdfFindParamByName(cdfgData name)
   cb=p->callback
   when(and(stringp(cb) strlen(cb)>0)
    unless(errset(evalstring(cb) t) error("CDF callback failed: %s/%s" inst~>name name))))
  foreach(p cdfgData->parameters
   typ=p2Type(p->value)
   when(typ dbReplaceProp(inst p->name typ p->value)))
  cdfgData=cdfGetInstCDF(inst)
  foreach(pair props
   p=cdfFindParamByName(cdfgData car(pair))
   unless(p error("CDF value disappeared"))
   if(car(pair)=="connection" then
    unless(p->value==cadr(pair) error("CDF connection changed"))
   else
    unless(abs(if(stringp(p->value) then cdfParseFloatString(p->value) else p->value)-if(stringp(cadr(pair)) then cdfParseFloatString(cadr(pair)) else cadr(pair)))<1e-15
     error("CDF changed requested parameter %s/%s requested=%L actual=%L" inst~>name car(pair) cadr(pair) p->value))))
  p2Readback=cons(list(inst~>name inst~>cellName
   foreach(mapcar p cdfgData->parameters list(p->name p->value))) p2Readback)))
procedure(p2Pin(inst name)
 let((term pin)
  term=dbFindTermByName(inst~>master name)
  unless(term error("Missing pin %s/%s" inst~>name name))
  pin=car(term~>pins)
  dbTransformPoint(centerBox(pin~>fig~>bBox) inst~>transform)))
procedure(p2Create(name objects ports)
 let((cv master inst pt finish wire idx checks pm port pinWire)
  when(ddGetObj("project1" name) error("Target exists; never overwrite %s" name))
  p2Readback=nil
  cv=dbOpenCellViewByType("project1" name "schematic" "schematic" "w")
  unless(cv error("Cannot create target"))
  dbReplaceProp(cv "p2Source" "string" "frontend_school_r3_with_real_adc_20260923")
  dbReplaceProp(cv "p2Qualification" "string" "UNVERIFIED_GENERATED")
  dbSave(cv)
  idx=0
  foreach(obj objects
   master=dbOpenCellViewByType(cadr(obj) caddr(obj) "symbol" "" "r")
   unless(master error("Missing master"))
   inst=dbCreateInst(cv master car(obj) list(mod(idx 6)*12 -floor(idx/6)*5) "R0")
   unless(inst error("Instance creation failed"))
   if(cadr(obj)=="sky130_fd_pr_main" then
    unless(errset(p2Set(inst nth(4 obj) nth(5 obj)) t)
     dbSave(cv) error("Sizing failed; partial target retained"))
   else foreach(pair nth(4 obj) dbReplaceProp(inst car(pair) p2Type(cadr(pair)) cadr(pair))))
   foreach(pair nth(3 obj)
    pt=p2Pin(inst car(pair))
    cond((member(car(pair) list("IN1" "IN2")) finish=list(xCoord(pt)-0.75 yCoord(pt)))
         (member(car(pair) list("OUT1" "OUT2")) finish=list(xCoord(pt)+0.75 yCoord(pt)))
         (car(pair)=="G" finish=list(xCoord(pt)-0.75 yCoord(pt)))
         (car(pair)=="B" finish=list(xCoord(pt)+0.75 yCoord(pt)))
         (member(car(pair) list("D" "S"))
          finish=list(xCoord(pt) yCoord(pt)+if(yCoord(pt)>yCoord(inst~>xy) 0.5 -0.5)))
         (car(pair)=="PLUS" finish=list(xCoord(pt) yCoord(pt)+0.5))
         (t finish=list(xCoord(pt) yCoord(pt)-0.5)))
    wire=schCreateWire(cv "draw" "full" list(pt finish) 0.0625 0.0625 0.0)
    unless(wire error("Wire failed"))
    if(cadr(pair)=="0" then
     dbCreateInst(cv dbOpenCellViewByType("analogLib" "gnd" "symbol" "" "r") nil finish "R0")
    else
     unless(schCreateWireLabel(cv car(wire) finish cadr(pair) "lowerLeft" "R0" "stick" 0.0625 nil)
      error("Net label failed"))))
   dbSave(cv) dbClose(master)
   idx=idx+1)
  pm=dbOpenCellViewByType("basic" "iopin" "symbol" "" "r")
  unless(pm error("Missing schematic pin master"))
  idx=0
  foreach(port ports
   pt=list(-4 2-idx*0.75)
   unless(schCreatePin(cv pm port "inputOutput" nil pt "R0") error("Schematic port failed"))
   finish=list(xCoord(pt)+0.5 yCoord(pt))
   pinWire=schCreateWire(cv "draw" "full" list(pt finish) 0.0625 0.0625 0.0)
   unless(pinWire error("Port wire failed"))
   unless(schCreateWireLabel(cv car(pinWire) finish port "lowerLeft" "R0" "stick" 0.0625 nil) error("Port label failed"))
   idx=idx+1)
  dbClose(pm)
  checks=schCheck(cv)
  dbSave(cv) dbClose(cv)
  list(name checks reverse(p2Readback))))

procedure(p2adcSymbol(name ports)
 let((cv pm idx pt height)
  when(ddGetObj("project1" name "symbol") error("Symbol exists; refuse overwrite"))
  cv=dbOpenCellViewByType("project1" name "symbol" "schematicSymbol" "w")
  unless(cv error("Symbol open failed"))
  pm=dbOpenCellViewByType("basic" "sympin" "symbolNN" "" "r")
  unless(pm error("Symbol pin master missing"))
  height=max(2.0 (length(ports)+1)*0.375)
  dbCreateRect(cv list("device" "drawing") list(list(0 0) list(5 height)))
  idx=0
  foreach(port ports
   pt=list(0 height-0.375-idx*0.375)
   unless(schCreateSymbolPin(cv pm port "inputOutput" pt "R0") error("Symbol pin failed"))
   dbCreateLabel(cv list("device" "drawing") list(0.125 yCoord(pt)) port "centerLeft" "R0" "stick" 0.1)
   idx=idx+1)
  dbCreateLabel(cv list("device" "drawing") list(2.5 height+0.25) name "centerCenter" "R0" "stick" 0.125)
  dbReplaceProp(cv "p2Source" "string" "frontend_school_r3_with_real_adc_20260923")
  dbSave(cv) dbClose(cv) dbClose(pm)
  t))

when(ddGetObj("project1" "p2adc_frontend_school_r3") error("Existing target; refuse overwrite"))
p2adcOne=p2Create("p2adc_frontend_school_r3" list(list("XPGA_XI0_XN" "sky130_fd_pr_main" "nfet_01v8" list(list("D" "XPGA_S0B") list("G" "SEL0") list("S" "VSS") list("B" "VSS")) list(list("w" "2u") list("fw" "2u") list("l" "0.15u") list("fingers" "1") list("m" "1")) list("fingers" "l" "fw" "m")) list("XPGA_XI0_XP" "sky130_fd_pr_main" "pfet_01v8" list(list("D" "XPGA_S0B") list("G" "SEL0") list("S" "VDD") list("B" "VDD")) list(list("w" "4u") list("fw" "4u") list("l" "0.15u") list("fingers" "1") list("m" "1")) list("fingers" "l" "fw" "m")) list("XPGA_XI1_XN" "sky130_fd_pr_main" "nfet_01v8" list(list("D" "XPGA_S1B") list("G" "SEL1") list("S" "VSS") list("B" "VSS")) list(list("w" "2u") list("fw" "2u") list("l" "0.15u") list("fingers" "1") list("m" "1")) list("fingers" "l" "fw" "m")) list("XPGA_XI1_XP" "sky130_fd_pr_main" "pfet_01v8" list(list("D" "XPGA_S1B") list("G" "SEL1") list("S" "VDD") list("B" "VDD")) list(list("w" "4u") list("fw" "4u") list("l" "0.15u") list("fingers" "1") list("m" "1")) list("fingers" "l" "fw" "m")) list("XPGA_XN1_XN0" "sky130_fd_pr_main" "nfet_01v8" list(list("D" "XPGA_E1B") list("G" "XPGA_S0B") list("S" "XPGA_XN1_N") list("B" "VSS")) list(list("w" "2u") list("fw" "2u") list("l" "0.15u") list("fingers" "1") list("m" "1")) list("fingers" "l" "fw" "m")) list("XPGA_XN1_XN1" "sky130_fd_pr_main" "nfet_01v8" list(list("D" "XPGA_XN1_N") list("G" "XPGA_S1B") list("S" "VSS") list("B" "VSS")) list(list("w" "2u") list("fw" "2u") list("l" "0.15u") list("fingers" "1") list("m" "1")) list("fingers" "l" "fw" "m")) list("XPGA_XN1_XP0" "sky130_fd_pr_main" "pfet_01v8" list(list("D" "XPGA_E1B") list("G" "XPGA_S0B") list("S" "VDD") list("B" "VDD")) list(list("w" "4u") list("fw" "4u") list("l" "0.15u") list("fingers" "1") list("m" "1")) list("fingers" "l" "fw" "m")) list("XPGA_XN1_XP1" "sky130_fd_pr_main" "pfet_01v8" list(list("D" "XPGA_E1B") list("G" "XPGA_S1B") list("S" "VDD") list("B" "VDD")) list(list("w" "4u") list("fw" "4u") list("l" "0.15u") list("fingers" "1") list("m" "1")) list("fingers" "l" "fw" "m")) list("XPGA_XN4_XN0" "sky130_fd_pr_main" "nfet_01v8" list(list("D" "XPGA_E4B") list("G" "SEL0") list("S" "XPGA_XN4_N") list("B" "VSS")) list(list("w" "2u") list("fw" "2u") list("l" "0.15u") list("fingers" "1") list("m" "1")) list("fingers" "l" "fw" "m")) list("XPGA_XN4_XN1" "sky130_fd_pr_main" "nfet_01v8" list(list("D" "XPGA_XN4_N") list("G" "XPGA_S1B") list("S" "VSS") list("B" "VSS")) list(list("w" "2u") list("fw" "2u") list("l" "0.15u") list("fingers" "1") list("m" "1")) list("fingers" "l" "fw" "m")) list("XPGA_XN4_XP0" "sky130_fd_pr_main" "pfet_01v8" list(list("D" "XPGA_E4B") list("G" "SEL0") list("S" "VDD") list("B" "VDD")) list(list("w" "4u") list("fw" "4u") list("l" "0.15u") list("fingers" "1") list("m" "1")) list("fingers" "l" "fw" "m")) list("XPGA_XN4_XP1" "sky130_fd_pr_main" "pfet_01v8" list(list("D" "XPGA_E4B") list("G" "XPGA_S1B") list("S" "VDD") list("B" "VDD")) list(list("w" "4u") list("fw" "4u") list("l" "0.15u") list("fingers" "1") list("m" "1")) list("fingers" "l" "fw" "m")) list("XPGA_XN16_XN0" "sky130_fd_pr_main" "nfet_01v8" list(list("D" "XPGA_E16B") list("G" "XPGA_S0B") list("S" "XPGA_XN16_N") list("B" "VSS")) list(list("w" "2u") list("fw" "2u") list("l" "0.15u") list("fingers" "1") list("m" "1")) list("fingers" "l" "fw" "m")) list("XPGA_XN16_XN1" "sky130_fd_pr_main" "nfet_01v8" list(list("D" "XPGA_XN16_N") list("G" "SEL1") list("S" "VSS") list("B" "VSS")) list(list("w" "2u") list("fw" "2u") list("l" "0.15u") list("fingers" "1") list("m" "1")) list("fingers" "l" "fw" "m")) list("XPGA_XN16_XP0" "sky130_fd_pr_main" "pfet_01v8" list(list("D" "XPGA_E16B") list("G" "XPGA_S0B") list("S" "VDD") list("B" "VDD")) list(list("w" "4u") list("fw" "4u") list("l" "0.15u") list("fingers" "1") list("m" "1")) list("fingers" "l" "fw" "m")) list("XPGA_XN16_XP1" "sky130_fd_pr_main" "pfet_01v8" list(list("D" "XPGA_E16B") list("G" "SEL1") list("S" "VDD") list("B" "VDD")) list(list("w" "4u") list("fw" "4u") list("l" "0.15u") list("fingers" "1") list("m" "1")) list("fingers" "l" "fw" "m")) list("XPGA_XIE1_XN" "sky130_fd_pr_main" "nfet_01v8" list(list("D" "XPGA_E1") list("G" "XPGA_E1B") list("S" "VSS") list("B" "VSS")) list(list("w" "2u") list("fw" "2u") list("l" "0.15u") list("fingers" "1") list("m" "1")) list("fingers" "l" "fw" "m")) list("XPGA_XIE1_XP" "sky130_fd_pr_main" "pfet_01v8" list(list("D" "XPGA_E1") list("G" "XPGA_E1B") list("S" "VDD") list("B" "VDD")) list(list("w" "4u") list("fw" "4u") list("l" "0.15u") list("fingers" "1") list("m" "1")) list("fingers" "l" "fw" "m")) list("XPGA_XIE4_XN" "sky130_fd_pr_main" "nfet_01v8" list(list("D" "XPGA_E4") list("G" "XPGA_E4B") list("S" "VSS") list("B" "VSS")) list(list("w" "2u") list("fw" "2u") list("l" "0.15u") list("fingers" "1") list("m" "1")) list("fingers" "l" "fw" "m")) list("XPGA_XIE4_XP" "sky130_fd_pr_main" "pfet_01v8" list(list("D" "XPGA_E4") list("G" "XPGA_E4B") list("S" "VDD") list("B" "VDD")) list(list("w" "4u") list("fw" "4u") list("l" "0.15u") list("fingers" "1") list("m" "1")) list("fingers" "l" "fw" "m")) list("XPGA_XIE16_XN" "sky130_fd_pr_main" "nfet_01v8" list(list("D" "XPGA_E16") list("G" "XPGA_E16B") list("S" "VSS") list("B" "VSS")) list(list("w" "2u") list("fw" "2u") list("l" "0.15u") list("fingers" "1") list("m" "1")) list("fingers" "l" "fw" "m")) list("XPGA_XIE16_XP" "sky130_fd_pr_main" "pfet_01v8" list(list("D" "XPGA_E16") list("G" "XPGA_E16B") list("S" "VDD") list("B" "VDD")) list(list("w" "4u") list("fw" "4u") list("l" "0.15u") list("fingers" "1") list("m" "1")) list("fingers" "l" "fw" "m")) list("XPGA_XRINP_XR" "sky130_fd_pr_main" "res_high_po_0p35" list(list("PLUS" "IP") list("MINUS" "XPGA_SUMPOS") list("B" "VSS")) list(list("segL" "9.105u") list("segW" "0.35u") list("segments" 1) list("connection" "Series")) list("segL")) list("XPGA_XRINN_XR" "sky130_fd_pr_main" "res_high_po_0p35" list(list("PLUS" "IN") list("MINUS" "XPGA_SUMNEG") list("B" "VSS")) list(list("segL" "9.105u") list("segW" "0.35u") list("segments" 1) list("connection" "Series")) list("segL")) list("XPGA_XFP1_XR_XR" "sky130_fd_pr_main" "res_high_po_0p35" list(list("PLUS" "ON") list("MINUS" "XPGA_XFP1_N") list("B" "VSS")) list(list("segL" "8.895u") list("segW" "0.35u") list("segments" 1) list("connection" "Series")) list("segL")) list("XPGA_XFP1_XSW_XN" "sky130_fd_pr_main" "nfet_01v8" list(list("D" "XPGA_SUMPOS") list("G" "XPGA_E1") list("S" "XPGA_XFP1_N") list("B" "VSS")) list(list("w" "12u") list("fw" "12u") list("l" "0.15u") list("fingers" "1") list("m" "1")) list("fingers" "l" "fw" "m")) list("XPGA_XFP1_XSW_XP" "sky130_fd_pr_main" "pfet_01v8" list(list("D" "XPGA_SUMPOS") list("G" "XPGA_E1B") list("S" "XPGA_XFP1_N") list("B" "VDD")) list(list("w" "24u") list("fw" "24u") list("l" "0.15u") list("fingers" "1") list("m" "1")) list("fingers" "l" "fw" "m")) list("XPGA_XFN1_XR_XR" "sky130_fd_pr_main" "res_high_po_0p35" list(list("PLUS" "OP") list("MINUS" "XPGA_XFN1_N") list("B" "VSS")) list(list("segL" "8.895u") list("segW" "0.35u") list("segments" 1) list("connection" "Series")) list("segL")) list("XPGA_XFN1_XSW_XN" "sky130_fd_pr_main" "nfet_01v8" list(list("D" "XPGA_SUMNEG") list("G" "XPGA_E1") list("S" "XPGA_XFN1_N") list("B" "VSS")) list(list("w" "12u") list("fw" "12u") list("l" "0.15u") list("fingers" "1") list("m" "1")) list("fingers" "l" "fw" "m")) list("XPGA_XFN1_XSW_XP" "sky130_fd_pr_main" "pfet_01v8" list(list("D" "XPGA_SUMNEG") list("G" "XPGA_E1B") list("S" "XPGA_XFN1_N") list("B" "VDD")) list(list("w" "24u") list("fw" "24u") list("l" "0.15u") list("fingers" "1") list("m" "1")) list("fingers" "l" "fw" "m")) list("XPGA_XFP4_XR_XR" "sky130_fd_pr_main" "res_high_po_0p35" list(list("PLUS" "ON") list("MINUS" "XPGA_XFP4_N") list("B" "VSS")) list(list("segL" "38.95u") list("segW" "0.35u") list("segments" 1) list("connection" "Series")) list("segL")) list("XPGA_XFP4_XSW_XN" "sky130_fd_pr_main" "nfet_01v8" list(list("D" "XPGA_SUMPOS") list("G" "XPGA_E4") list("S" "XPGA_XFP4_N") list("B" "VSS")) list(list("w" "12u") list("fw" "12u") list("l" "0.15u") list("fingers" "1") list("m" "1")) list("fingers" "l" "fw" "m")) list("XPGA_XFP4_XSW_XP" "sky130_fd_pr_main" "pfet_01v8" list(list("D" "XPGA_SUMPOS") list("G" "XPGA_E4B") list("S" "XPGA_XFP4_N") list("B" "VDD")) list(list("w" "24u") list("fw" "24u") list("l" "0.15u") list("fingers" "1") list("m" "1")) list("fingers" "l" "fw" "m")) list("XPGA_XFN4_XR_XR" "sky130_fd_pr_main" "res_high_po_0p35" list(list("PLUS" "OP") list("MINUS" "XPGA_XFN4_N") list("B" "VSS")) list(list("segL" "38.95u") list("segW" "0.35u") list("segments" 1) list("connection" "Series")) list("segL")) list("XPGA_XFN4_XSW_XN" "sky130_fd_pr_main" "nfet_01v8" list(list("D" "XPGA_SUMNEG") list("G" "XPGA_E4") list("S" "XPGA_XFN4_N") list("B" "VSS")) list(list("w" "12u") list("fw" "12u") list("l" "0.15u") list("fingers" "1") list("m" "1")) list("fingers" "l" "fw" "m")) list("XPGA_XFN4_XSW_XP" "sky130_fd_pr_main" "pfet_01v8" list(list("D" "XPGA_SUMNEG") list("G" "XPGA_E4B") list("S" "XPGA_XFN4_N") list("B" "VDD")) list(list("w" "24u") list("fw" "24u") list("l" "0.15u") list("fingers" "1") list("m" "1")) list("fingers" "l" "fw" "m")) list("XPGA_XFP16_XR_XR_SEG_01" "sky130_fd_pr_main" "res_high_po_0p35" list(list("PLUS" "ON") list("MINUS" "XPGA_XFP16_XR_XR_SERIES_NODE_01") list("B" "VSS")) list(list("segL" "79.425u") list("segW" "0.35u") list("segments" 1) list("connection" "Series")) list("segL")) list("XPGA_XFP16_XR_XR_SEG_02" "sky130_fd_pr_main" "res_high_po_0p35" list(list("PLUS" "XPGA_XFP16_XR_XR_SERIES_NODE_01") list("MINUS" "XPGA_XFP16_N") list("B" "VSS")) list(list("segL" "79.425u") list("segW" "0.35u") list("segments" 1) list("connection" "Series")) list("segL")) list("XPGA_XFP16_XSW_XN" "sky130_fd_pr_main" "nfet_01v8" list(list("D" "XPGA_SUMPOS") list("G" "XPGA_E16") list("S" "XPGA_XFP16_N") list("B" "VSS")) list(list("w" "12u") list("fw" "12u") list("l" "0.15u") list("fingers" "1") list("m" "1")) list("fingers" "l" "fw" "m")) list("XPGA_XFP16_XSW_XP" "sky130_fd_pr_main" "pfet_01v8" list(list("D" "XPGA_SUMPOS") list("G" "XPGA_E16B") list("S" "XPGA_XFP16_N") list("B" "VDD")) list(list("w" "24u") list("fw" "24u") list("l" "0.15u") list("fingers" "1") list("m" "1")) list("fingers" "l" "fw" "m")) list("XPGA_XFN16_XR_XR_SEG_01" "sky130_fd_pr_main" "res_high_po_0p35" list(list("PLUS" "OP") list("MINUS" "XPGA_XFN16_XR_XR_SERIES_NODE_01") list("B" "VSS")) list(list("segL" "79.425u") list("segW" "0.35u") list("segments" 1) list("connection" "Series")) list("segL")) list("XPGA_XFN16_XR_XR_SEG_02" "sky130_fd_pr_main" "res_high_po_0p35" list(list("PLUS" "XPGA_XFN16_XR_XR_SERIES_NODE_01") list("MINUS" "XPGA_XFN16_N") list("B" "VSS")) list(list("segL" "79.425u") list("segW" "0.35u") list("segments" 1) list("connection" "Series")) list("segL")) list("XPGA_XFN16_XSW_XN" "sky130_fd_pr_main" "nfet_01v8" list(list("D" "XPGA_SUMNEG") list("G" "XPGA_E16") list("S" "XPGA_XFN16_N") list("B" "VSS")) list(list("w" "12u") list("fw" "12u") list("l" "0.15u") list("fingers" "1") list("m" "1")) list("fingers" "l" "fw" "m")) list("XPGA_XFN16_XSW_XP" "sky130_fd_pr_main" "pfet_01v8" list(list("D" "XPGA_SUMNEG") list("G" "XPGA_E16B") list("S" "XPGA_XFN16_N") list("B" "VDD")) list(list("w" "24u") list("fw" "24u") list("l" "0.15u") list("fingers" "1") list("m" "1")) list("fingers" "l" "fw" "m")) list("XPGA_XOTA_XBIAS_XRBN_XR" "sky130_fd_pr_main" "res_high_po_0p35" list(list("PLUS" "VDD") list("MINUS" "XPGA_XOTA_BN") list("B" "VSS")) list(list("segL" "23.2u") list("segW" "0.35u") list("segments" 1) list("connection" "Series")) list("segL")) list("XPGA_XOTA_XBIAS_XDBN" "sky130_fd_pr_main" "nfet_01v8" list(list("D" "XPGA_XOTA_BN") list("G" "XPGA_XOTA_BN") list("S" "VSS") list("B" "VSS")) list(list("w" "20u") list("fw" "20u") list("l" "1u") list("fingers" "1") list("m" "1")) list("fingers" "l" "fw" "m")) list("XPGA_XOTA_XBIAS_XRBP_XR_SEG_01" "sky130_fd_pr_main" "res_high_po_0p35" list(list("PLUS" "XPGA_XOTA_BP") list("MINUS" "XPGA_XOTA_XBIAS_XRBP_XR_SERIES_NODE_01") list("B" "VSS")) list(list("segL" "90.58u") list("segW" "0.35u") list("segments" 1) list("connection" "Series")) list("segL")) list("XPGA_XOTA_XBIAS_XRBP_XR_SEG_02" "sky130_fd_pr_main" "res_high_po_0p35" list(list("PLUS" "XPGA_XOTA_XBIAS_XRBP_XR_SERIES_NODE_01") list("MINUS" "XPGA_XOTA_XBIAS_XRBP_XR_SERIES_NODE_02") list("B" "VSS")) list(list("segL" "90.58u") list("segW" "0.35u") list("segments" 1) list("connection" "Series")) list("segL")) list("XPGA_XOTA_XBIAS_XRBP_XR_SEG_03" "sky130_fd_pr_main" "res_high_po_0p35" list(list("PLUS" "XPGA_XOTA_XBIAS_XRBP_XR_SERIES_NODE_02") list("MINUS" "XPGA_XOTA_XBIAS_XRBP_XR_SERIES_NODE_03") list("B" "VSS")) list(list("segL" "90.58u") list("segW" "0.35u") list("segments" 1) list("connection" "Series")) list("segL")) list("XPGA_XOTA_XBIAS_XRBP_XR_SEG_04" "sky130_fd_pr_main" "res_high_po_0p35" list(list("PLUS" "XPGA_XOTA_XBIAS_XRBP_XR_SERIES_NODE_03") list("MINUS" "XPGA_XOTA_XBIAS_XRBP_XR_SERIES_NODE_04") list("B" "VSS")) list(list("segL" "90.58u") list("segW" "0.35u") list("segments" 1) list("connection" "Series")) list("segL")) list("XPGA_XOTA_XBIAS_XRBP_XR_SEG_05" "sky130_fd_pr_main" "res_high_po_0p35" list(list("PLUS" "XPGA_XOTA_XBIAS_XRBP_XR_SERIES_NODE_04") list("MINUS" "XPGA_XOTA_XBIAS_XRBP_XR_SERIES_NODE_05") list("B" "VSS")) list(list("segL" "90.58u") list("segW" "0.35u") list("segments" 1) list("connection" "Series")) list("segL")) list("XPGA_XOTA_XBIAS_XRBP_XR_SEG_06" "sky130_fd_pr_main" "res_high_po_0p35" list(list("PLUS" "XPGA_XOTA_XBIAS_XRBP_XR_SERIES_NODE_05") list("MINUS" "XPGA_XOTA_XBIAS_XRBP_XR_SERIES_NODE_06") list("B" "VSS")) list(list("segL" "90.58u") list("segW" "0.35u") list("segments" 1) list("connection" "Series")) list("segL")) list("XPGA_XOTA_XBIAS_XRBP_XR_SEG_07" "sky130_fd_pr_main" "res_high_po_0p35" list(list("PLUS" "XPGA_XOTA_XBIAS_XRBP_XR_SERIES_NODE_06") list("MINUS" "XPGA_XOTA_XBIAS_XRBP_XR_SERIES_NODE_07") list("B" "VSS")) list(list("segL" "90.58u") list("segW" "0.35u") list("segments" 1) list("connection" "Series")) list("segL")) list("XPGA_XOTA_XBIAS_XRBP_XR_SEG_08" "sky130_fd_pr_main" "res_high_po_0p35" list(list("PLUS" "XPGA_XOTA_XBIAS_XRBP_XR_SERIES_NODE_07") list("MINUS" "XPGA_XOTA_XBIAS_XRBP_XR_SERIES_NODE_08") list("B" "VSS")) list(list("segL" "90.58u") list("segW" "0.35u") list("segments" 1) list("connection" "Series")) list("segL")) list("XPGA_XOTA_XBIAS_XRBP_XR_SEG_09" "sky130_fd_pr_main" "res_high_po_0p35" list(list("PLUS" "XPGA_XOTA_XBIAS_XRBP_XR_SERIES_NODE_08") list("MINUS" "XPGA_XOTA_XBIAS_XRBP_XR_SERIES_NODE_09") list("B" "VSS")) list(list("segL" "90.58u") list("segW" "0.35u") list("segments" 1) list("connection" "Series")) list("segL")) list("XPGA_XOTA_XBIAS_XRBP_XR_SEG_10" "sky130_fd_pr_main" "res_high_po_0p35" list(list("PLUS" "XPGA_XOTA_XBIAS_XRBP_XR_SERIES_NODE_09") list("MINUS" "XPGA_XOTA_XBIAS_XRBP_XR_SERIES_NODE_10") list("B" "VSS")) list(list("segL" "90.58u") list("segW" "0.35u") list("segments" 1) list("connection" "Series")) list("segL")) list("XPGA_XOTA_XBIAS_XRBP_XR_SEG_11" "sky130_fd_pr_main" "res_high_po_0p35" list(list("PLUS" "XPGA_XOTA_XBIAS_XRBP_XR_SERIES_NODE_10") list("MINUS" "XPGA_XOTA_BN") list("B" "VSS")) list(list("segL" "90.58u") list("segW" "0.35u") list("segments" 1) list("connection" "Series")) list("segL")) list("XPGA_XOTA_XMIP" "sky130_fd_pr_main" "nfet_01v8" list(list("D" "XPGA_XOTA_N1") list("G" "XPGA_SUMPOS") list("S" "XPGA_XOTA_TAIL") list("B" "VSS")) list(list("w" "80u") list("fw" "40u") list("l" "1u") list("fingers" "2") list("m" "1")) list("fingers" "l" "fw" "m")) list("XPGA_XOTA_XMIN" "sky130_fd_pr_main" "nfet_01v8" list(list("D" "XPGA_XOTA_N2") list("G" "XPGA_SUMNEG") list("S" "XPGA_XOTA_TAIL") list("B" "VSS")) list(list("w" "80u") list("fw" "40u") list("l" "1u") list("fingers" "2") list("m" "1")) list("fingers" "l" "fw" "m")) list("XPGA_XOTA_XMTAIL" "sky130_fd_pr_main" "nfet_01v8" list(list("D" "XPGA_XOTA_TAIL") list("G" "XPGA_XOTA_BN") list("S" "VSS") list("B" "VSS")) list(list("w" "40u") list("fw" "40u") list("l" "1u") list("fingers" "1") list("m" "1")) list("fingers" "l" "fw" "m")) list("XPGA_XOTA_XMLP" "sky130_fd_pr_main" "pfet_01v8" list(list("D" "XPGA_XOTA_N1") list("G" "XPGA_XOTA_NCM") list("S" "VDD") list("B" "VDD")) list(list("w" "64u") list("fw" "32u") list("l" "1u") list("fingers" "2") list("m" "1")) list("fingers" "l" "fw" "m")) list("XPGA_XOTA_XMLN" "sky130_fd_pr_main" "pfet_01v8" list(list("D" "XPGA_XOTA_N2") list("G" "XPGA_XOTA_NCM") list("S" "VDD") list("B" "VDD")) list(list("w" "64u") list("fw" "32u") list("l" "1u") list("fingers" "2") list("m" "1")) list("fingers" "l" "fw" "m")) list("XPGA_XOTA_XRN1_XR" "sky130_fd_pr_main" "res_high_po_0p35" list(list("PLUS" "XPGA_XOTA_N1") list("MINUS" "XPGA_XOTA_NCM") list("B" "VSS")) list(list("segL" "99.735u") list("segW" "0.35u") list("segments" 1) list("connection" "Series")) list("segL")) list("XPGA_XOTA_XRN2_XR" "sky130_fd_pr_main" "res_high_po_0p35" list(list("PLUS" "XPGA_XOTA_N2") list("MINUS" "XPGA_XOTA_NCM") list("B" "VSS")) list(list("segL" "99.735u") list("segW" "0.35u") list("segments" 1) list("connection" "Series")) list("segL")) list("XPGA_XOTA_XCN1_XC" "sky130_fd_pr_main" "cap_mim_m3__base" list(list("PLUS" "XPGA_XOTA_N1") list("MINUS" "XPGA_XOTA_NCM")) list(list("w" "22.215u") list("l" "22.215u") list("m" "1")) list("w" "l" "m")) list("XPGA_XOTA_XCN2_XC" "sky130_fd_pr_main" "cap_mim_m3__base" list(list("PLUS" "XPGA_XOTA_N2") list("MINUS" "XPGA_XOTA_NCM")) list(list("w" "22.215u") list("l" "22.215u") list("m" "1")) list("w" "l" "m")) list("XPGA_XOTA_XMSP" "sky130_fd_pr_main" "pfet_01v8" list(list("D" "OP") list("G" "XPGA_XOTA_N1") list("S" "VDD") list("B" "VDD")) list(list("w" "180u") list("fw" "45u") list("l" "1u") list("fingers" "4") list("m" "1")) list("fingers" "l" "fw" "m")) list("XPGA_XOTA_XMSN" "sky130_fd_pr_main" "pfet_01v8" list(list("D" "ON") list("G" "XPGA_XOTA_N2") list("S" "VDD") list("B" "VDD")) list(list("w" "180u") list("fw" "45u") list("l" "1u") list("fingers" "4") list("m" "1")) list("fingers" "l" "fw" "m")) list("XPGA_XOTA_XMOP" "sky130_fd_pr_main" "nfet_01v8" list(list("D" "OP") list("G" "XPGA_XOTA_CMG") list("S" "VSS") list("B" "VSS")) list(list("w" "9u") list("fw" "9u") list("l" "1u") list("fingers" "1") list("m" "1")) list("fingers" "l" "fw" "m")) list("XPGA_XOTA_XMON" "sky130_fd_pr_main" "nfet_01v8" list(list("D" "ON") list("G" "XPGA_XOTA_CMG") list("S" "VSS") list("B" "VSS")) list(list("w" "9u") list("fw" "9u") list("l" "1u") list("fingers" "1") list("m" "1")) list("fingers" "l" "fw" "m")) list("XPGA_XOTA_XRZP_XR" "sky130_fd_pr_main" "res_high_po_0p69" list(list("PLUS" "XPGA_XOTA_N1") list("MINUS" "XPGA_XOTA_CZP") list("B" "VSS")) list(list("segL" "0.855u") list("segW" "0.69u") list("segments" 1) list("connection" "Series")) list("segL")) list("XPGA_XOTA_XRZN_XR" "sky130_fd_pr_main" "res_high_po_0p69" list(list("PLUS" "XPGA_XOTA_N2") list("MINUS" "XPGA_XOTA_CZN") list("B" "VSS")) list(list("segL" "0.855u") list("segW" "0.69u") list("segments" 1) list("connection" "Series")) list("segL")) list("XPGA_XOTA_XCCP_XC0_XC0_XC" "sky130_fd_pr_main" "cap_mim_m3__base" list(list("PLUS" "XPGA_XOTA_CZP") list("MINUS" "OP")) list(list("w" "22.215u") list("l" "22.215u") list("m" "1")) list("w" "l" "m")) list("XPGA_XOTA_XCCP_XC0_XC1_XC" "sky130_fd_pr_main" "cap_mim_m3__base" list(list("PLUS" "XPGA_XOTA_CZP") list("MINUS" "OP")) list(list("w" "22.215u") list("l" "22.215u") list("m" "1")) list("w" "l" "m")) list("XPGA_XOTA_XCCP_XC0_XC2_XC" "sky130_fd_pr_main" "cap_mim_m3__base" list(list("PLUS" "XPGA_XOTA_CZP") list("MINUS" "OP")) list(list("w" "22.215u") list("l" "22.215u") list("m" "1")) list("w" "l" "m")) list("XPGA_XOTA_XCCP_XC0_XC3_XC" "sky130_fd_pr_main" "cap_mim_m3__base" list(list("PLUS" "XPGA_XOTA_CZP") list("MINUS" "OP")) list(list("w" "22.215u") list("l" "22.215u") list("m" "1")) list("w" "l" "m")) list("XPGA_XOTA_XCCP_XC1_XC0_XC" "sky130_fd_pr_main" "cap_mim_m3__base" list(list("PLUS" "XPGA_XOTA_CZP") list("MINUS" "OP")) list(list("w" "22.215u") list("l" "22.215u") list("m" "1")) list("w" "l" "m")) list("XPGA_XOTA_XCCP_XC1_XC1_XC" "sky130_fd_pr_main" "cap_mim_m3__base" list(list("PLUS" "XPGA_XOTA_CZP") list("MINUS" "OP")) list(list("w" "22.215u") list("l" "22.215u") list("m" "1")) list("w" "l" "m")) list("XPGA_XOTA_XCCP_XC1_XC2_XC" "sky130_fd_pr_main" "cap_mim_m3__base" list(list("PLUS" "XPGA_XOTA_CZP") list("MINUS" "OP")) list(list("w" "22.215u") list("l" "22.215u") list("m" "1")) list("w" "l" "m")) list("XPGA_XOTA_XCCP_XC1_XC3_XC" "sky130_fd_pr_main" "cap_mim_m3__base" list(list("PLUS" "XPGA_XOTA_CZP") list("MINUS" "OP")) list(list("w" "22.215u") list("l" "22.215u") list("m" "1")) list("w" "l" "m")) list("XPGA_XOTA_XCCN_XC0_XC0_XC" "sky130_fd_pr_main" "cap_mim_m3__base" list(list("PLUS" "XPGA_XOTA_CZN") list("MINUS" "ON")) list(list("w" "22.215u") list("l" "22.215u") list("m" "1")) list("w" "l" "m")) list("XPGA_XOTA_XCCN_XC0_XC1_XC" "sky130_fd_pr_main" "cap_mim_m3__base" list(list("PLUS" "XPGA_XOTA_CZN") list("MINUS" "ON")) list(list("w" "22.215u") list("l" "22.215u") list("m" "1")) list("w" "l" "m")) list("XPGA_XOTA_XCCN_XC0_XC2_XC" "sky130_fd_pr_main" "cap_mim_m3__base" list(list("PLUS" "XPGA_XOTA_CZN") list("MINUS" "ON")) list(list("w" "22.215u") list("l" "22.215u") list("m" "1")) list("w" "l" "m")) list("XPGA_XOTA_XCCN_XC0_XC3_XC" "sky130_fd_pr_main" "cap_mim_m3__base" list(list("PLUS" "XPGA_XOTA_CZN") list("MINUS" "ON")) list(list("w" "22.215u") list("l" "22.215u") list("m" "1")) list("w" "l" "m")) list("XPGA_XOTA_XCCN_XC1_XC0_XC" "sky130_fd_pr_main" "cap_mim_m3__base" list(list("PLUS" "XPGA_XOTA_CZN") list("MINUS" "ON")) list(list("w" "22.215u") list("l" "22.215u") list("m" "1")) list("w" "l" "m")) list("XPGA_XOTA_XCCN_XC1_XC1_XC" "sky130_fd_pr_main" "cap_mim_m3__base" list(list("PLUS" "XPGA_XOTA_CZN") list("MINUS" "ON")) list(list("w" "22.215u") list("l" "22.215u") list("m" "1")) list("w" "l" "m")) list("XPGA_XOTA_XCCN_XC1_XC2_XC" "sky130_fd_pr_main" "cap_mim_m3__base" list(list("PLUS" "XPGA_XOTA_CZN") list("MINUS" "ON")) list(list("w" "22.215u") list("l" "22.215u") list("m" "1")) list("w" "l" "m")) list("XPGA_XOTA_XCCN_XC1_XC3_XC" "sky130_fd_pr_main" "cap_mim_m3__base" list(list("PLUS" "XPGA_XOTA_CZN") list("MINUS" "ON")) list(list("w" "22.215u") list("l" "22.215u") list("m" "1")) list("w" "l" "m")) list("XPGA_XOTA_XRCMP_XR" "sky130_fd_pr_main" "res_high_po_0p35" list(list("PLUS" "OP") list("MINUS" "XPGA_XOTA_CMS") list("B" "VSS")) list(list("segL" "99.735u") list("segW" "0.35u") list("segments" 1) list("connection" "Series")) list("segL")) list("XPGA_XOTA_XRCMN_XR" "sky130_fd_pr_main" "res_high_po_0p35" list(list("PLUS" "ON") list("MINUS" "XPGA_XOTA_CMS") list("B" "VSS")) list(list("segL" "99.735u") list("segW" "0.35u") list("segments" 1) list("connection" "Series")) list("segL")) list("XPGA_XOTA_XCSMP_XC" "sky130_fd_pr_main" "cap_mim_m3__base" list(list("PLUS" "OP") list("MINUS" "XPGA_XOTA_CMS")) list(list("w" "22.215u") list("l" "22.215u") list("m" "1")) list("w" "l" "m")) list("XPGA_XOTA_XCSMN_XC" "sky130_fd_pr_main" "cap_mim_m3__base" list(list("PLUS" "ON") list("MINUS" "XPGA_XOTA_CMS")) list(list("w" "22.215u") list("l" "22.215u") list("m" "1")) list("w" "l" "m")) list("XPGA_XOTA_XCMS" "sky130_fd_pr_main" "nfet_01v8" list(list("D" "XPGA_XOTA_DS") list("G" "XPGA_XOTA_CMS") list("S" "XPGA_XOTA_CS") list("B" "VSS")) list(list("w" "20u") list("fw" "20u") list("l" "1u") list("fingers" "1") list("m" "1")) list("fingers" "l" "fw" "m")) list("XPGA_XOTA_XCMR" "sky130_fd_pr_main" "nfet_01v8" list(list("D" "XPGA_XOTA_CMG") list("G" "VCM") list("S" "XPGA_XOTA_CR") list("B" "VSS")) list(list("w" "20u") list("fw" "20u") list("l" "1u") list("fingers" "1") list("m" "1")) list("fingers" "l" "fw" "m")) list("XPGA_XOTA_XRSCS_XR" "sky130_fd_pr_main" "res_high_po_0p35" list(list("PLUS" "XPGA_XOTA_CS") list("MINUS" "XPGA_XOTA_CTAIL") list("B" "VSS")) list(list("segL" "9.105u") list("segW" "0.35u") list("segments" 1) list("connection" "Series")) list("segL")) list("XPGA_XOTA_XRSCR_XR" "sky130_fd_pr_main" "res_high_po_0p35" list(list("PLUS" "XPGA_XOTA_CR") list("MINUS" "XPGA_XOTA_CTAIL") list("B" "VSS")) list(list("segL" "9.105u") list("segW" "0.35u") list("segments" 1) list("connection" "Series")) list("segL")) list("XPGA_XOTA_XCMT" "sky130_fd_pr_main" "nfet_01v8" list(list("D" "XPGA_XOTA_CTAIL") list("G" "XPGA_XOTA_BN") list("S" "VSS") list("B" "VSS")) list(list("w" "9.2u") list("fw" "9.2u") list("l" "1u") list("fingers" "1") list("m" "1")) list("fingers" "l" "fw" "m")) list("XPGA_XOTA_XRDS_XR_SEG_01" "sky130_fd_pr_main" "res_high_po_0p35" list(list("PLUS" "VDD") list("MINUS" "XPGA_XOTA_XRDS_XR_SERIES_NODE_01") list("B" "VSS")) list(list("segL" "51.9u") list("segW" "0.35u") list("segments" 1) list("connection" "Series")) list("segL")) list("XPGA_XOTA_XRDS_XR_SEG_02" "sky130_fd_pr_main" "res_high_po_0p35" list(list("PLUS" "XPGA_XOTA_XRDS_XR_SERIES_NODE_01") list("MINUS" "XPGA_XOTA_DS") list("B" "VSS")) list(list("segL" "51.9u") list("segW" "0.35u") list("segments" 1) list("connection" "Series")) list("segL")) list("XPGA_XOTA_XRCMG_XR_SEG_01" "sky130_fd_pr_main" "res_high_po_0p35" list(list("PLUS" "VDD") list("MINUS" "XPGA_XOTA_XRCMG_XR_SERIES_NODE_01") list("B" "VSS")) list(list("segL" "51.9u") list("segW" "0.35u") list("segments" 1) list("connection" "Series")) list("segL")) list("XPGA_XOTA_XRCMG_XR_SEG_02" "sky130_fd_pr_main" "res_high_po_0p35" list(list("PLUS" "XPGA_XOTA_XRCMG_XR_SERIES_NODE_01") list("MINUS" "XPGA_XOTA_CMG") list("B" "VSS")) list(list("segL" "51.9u") list("segW" "0.35u") list("segments" 1) list("connection" "Series")) list("segL")) list("XRIP_XR" "sky130_fd_pr_main" "res_high_po_0p35" list(list("PLUS" "OP") list("MINUS" "FP") list("B" "VSS")) list(list("segL" "0.545u") list("segW" "0.35u") list("segments" 1) list("connection" "Series")) list("segL")) list("XRIN_XR" "sky130_fd_pr_main" "res_high_po_0p35" list(list("PLUS" "ON") list("MINUS" "FN") list("B" "VSS")) list(list("segL" "0.545u") list("segW" "0.35u") list("segments" 1) list("connection" "Series")) list("segL")) list("XCFP_XC0_XC" "sky130_fd_pr_main" "cap_mim_m3__base" list(list("PLUS" "FP") list("MINUS" "VSS")) list(list("w" "22.215u") list("l" "22.215u") list("m" "1")) list("w" "l" "m")) list("XCFP_XC1_XC" "sky130_fd_pr_main" "cap_mim_m3__base" list(list("PLUS" "FP") list("MINUS" "VSS")) list(list("w" "22.215u") list("l" "22.215u") list("m" "1")) list("w" "l" "m")) list("XCFP_XC2_XC" "sky130_fd_pr_main" "cap_mim_m3__base" list(list("PLUS" "FP") list("MINUS" "VSS")) list(list("w" "22.215u") list("l" "22.215u") list("m" "1")) list("w" "l" "m")) list("XCFP_XC3_XC" "sky130_fd_pr_main" "cap_mim_m3__base" list(list("PLUS" "FP") list("MINUS" "VSS")) list(list("w" "22.215u") list("l" "22.215u") list("m" "1")) list("w" "l" "m")) list("XCFN_XC0_XC" "sky130_fd_pr_main" "cap_mim_m3__base" list(list("PLUS" "FN") list("MINUS" "VSS")) list(list("w" "22.215u") list("l" "22.215u") list("m" "1")) list("w" "l" "m")) list("XCFN_XC1_XC" "sky130_fd_pr_main" "cap_mim_m3__base" list(list("PLUS" "FN") list("MINUS" "VSS")) list(list("w" "22.215u") list("l" "22.215u") list("m" "1")) list("w" "l" "m")) list("XCFN_XC2_XC" "sky130_fd_pr_main" "cap_mim_m3__base" list(list("PLUS" "FN") list("MINUS" "VSS")) list(list("w" "22.215u") list("l" "22.215u") list("m" "1")) list("w" "l" "m")) list("XCFN_XC3_XC" "sky130_fd_pr_main" "cap_mim_m3__base" list(list("PLUS" "FN") list("MINUS" "VSS")) list(list("w" "22.215u") list("l" "22.215u") list("m" "1")) list("w" "l" "m"))) list("IP" "IN" "FP" "FN" "SEL0" "SEL1" "VCM" "VDD" "VSS"))
p2adcSymbol("p2adc_frontend_school_r3" list("IP" "IN" "FP" "FN" "SEL0" "SEL1" "VCM" "VDD" "VSS"))
p2adcOne
