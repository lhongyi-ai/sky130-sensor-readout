* NGSPICE file created from adc_tgate_flat.ext - technology: sky130A

.subckt adc_tgate_flat A B EN ENB VDD VSS
X0 A.t0 EN.t1 B.t0 VSS.t0 sky130_fd_pr__nfet_01v8_lvt ad=1.16 pd=8.58 as=1.16 ps=8.58 w=4 l=0.15
X1 A.t1 ENB.t1 B.t5 VDD.t0 sky130_fd_pr__pfet_01v8_lvt ad=2.32 pd=16.58 as=2.32 ps=16.58 w=8 l=0.35
X2 B.t4 ENB.t0 B.t3 VSS.t0 sky130_fd_pr__nfet_01v8_lvt ad=0.58 pd=4.58 as=0 ps=0 w=2 l=0.15
X3 B.t2 EN.t0 B.t1 VDD.t0 sky130_fd_pr__pfet_01v8_lvt ad=1.16 pd=8.58 as=0 ps=0 w=4 l=0.35
R0 ENB.n0 ENB.t1 766.25
R1 ENB ENB.t0 555.236
R2 ENB ENB.n0 0.0616
R3 ENB.n0 ENB 0.00708
R4 A.n0 A.t1 35.9083
R5 A.n0 A.t0 26.7229
R6 A A.n0 0.892861
R7 B.n0 B.t2 61.3912
R8 B.n0 B.t1 61.169
R9 B.n1 B.t4 41.5466
R10 B.n1 B.t3 41.3938
R11 B.n3 B.t5 35.8388
R12 B.n3 B.t0 26.7229
R13 B.n2 B.n0 6.39286
R14 B.n2 B.n1 4.62203
R15 B.n4 B.n2 3.40675
R16 B B.n4 0.313
R17 B.n4 B.n3 0.184528
R18 EN.n0 EN.t1 874.653
R19 EN.n0 EN.t0 491.341
R20 EN EN.n0 0.226687
R21 VDD.n10 VDD.n9 3977.65
R22 VDD.n11 VDD.n9 3977.65
R23 VDD.n15 VDD.n11 3977.65
R24 VDD.n15 VDD.n10 3977.65
R25 VDD.n16 VDD.n4 2565.88
R26 VDD.n16 VDD.n3 2565.88
R27 VDD.n7 VDD.n4 2565.88
R28 VDD.n7 VDD.n3 2565.88
R29 VDD.n13 VDD.n0 424.283
R30 VDD.n14 VDD.n13 424.283
R31 VDD.n12 VDD.n0 424.283
R32 VDD.n14 VDD.n12 424.283
R33 VDD.n17 VDD.n2 273.695
R34 VDD.n17 VDD.n1 273.695
R35 VDD.n6 VDD.n2 273.695
R36 VDD.n6 VDD.n1 273.695
R37 VDD.t0 VDD.n9 61.6672
R38 VDD.n9 VDD.n0 61.6672
R39 VDD.t0 VDD.n15 61.6672
R40 VDD.n15 VDD.n14 61.6672
R41 VDD.t0 VDD.n7 61.6672
R42 VDD.n7 VDD.n6 61.6672
R43 VDD.n16 VDD.t0 61.6672
R44 VDD.n17 VDD.n16 61.6672
R45 VDD.t0 VDD.n8 49.1861
R46 VDD.t0 VDD.n5 49.1861
R47 VDD.n18 VDD.n0 21.0234
R48 VDD.n18 VDD.n17 20.2127
R49 VDD.n5 VDD.n3 13.2148
R50 VDD.n3 VDD.n1 13.2148
R51 VDD.n8 VDD.n4 13.2148
R52 VDD.n4 VDD.n2 13.2148
R53 VDD.n11 VDD.n8 7.11588
R54 VDD.n13 VDD.n11 7.11588
R55 VDD.n10 VDD.n5 7.11588
R56 VDD.n12 VDD.n10 7.11588
R57 VDD VDD.n18 0.01648
R58 VSS.n10 VSS.n9 4044.29
R59 VSS.n11 VSS.n9 4044.29
R60 VSS.n15 VSS.n11 4044.29
R61 VSS.n15 VSS.n10 4044.29
R62 VSS.n16 VSS.n4 2885.47
R63 VSS.n16 VSS.n3 2885.47
R64 VSS.n7 VSS.n4 2885.47
R65 VSS.n7 VSS.n3 2885.47
R66 VSS.t0 VSS.n9 292.5
R67 VSS.n9 VSS.n0 292.5
R68 VSS.t0 VSS.n15 292.5
R69 VSS.n15 VSS.n14 292.5
R70 VSS.t0 VSS.n7 292.5
R71 VSS.n7 VSS.n6 292.5
R72 VSS.n16 VSS.t0 292.5
R73 VSS.n17 VSS.n16 292.5
R74 VSS.n13 VSS.n0 262.776
R75 VSS.n14 VSS.n13 262.776
R76 VSS.n12 VSS.n0 262.776
R77 VSS.n14 VSS.n12 262.776
R78 VSS.t0 VSS.n8 200.983
R79 VSS.t0 VSS.n5 200.983
R80 VSS.n17 VSS.n2 187.482
R81 VSS.n17 VSS.n1 187.482
R82 VSS.n6 VSS.n2 187.482
R83 VSS.n6 VSS.n1 187.482
R84 VSS.n5 VSS.n3 73.1255
R85 VSS.n3 VSS.n1 73.1255
R86 VSS.n8 VSS.n4 73.1255
R87 VSS.n4 VSS.n2 73.1255
R88 VSS.n11 VSS.n8 41.7862
R89 VSS.n13 VSS.n11 41.7862
R90 VSS.n10 VSS.n5 41.7862
R91 VSS.n12 VSS.n10 41.7862
R92 VSS.n18 VSS.n0 19.6323
R93 VSS.n18 VSS.n17 18.704
R94 VSS VSS.n18 0.137387
C0 A VDD 0.57452f
C1 ENB VDD 0.6058f
C2 B VDD 1.17993f
C3 A EN 0.24174f
C4 ENB EN 0.69864f
C5 B EN 0.43553f
C6 ENB A 0.24832f
C7 A B 1.22031f
C8 ENB B 0.57946f
C9 EN VDD 0.58618f
C10 ENB VSS 3.1378f
C11 A VSS 0.81476f
C12 B VSS 2.36404f
C13 EN VSS 1.77683f
C14 VDD VSS 7.84089f
C15 VDD.n0 VSS 0.10419f
C16 VDD.n1 VSS 0.02996f
C17 VDD.n2 VSS 0.02996f
C18 VDD.n3 VSS 0.02996f
C19 VDD.n4 VSS 0.02996f
C20 VDD.n5 VSS 0.58494f
C21 VDD.n6 VSS 0.03066f
C22 VDD.n7 VSS 0.03066f
C23 VDD.n8 VSS 0.58494f
C24 VDD.n9 VSS 0.04708f
C25 VDD.n10 VSS 0.04613f
C26 VDD.n11 VSS 0.04613f
C27 VDD.n12 VSS 0.04613f
C28 VDD.n13 VSS 0.04613f
C29 VDD.n14 VSS 0.04708f
C30 VDD.n15 VSS 0.04708f
C31 VDD.t0 VSS 0.73323f
C32 VDD.n16 VSS 0.03066f
C33 VDD.n17 VSS 0.08049f
C34 VDD.n18 VSS 0.31713f
C35 EN.n0 VSS 1.54122f
C36 B.t2 VSS 0.25951f
C37 B.t1 VSS 0.25864f
C38 B.n0 VSS 0.53575f
C39 B.t4 VSS 0.11067f
C40 B.t3 VSS 0.11021f
C41 B.n1 VSS 0.26895f
C42 B.n2 VSS 0.46671f
C43 B.t5 VSS 0.55606f
C44 B.t0 VSS 0.23921f
C45 B.n3 VSS 0.86057f
C46 B.n4 VSS 0.27485f
C47 A.t1 VSS 0.74001f
C48 A.t0 VSS 0.32664f
C49 A.n0 VSS 1.36058f
C50 ENB.n0 VSS 0.44405f
.ends
