* NGSPICE file created from adc_tgate_layout.ext - technology: sky130A

.subckt tg_nfet_lvt B D S G
X0 S G D B sky130_fd_pr__nfet_01v8_lvt ad=1.16 pd=8.58 as=1.16 ps=8.58 w=4 l=0.15
.ends

.subckt tg_pfet_dummy B D S G
X0 S G D B sky130_fd_pr__pfet_01v8_lvt ad=1.16 pd=8.58 as=1.16 ps=8.58 w=4 l=0.35
.ends

.subckt tg_pfet_lvt B D S G
X0 S G D B sky130_fd_pr__pfet_01v8_lvt ad=2.32 pd=16.58 as=2.32 ps=16.58 w=8 l=0.35
.ends

.subckt tg_nfet_dummy B D S G
X0 S G D B sky130_fd_pr__nfet_01v8_lvt ad=0.58 pd=4.58 as=0.58 ps=4.58 w=2 l=0.15
.ends

.subckt adc_tgate_layout A B EN ENB VDD VSS
XXN VSS B A EN tg_nfet_lvt
XXPD VDD B B EN tg_pfet_dummy
XXP VDD B A ENB tg_pfet_lvt
XXND VSS B B ENB tg_nfet_dummy
.ends
