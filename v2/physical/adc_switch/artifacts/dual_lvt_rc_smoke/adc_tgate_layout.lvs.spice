* NGSPICE file created from adc_tgate_layout.ext - technology: sky130A

.subckt tg_nfet_lvt B D S G
X0 S G D B sky130_fd_pr__nfet_01v8_lvt ad=1.16 pd=8.58 as=1.16 ps=8.58 w=4 l=0.15
.ends

.subckt tg_pfet_lvt B D S G
X0 S G D B sky130_fd_pr__pfet_01v8_lvt ad=1.45 pd=10.58 as=1.45 ps=10.58 w=5 l=0.35
.ends

.subckt adc_tgate_layout A B EN ENB VDD VSS
XXN VSS B A EN tg_nfet_lvt
XXP VDD B A ENB tg_pfet_lvt
.ends
