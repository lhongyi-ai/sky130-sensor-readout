* NGSPICE file created from adc_tgate_flat.ext - technology: sky130A

.subckt adc_tgate_flat A B EN ENB VDD VSS
X0 A.t0 EN.t0 B.t0 VSS.t0 sky130_fd_pr__nfet_01v8_lvt ad=1.16 pd=8.58 as=1.16 ps=8.58 w=4 l=0.15
X1 A.t1 ENB.t0 B.t1 VDD.t0 sky130_fd_pr__pfet_01v8_lvt ad=1.45 pd=10.58 as=1.45 ps=10.58 w=5 l=0.35
R0 ENB ENB.t0 549.764
R1 A.n0 A.t1 54.6431
R2 A.n0 A.t0 26.7229
R3 A A.n0 0.892861
R4 B.n0 B.t1 54.5737
R5 B.n0 B.t0 26.7229
R6 B B.n0 0.497028
R7 EN EN.t0 863.523
R8 VDD.n4 VDD.n1 2918.82
R9 VDD.n7 VDD.n3 2918.82
R10 VDD.n9 VDD.n8 311.341
R11 VDD.n8 VDD.n2 311.341
R12 VDD.n9 VDD.n0 311.341
R13 VDD.n2 VDD.n0 311.341
R14 VDD.n7 VDD.n6 120.62
R15 VDD.n5 VDD.n4 120.62
R16 VDD.n9 VDD.n1 61.6672
R17 VDD.n3 VDD.n2 61.6672
R18 VDD.n6 VDD.n1 57.8962
R19 VDD.n5 VDD.n3 57.8962
R20 VDD.n8 VDD.n7 10.8829
R21 VDD.n4 VDD.n0 10.8829
R22 VDD VDD.n9 9.363
R23 VDD.t0 VDD.n5 2.54934
R24 VDD.n6 VDD.t0 2.54934
R25 VSS.n4 VSS.n1 4044.29
R26 VSS.n7 VSS.n3 4044.29
R27 VSS.n7 VSS.n6 436.897
R28 VSS.n5 VSS.n4 436.897
R29 VSS.n9 VSS.n1 292.5
R30 VSS.n3 VSS.n2 292.5
R31 VSS.n9 VSS.n8 262.776
R32 VSS.n8 VSS.n2 262.776
R33 VSS.n9 VSS.n0 262.776
R34 VSS.n2 VSS.n0 262.776
R35 VSS.n6 VSS.n1 243.305
R36 VSS.n5 VSS.n3 243.305
R37 VSS.n8 VSS.n7 41.7862
R38 VSS.n4 VSS.n0 41.7862
R39 VSS.t0 VSS.n5 31.5992
R40 VSS.n6 VSS.t0 31.5992
R41 VSS VSS.n9 9.363
C0 A EN 0.08112f
C1 A VDD 0.40382f
C2 B A 1.03495f
C3 A ENB 0.15814f
C4 EN VDD 0.00231f
C5 B EN 0.08351f
C6 B VDD 0.36795f
C7 ENB VDD 0.24484f
C8 B ENB 0.13878f
C9 ENB VSS 0.20762f
C10 A VSS 0.90096f
C11 B VSS 0.82823f
C12 EN VSS 0.36129f
C13 VDD VSS 2.60881f
C14 VDD.n0 VSS 0.03221f
C15 VDD.n1 VSS 0.03296f
C16 VDD.n2 VSS 0.03296f
C17 VDD.n3 VSS 0.03296f
C18 VDD.n4 VSS 0.24445f
C19 VDD.t0 VSS 0.32994f
C20 VDD.n7 VSS 0.24445f
C21 VDD.n8 VSS 0.03221f
C22 VDD.n9 VSS 0.03298f
C23 B.t1 VSS 0.50796f
C24 B.t0 VSS 0.30389f
C25 B.n0 VSS 1.03322f
C26 A.t1 VSS 0.50264f
C27 A.t0 VSS 0.29877f
C28 A.n0 VSS 1.06064f
.ends
